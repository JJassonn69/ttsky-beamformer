* NGSPICE file created from v3_four_channel_power_integration.ext - technology: sky130A

X0 v3_four_channel_output_load_integration_0/combined_p VGND sky130_fd_pr__cap_mim_m3_1 l=4.2 w=4.2
X1 v3_four_channel_output_load_integration_0/v3_four_channel_shared_support_integration_0/v3_tail_bias_support_block_0/vbias v3_four_channel_output_load_integration_0/v3_four_channel_shared_support_integration_0/v3_tail_bias_support_block_0/vbias VGND VGND sky130_fd_pr__nfet_01v8 ad=1.16 pd=8.29 as=1.16 ps=8.29 w=8 l=1
X2 v3_four_channel_output_load_integration_0/v3_four_channel_shared_support_integration_0/v3_tail_bias_support_block_0/vbias v3_four_channel_output_load_integration_0/v3_four_channel_shared_support_integration_0/v3_tail_bias_support_block_0/vbias VGND VGND sky130_fd_pr__nfet_01v8 ad=2.32 pd=16.58 as=1.16 ps=8.29 w=8 l=1
X3 VGND v3_four_channel_output_load_integration_0/v3_four_channel_shared_support_integration_0/v3_tail_bias_support_block_0/vbias v3_four_channel_output_load_integration_0/v3_four_channel_shared_support_integration_0/v3_tail_bias_support_block_0/vbias VGND sky130_fd_pr__nfet_01v8 ad=1.16 pd=8.29 as=1.16 ps=8.29 w=8 l=1
X4 v3_four_channel_output_load_integration_0/v3_four_channel_shared_support_integration_0/v3_tail_bias_support_block_0/vbias v3_four_channel_output_load_integration_0/v3_four_channel_shared_support_integration_0/v3_tail_bias_support_block_0/vbias VGND VGND sky130_fd_pr__nfet_01v8 ad=1.16 pd=8.29 as=1.16 ps=8.29 w=8 l=1
X5 v3_four_channel_output_load_integration_0/v3_four_channel_shared_support_integration_0/v3_tail_bias_support_block_0/vbias VGND sky130_fd_pr__cap_mim_m3_1 l=22 w=22
X6 VGND v3_four_channel_output_load_integration_0/v3_four_channel_shared_support_integration_0/v3_tail_bias_support_block_0/vbias v3_four_channel_output_load_integration_0/v3_four_channel_shared_support_integration_0/v3_tail_bias_support_block_0/vbias VGND sky130_fd_pr__nfet_01v8 ad=1.16 pd=8.29 as=2.32 ps=16.58 w=8 l=1
X7 VDPWR v3_four_channel_output_load_integration_0/v3_four_channel_shared_support_integration_0/v3_tail_bias_support_block_0/vbias VGND sky130_fd_pr__res_high_po_1p41 l=44.98
X8 VGND v3_four_channel_output_load_integration_0/v3_four_channel_shared_support_integration_0/v3_tail_bias_support_block_0/vbias v3_four_channel_output_load_integration_0/v3_four_channel_shared_support_integration_0/v3_tail_bias_support_block_0/vbias VGND sky130_fd_pr__nfet_01v8 ad=1.16 pd=8.29 as=1.16 ps=8.29 w=8 l=1
X9 VGND v3_four_channel_output_load_integration_0/v3_four_channel_shared_support_integration_0/v3_tail_bias_support_block_0/vbias v3_four_channel_output_load_integration_0/v3_four_channel_shared_support_integration_0/v3_tail_bias_support_block_0/vbias VGND sky130_fd_pr__nfet_01v8 ad=1.16 pd=8.29 as=1.16 ps=8.29 w=8 l=1
X10 v3_four_channel_output_load_integration_0/v3_four_channel_shared_support_integration_0/v3_tail_bias_support_block_0/vbias v3_four_channel_output_load_integration_0/v3_four_channel_shared_support_integration_0/v3_tail_bias_support_block_0/vbias VGND VGND sky130_fd_pr__nfet_01v8 ad=1.16 pd=8.29 as=1.16 ps=8.29 w=8 l=1
X11 v3_four_channel_output_load_integration_0/v3_four_channel_shared_support_integration_0/v3_tail_bias_support_block_0/vbias VGND sky130_fd_pr__cap_mim_m3_1 l=22 w=22
X12 v3_four_channel_output_load_integration_0/v3_four_channel_shared_support_integration_0/v3_vcm_support_block_0/a_4259_24172# v3_four_channel_output_load_integration_0/v3_four_channel_shared_support_integration_0/v3_vcm_support_block_0/ref VGND sky130_fd_pr__res_xhigh_po_1p41 l=5.88
X13 v3_four_channel_output_load_integration_0/v3_four_channel_shared_support_integration_0/v3_vcm_support_block_0/a_4259_27772# v3_four_channel_output_load_integration_0/v3_four_channel_shared_support_integration_0/v3_vcm_support_block_0/a_4259_24172# VGND sky130_fd_pr__res_xhigh_po_1p41 l=5.88
X14 v3_four_channel_output_load_integration_0/v3_four_channel_shared_support_integration_0/v3_vcm_support_block_0/ref VGND sky130_fd_pr__cap_mim_m3_1 l=22 w=22
X15 v3_four_channel_output_load_integration_0/v3_four_channel_shared_support_integration_0/v3_vcm_support_block_0/ref VGND sky130_fd_pr__cap_mim_m3_1 l=22 w=22
X16 v3_four_channel_output_load_integration_0/v3_four_channel_shared_support_integration_0/v3_vcm_support_block_0/ref VGND sky130_fd_pr__cap_mim_m3_1 l=22 w=22
X17 v3_four_channel_output_load_integration_0/v3_four_channel_shared_support_integration_0/v3_vcm_support_block_0/a_8459_24172# VGND VGND sky130_fd_pr__res_xhigh_po_1p41 l=5.88
X18 v3_four_channel_output_load_integration_0/v3_four_channel_shared_support_integration_0/v3_vcm_support_block_0/a_4259_27772# v3_four_channel_output_load_integration_0/v3_four_channel_shared_support_integration_0/v3_vcm_support_block_0/a_8459_24172# VGND sky130_fd_pr__res_xhigh_po_1p41 l=5.88
X19 v3_four_channel_output_load_integration_0/v3_four_channel_shared_support_integration_0/v3_vcm_support_block_0/a_6359_24172# v3_four_channel_output_load_integration_0/v3_four_channel_shared_support_integration_0/v3_vcm_support_block_0/ref VGND sky130_fd_pr__res_xhigh_po_1p41 l=5.88
X20 VDPWR v3_four_channel_output_load_integration_0/v3_four_channel_shared_support_integration_0/v3_vcm_support_block_0/a_6359_24172# VGND sky130_fd_pr__res_xhigh_po_1p41 l=5.88
X21 v3_four_channel_output_load_integration_0/v3_four_channel_shared_support_integration_0/v3_four_channel_bias_reference_distribution_0/v3_four_channel_phase_distribution_0/v3_four_channel_output_collection_0/v3_four_channel_placement_0/v3_channel_selector_late_promotion_0/v3_channel_input_bias_late_promotion_0/a_4678_23422# v3_four_channel_output_load_integration_0/v3_four_channel_shared_support_integration_0/v3_four_channel_bias_reference_distribution_0/v3_four_channel_phase_distribution_0/v3_four_channel_output_collection_0/v3_four_channel_placement_0/v3_channel_selector_late_promotion_0/v3_selector_route_pilot_0/group3_lo_p v3_four_channel_output_load_integration_0/combined_n VGND sky130_fd_pr__nfet_01v8 ad=0.1885 pd=1.88 as=0.1885 ps=1.88 w=0.65 l=0.15
X22 v3_four_channel_output_load_integration_0/combined_n v3_four_channel_output_load_integration_0/v3_four_channel_shared_support_integration_0/v3_four_channel_bias_reference_distribution_0/v3_four_channel_phase_distribution_0/v3_four_channel_output_collection_0/v3_four_channel_placement_0/v3_channel_selector_late_promotion_0/v3_selector_route_pilot_0/group3_lo_p v3_four_channel_output_load_integration_0/v3_four_channel_shared_support_integration_0/v3_four_channel_bias_reference_distribution_0/v3_four_channel_phase_distribution_0/v3_four_channel_output_collection_0/v3_four_channel_placement_0/v3_channel_selector_late_promotion_0/v3_channel_input_bias_late_promotion_0/a_4254_6978# VGND sky130_fd_pr__nfet_01v8 ad=0.1885 pd=1.88 as=0.1885 ps=1.88 w=0.65 l=0.15
X23 v3_four_channel_output_load_integration_0/v3_four_channel_shared_support_integration_0/v3_four_channel_bias_reference_distribution_0/v3_four_channel_phase_distribution_0/v3_four_channel_output_collection_0/v3_four_channel_placement_0/v3_channel_selector_late_promotion_0/v3_channel_input_bias_late_promotion_0/a_4678_23422# v3_four_channel_output_load_integration_0/v3_four_channel_shared_support_integration_0/v3_vcm_support_block_0/ref v3_four_channel_output_load_integration_0/v3_four_channel_shared_support_integration_0/v3_four_channel_bias_reference_distribution_0/v3_four_channel_phase_distribution_0/v3_four_channel_output_collection_0/v3_four_channel_placement_0/v3_channel_selector_late_promotion_0/v3_channel_input_bias_late_promotion_0/a_4382_21688# VGND sky130_fd_pr__nfet_01v8 ad=0.2436 pd=2.26 as=0.2436 ps=2.26 w=0.84 l=0.6
X24 v3_four_channel_output_load_integration_0/combined_n v3_four_channel_output_load_integration_0/v3_four_channel_shared_support_integration_0/v3_four_channel_bias_reference_distribution_0/v3_four_channel_phase_distribution_0/v3_four_channel_output_collection_0/v3_four_channel_placement_0/v3_channel_selector_late_promotion_0/v3_selector_route_pilot_0/group3_lo_n v3_four_channel_output_load_integration_0/v3_four_channel_shared_support_integration_0/v3_four_channel_bias_reference_distribution_0/v3_four_channel_phase_distribution_0/v3_four_channel_output_collection_0/v3_four_channel_placement_0/v3_channel_selector_late_promotion_0/v3_channel_input_bias_late_promotion_0/a_7038_22978# VGND sky130_fd_pr__nfet_01v8 ad=0.1885 pd=1.88 as=0.1885 ps=1.88 w=0.65 l=0.15
X25 v3_four_channel_output_load_integration_0/combined_n v3_four_channel_output_load_integration_0/v3_four_channel_shared_support_integration_0/v3_four_channel_bias_reference_distribution_0/v3_four_channel_phase_distribution_0/v3_four_channel_output_collection_0/v3_four_channel_placement_0/v3_channel_selector_late_promotion_0/v3_selector_route_pilot_0/group3_lo_p v3_four_channel_output_load_integration_0/v3_four_channel_shared_support_integration_0/v3_four_channel_bias_reference_distribution_0/v3_four_channel_phase_distribution_0/v3_four_channel_output_collection_0/v3_four_channel_placement_0/v3_channel_selector_late_promotion_0/v3_channel_input_bias_late_promotion_0/a_7038_6978# VGND sky130_fd_pr__nfet_01v8 ad=0.1885 pd=1.88 as=0.1885 ps=1.88 w=0.65 l=0.15
X26 v3_four_channel_output_load_integration_0/v3_four_channel_shared_support_integration_0/v3_four_channel_bias_reference_distribution_0/v3_four_channel_phase_distribution_0/v3_four_channel_output_collection_0/v3_four_channel_placement_0/v3_channel_selector_late_promotion_0/v3_channel_input_bias_late_promotion_0/a_7462_11422# v3_four_channel_output_load_integration_0/v3_four_channel_shared_support_integration_0/v3_four_channel_bias_reference_distribution_0/v3_four_channel_phase_distribution_0/v3_four_channel_output_collection_0/v3_four_channel_placement_0/v3_channel_selector_late_promotion_0/element_input v3_four_channel_output_load_integration_0/v3_four_channel_shared_support_integration_0/v3_four_channel_bias_reference_distribution_0/v3_four_channel_phase_distribution_0/v3_four_channel_output_collection_0/v3_four_channel_placement_0/v3_channel_selector_late_promotion_0/v3_channel_input_bias_late_promotion_0/a_7216_10978# VGND sky130_fd_pr__nfet_01v8 ad=0.2436 pd=2.26 as=0.2436 ps=2.26 w=0.84 l=0.6
X27 v3_four_channel_output_load_integration_0/v3_four_channel_shared_support_integration_0/v3_four_channel_bias_reference_distribution_0/v3_four_channel_phase_distribution_0/v3_four_channel_output_collection_0/v3_four_channel_placement_0/v3_channel_selector_late_promotion_0/v3_channel_input_bias_late_promotion_0/a_7462_11422# v3_four_channel_output_load_integration_0/v3_four_channel_shared_support_integration_0/v3_four_channel_bias_reference_distribution_0/v3_four_channel_phase_distribution_0/v3_four_channel_output_collection_0/v3_four_channel_placement_0/v3_channel_selector_late_promotion_0/v3_selector_route_pilot_0/group2_lo_n v3_four_channel_output_load_integration_0/combined_n VGND sky130_fd_pr__nfet_01v8 ad=0.1885 pd=1.88 as=0.1885 ps=1.88 w=0.65 l=0.15
X28 v3_four_channel_output_load_integration_0/v3_four_channel_shared_support_integration_0/v3_four_channel_bias_reference_distribution_0/v3_four_channel_phase_distribution_0/v3_four_channel_output_collection_0/v3_four_channel_placement_0/v3_channel_selector_late_promotion_0/v3_channel_input_bias_late_promotion_0/a_5774_21688# v3_four_channel_output_load_integration_0/v3_four_channel_shared_support_integration_0/v3_four_channel_bias_reference_distribution_0/v3_four_channel_phase_distribution_0/v3_four_channel_output_collection_0/v3_four_channel_placement_0/v3_channel_selector_late_promotion_0/element_input v3_four_channel_output_load_integration_0/v3_four_channel_shared_support_integration_0/v3_four_channel_bias_reference_distribution_0/v3_four_channel_phase_distribution_0/v3_four_channel_output_collection_0/v3_four_channel_placement_0/v3_channel_selector_late_promotion_0/v3_channel_input_bias_late_promotion_0/a_5646_22978# VGND sky130_fd_pr__nfet_01v8 ad=0.2436 pd=2.26 as=0.2436 ps=2.26 w=0.84 l=0.6
X29 VGND v3_four_channel_output_load_integration_0/v3_four_channel_shared_support_integration_0/v3_tail_bias_support_block_0/vbias v3_four_channel_output_load_integration_0/v3_four_channel_shared_support_integration_0/v3_four_channel_bias_reference_distribution_0/v3_four_channel_phase_distribution_0/v3_four_channel_output_collection_0/v3_four_channel_placement_0/v3_channel_selector_late_promotion_0/v3_channel_input_bias_late_promotion_0/a_5774_17688# VGND sky130_fd_pr__nfet_01v8 ad=1.4703 pd=10.72 as=1.4703 ps=10.72 w=5.07 l=1
X30 v3_four_channel_output_load_integration_0/v3_four_channel_shared_support_integration_0/v3_four_channel_bias_reference_distribution_0/v3_four_channel_phase_distribution_0/v3_four_channel_output_collection_0/v3_four_channel_placement_0/v3_channel_selector_late_promotion_0/v3_channel_input_bias_late_promotion_0/a_6070_7422# v3_four_channel_output_load_integration_0/v3_four_channel_shared_support_integration_0/v3_four_channel_bias_reference_distribution_0/v3_four_channel_phase_distribution_0/v3_four_channel_output_collection_0/v3_four_channel_placement_0/v3_channel_selector_late_promotion_0/element_input v3_four_channel_output_load_integration_0/v3_four_channel_shared_support_integration_0/v3_four_channel_bias_reference_distribution_0/v3_four_channel_phase_distribution_0/v3_four_channel_output_collection_0/v3_four_channel_placement_0/v3_channel_selector_late_promotion_0/v3_channel_input_bias_late_promotion_0/a_5824_6978# VGND sky130_fd_pr__nfet_01v8 ad=0.2436 pd=2.26 as=0.2436 ps=2.26 w=0.84 l=0.6
X31 v3_four_channel_output_load_integration_0/v3_four_channel_shared_support_integration_0/v3_four_channel_bias_reference_distribution_0/v3_four_channel_phase_distribution_0/v3_four_channel_output_collection_0/v3_four_channel_placement_0/v3_channel_selector_late_promotion_0/v3_channel_input_bias_late_promotion_0/a_6070_7422# v3_four_channel_output_load_integration_0/v3_four_channel_shared_support_integration_0/v3_four_channel_bias_reference_distribution_0/v3_four_channel_phase_distribution_0/v3_four_channel_output_collection_0/v3_four_channel_placement_0/v3_channel_selector_late_promotion_0/v3_selector_route_pilot_0/group3_lo_n v3_four_channel_output_load_integration_0/combined_n VGND sky130_fd_pr__nfet_01v8 ad=0.1885 pd=1.88 as=0.1885 ps=1.88 w=0.65 l=0.15
X32 v3_four_channel_output_load_integration_0/v3_four_channel_shared_support_integration_0/v3_vcm_support_block_0/ref v3_four_channel_output_load_integration_0/v3_four_channel_shared_support_integration_0/v3_four_channel_bias_reference_distribution_0/v3_four_channel_phase_distribution_0/v3_four_channel_output_collection_0/v3_four_channel_placement_0/v3_channel_selector_late_promotion_0/element_input VGND sky130_fd_pr__res_xhigh_po_0p35 l=17.36
X33 v3_four_channel_output_load_integration_0/v3_four_channel_shared_support_integration_0/v3_four_channel_bias_reference_distribution_0/v3_four_channel_phase_distribution_0/v3_four_channel_output_collection_0/v3_four_channel_placement_0/v3_channel_selector_late_promotion_0/v3_channel_input_bias_late_promotion_0/a_7462_23422# v3_four_channel_output_load_integration_0/v3_four_channel_shared_support_integration_0/v3_vcm_support_block_0/ref v3_four_channel_output_load_integration_0/v3_four_channel_shared_support_integration_0/v3_four_channel_bias_reference_distribution_0/v3_four_channel_phase_distribution_0/v3_four_channel_output_collection_0/v3_four_channel_placement_0/v3_channel_selector_late_promotion_0/v3_channel_input_bias_late_promotion_0/a_7166_21688# VGND sky130_fd_pr__nfet_01v8 ad=0.2436 pd=2.26 as=0.2436 ps=2.26 w=0.84 l=0.6
X34 v3_four_channel_output_load_integration_0/v3_four_channel_shared_support_integration_0/v3_four_channel_bias_reference_distribution_0/v3_four_channel_phase_distribution_0/v3_four_channel_output_collection_0/v3_four_channel_placement_0/v3_channel_selector_late_promotion_0/v3_channel_input_bias_late_promotion_0/a_7462_23422# v3_four_channel_output_load_integration_0/v3_four_channel_shared_support_integration_0/v3_four_channel_bias_reference_distribution_0/v3_four_channel_phase_distribution_0/v3_four_channel_output_collection_0/v3_four_channel_placement_0/v3_channel_selector_late_promotion_0/v3_selector_route_pilot_0/group3_lo_p v3_four_channel_output_load_integration_0/combined_n VGND sky130_fd_pr__nfet_01v8 ad=0.1885 pd=1.88 as=0.1885 ps=1.88 w=0.65 l=0.15
X35 VGND v3_four_channel_output_load_integration_0/v3_four_channel_shared_support_integration_0/v3_tail_bias_support_block_0/vbias v3_four_channel_output_load_integration_0/v3_four_channel_shared_support_integration_0/v3_four_channel_bias_reference_distribution_0/v3_four_channel_phase_distribution_0/v3_four_channel_output_collection_0/v3_four_channel_placement_0/v3_channel_selector_late_promotion_0/v3_channel_input_bias_late_promotion_0/a_4382_21688# VGND sky130_fd_pr__nfet_01v8 ad=1.4703 pd=10.72 as=1.4703 ps=10.72 w=5.07 l=1
X36 VGND v3_four_channel_output_load_integration_0/v3_four_channel_shared_support_integration_0/v3_tail_bias_support_block_0/vbias v3_four_channel_output_load_integration_0/v3_four_channel_shared_support_integration_0/v3_four_channel_bias_reference_distribution_0/v3_four_channel_phase_distribution_0/v3_four_channel_output_collection_0/v3_four_channel_placement_0/v3_channel_selector_late_promotion_0/v3_channel_input_bias_late_promotion_0/a_5774_13688# VGND sky130_fd_pr__nfet_01v8 ad=1.4703 pd=10.72 as=1.4703 ps=10.72 w=5.07 l=1
X37 VGND v3_four_channel_output_load_integration_0/v3_four_channel_shared_support_integration_0/v3_tail_bias_support_block_0/vbias v3_four_channel_output_load_integration_0/v3_four_channel_shared_support_integration_0/v3_four_channel_bias_reference_distribution_0/v3_four_channel_phase_distribution_0/v3_four_channel_output_collection_0/v3_four_channel_placement_0/v3_channel_selector_late_promotion_0/v3_channel_input_bias_late_promotion_0/a_7166_17688# VGND sky130_fd_pr__nfet_01v8 ad=1.4703 pd=10.72 as=1.4703 ps=10.72 w=5.07 l=1
X38 VGND VGND VGND VGND sky130_fd_pr__nfet_01v8 ad=0.1885 pd=1.88 as=176.39079 ps=1.364k w=0.65 l=0.15
X39 v3_four_channel_output_load_integration_0/combined_p v3_four_channel_output_load_integration_0/v3_four_channel_shared_support_integration_0/v3_four_channel_bias_reference_distribution_0/v3_four_channel_phase_distribution_0/v3_four_channel_output_collection_0/v3_four_channel_placement_0/v3_channel_selector_late_promotion_0/v3_selector_route_pilot_0/group3_lo_p v3_four_channel_output_load_integration_0/v3_four_channel_shared_support_integration_0/v3_four_channel_bias_reference_distribution_0/v3_four_channel_phase_distribution_0/v3_four_channel_output_collection_0/v3_four_channel_placement_0/v3_channel_selector_late_promotion_0/v3_channel_input_bias_late_promotion_0/a_5646_18978# VGND sky130_fd_pr__nfet_01v8 ad=0.1885 pd=1.88 as=0.1885 ps=1.88 w=0.65 l=0.15
X40 VGND VGND VGND VGND sky130_fd_pr__nfet_01v8 ad=0.1885 pd=1.88 as=0 ps=0 w=0.65 l=0.15
X41 v3_four_channel_output_load_integration_0/v3_four_channel_shared_support_integration_0/v3_four_channel_bias_reference_distribution_0/v3_four_channel_phase_distribution_0/v3_four_channel_output_collection_0/v3_four_channel_placement_0/v3_channel_selector_late_promotion_0/v3_channel_input_bias_late_promotion_0/a_6070_19422# v3_four_channel_output_load_integration_0/v3_four_channel_shared_support_integration_0/v3_four_channel_bias_reference_distribution_0/v3_four_channel_phase_distribution_0/v3_four_channel_output_collection_0/v3_four_channel_placement_0/v3_channel_selector_late_promotion_0/v3_selector_route_pilot_0/group3_lo_n v3_four_channel_output_load_integration_0/combined_p VGND sky130_fd_pr__nfet_01v8 ad=0.1885 pd=1.88 as=0.1885 ps=1.88 w=0.65 l=0.15
X42 VGND VGND VGND VGND sky130_fd_pr__nfet_01v8 ad=0.1885 pd=1.88 as=0 ps=0 w=0.65 l=0.15
X43 v3_four_channel_output_load_integration_0/combined_p v3_four_channel_output_load_integration_0/v3_four_channel_shared_support_integration_0/v3_four_channel_bias_reference_distribution_0/v3_four_channel_phase_distribution_0/v3_four_channel_output_collection_0/v3_four_channel_placement_0/v3_channel_selector_late_promotion_0/v3_selector_route_pilot_0/group2_lo_p v3_four_channel_output_load_integration_0/v3_four_channel_shared_support_integration_0/v3_four_channel_bias_reference_distribution_0/v3_four_channel_phase_distribution_0/v3_four_channel_output_collection_0/v3_four_channel_placement_0/v3_channel_selector_late_promotion_0/v3_channel_input_bias_late_promotion_0/a_4254_18978# VGND sky130_fd_pr__nfet_01v8 ad=0.1885 pd=1.88 as=0.1885 ps=1.88 w=0.65 l=0.15
X44 v3_four_channel_output_load_integration_0/v3_four_channel_shared_support_integration_0/v3_four_channel_bias_reference_distribution_0/v3_four_channel_phase_distribution_0/v3_four_channel_output_collection_0/v3_four_channel_placement_0/v3_channel_selector_late_promotion_0/v3_channel_input_bias_late_promotion_0/a_7216_14978# v3_four_channel_output_load_integration_0/v3_four_channel_shared_support_integration_0/v3_tail_bias_support_block_0/vbias VGND VGND sky130_fd_pr__nfet_01v8 ad=1.4703 pd=10.72 as=1.4703 ps=10.72 w=5.07 l=1
X45 VGND VGND VGND VGND sky130_fd_pr__nfet_01v8 ad=0.1885 pd=1.88 as=0 ps=0 w=0.65 l=0.15
X46 VGND VGND VGND VGND sky130_fd_pr__nfet_01v8 ad=0.1885 pd=1.88 as=0 ps=0 w=0.65 l=0.15
X47 v3_four_channel_output_load_integration_0/v3_four_channel_shared_support_integration_0/v3_four_channel_bias_reference_distribution_0/v3_four_channel_phase_distribution_0/v3_four_channel_output_collection_0/v3_four_channel_placement_0/v3_channel_selector_late_promotion_0/v3_channel_input_bias_late_promotion_0/a_4382_17688# v3_four_channel_output_load_integration_0/v3_four_channel_shared_support_integration_0/v3_four_channel_bias_reference_distribution_0/v3_four_channel_phase_distribution_0/v3_four_channel_output_collection_0/v3_four_channel_placement_0/v3_channel_selector_late_promotion_0/element_input v3_four_channel_output_load_integration_0/v3_four_channel_shared_support_integration_0/v3_four_channel_bias_reference_distribution_0/v3_four_channel_phase_distribution_0/v3_four_channel_output_collection_0/v3_four_channel_placement_0/v3_channel_selector_late_promotion_0/v3_channel_input_bias_late_promotion_0/a_4254_18978# VGND sky130_fd_pr__nfet_01v8 ad=0.2436 pd=2.26 as=0.2436 ps=2.26 w=0.84 l=0.6
X48 v3_four_channel_output_load_integration_0/v3_four_channel_shared_support_integration_0/v3_four_channel_bias_reference_distribution_0/v3_four_channel_phase_distribution_0/v3_four_channel_output_collection_0/v3_four_channel_placement_0/v3_channel_selector_late_promotion_0/v3_channel_input_bias_late_promotion_0/a_4678_19422# v3_four_channel_output_load_integration_0/v3_four_channel_shared_support_integration_0/v3_four_channel_bias_reference_distribution_0/v3_four_channel_phase_distribution_0/v3_four_channel_output_collection_0/v3_four_channel_placement_0/v3_channel_selector_late_promotion_0/v3_selector_route_pilot_0/group2_lo_n v3_four_channel_output_load_integration_0/combined_p VGND sky130_fd_pr__nfet_01v8 ad=0.1885 pd=1.88 as=0.1885 ps=1.88 w=0.65 l=0.15
X49 v3_four_channel_output_load_integration_0/combined_p v3_four_channel_output_load_integration_0/v3_four_channel_shared_support_integration_0/v3_four_channel_bias_reference_distribution_0/v3_four_channel_phase_distribution_0/v3_four_channel_output_collection_0/v3_four_channel_placement_0/v3_channel_selector_late_promotion_0/v3_selector_route_pilot_0/group0_lo_p v3_four_channel_output_load_integration_0/v3_four_channel_shared_support_integration_0/v3_four_channel_bias_reference_distribution_0/v3_four_channel_phase_distribution_0/v3_four_channel_output_collection_0/v3_four_channel_placement_0/v3_channel_selector_late_promotion_0/v3_channel_input_bias_late_promotion_0/a_5646_14978# VGND sky130_fd_pr__nfet_01v8 ad=0.1885 pd=1.88 as=0.1885 ps=1.88 w=0.65 l=0.15
X50 v3_four_channel_output_load_integration_0/combined_p v3_four_channel_output_load_integration_0/v3_four_channel_shared_support_integration_0/v3_four_channel_bias_reference_distribution_0/v3_four_channel_phase_distribution_0/v3_four_channel_output_collection_0/v3_four_channel_placement_0/v3_channel_selector_late_promotion_0/v3_selector_route_pilot_0/group2_lo_p v3_four_channel_output_load_integration_0/v3_four_channel_shared_support_integration_0/v3_four_channel_bias_reference_distribution_0/v3_four_channel_phase_distribution_0/v3_four_channel_output_collection_0/v3_four_channel_placement_0/v3_channel_selector_late_promotion_0/v3_channel_input_bias_late_promotion_0/a_7038_18978# VGND sky130_fd_pr__nfet_01v8 ad=0.1885 pd=1.88 as=0.1885 ps=1.88 w=0.65 l=0.15
X51 VGND VGND VGND VGND sky130_fd_pr__nfet_01v8 ad=1.4703 pd=10.72 as=0 ps=0 w=5.07 l=1
X52 v3_four_channel_output_load_integration_0/v3_four_channel_shared_support_integration_0/v3_four_channel_bias_reference_distribution_0/v3_four_channel_phase_distribution_0/v3_four_channel_output_collection_0/v3_four_channel_placement_0/v3_channel_selector_late_promotion_0/v3_channel_input_bias_late_promotion_0/a_6070_15422# v3_four_channel_output_load_integration_0/v3_four_channel_shared_support_integration_0/v3_four_channel_bias_reference_distribution_0/v3_four_channel_phase_distribution_0/v3_four_channel_output_collection_0/v3_four_channel_placement_0/v3_channel_selector_late_promotion_0/v3_selector_route_pilot_0/group0_lo_n v3_four_channel_output_load_integration_0/combined_p VGND sky130_fd_pr__nfet_01v8 ad=0.1885 pd=1.88 as=0.1885 ps=1.88 w=0.65 l=0.15
X53 v3_four_channel_output_load_integration_0/v3_four_channel_shared_support_integration_0/v3_four_channel_bias_reference_distribution_0/v3_four_channel_phase_distribution_0/v3_four_channel_output_collection_0/v3_four_channel_placement_0/v3_channel_selector_late_promotion_0/v3_channel_input_bias_late_promotion_0/a_7166_17688# v3_four_channel_output_load_integration_0/v3_four_channel_shared_support_integration_0/v3_four_channel_bias_reference_distribution_0/v3_four_channel_phase_distribution_0/v3_four_channel_output_collection_0/v3_four_channel_placement_0/v3_channel_selector_late_promotion_0/element_input v3_four_channel_output_load_integration_0/v3_four_channel_shared_support_integration_0/v3_four_channel_bias_reference_distribution_0/v3_four_channel_phase_distribution_0/v3_four_channel_output_collection_0/v3_four_channel_placement_0/v3_channel_selector_late_promotion_0/v3_channel_input_bias_late_promotion_0/a_7038_18978# VGND sky130_fd_pr__nfet_01v8 ad=0.2436 pd=2.26 as=0.2436 ps=2.26 w=0.84 l=0.6
X54 v3_four_channel_output_load_integration_0/combined_n v3_four_channel_output_load_integration_0/v3_four_channel_shared_support_integration_0/v3_four_channel_bias_reference_distribution_0/v3_four_channel_phase_distribution_0/v3_four_channel_output_collection_0/v3_four_channel_placement_0/v3_channel_selector_late_promotion_0/v3_selector_route_pilot_0/group3_lo_n v3_four_channel_output_load_integration_0/v3_four_channel_shared_support_integration_0/v3_four_channel_bias_reference_distribution_0/v3_four_channel_phase_distribution_0/v3_four_channel_output_collection_0/v3_four_channel_placement_0/v3_channel_selector_late_promotion_0/v3_channel_input_bias_late_promotion_0/a_5646_18978# VGND sky130_fd_pr__nfet_01v8 ad=0.1885 pd=1.88 as=0.1885 ps=1.88 w=0.65 l=0.15
X55 VGND v3_four_channel_output_load_integration_0/v3_four_channel_shared_support_integration_0/v3_tail_bias_support_block_0/vbias v3_four_channel_output_load_integration_0/v3_four_channel_shared_support_integration_0/v3_four_channel_bias_reference_distribution_0/v3_four_channel_phase_distribution_0/v3_four_channel_output_collection_0/v3_four_channel_placement_0/v3_channel_selector_late_promotion_0/v3_channel_input_bias_late_promotion_0/a_5774_21688# VGND sky130_fd_pr__nfet_01v8 ad=1.4703 pd=10.72 as=1.4703 ps=10.72 w=5.07 l=1
X56 v3_four_channel_output_load_integration_0/v3_four_channel_shared_support_integration_0/v3_four_channel_bias_reference_distribution_0/v3_four_channel_phase_distribution_0/v3_four_channel_output_collection_0/v3_four_channel_placement_0/v3_channel_selector_late_promotion_0/v3_channel_input_bias_late_promotion_0/a_6070_19422# v3_four_channel_output_load_integration_0/v3_four_channel_shared_support_integration_0/v3_vcm_support_block_0/ref v3_four_channel_output_load_integration_0/v3_four_channel_shared_support_integration_0/v3_four_channel_bias_reference_distribution_0/v3_four_channel_phase_distribution_0/v3_four_channel_output_collection_0/v3_four_channel_placement_0/v3_channel_selector_late_promotion_0/v3_channel_input_bias_late_promotion_0/a_5774_17688# VGND sky130_fd_pr__nfet_01v8 ad=0.2436 pd=2.26 as=0.2436 ps=2.26 w=0.84 l=0.6
X57 VGND VGND VGND VGND sky130_fd_pr__nfet_01v8 ad=1.4703 pd=10.72 as=0 ps=0 w=5.07 l=1
X58 v3_four_channel_output_load_integration_0/combined_p v3_four_channel_output_load_integration_0/v3_four_channel_shared_support_integration_0/v3_four_channel_bias_reference_distribution_0/v3_four_channel_phase_distribution_0/v3_four_channel_output_collection_0/v3_four_channel_placement_0/v3_channel_selector_late_promotion_0/v3_selector_route_pilot_0/group1_lo_p v3_four_channel_output_load_integration_0/v3_four_channel_shared_support_integration_0/v3_four_channel_bias_reference_distribution_0/v3_four_channel_phase_distribution_0/v3_four_channel_output_collection_0/v3_four_channel_placement_0/v3_channel_selector_late_promotion_0/v3_channel_input_bias_late_promotion_0/a_4254_14978# VGND sky130_fd_pr__nfet_01v8 ad=0.1885 pd=1.88 as=0.1885 ps=1.88 w=0.65 l=0.15
X59 v3_four_channel_output_load_integration_0/v3_four_channel_shared_support_integration_0/v3_four_channel_bias_reference_distribution_0/v3_four_channel_phase_distribution_0/v3_four_channel_output_collection_0/v3_four_channel_placement_0/v3_channel_selector_late_promotion_0/v3_channel_input_bias_late_promotion_0/a_6070_19422# v3_four_channel_output_load_integration_0/v3_four_channel_shared_support_integration_0/v3_four_channel_bias_reference_distribution_0/v3_four_channel_phase_distribution_0/v3_four_channel_output_collection_0/v3_four_channel_placement_0/v3_channel_selector_late_promotion_0/v3_selector_route_pilot_0/group3_lo_p v3_four_channel_output_load_integration_0/combined_n VGND sky130_fd_pr__nfet_01v8 ad=0.1885 pd=1.88 as=0.1885 ps=1.88 w=0.65 l=0.15
X60 VGND VGND VGND VGND sky130_fd_pr__nfet_01v8 ad=0.1885 pd=1.88 as=0 ps=0 w=0.65 l=0.15
X61 v3_four_channel_output_load_integration_0/v3_four_channel_shared_support_integration_0/v3_four_channel_bias_reference_distribution_0/v3_four_channel_phase_distribution_0/v3_four_channel_output_collection_0/v3_four_channel_placement_0/v3_channel_selector_late_promotion_0/v3_channel_input_bias_late_promotion_0/a_5824_10978# v3_four_channel_output_load_integration_0/v3_four_channel_shared_support_integration_0/v3_tail_bias_support_block_0/vbias VGND VGND sky130_fd_pr__nfet_01v8 ad=1.4703 pd=10.72 as=1.4703 ps=10.72 w=5.07 l=1
X62 v3_four_channel_output_load_integration_0/v3_four_channel_shared_support_integration_0/v3_four_channel_bias_reference_distribution_0/v3_four_channel_phase_distribution_0/v3_four_channel_output_collection_0/v3_four_channel_placement_0/v3_channel_selector_late_promotion_0/v3_channel_input_bias_late_promotion_0/a_4382_13688# v3_four_channel_output_load_integration_0/v3_four_channel_shared_support_integration_0/v3_four_channel_bias_reference_distribution_0/v3_four_channel_phase_distribution_0/v3_four_channel_output_collection_0/v3_four_channel_placement_0/v3_channel_selector_late_promotion_0/element_input v3_four_channel_output_load_integration_0/v3_four_channel_shared_support_integration_0/v3_four_channel_bias_reference_distribution_0/v3_four_channel_phase_distribution_0/v3_four_channel_output_collection_0/v3_four_channel_placement_0/v3_channel_selector_late_promotion_0/v3_channel_input_bias_late_promotion_0/a_4254_14978# VGND sky130_fd_pr__nfet_01v8 ad=0.2436 pd=2.26 as=0.2436 ps=2.26 w=0.84 l=0.6
X63 v3_four_channel_output_load_integration_0/v3_four_channel_shared_support_integration_0/v3_four_channel_bias_reference_distribution_0/v3_four_channel_phase_distribution_0/v3_four_channel_output_collection_0/v3_four_channel_placement_0/v3_channel_selector_late_promotion_0/v3_channel_input_bias_late_promotion_0/a_4678_15422# v3_four_channel_output_load_integration_0/v3_four_channel_shared_support_integration_0/v3_four_channel_bias_reference_distribution_0/v3_four_channel_phase_distribution_0/v3_four_channel_output_collection_0/v3_four_channel_placement_0/v3_channel_selector_late_promotion_0/v3_selector_route_pilot_0/group1_lo_n v3_four_channel_output_load_integration_0/combined_p VGND sky130_fd_pr__nfet_01v8 ad=0.1885 pd=1.88 as=0.1885 ps=1.88 w=0.65 l=0.15
X64 v3_four_channel_output_load_integration_0/combined_n v3_four_channel_output_load_integration_0/v3_four_channel_shared_support_integration_0/v3_four_channel_bias_reference_distribution_0/v3_four_channel_phase_distribution_0/v3_four_channel_output_collection_0/v3_four_channel_placement_0/v3_channel_selector_late_promotion_0/v3_selector_route_pilot_0/group2_lo_n v3_four_channel_output_load_integration_0/v3_four_channel_shared_support_integration_0/v3_four_channel_bias_reference_distribution_0/v3_four_channel_phase_distribution_0/v3_four_channel_output_collection_0/v3_four_channel_placement_0/v3_channel_selector_late_promotion_0/v3_channel_input_bias_late_promotion_0/a_4254_18978# VGND sky130_fd_pr__nfet_01v8 ad=0.1885 pd=1.88 as=0.1885 ps=1.88 w=0.65 l=0.15
X65 v3_four_channel_output_load_integration_0/combined_p v3_four_channel_output_load_integration_0/v3_four_channel_shared_support_integration_0/v3_four_channel_bias_reference_distribution_0/v3_four_channel_phase_distribution_0/v3_four_channel_output_collection_0/v3_four_channel_placement_0/v3_channel_selector_late_promotion_0/v3_selector_route_pilot_0/group3_lo_n v3_four_channel_output_load_integration_0/v3_four_channel_shared_support_integration_0/v3_four_channel_bias_reference_distribution_0/v3_four_channel_phase_distribution_0/v3_four_channel_output_collection_0/v3_four_channel_placement_0/v3_channel_selector_late_promotion_0/v3_channel_input_bias_late_promotion_0/a_5646_10978# VGND sky130_fd_pr__nfet_01v8 ad=0.1885 pd=1.88 as=0.1885 ps=1.88 w=0.65 l=0.15
X66 v3_four_channel_output_load_integration_0/combined_p v3_four_channel_output_load_integration_0/v3_four_channel_shared_support_integration_0/v3_four_channel_bias_reference_distribution_0/v3_four_channel_phase_distribution_0/v3_four_channel_output_collection_0/v3_four_channel_placement_0/v3_channel_selector_late_promotion_0/v3_selector_route_pilot_0/group1_lo_n v3_four_channel_output_load_integration_0/v3_four_channel_shared_support_integration_0/v3_four_channel_bias_reference_distribution_0/v3_four_channel_phase_distribution_0/v3_four_channel_output_collection_0/v3_four_channel_placement_0/v3_channel_selector_late_promotion_0/v3_channel_input_bias_late_promotion_0/a_7038_14978# VGND sky130_fd_pr__nfet_01v8 ad=0.1885 pd=1.88 as=0.1885 ps=1.88 w=0.65 l=0.15
X67 v3_four_channel_output_load_integration_0/v3_four_channel_shared_support_integration_0/v3_four_channel_bias_reference_distribution_0/v3_four_channel_phase_distribution_0/v3_four_channel_output_collection_0/v3_four_channel_placement_0/v3_channel_selector_late_promotion_0/v3_channel_input_bias_late_promotion_0/a_7462_19422# v3_four_channel_output_load_integration_0/v3_four_channel_shared_support_integration_0/v3_four_channel_bias_reference_distribution_0/v3_four_channel_phase_distribution_0/v3_four_channel_output_collection_0/v3_four_channel_placement_0/v3_channel_selector_late_promotion_0/v3_selector_route_pilot_0/group2_lo_n v3_four_channel_output_load_integration_0/combined_p VGND sky130_fd_pr__nfet_01v8 ad=0.1885 pd=1.88 as=0.1885 ps=1.88 w=0.65 l=0.15
X68 v3_four_channel_output_load_integration_0/v3_four_channel_shared_support_integration_0/v3_four_channel_bias_reference_distribution_0/v3_four_channel_phase_distribution_0/v3_four_channel_output_collection_0/v3_four_channel_placement_0/v3_channel_selector_late_promotion_0/v3_channel_input_bias_late_promotion_0/a_4678_7422# v3_four_channel_output_load_integration_0/v3_four_channel_shared_support_integration_0/v3_four_channel_bias_reference_distribution_0/v3_four_channel_phase_distribution_0/v3_four_channel_output_collection_0/v3_four_channel_placement_0/v3_channel_selector_late_promotion_0/v3_selector_route_pilot_0/group3_lo_p v3_four_channel_output_load_integration_0/combined_p VGND sky130_fd_pr__nfet_01v8 ad=0.1885 pd=1.88 as=0.1885 ps=1.88 w=0.65 l=0.15
X69 v3_four_channel_output_load_integration_0/v3_four_channel_shared_support_integration_0/v3_four_channel_bias_reference_distribution_0/v3_four_channel_phase_distribution_0/v3_four_channel_output_collection_0/v3_four_channel_placement_0/v3_channel_selector_late_promotion_0/v3_channel_input_bias_late_promotion_0/a_6070_11422# v3_four_channel_output_load_integration_0/v3_four_channel_shared_support_integration_0/v3_four_channel_bias_reference_distribution_0/v3_four_channel_phase_distribution_0/v3_four_channel_output_collection_0/v3_four_channel_placement_0/v3_channel_selector_late_promotion_0/v3_selector_route_pilot_0/group3_lo_p v3_four_channel_output_load_integration_0/combined_p VGND sky130_fd_pr__nfet_01v8 ad=0.1885 pd=1.88 as=0.1885 ps=1.88 w=0.65 l=0.15
X70 v3_four_channel_output_load_integration_0/v3_four_channel_shared_support_integration_0/v3_four_channel_bias_reference_distribution_0/v3_four_channel_phase_distribution_0/v3_four_channel_output_collection_0/v3_four_channel_placement_0/v3_channel_selector_late_promotion_0/v3_channel_input_bias_late_promotion_0/a_7216_10978# v3_four_channel_output_load_integration_0/v3_four_channel_shared_support_integration_0/v3_tail_bias_support_block_0/vbias VGND VGND sky130_fd_pr__nfet_01v8 ad=1.4703 pd=10.72 as=1.4703 ps=10.72 w=5.07 l=1
X71 v3_four_channel_output_load_integration_0/v3_four_channel_shared_support_integration_0/v3_four_channel_bias_reference_distribution_0/v3_four_channel_phase_distribution_0/v3_four_channel_output_collection_0/v3_four_channel_placement_0/v3_channel_selector_late_promotion_0/v3_channel_input_bias_late_promotion_0/a_7216_14978# v3_four_channel_output_load_integration_0/v3_four_channel_shared_support_integration_0/v3_vcm_support_block_0/ref v3_four_channel_output_load_integration_0/v3_four_channel_shared_support_integration_0/v3_four_channel_bias_reference_distribution_0/v3_four_channel_phase_distribution_0/v3_four_channel_output_collection_0/v3_four_channel_placement_0/v3_channel_selector_late_promotion_0/v3_channel_input_bias_late_promotion_0/a_7038_14978# VGND sky130_fd_pr__nfet_01v8 ad=0.2436 pd=2.26 as=0.2436 ps=2.26 w=0.84 l=0.6
X72 v3_four_channel_output_load_integration_0/v3_four_channel_shared_support_integration_0/v3_four_channel_bias_reference_distribution_0/v3_four_channel_phase_distribution_0/v3_four_channel_output_collection_0/v3_four_channel_placement_0/v3_channel_selector_late_promotion_0/v3_channel_input_bias_late_promotion_0/a_4678_19422# v3_four_channel_output_load_integration_0/v3_four_channel_shared_support_integration_0/v3_vcm_support_block_0/ref v3_four_channel_output_load_integration_0/v3_four_channel_shared_support_integration_0/v3_four_channel_bias_reference_distribution_0/v3_four_channel_phase_distribution_0/v3_four_channel_output_collection_0/v3_four_channel_placement_0/v3_channel_selector_late_promotion_0/v3_channel_input_bias_late_promotion_0/a_4382_17688# VGND sky130_fd_pr__nfet_01v8 ad=0.2436 pd=2.26 as=0.2436 ps=2.26 w=0.84 l=0.6
X73 v3_four_channel_output_load_integration_0/v3_four_channel_shared_support_integration_0/v3_four_channel_bias_reference_distribution_0/v3_four_channel_phase_distribution_0/v3_four_channel_output_collection_0/v3_four_channel_placement_0/v3_channel_selector_late_promotion_0/v3_channel_input_bias_late_promotion_0/a_4678_19422# v3_four_channel_output_load_integration_0/v3_four_channel_shared_support_integration_0/v3_four_channel_bias_reference_distribution_0/v3_four_channel_phase_distribution_0/v3_four_channel_output_collection_0/v3_four_channel_placement_0/v3_channel_selector_late_promotion_0/v3_selector_route_pilot_0/group2_lo_p v3_four_channel_output_load_integration_0/combined_n VGND sky130_fd_pr__nfet_01v8 ad=0.1885 pd=1.88 as=0.1885 ps=1.88 w=0.65 l=0.15
X74 v3_four_channel_output_load_integration_0/combined_n v3_four_channel_output_load_integration_0/v3_four_channel_shared_support_integration_0/v3_four_channel_bias_reference_distribution_0/v3_four_channel_phase_distribution_0/v3_four_channel_output_collection_0/v3_four_channel_placement_0/v3_channel_selector_late_promotion_0/v3_selector_route_pilot_0/group0_lo_n v3_four_channel_output_load_integration_0/v3_four_channel_shared_support_integration_0/v3_four_channel_bias_reference_distribution_0/v3_four_channel_phase_distribution_0/v3_four_channel_output_collection_0/v3_four_channel_placement_0/v3_channel_selector_late_promotion_0/v3_channel_input_bias_late_promotion_0/a_5646_14978# VGND sky130_fd_pr__nfet_01v8 ad=0.1885 pd=1.88 as=0.1885 ps=1.88 w=0.65 l=0.15
X75 v3_four_channel_output_load_integration_0/combined_n v3_four_channel_output_load_integration_0/v3_four_channel_shared_support_integration_0/v3_four_channel_bias_reference_distribution_0/v3_four_channel_phase_distribution_0/v3_four_channel_output_collection_0/v3_four_channel_placement_0/v3_channel_selector_late_promotion_0/v3_selector_route_pilot_0/group2_lo_n v3_four_channel_output_load_integration_0/v3_four_channel_shared_support_integration_0/v3_four_channel_bias_reference_distribution_0/v3_four_channel_phase_distribution_0/v3_four_channel_output_collection_0/v3_four_channel_placement_0/v3_channel_selector_late_promotion_0/v3_channel_input_bias_late_promotion_0/a_7038_18978# VGND sky130_fd_pr__nfet_01v8 ad=0.1885 pd=1.88 as=0.1885 ps=1.88 w=0.65 l=0.15
X76 v3_four_channel_output_load_integration_0/v3_four_channel_shared_support_integration_0/v3_four_channel_bias_reference_distribution_0/v3_four_channel_phase_distribution_0/v3_four_channel_output_collection_0/v3_four_channel_placement_0/v3_channel_selector_late_promotion_0/v3_channel_input_bias_late_promotion_0/a_7462_7422# v3_four_channel_output_load_integration_0/v3_four_channel_shared_support_integration_0/v3_four_channel_bias_reference_distribution_0/v3_four_channel_phase_distribution_0/v3_four_channel_output_collection_0/v3_four_channel_placement_0/v3_channel_selector_late_promotion_0/v3_selector_route_pilot_0/group3_lo_p v3_four_channel_output_load_integration_0/combined_p VGND sky130_fd_pr__nfet_01v8 ad=0.1885 pd=1.88 as=0.1885 ps=1.88 w=0.65 l=0.15
X77 VGND v3_four_channel_output_load_integration_0/v3_four_channel_shared_support_integration_0/v3_tail_bias_support_block_0/vbias v3_four_channel_output_load_integration_0/v3_four_channel_shared_support_integration_0/v3_four_channel_bias_reference_distribution_0/v3_four_channel_phase_distribution_0/v3_four_channel_output_collection_0/v3_four_channel_placement_0/v3_channel_selector_late_promotion_0/v3_channel_input_bias_late_promotion_0/a_7166_21688# VGND sky130_fd_pr__nfet_01v8 ad=1.4703 pd=10.72 as=1.4703 ps=10.72 w=5.07 l=1
X78 v3_four_channel_output_load_integration_0/v3_four_channel_shared_support_integration_0/v3_four_channel_bias_reference_distribution_0/v3_four_channel_phase_distribution_0/v3_four_channel_output_collection_0/v3_four_channel_placement_0/v3_channel_selector_late_promotion_0/v3_channel_input_bias_late_promotion_0/a_6070_15422# v3_four_channel_output_load_integration_0/v3_four_channel_shared_support_integration_0/v3_vcm_support_block_0/ref v3_four_channel_output_load_integration_0/v3_four_channel_shared_support_integration_0/v3_four_channel_bias_reference_distribution_0/v3_four_channel_phase_distribution_0/v3_four_channel_output_collection_0/v3_four_channel_placement_0/v3_channel_selector_late_promotion_0/v3_channel_input_bias_late_promotion_0/a_5774_13688# VGND sky130_fd_pr__nfet_01v8 ad=0.2436 pd=2.26 as=0.2436 ps=2.26 w=0.84 l=0.6
X79 v3_four_channel_output_load_integration_0/combined_p v3_four_channel_output_load_integration_0/v3_four_channel_shared_support_integration_0/v3_four_channel_bias_reference_distribution_0/v3_four_channel_phase_distribution_0/v3_four_channel_output_collection_0/v3_four_channel_placement_0/v3_channel_selector_late_promotion_0/v3_selector_route_pilot_0/group2_lo_n v3_four_channel_output_load_integration_0/v3_four_channel_shared_support_integration_0/v3_four_channel_bias_reference_distribution_0/v3_four_channel_phase_distribution_0/v3_four_channel_output_collection_0/v3_four_channel_placement_0/v3_channel_selector_late_promotion_0/v3_channel_input_bias_late_promotion_0/a_4254_10978# VGND sky130_fd_pr__nfet_01v8 ad=0.1885 pd=1.88 as=0.1885 ps=1.88 w=0.65 l=0.15
X80 v3_four_channel_output_load_integration_0/v3_four_channel_shared_support_integration_0/v3_four_channel_bias_reference_distribution_0/v3_four_channel_phase_distribution_0/v3_four_channel_output_collection_0/v3_four_channel_placement_0/v3_channel_selector_late_promotion_0/v3_channel_input_bias_late_promotion_0/a_6070_15422# v3_four_channel_output_load_integration_0/v3_four_channel_shared_support_integration_0/v3_four_channel_bias_reference_distribution_0/v3_four_channel_phase_distribution_0/v3_four_channel_output_collection_0/v3_four_channel_placement_0/v3_channel_selector_late_promotion_0/v3_selector_route_pilot_0/group0_lo_p v3_four_channel_output_load_integration_0/combined_n VGND sky130_fd_pr__nfet_01v8 ad=0.1885 pd=1.88 as=0.1885 ps=1.88 w=0.65 l=0.15
X81 v3_four_channel_output_load_integration_0/v3_four_channel_shared_support_integration_0/v3_four_channel_bias_reference_distribution_0/v3_four_channel_phase_distribution_0/v3_four_channel_output_collection_0/v3_four_channel_placement_0/v3_channel_selector_late_promotion_0/v3_channel_input_bias_late_promotion_0/a_5824_6978# v3_four_channel_output_load_integration_0/v3_four_channel_shared_support_integration_0/v3_vcm_support_block_0/ref v3_four_channel_output_load_integration_0/v3_four_channel_shared_support_integration_0/v3_four_channel_bias_reference_distribution_0/v3_four_channel_phase_distribution_0/v3_four_channel_output_collection_0/v3_four_channel_placement_0/v3_channel_selector_late_promotion_0/v3_channel_input_bias_late_promotion_0/a_5646_6978# VGND sky130_fd_pr__nfet_01v8 ad=0.2436 pd=2.26 as=0.2436 ps=2.26 w=0.84 l=0.6
X82 v3_four_channel_output_load_integration_0/v3_four_channel_shared_support_integration_0/v3_four_channel_bias_reference_distribution_0/v3_four_channel_phase_distribution_0/v3_four_channel_output_collection_0/v3_four_channel_placement_0/v3_channel_selector_late_promotion_0/v3_channel_input_bias_late_promotion_0/a_5774_17688# v3_four_channel_output_load_integration_0/v3_four_channel_shared_support_integration_0/v3_four_channel_bias_reference_distribution_0/v3_four_channel_phase_distribution_0/v3_four_channel_output_collection_0/v3_four_channel_placement_0/v3_channel_selector_late_promotion_0/element_input v3_four_channel_output_load_integration_0/v3_four_channel_shared_support_integration_0/v3_four_channel_bias_reference_distribution_0/v3_four_channel_phase_distribution_0/v3_four_channel_output_collection_0/v3_four_channel_placement_0/v3_channel_selector_late_promotion_0/v3_channel_input_bias_late_promotion_0/a_5646_18978# VGND sky130_fd_pr__nfet_01v8 ad=0.2436 pd=2.26 as=0.2436 ps=2.26 w=0.84 l=0.6
X83 v3_four_channel_output_load_integration_0/combined_p v3_four_channel_output_load_integration_0/v3_four_channel_shared_support_integration_0/v3_four_channel_bias_reference_distribution_0/v3_four_channel_phase_distribution_0/v3_four_channel_output_collection_0/v3_four_channel_placement_0/v3_channel_selector_late_promotion_0/v3_selector_route_pilot_0/group3_lo_p v3_four_channel_output_load_integration_0/v3_four_channel_shared_support_integration_0/v3_four_channel_bias_reference_distribution_0/v3_four_channel_phase_distribution_0/v3_four_channel_output_collection_0/v3_four_channel_placement_0/v3_channel_selector_late_promotion_0/v3_channel_input_bias_late_promotion_0/a_5646_22978# VGND sky130_fd_pr__nfet_01v8 ad=0.1885 pd=1.88 as=0.1885 ps=1.88 w=0.65 l=0.15
X84 v3_four_channel_output_load_integration_0/v3_four_channel_shared_support_integration_0/v3_four_channel_bias_reference_distribution_0/v3_four_channel_phase_distribution_0/v3_four_channel_output_collection_0/v3_four_channel_placement_0/v3_channel_selector_late_promotion_0/v3_channel_input_bias_late_promotion_0/a_5824_6978# v3_four_channel_output_load_integration_0/v3_four_channel_shared_support_integration_0/v3_tail_bias_support_block_0/vbias VGND VGND sky130_fd_pr__nfet_01v8 ad=1.4703 pd=10.72 as=1.4703 ps=10.72 w=5.07 l=1
X85 v3_four_channel_output_load_integration_0/v3_four_channel_shared_support_integration_0/v3_four_channel_bias_reference_distribution_0/v3_four_channel_phase_distribution_0/v3_four_channel_output_collection_0/v3_four_channel_placement_0/v3_channel_selector_late_promotion_0/v3_channel_input_bias_late_promotion_0/a_4432_10978# v3_four_channel_output_load_integration_0/v3_four_channel_shared_support_integration_0/v3_vcm_support_block_0/ref v3_four_channel_output_load_integration_0/v3_four_channel_shared_support_integration_0/v3_four_channel_bias_reference_distribution_0/v3_four_channel_phase_distribution_0/v3_four_channel_output_collection_0/v3_four_channel_placement_0/v3_channel_selector_late_promotion_0/v3_channel_input_bias_late_promotion_0/a_4254_10978# VGND sky130_fd_pr__nfet_01v8 ad=0.2436 pd=2.26 as=0.2436 ps=2.26 w=0.84 l=0.6
X86 v3_four_channel_output_load_integration_0/v3_four_channel_shared_support_integration_0/v3_four_channel_bias_reference_distribution_0/v3_four_channel_phase_distribution_0/v3_four_channel_output_collection_0/v3_four_channel_placement_0/v3_channel_selector_late_promotion_0/v3_channel_input_bias_late_promotion_0/a_4678_11422# v3_four_channel_output_load_integration_0/v3_four_channel_shared_support_integration_0/v3_four_channel_bias_reference_distribution_0/v3_four_channel_phase_distribution_0/v3_four_channel_output_collection_0/v3_four_channel_placement_0/v3_channel_selector_late_promotion_0/v3_selector_route_pilot_0/group2_lo_p v3_four_channel_output_load_integration_0/combined_p VGND sky130_fd_pr__nfet_01v8 ad=0.1885 pd=1.88 as=0.1885 ps=1.88 w=0.65 l=0.15
X87 v3_four_channel_output_load_integration_0/v3_four_channel_shared_support_integration_0/v3_four_channel_bias_reference_distribution_0/v3_four_channel_phase_distribution_0/v3_four_channel_output_collection_0/v3_four_channel_placement_0/v3_channel_selector_late_promotion_0/v3_channel_input_bias_late_promotion_0/a_6070_23422# v3_four_channel_output_load_integration_0/v3_four_channel_shared_support_integration_0/v3_four_channel_bias_reference_distribution_0/v3_four_channel_phase_distribution_0/v3_four_channel_output_collection_0/v3_four_channel_placement_0/v3_channel_selector_late_promotion_0/v3_selector_route_pilot_0/group3_lo_n v3_four_channel_output_load_integration_0/combined_p VGND sky130_fd_pr__nfet_01v8 ad=0.1885 pd=1.88 as=0.1885 ps=1.88 w=0.65 l=0.15
X88 v3_four_channel_output_load_integration_0/combined_n v3_four_channel_output_load_integration_0/v3_four_channel_shared_support_integration_0/v3_four_channel_bias_reference_distribution_0/v3_four_channel_phase_distribution_0/v3_four_channel_output_collection_0/v3_four_channel_placement_0/v3_channel_selector_late_promotion_0/v3_selector_route_pilot_0/group1_lo_n v3_four_channel_output_load_integration_0/v3_four_channel_shared_support_integration_0/v3_four_channel_bias_reference_distribution_0/v3_four_channel_phase_distribution_0/v3_four_channel_output_collection_0/v3_four_channel_placement_0/v3_channel_selector_late_promotion_0/v3_channel_input_bias_late_promotion_0/a_4254_14978# VGND sky130_fd_pr__nfet_01v8 ad=0.1885 pd=1.88 as=0.1885 ps=1.88 w=0.65 l=0.15
X89 v3_four_channel_output_load_integration_0/combined_p v3_four_channel_output_load_integration_0/v3_four_channel_shared_support_integration_0/v3_four_channel_bias_reference_distribution_0/v3_four_channel_phase_distribution_0/v3_four_channel_output_collection_0/v3_four_channel_placement_0/v3_channel_selector_late_promotion_0/v3_selector_route_pilot_0/group2_lo_n v3_four_channel_output_load_integration_0/v3_four_channel_shared_support_integration_0/v3_four_channel_bias_reference_distribution_0/v3_four_channel_phase_distribution_0/v3_four_channel_output_collection_0/v3_four_channel_placement_0/v3_channel_selector_late_promotion_0/v3_channel_input_bias_late_promotion_0/a_7038_10978# VGND sky130_fd_pr__nfet_01v8 ad=0.1885 pd=1.88 as=0.1885 ps=1.88 w=0.65 l=0.15
X90 v3_four_channel_output_load_integration_0/v3_four_channel_shared_support_integration_0/v3_four_channel_bias_reference_distribution_0/v3_four_channel_phase_distribution_0/v3_four_channel_output_collection_0/v3_four_channel_placement_0/v3_channel_selector_late_promotion_0/v3_channel_input_bias_late_promotion_0/a_7462_15422# v3_four_channel_output_load_integration_0/v3_four_channel_shared_support_integration_0/v3_four_channel_bias_reference_distribution_0/v3_four_channel_phase_distribution_0/v3_four_channel_output_collection_0/v3_four_channel_placement_0/v3_channel_selector_late_promotion_0/v3_selector_route_pilot_0/group1_lo_p v3_four_channel_output_load_integration_0/combined_p VGND sky130_fd_pr__nfet_01v8 ad=0.1885 pd=1.88 as=0.1885 ps=1.88 w=0.65 l=0.15
X91 VGND VGND VGND VGND sky130_fd_pr__nfet_01v8 ad=1.4703 pd=10.72 as=0 ps=0 w=5.07 l=1
X92 v3_four_channel_output_load_integration_0/v3_four_channel_shared_support_integration_0/v3_four_channel_bias_reference_distribution_0/v3_four_channel_phase_distribution_0/v3_four_channel_output_collection_0/v3_four_channel_placement_0/v3_channel_selector_late_promotion_0/v3_channel_input_bias_late_promotion_0/a_7216_6978# v3_four_channel_output_load_integration_0/v3_four_channel_shared_support_integration_0/v3_tail_bias_support_block_0/vbias VGND VGND sky130_fd_pr__nfet_01v8 ad=1.4703 pd=10.72 as=1.4703 ps=10.72 w=5.07 l=1
X93 v3_four_channel_output_load_integration_0/v3_four_channel_shared_support_integration_0/v3_four_channel_bias_reference_distribution_0/v3_four_channel_phase_distribution_0/v3_four_channel_output_collection_0/v3_four_channel_placement_0/v3_channel_selector_late_promotion_0/v3_channel_input_bias_late_promotion_0/a_7216_10978# v3_four_channel_output_load_integration_0/v3_four_channel_shared_support_integration_0/v3_vcm_support_block_0/ref v3_four_channel_output_load_integration_0/v3_four_channel_shared_support_integration_0/v3_four_channel_bias_reference_distribution_0/v3_four_channel_phase_distribution_0/v3_four_channel_output_collection_0/v3_four_channel_placement_0/v3_channel_selector_late_promotion_0/v3_channel_input_bias_late_promotion_0/a_7038_10978# VGND sky130_fd_pr__nfet_01v8 ad=0.2436 pd=2.26 as=0.2436 ps=2.26 w=0.84 l=0.6
X94 v3_four_channel_output_load_integration_0/v3_four_channel_shared_support_integration_0/v3_four_channel_bias_reference_distribution_0/v3_four_channel_phase_distribution_0/v3_four_channel_output_collection_0/v3_four_channel_placement_0/v3_channel_selector_late_promotion_0/v3_channel_input_bias_late_promotion_0/a_4678_15422# v3_four_channel_output_load_integration_0/v3_four_channel_shared_support_integration_0/v3_vcm_support_block_0/ref v3_four_channel_output_load_integration_0/v3_four_channel_shared_support_integration_0/v3_four_channel_bias_reference_distribution_0/v3_four_channel_phase_distribution_0/v3_four_channel_output_collection_0/v3_four_channel_placement_0/v3_channel_selector_late_promotion_0/v3_channel_input_bias_late_promotion_0/a_4382_13688# VGND sky130_fd_pr__nfet_01v8 ad=0.2436 pd=2.26 as=0.2436 ps=2.26 w=0.84 l=0.6
X95 v3_four_channel_output_load_integration_0/v3_four_channel_shared_support_integration_0/v3_four_channel_bias_reference_distribution_0/v3_four_channel_phase_distribution_0/v3_four_channel_output_collection_0/v3_four_channel_placement_0/v3_channel_selector_late_promotion_0/v3_channel_input_bias_late_promotion_0/a_4678_15422# v3_four_channel_output_load_integration_0/v3_four_channel_shared_support_integration_0/v3_four_channel_bias_reference_distribution_0/v3_four_channel_phase_distribution_0/v3_four_channel_output_collection_0/v3_four_channel_placement_0/v3_channel_selector_late_promotion_0/v3_selector_route_pilot_0/group1_lo_p v3_four_channel_output_load_integration_0/combined_n VGND sky130_fd_pr__nfet_01v8 ad=0.1885 pd=1.88 as=0.1885 ps=1.88 w=0.65 l=0.15
X96 v3_four_channel_output_load_integration_0/combined_p v3_four_channel_output_load_integration_0/v3_four_channel_shared_support_integration_0/v3_four_channel_bias_reference_distribution_0/v3_four_channel_phase_distribution_0/v3_four_channel_output_collection_0/v3_four_channel_placement_0/v3_channel_selector_late_promotion_0/v3_selector_route_pilot_0/group3_lo_p v3_four_channel_output_load_integration_0/v3_four_channel_shared_support_integration_0/v3_four_channel_bias_reference_distribution_0/v3_four_channel_phase_distribution_0/v3_four_channel_output_collection_0/v3_four_channel_placement_0/v3_channel_selector_late_promotion_0/v3_channel_input_bias_late_promotion_0/a_4254_22978# VGND sky130_fd_pr__nfet_01v8 ad=0.1885 pd=1.88 as=0.1885 ps=1.88 w=0.65 l=0.15
X97 v3_four_channel_output_load_integration_0/v3_four_channel_shared_support_integration_0/v3_four_channel_bias_reference_distribution_0/v3_four_channel_phase_distribution_0/v3_four_channel_output_collection_0/v3_four_channel_placement_0/v3_channel_selector_late_promotion_0/v3_channel_input_bias_late_promotion_0/a_7462_19422# v3_four_channel_output_load_integration_0/v3_four_channel_shared_support_integration_0/v3_vcm_support_block_0/ref v3_four_channel_output_load_integration_0/v3_four_channel_shared_support_integration_0/v3_four_channel_bias_reference_distribution_0/v3_four_channel_phase_distribution_0/v3_four_channel_output_collection_0/v3_four_channel_placement_0/v3_channel_selector_late_promotion_0/v3_channel_input_bias_late_promotion_0/a_7166_17688# VGND sky130_fd_pr__nfet_01v8 ad=0.2436 pd=2.26 as=0.2436 ps=2.26 w=0.84 l=0.6
X98 v3_four_channel_output_load_integration_0/combined_n v3_four_channel_output_load_integration_0/v3_four_channel_shared_support_integration_0/v3_four_channel_bias_reference_distribution_0/v3_four_channel_phase_distribution_0/v3_four_channel_output_collection_0/v3_four_channel_placement_0/v3_channel_selector_late_promotion_0/v3_selector_route_pilot_0/group3_lo_p v3_four_channel_output_load_integration_0/v3_four_channel_shared_support_integration_0/v3_four_channel_bias_reference_distribution_0/v3_four_channel_phase_distribution_0/v3_four_channel_output_collection_0/v3_four_channel_placement_0/v3_channel_selector_late_promotion_0/v3_channel_input_bias_late_promotion_0/a_5646_10978# VGND sky130_fd_pr__nfet_01v8 ad=0.1885 pd=1.88 as=0.1885 ps=1.88 w=0.65 l=0.15
X99 v3_four_channel_output_load_integration_0/combined_n v3_four_channel_output_load_integration_0/v3_four_channel_shared_support_integration_0/v3_four_channel_bias_reference_distribution_0/v3_four_channel_phase_distribution_0/v3_four_channel_output_collection_0/v3_four_channel_placement_0/v3_channel_selector_late_promotion_0/v3_selector_route_pilot_0/group1_lo_p v3_four_channel_output_load_integration_0/v3_four_channel_shared_support_integration_0/v3_four_channel_bias_reference_distribution_0/v3_four_channel_phase_distribution_0/v3_four_channel_output_collection_0/v3_four_channel_placement_0/v3_channel_selector_late_promotion_0/v3_channel_input_bias_late_promotion_0/a_7038_14978# VGND sky130_fd_pr__nfet_01v8 ad=0.1885 pd=1.88 as=0.1885 ps=1.88 w=0.65 l=0.15
X100 v3_four_channel_output_load_integration_0/v3_four_channel_shared_support_integration_0/v3_four_channel_bias_reference_distribution_0/v3_four_channel_phase_distribution_0/v3_four_channel_output_collection_0/v3_four_channel_placement_0/v3_channel_selector_late_promotion_0/v3_channel_input_bias_late_promotion_0/a_7462_19422# v3_four_channel_output_load_integration_0/v3_four_channel_shared_support_integration_0/v3_four_channel_bias_reference_distribution_0/v3_four_channel_phase_distribution_0/v3_four_channel_output_collection_0/v3_four_channel_placement_0/v3_channel_selector_late_promotion_0/v3_selector_route_pilot_0/group2_lo_p v3_four_channel_output_load_integration_0/combined_n VGND sky130_fd_pr__nfet_01v8 ad=0.1885 pd=1.88 as=0.1885 ps=1.88 w=0.65 l=0.15
X101 v3_four_channel_output_load_integration_0/v3_four_channel_shared_support_integration_0/v3_four_channel_bias_reference_distribution_0/v3_four_channel_phase_distribution_0/v3_four_channel_output_collection_0/v3_four_channel_placement_0/v3_channel_selector_late_promotion_0/v3_channel_input_bias_late_promotion_0/a_4678_7422# v3_four_channel_output_load_integration_0/v3_four_channel_shared_support_integration_0/v3_four_channel_bias_reference_distribution_0/v3_four_channel_phase_distribution_0/v3_four_channel_output_collection_0/v3_four_channel_placement_0/v3_channel_selector_late_promotion_0/element_input v3_four_channel_output_load_integration_0/v3_four_channel_shared_support_integration_0/v3_four_channel_bias_reference_distribution_0/v3_four_channel_phase_distribution_0/v3_four_channel_output_collection_0/v3_four_channel_placement_0/v3_channel_selector_late_promotion_0/v3_channel_input_bias_late_promotion_0/a_4432_6978# VGND sky130_fd_pr__nfet_01v8 ad=0.2436 pd=2.26 as=0.2436 ps=2.26 w=0.84 l=0.6
X102 v3_four_channel_output_load_integration_0/combined_p v3_four_channel_output_load_integration_0/v3_four_channel_shared_support_integration_0/v3_four_channel_bias_reference_distribution_0/v3_four_channel_phase_distribution_0/v3_four_channel_output_collection_0/v3_four_channel_placement_0/v3_channel_selector_late_promotion_0/v3_selector_route_pilot_0/group3_lo_n v3_four_channel_output_load_integration_0/v3_four_channel_shared_support_integration_0/v3_four_channel_bias_reference_distribution_0/v3_four_channel_phase_distribution_0/v3_four_channel_output_collection_0/v3_four_channel_placement_0/v3_channel_selector_late_promotion_0/v3_channel_input_bias_late_promotion_0/a_5646_6978# VGND sky130_fd_pr__nfet_01v8 ad=0.1885 pd=1.88 as=0.1885 ps=1.88 w=0.65 l=0.15
X103 v3_four_channel_output_load_integration_0/v3_four_channel_shared_support_integration_0/v3_four_channel_bias_reference_distribution_0/v3_four_channel_phase_distribution_0/v3_four_channel_output_collection_0/v3_four_channel_placement_0/v3_channel_selector_late_promotion_0/v3_channel_input_bias_late_promotion_0/a_4678_7422# v3_four_channel_output_load_integration_0/v3_four_channel_shared_support_integration_0/v3_four_channel_bias_reference_distribution_0/v3_four_channel_phase_distribution_0/v3_four_channel_output_collection_0/v3_four_channel_placement_0/v3_channel_selector_late_promotion_0/v3_selector_route_pilot_0/group3_lo_n v3_four_channel_output_load_integration_0/combined_n VGND sky130_fd_pr__nfet_01v8 ad=0.1885 pd=1.88 as=0.1885 ps=1.88 w=0.65 l=0.15
X104 v3_four_channel_output_load_integration_0/v3_four_channel_shared_support_integration_0/v3_four_channel_bias_reference_distribution_0/v3_four_channel_phase_distribution_0/v3_four_channel_output_collection_0/v3_four_channel_placement_0/v3_channel_selector_late_promotion_0/v3_channel_input_bias_late_promotion_0/a_6070_11422# v3_four_channel_output_load_integration_0/v3_four_channel_shared_support_integration_0/v3_four_channel_bias_reference_distribution_0/v3_four_channel_phase_distribution_0/v3_four_channel_output_collection_0/v3_four_channel_placement_0/v3_channel_selector_late_promotion_0/element_input v3_four_channel_output_load_integration_0/v3_four_channel_shared_support_integration_0/v3_four_channel_bias_reference_distribution_0/v3_four_channel_phase_distribution_0/v3_four_channel_output_collection_0/v3_four_channel_placement_0/v3_channel_selector_late_promotion_0/v3_channel_input_bias_late_promotion_0/a_5824_10978# VGND sky130_fd_pr__nfet_01v8 ad=0.2436 pd=2.26 as=0.2436 ps=2.26 w=0.84 l=0.6
X105 v3_four_channel_output_load_integration_0/v3_four_channel_shared_support_integration_0/v3_four_channel_bias_reference_distribution_0/v3_four_channel_phase_distribution_0/v3_four_channel_output_collection_0/v3_four_channel_placement_0/v3_channel_selector_late_promotion_0/v3_channel_input_bias_late_promotion_0/a_6070_11422# v3_four_channel_output_load_integration_0/v3_four_channel_shared_support_integration_0/v3_four_channel_bias_reference_distribution_0/v3_four_channel_phase_distribution_0/v3_four_channel_output_collection_0/v3_four_channel_placement_0/v3_channel_selector_late_promotion_0/v3_selector_route_pilot_0/group3_lo_n v3_four_channel_output_load_integration_0/combined_n VGND sky130_fd_pr__nfet_01v8 ad=0.1885 pd=1.88 as=0.1885 ps=1.88 w=0.65 l=0.15
X106 v3_four_channel_output_load_integration_0/v3_four_channel_shared_support_integration_0/v3_four_channel_bias_reference_distribution_0/v3_four_channel_phase_distribution_0/v3_four_channel_output_collection_0/v3_four_channel_placement_0/v3_channel_selector_late_promotion_0/v3_channel_input_bias_late_promotion_0/a_4382_21688# v3_four_channel_output_load_integration_0/v3_four_channel_shared_support_integration_0/v3_four_channel_bias_reference_distribution_0/v3_four_channel_phase_distribution_0/v3_four_channel_output_collection_0/v3_four_channel_placement_0/v3_channel_selector_late_promotion_0/element_input v3_four_channel_output_load_integration_0/v3_four_channel_shared_support_integration_0/v3_four_channel_bias_reference_distribution_0/v3_four_channel_phase_distribution_0/v3_four_channel_output_collection_0/v3_four_channel_placement_0/v3_channel_selector_late_promotion_0/v3_channel_input_bias_late_promotion_0/a_4254_22978# VGND sky130_fd_pr__nfet_01v8 ad=0.2436 pd=2.26 as=0.2436 ps=2.26 w=0.84 l=0.6
X107 v3_four_channel_output_load_integration_0/v3_four_channel_shared_support_integration_0/v3_four_channel_bias_reference_distribution_0/v3_four_channel_phase_distribution_0/v3_four_channel_output_collection_0/v3_four_channel_placement_0/v3_channel_selector_late_promotion_0/v3_channel_input_bias_late_promotion_0/a_4678_23422# v3_four_channel_output_load_integration_0/v3_four_channel_shared_support_integration_0/v3_four_channel_bias_reference_distribution_0/v3_four_channel_phase_distribution_0/v3_four_channel_output_collection_0/v3_four_channel_placement_0/v3_channel_selector_late_promotion_0/v3_selector_route_pilot_0/group3_lo_n v3_four_channel_output_load_integration_0/combined_p VGND sky130_fd_pr__nfet_01v8 ad=0.1885 pd=1.88 as=0.1885 ps=1.88 w=0.65 l=0.15
X108 v3_four_channel_output_load_integration_0/combined_p v3_four_channel_output_load_integration_0/v3_four_channel_shared_support_integration_0/v3_four_channel_bias_reference_distribution_0/v3_four_channel_phase_distribution_0/v3_four_channel_output_collection_0/v3_four_channel_placement_0/v3_channel_selector_late_promotion_0/v3_selector_route_pilot_0/group3_lo_n v3_four_channel_output_load_integration_0/v3_four_channel_shared_support_integration_0/v3_four_channel_bias_reference_distribution_0/v3_four_channel_phase_distribution_0/v3_four_channel_output_collection_0/v3_four_channel_placement_0/v3_channel_selector_late_promotion_0/v3_channel_input_bias_late_promotion_0/a_4254_6978# VGND sky130_fd_pr__nfet_01v8 ad=0.1885 pd=1.88 as=0.1885 ps=1.88 w=0.65 l=0.15
X109 v3_four_channel_output_load_integration_0/v3_four_channel_shared_support_integration_0/v3_four_channel_bias_reference_distribution_0/v3_four_channel_phase_distribution_0/v3_four_channel_output_collection_0/v3_four_channel_placement_0/v3_channel_selector_late_promotion_0/v3_channel_input_bias_late_promotion_0/a_5774_13688# v3_four_channel_output_load_integration_0/v3_four_channel_shared_support_integration_0/v3_four_channel_bias_reference_distribution_0/v3_four_channel_phase_distribution_0/v3_four_channel_output_collection_0/v3_four_channel_placement_0/v3_channel_selector_late_promotion_0/element_input v3_four_channel_output_load_integration_0/v3_four_channel_shared_support_integration_0/v3_four_channel_bias_reference_distribution_0/v3_four_channel_phase_distribution_0/v3_four_channel_output_collection_0/v3_four_channel_placement_0/v3_channel_selector_late_promotion_0/v3_channel_input_bias_late_promotion_0/a_5646_14978# VGND sky130_fd_pr__nfet_01v8 ad=0.2436 pd=2.26 as=0.2436 ps=2.26 w=0.84 l=0.6
X110 v3_four_channel_output_load_integration_0/combined_p v3_four_channel_output_load_integration_0/v3_four_channel_shared_support_integration_0/v3_four_channel_bias_reference_distribution_0/v3_four_channel_phase_distribution_0/v3_four_channel_output_collection_0/v3_four_channel_placement_0/v3_channel_selector_late_promotion_0/v3_selector_route_pilot_0/group3_lo_p v3_four_channel_output_load_integration_0/v3_four_channel_shared_support_integration_0/v3_four_channel_bias_reference_distribution_0/v3_four_channel_phase_distribution_0/v3_four_channel_output_collection_0/v3_four_channel_placement_0/v3_channel_selector_late_promotion_0/v3_channel_input_bias_late_promotion_0/a_7038_22978# VGND sky130_fd_pr__nfet_01v8 ad=0.1885 pd=1.88 as=0.1885 ps=1.88 w=0.65 l=0.15
X111 v3_four_channel_output_load_integration_0/v3_four_channel_shared_support_integration_0/v3_four_channel_bias_reference_distribution_0/v3_four_channel_phase_distribution_0/v3_four_channel_output_collection_0/v3_four_channel_placement_0/v3_channel_selector_late_promotion_0/v3_channel_input_bias_late_promotion_0/a_7462_7422# v3_four_channel_output_load_integration_0/v3_four_channel_shared_support_integration_0/v3_four_channel_bias_reference_distribution_0/v3_four_channel_phase_distribution_0/v3_four_channel_output_collection_0/v3_four_channel_placement_0/v3_channel_selector_late_promotion_0/element_input v3_four_channel_output_load_integration_0/v3_four_channel_shared_support_integration_0/v3_four_channel_bias_reference_distribution_0/v3_four_channel_phase_distribution_0/v3_four_channel_output_collection_0/v3_four_channel_placement_0/v3_channel_selector_late_promotion_0/v3_channel_input_bias_late_promotion_0/a_7216_6978# VGND sky130_fd_pr__nfet_01v8 ad=0.2436 pd=2.26 as=0.2436 ps=2.26 w=0.84 l=0.6
X112 v3_four_channel_output_load_integration_0/v3_four_channel_shared_support_integration_0/v3_four_channel_bias_reference_distribution_0/v3_four_channel_phase_distribution_0/v3_four_channel_output_collection_0/v3_four_channel_placement_0/v3_channel_selector_late_promotion_0/v3_channel_input_bias_late_promotion_0/a_4432_10978# v3_four_channel_output_load_integration_0/v3_four_channel_shared_support_integration_0/v3_tail_bias_support_block_0/vbias VGND VGND sky130_fd_pr__nfet_01v8 ad=1.4703 pd=10.72 as=1.4703 ps=10.72 w=5.07 l=1
X113 v3_four_channel_output_load_integration_0/v3_four_channel_shared_support_integration_0/v3_four_channel_bias_reference_distribution_0/v3_four_channel_phase_distribution_0/v3_four_channel_output_collection_0/v3_four_channel_placement_0/v3_channel_selector_late_promotion_0/v3_channel_input_bias_late_promotion_0/a_7462_7422# v3_four_channel_output_load_integration_0/v3_four_channel_shared_support_integration_0/v3_four_channel_bias_reference_distribution_0/v3_four_channel_phase_distribution_0/v3_four_channel_output_collection_0/v3_four_channel_placement_0/v3_channel_selector_late_promotion_0/v3_selector_route_pilot_0/group3_lo_n v3_four_channel_output_load_integration_0/combined_n VGND sky130_fd_pr__nfet_01v8 ad=0.1885 pd=1.88 as=0.1885 ps=1.88 w=0.65 l=0.15
X114 VGND v3_four_channel_output_load_integration_0/v3_four_channel_shared_support_integration_0/v3_tail_bias_support_block_0/vbias v3_four_channel_output_load_integration_0/v3_four_channel_shared_support_integration_0/v3_four_channel_bias_reference_distribution_0/v3_four_channel_phase_distribution_0/v3_four_channel_output_collection_0/v3_four_channel_placement_0/v3_channel_selector_late_promotion_0/v3_channel_input_bias_late_promotion_0/a_4382_17688# VGND sky130_fd_pr__nfet_01v8 ad=1.4703 pd=10.72 as=1.4703 ps=10.72 w=5.07 l=1
X115 v3_four_channel_output_load_integration_0/combined_p v3_four_channel_output_load_integration_0/v3_four_channel_shared_support_integration_0/v3_four_channel_bias_reference_distribution_0/v3_four_channel_phase_distribution_0/v3_four_channel_output_collection_0/v3_four_channel_placement_0/v3_channel_selector_late_promotion_0/v3_selector_route_pilot_0/group3_lo_n v3_four_channel_output_load_integration_0/v3_four_channel_shared_support_integration_0/v3_four_channel_bias_reference_distribution_0/v3_four_channel_phase_distribution_0/v3_four_channel_output_collection_0/v3_four_channel_placement_0/v3_channel_selector_late_promotion_0/v3_channel_input_bias_late_promotion_0/a_7038_6978# VGND sky130_fd_pr__nfet_01v8 ad=0.1885 pd=1.88 as=0.1885 ps=1.88 w=0.65 l=0.15
X116 v3_four_channel_output_load_integration_0/combined_n v3_four_channel_output_load_integration_0/v3_four_channel_shared_support_integration_0/v3_four_channel_bias_reference_distribution_0/v3_four_channel_phase_distribution_0/v3_four_channel_output_collection_0/v3_four_channel_placement_0/v3_channel_selector_late_promotion_0/v3_selector_route_pilot_0/group2_lo_p v3_four_channel_output_load_integration_0/v3_four_channel_shared_support_integration_0/v3_four_channel_bias_reference_distribution_0/v3_four_channel_phase_distribution_0/v3_four_channel_output_collection_0/v3_four_channel_placement_0/v3_channel_selector_late_promotion_0/v3_channel_input_bias_late_promotion_0/a_4254_10978# VGND sky130_fd_pr__nfet_01v8 ad=0.1885 pd=1.88 as=0.1885 ps=1.88 w=0.65 l=0.15
X117 v3_four_channel_output_load_integration_0/v3_four_channel_shared_support_integration_0/v3_four_channel_bias_reference_distribution_0/v3_four_channel_phase_distribution_0/v3_four_channel_output_collection_0/v3_four_channel_placement_0/v3_channel_selector_late_promotion_0/v3_channel_input_bias_late_promotion_0/a_7462_11422# v3_four_channel_output_load_integration_0/v3_four_channel_shared_support_integration_0/v3_four_channel_bias_reference_distribution_0/v3_four_channel_phase_distribution_0/v3_four_channel_output_collection_0/v3_four_channel_placement_0/v3_channel_selector_late_promotion_0/v3_selector_route_pilot_0/group2_lo_p v3_four_channel_output_load_integration_0/combined_p VGND sky130_fd_pr__nfet_01v8 ad=0.1885 pd=1.88 as=0.1885 ps=1.88 w=0.65 l=0.15
X118 v3_four_channel_output_load_integration_0/v3_four_channel_shared_support_integration_0/v3_four_channel_bias_reference_distribution_0/v3_four_channel_phase_distribution_0/v3_four_channel_output_collection_0/v3_four_channel_placement_0/v3_channel_selector_late_promotion_0/v3_channel_input_bias_late_promotion_0/a_7166_21688# v3_four_channel_output_load_integration_0/v3_four_channel_shared_support_integration_0/v3_four_channel_bias_reference_distribution_0/v3_four_channel_phase_distribution_0/v3_four_channel_output_collection_0/v3_four_channel_placement_0/v3_channel_selector_late_promotion_0/element_input v3_four_channel_output_load_integration_0/v3_four_channel_shared_support_integration_0/v3_four_channel_bias_reference_distribution_0/v3_four_channel_phase_distribution_0/v3_four_channel_output_collection_0/v3_four_channel_placement_0/v3_channel_selector_late_promotion_0/v3_channel_input_bias_late_promotion_0/a_7038_22978# VGND sky130_fd_pr__nfet_01v8 ad=0.2436 pd=2.26 as=0.2436 ps=2.26 w=0.84 l=0.6
X119 v3_four_channel_output_load_integration_0/combined_n v3_four_channel_output_load_integration_0/v3_four_channel_shared_support_integration_0/v3_four_channel_bias_reference_distribution_0/v3_four_channel_phase_distribution_0/v3_four_channel_output_collection_0/v3_four_channel_placement_0/v3_channel_selector_late_promotion_0/v3_selector_route_pilot_0/group3_lo_n v3_four_channel_output_load_integration_0/v3_four_channel_shared_support_integration_0/v3_four_channel_bias_reference_distribution_0/v3_four_channel_phase_distribution_0/v3_four_channel_output_collection_0/v3_four_channel_placement_0/v3_channel_selector_late_promotion_0/v3_channel_input_bias_late_promotion_0/a_5646_22978# VGND sky130_fd_pr__nfet_01v8 ad=0.1885 pd=1.88 as=0.1885 ps=1.88 w=0.65 l=0.15
X120 v3_four_channel_output_load_integration_0/v3_four_channel_shared_support_integration_0/v3_four_channel_bias_reference_distribution_0/v3_four_channel_phase_distribution_0/v3_four_channel_output_collection_0/v3_four_channel_placement_0/v3_channel_selector_late_promotion_0/v3_channel_input_bias_late_promotion_0/a_4678_11422# v3_four_channel_output_load_integration_0/v3_four_channel_shared_support_integration_0/v3_four_channel_bias_reference_distribution_0/v3_four_channel_phase_distribution_0/v3_four_channel_output_collection_0/v3_four_channel_placement_0/v3_channel_selector_late_promotion_0/element_input v3_four_channel_output_load_integration_0/v3_four_channel_shared_support_integration_0/v3_four_channel_bias_reference_distribution_0/v3_four_channel_phase_distribution_0/v3_four_channel_output_collection_0/v3_four_channel_placement_0/v3_channel_selector_late_promotion_0/v3_channel_input_bias_late_promotion_0/a_4432_10978# VGND sky130_fd_pr__nfet_01v8 ad=0.2436 pd=2.26 as=0.2436 ps=2.26 w=0.84 l=0.6
X121 v3_four_channel_output_load_integration_0/v3_four_channel_shared_support_integration_0/v3_four_channel_bias_reference_distribution_0/v3_four_channel_phase_distribution_0/v3_four_channel_output_collection_0/v3_four_channel_placement_0/v3_channel_selector_late_promotion_0/v3_channel_input_bias_late_promotion_0/a_6070_23422# v3_four_channel_output_load_integration_0/v3_four_channel_shared_support_integration_0/v3_vcm_support_block_0/ref v3_four_channel_output_load_integration_0/v3_four_channel_shared_support_integration_0/v3_four_channel_bias_reference_distribution_0/v3_four_channel_phase_distribution_0/v3_four_channel_output_collection_0/v3_four_channel_placement_0/v3_channel_selector_late_promotion_0/v3_channel_input_bias_late_promotion_0/a_5774_21688# VGND sky130_fd_pr__nfet_01v8 ad=0.2436 pd=2.26 as=0.2436 ps=2.26 w=0.84 l=0.6
X122 v3_four_channel_output_load_integration_0/v3_four_channel_shared_support_integration_0/v3_four_channel_bias_reference_distribution_0/v3_four_channel_phase_distribution_0/v3_four_channel_output_collection_0/v3_four_channel_placement_0/v3_channel_selector_late_promotion_0/v3_channel_input_bias_late_promotion_0/a_6070_23422# v3_four_channel_output_load_integration_0/v3_four_channel_shared_support_integration_0/v3_four_channel_bias_reference_distribution_0/v3_four_channel_phase_distribution_0/v3_four_channel_output_collection_0/v3_four_channel_placement_0/v3_channel_selector_late_promotion_0/v3_selector_route_pilot_0/group3_lo_p v3_four_channel_output_load_integration_0/combined_n VGND sky130_fd_pr__nfet_01v8 ad=0.1885 pd=1.88 as=0.1885 ps=1.88 w=0.65 l=0.15
X123 v3_four_channel_output_load_integration_0/v3_four_channel_shared_support_integration_0/v3_four_channel_bias_reference_distribution_0/v3_four_channel_phase_distribution_0/v3_four_channel_output_collection_0/v3_four_channel_placement_0/v3_channel_selector_late_promotion_0/v3_channel_input_bias_late_promotion_0/a_4678_11422# v3_four_channel_output_load_integration_0/v3_four_channel_shared_support_integration_0/v3_four_channel_bias_reference_distribution_0/v3_four_channel_phase_distribution_0/v3_four_channel_output_collection_0/v3_four_channel_placement_0/v3_channel_selector_late_promotion_0/v3_selector_route_pilot_0/group2_lo_n v3_four_channel_output_load_integration_0/combined_n VGND sky130_fd_pr__nfet_01v8 ad=0.1885 pd=1.88 as=0.1885 ps=1.88 w=0.65 l=0.15
X124 v3_four_channel_output_load_integration_0/v3_four_channel_shared_support_integration_0/v3_four_channel_bias_reference_distribution_0/v3_four_channel_phase_distribution_0/v3_four_channel_output_collection_0/v3_four_channel_placement_0/v3_channel_selector_late_promotion_0/v3_channel_input_bias_late_promotion_0/a_7462_15422# v3_four_channel_output_load_integration_0/v3_four_channel_shared_support_integration_0/v3_four_channel_bias_reference_distribution_0/v3_four_channel_phase_distribution_0/v3_four_channel_output_collection_0/v3_four_channel_placement_0/v3_channel_selector_late_promotion_0/element_input v3_four_channel_output_load_integration_0/v3_four_channel_shared_support_integration_0/v3_four_channel_bias_reference_distribution_0/v3_four_channel_phase_distribution_0/v3_four_channel_output_collection_0/v3_four_channel_placement_0/v3_channel_selector_late_promotion_0/v3_channel_input_bias_late_promotion_0/a_7216_14978# VGND sky130_fd_pr__nfet_01v8 ad=0.2436 pd=2.26 as=0.2436 ps=2.26 w=0.84 l=0.6
X125 v3_four_channel_output_load_integration_0/v3_four_channel_shared_support_integration_0/v3_four_channel_bias_reference_distribution_0/v3_four_channel_phase_distribution_0/v3_four_channel_output_collection_0/v3_four_channel_placement_0/v3_channel_selector_late_promotion_0/v3_channel_input_bias_late_promotion_0/a_6070_7422# v3_four_channel_output_load_integration_0/v3_four_channel_shared_support_integration_0/v3_four_channel_bias_reference_distribution_0/v3_four_channel_phase_distribution_0/v3_four_channel_output_collection_0/v3_four_channel_placement_0/v3_channel_selector_late_promotion_0/v3_selector_route_pilot_0/group3_lo_p v3_four_channel_output_load_integration_0/combined_p VGND sky130_fd_pr__nfet_01v8 ad=0.1885 pd=1.88 as=0.1885 ps=1.88 w=0.65 l=0.15
X126 v3_four_channel_output_load_integration_0/combined_n v3_four_channel_output_load_integration_0/v3_four_channel_shared_support_integration_0/v3_four_channel_bias_reference_distribution_0/v3_four_channel_phase_distribution_0/v3_four_channel_output_collection_0/v3_four_channel_placement_0/v3_channel_selector_late_promotion_0/v3_selector_route_pilot_0/group2_lo_p v3_four_channel_output_load_integration_0/v3_four_channel_shared_support_integration_0/v3_four_channel_bias_reference_distribution_0/v3_four_channel_phase_distribution_0/v3_four_channel_output_collection_0/v3_four_channel_placement_0/v3_channel_selector_late_promotion_0/v3_channel_input_bias_late_promotion_0/a_7038_10978# VGND sky130_fd_pr__nfet_01v8 ad=0.1885 pd=1.88 as=0.1885 ps=1.88 w=0.65 l=0.15
X127 v3_four_channel_output_load_integration_0/v3_four_channel_shared_support_integration_0/v3_four_channel_bias_reference_distribution_0/v3_four_channel_phase_distribution_0/v3_four_channel_output_collection_0/v3_four_channel_placement_0/v3_channel_selector_late_promotion_0/v3_channel_input_bias_late_promotion_0/a_7462_15422# v3_four_channel_output_load_integration_0/v3_four_channel_shared_support_integration_0/v3_four_channel_bias_reference_distribution_0/v3_four_channel_phase_distribution_0/v3_four_channel_output_collection_0/v3_four_channel_placement_0/v3_channel_selector_late_promotion_0/v3_selector_route_pilot_0/group1_lo_n v3_four_channel_output_load_integration_0/combined_n VGND sky130_fd_pr__nfet_01v8 ad=0.1885 pd=1.88 as=0.1885 ps=1.88 w=0.65 l=0.15
X128 v3_four_channel_output_load_integration_0/v3_four_channel_shared_support_integration_0/v3_four_channel_bias_reference_distribution_0/v3_four_channel_phase_distribution_0/v3_four_channel_output_collection_0/v3_four_channel_placement_0/v3_channel_selector_late_promotion_0/v3_channel_input_bias_late_promotion_0/a_4432_6978# v3_four_channel_output_load_integration_0/v3_four_channel_shared_support_integration_0/v3_vcm_support_block_0/ref v3_four_channel_output_load_integration_0/v3_four_channel_shared_support_integration_0/v3_four_channel_bias_reference_distribution_0/v3_four_channel_phase_distribution_0/v3_four_channel_output_collection_0/v3_four_channel_placement_0/v3_channel_selector_late_promotion_0/v3_channel_input_bias_late_promotion_0/a_4254_6978# VGND sky130_fd_pr__nfet_01v8 ad=0.2436 pd=2.26 as=0.2436 ps=2.26 w=0.84 l=0.6
X129 v3_four_channel_output_load_integration_0/v3_four_channel_shared_support_integration_0/v3_four_channel_bias_reference_distribution_0/v3_four_channel_phase_distribution_0/v3_four_channel_output_collection_0/v3_four_channel_placement_0/v3_channel_selector_late_promotion_0/v3_channel_input_bias_late_promotion_0/a_5824_10978# v3_four_channel_output_load_integration_0/v3_four_channel_shared_support_integration_0/v3_vcm_support_block_0/ref v3_four_channel_output_load_integration_0/v3_four_channel_shared_support_integration_0/v3_four_channel_bias_reference_distribution_0/v3_four_channel_phase_distribution_0/v3_four_channel_output_collection_0/v3_four_channel_placement_0/v3_channel_selector_late_promotion_0/v3_channel_input_bias_late_promotion_0/a_5646_10978# VGND sky130_fd_pr__nfet_01v8 ad=0.2436 pd=2.26 as=0.2436 ps=2.26 w=0.84 l=0.6
X130 v3_four_channel_output_load_integration_0/combined_n v3_four_channel_output_load_integration_0/v3_four_channel_shared_support_integration_0/v3_four_channel_bias_reference_distribution_0/v3_four_channel_phase_distribution_0/v3_four_channel_output_collection_0/v3_four_channel_placement_0/v3_channel_selector_late_promotion_0/v3_selector_route_pilot_0/group3_lo_n v3_four_channel_output_load_integration_0/v3_four_channel_shared_support_integration_0/v3_four_channel_bias_reference_distribution_0/v3_four_channel_phase_distribution_0/v3_four_channel_output_collection_0/v3_four_channel_placement_0/v3_channel_selector_late_promotion_0/v3_channel_input_bias_late_promotion_0/a_4254_22978# VGND sky130_fd_pr__nfet_01v8 ad=0.1885 pd=1.88 as=0.1885 ps=1.88 w=0.65 l=0.15
X131 v3_four_channel_output_load_integration_0/v3_four_channel_shared_support_integration_0/v3_four_channel_bias_reference_distribution_0/v3_four_channel_phase_distribution_0/v3_four_channel_output_collection_0/v3_four_channel_placement_0/v3_channel_selector_late_promotion_0/v3_channel_input_bias_late_promotion_0/a_7462_23422# v3_four_channel_output_load_integration_0/v3_four_channel_shared_support_integration_0/v3_four_channel_bias_reference_distribution_0/v3_four_channel_phase_distribution_0/v3_four_channel_output_collection_0/v3_four_channel_placement_0/v3_channel_selector_late_promotion_0/v3_selector_route_pilot_0/group3_lo_n v3_four_channel_output_load_integration_0/combined_p VGND sky130_fd_pr__nfet_01v8 ad=0.1885 pd=1.88 as=0.1885 ps=1.88 w=0.65 l=0.15
X132 v3_four_channel_output_load_integration_0/v3_four_channel_shared_support_integration_0/v3_four_channel_bias_reference_distribution_0/v3_four_channel_phase_distribution_0/v3_four_channel_output_collection_0/v3_four_channel_placement_0/v3_channel_selector_late_promotion_0/v3_channel_input_bias_late_promotion_0/a_4432_6978# v3_four_channel_output_load_integration_0/v3_four_channel_shared_support_integration_0/v3_tail_bias_support_block_0/vbias VGND VGND sky130_fd_pr__nfet_01v8 ad=1.4703 pd=10.72 as=1.4703 ps=10.72 w=5.07 l=1
X133 v3_four_channel_output_load_integration_0/v3_four_channel_shared_support_integration_0/v3_four_channel_bias_reference_distribution_0/v3_four_channel_phase_distribution_0/v3_four_channel_output_collection_0/v3_four_channel_placement_0/v3_channel_selector_late_promotion_0/v3_channel_input_bias_late_promotion_0/a_7216_6978# v3_four_channel_output_load_integration_0/v3_four_channel_shared_support_integration_0/v3_vcm_support_block_0/ref v3_four_channel_output_load_integration_0/v3_four_channel_shared_support_integration_0/v3_four_channel_bias_reference_distribution_0/v3_four_channel_phase_distribution_0/v3_four_channel_output_collection_0/v3_four_channel_placement_0/v3_channel_selector_late_promotion_0/v3_channel_input_bias_late_promotion_0/a_7038_6978# VGND sky130_fd_pr__nfet_01v8 ad=0.2436 pd=2.26 as=0.2436 ps=2.26 w=0.84 l=0.6
X134 v3_four_channel_output_load_integration_0/combined_n v3_four_channel_output_load_integration_0/v3_four_channel_shared_support_integration_0/v3_four_channel_bias_reference_distribution_0/v3_four_channel_phase_distribution_0/v3_four_channel_output_collection_0/v3_four_channel_placement_0/v3_channel_selector_late_promotion_0/v3_selector_route_pilot_0/group3_lo_p v3_four_channel_output_load_integration_0/v3_four_channel_shared_support_integration_0/v3_four_channel_bias_reference_distribution_0/v3_four_channel_phase_distribution_0/v3_four_channel_output_collection_0/v3_four_channel_placement_0/v3_channel_selector_late_promotion_0/v3_channel_input_bias_late_promotion_0/a_5646_6978# VGND sky130_fd_pr__nfet_01v8 ad=0.1885 pd=1.88 as=0.1885 ps=1.88 w=0.65 l=0.15
X135 VGND v3_four_channel_output_load_integration_0/v3_four_channel_shared_support_integration_0/v3_tail_bias_support_block_0/vbias v3_four_channel_output_load_integration_0/v3_four_channel_shared_support_integration_0/v3_four_channel_bias_reference_distribution_0/v3_four_channel_phase_distribution_0/v3_four_channel_output_collection_0/v3_four_channel_placement_0/v3_channel_selector_late_promotion_0/v3_channel_input_bias_late_promotion_0/a_4382_13688# VGND sky130_fd_pr__nfet_01v8 ad=1.4703 pd=10.72 as=1.4703 ps=10.72 w=5.07 l=1
X136 VDPWR v3_four_channel_output_load_integration_0/v3_four_channel_shared_support_integration_0/v3_four_channel_bias_reference_distribution_0/v3_four_channel_phase_distribution_0/v3_four_channel_output_collection_0/v3_four_channel_placement_0/v3_channel_selector_late_promotion_0/v3_selector_route_pilot_0/G1_MUX_POS/a_505_21# v3_four_channel_output_load_integration_0/v3_four_channel_shared_support_integration_0/v3_four_channel_bias_reference_distribution_0/v3_four_channel_phase_distribution_0/v3_four_channel_output_collection_0/v3_four_channel_placement_0/v3_channel_selector_late_promotion_0/v3_selector_route_pilot_0/G1_MUX_POS/a_535_374# VDPWR sky130_fd_pr__pfet_01v8_hvt ad=0.0693 pd=0.75 as=0.0441 ps=0.63 w=0.42 l=0.15
X137 v3_four_channel_output_load_integration_0/v3_four_channel_shared_support_integration_0/v3_four_channel_bias_reference_distribution_0/v3_four_channel_phase_distribution_0/v3_four_channel_output_collection_0/v3_four_channel_placement_0/v3_channel_selector_late_promotion_0/v3_selector_route_pilot_0/G1_MUX_POS/a_505_21# v3_four_channel_output_load_integration_0/v3_four_channel_shared_support_integration_0/v3_four_channel_bias_reference_distribution_0/v3_four_channel_phase_distribution_0/v3_four_channel_output_collection_0/v3_four_channel_placement_0/v3_channel_selector_late_promotion_0/group1_bit0 VDPWR VDPWR sky130_fd_pr__pfet_01v8_hvt ad=0.1176 pd=1.4 as=0.0693 ps=0.75 w=0.42 l=0.15
X138 v3_four_channel_output_load_integration_0/v3_four_channel_shared_support_integration_0/v3_four_channel_bias_reference_distribution_0/v3_four_channel_phase_distribution_0/v3_four_channel_output_collection_0/v3_four_channel_placement_0/v3_channel_selector_late_promotion_0/v3_selector_route_pilot_0/G1_MUX_POS/a_218_374# v3_four_channel_output_load_integration_0/v3_four_channel_shared_support_integration_0/v3_four_channel_bias_reference_distribution_0/v3_four_channel_phase_distribution_0/v3_four_channel_output_collection_0/v3_four_channel_placement_0/v3_channel_selector_late_promotion_0/group1_bit0 VDPWR VDPWR sky130_fd_pr__pfet_01v8_hvt ad=0.07665 pd=0.785 as=0.15835 ps=1.395 w=0.42 l=0.15
X139 VGND v3_four_channel_output_load_integration_0/v3_four_channel_shared_support_integration_0/v3_four_channel_bias_reference_distribution_0/v3_four_channel_phase_distribution_0/v3_four_channel_output_collection_0/v3_four_channel_placement_0/v3_channel_selector_late_promotion_0/v3_selector_route_pilot_0/G1_MUX_POS/a_505_21# v3_four_channel_output_load_integration_0/v3_four_channel_shared_support_integration_0/v3_four_channel_bias_reference_distribution_0/v3_four_channel_phase_distribution_0/v3_four_channel_output_collection_0/v3_four_channel_placement_0/v3_channel_selector_late_promotion_0/v3_selector_route_pilot_0/G1_MUX_POS/a_439_47# VGND sky130_fd_pr__nfet_01v8 ad=0.1449 pd=1.11 as=0.0693 ps=0.75 w=0.42 l=0.15
X140 v3_four_channel_output_load_integration_0/v3_four_channel_shared_support_integration_0/v3_four_channel_bias_reference_distribution_0/v3_four_channel_phase_distribution_0/v3_four_channel_output_collection_0/v3_four_channel_placement_0/v3_channel_selector_late_promotion_0/v3_selector_route_pilot_0/G1_MUX_POS/a_76_199# v3_four_channel_output_load_integration_0/v3_four_channel_shared_support_integration_0/v3_four_channel_bias_reference_distribution_0/v3_four_channel_phase_distribution_0/phase_0 v3_four_channel_output_load_integration_0/v3_four_channel_shared_support_integration_0/v3_four_channel_bias_reference_distribution_0/v3_four_channel_phase_distribution_0/v3_four_channel_output_collection_0/v3_four_channel_placement_0/v3_channel_selector_late_promotion_0/v3_selector_route_pilot_0/G1_MUX_POS/a_218_374# VDPWR sky130_fd_pr__pfet_01v8_hvt ad=0.1932 pd=1.34 as=0.07665 ps=0.785 w=0.42 l=0.15
X141 v3_four_channel_output_load_integration_0/v3_four_channel_shared_support_integration_0/v3_four_channel_bias_reference_distribution_0/v3_four_channel_phase_distribution_0/v3_four_channel_output_collection_0/v3_four_channel_placement_0/v3_channel_selector_late_promotion_0/v3_selector_route_pilot_0/G1_MUX_POS/a_505_21# v3_four_channel_output_load_integration_0/v3_four_channel_shared_support_integration_0/v3_four_channel_bias_reference_distribution_0/v3_four_channel_phase_distribution_0/v3_four_channel_output_collection_0/v3_four_channel_placement_0/v3_channel_selector_late_promotion_0/group1_bit0 VGND VGND sky130_fd_pr__nfet_01v8 ad=0.1092 pd=1.36 as=0.1449 ps=1.11 w=0.42 l=0.15
X142 v3_four_channel_output_load_integration_0/v3_four_channel_shared_support_integration_0/v3_four_channel_bias_reference_distribution_0/v3_four_channel_phase_distribution_0/v3_four_channel_output_collection_0/v3_four_channel_placement_0/v3_channel_selector_late_promotion_0/v3_selector_route_pilot_0/G1_MUX_POS/a_439_47# v3_four_channel_output_load_integration_0/v3_four_channel_shared_support_integration_0/v3_four_channel_bias_reference_distribution_0/v3_four_channel_phase_distribution_0/phase_0 v3_four_channel_output_load_integration_0/v3_four_channel_shared_support_integration_0/v3_four_channel_bias_reference_distribution_0/v3_four_channel_phase_distribution_0/v3_four_channel_output_collection_0/v3_four_channel_placement_0/v3_channel_selector_late_promotion_0/v3_selector_route_pilot_0/G1_MUX_POS/a_76_199# VGND sky130_fd_pr__nfet_01v8 ad=0.0693 pd=0.75 as=0.09975 ps=0.895 w=0.42 l=0.15
X143 v3_four_channel_output_load_integration_0/v3_four_channel_shared_support_integration_0/v3_four_channel_bias_reference_distribution_0/v3_four_channel_phase_distribution_0/v3_four_channel_output_collection_0/v3_four_channel_placement_0/v3_channel_selector_late_promotion_0/v3_selector_route_pilot_0/G1_MUX_POS/a_535_374# v3_four_channel_output_load_integration_0/v3_four_channel_shared_support_integration_0/v3_four_channel_bias_reference_distribution_0/v3_four_channel_phase_distribution_0/phase_90 v3_four_channel_output_load_integration_0/v3_four_channel_shared_support_integration_0/v3_four_channel_bias_reference_distribution_0/v3_four_channel_phase_distribution_0/v3_four_channel_output_collection_0/v3_four_channel_placement_0/v3_channel_selector_late_promotion_0/v3_selector_route_pilot_0/G1_MUX_POS/a_76_199# VDPWR sky130_fd_pr__pfet_01v8_hvt ad=0.0441 pd=0.63 as=0.1932 ps=1.34 w=0.42 l=0.15
X144 v3_four_channel_output_load_integration_0/v3_four_channel_shared_support_integration_0/v3_four_channel_bias_reference_distribution_0/v3_four_channel_phase_distribution_0/v3_four_channel_output_collection_0/v3_four_channel_placement_0/v3_channel_selector_late_promotion_0/v3_selector_route_pilot_0/G1_MUX_POS/a_76_199# v3_four_channel_output_load_integration_0/v3_four_channel_shared_support_integration_0/v3_four_channel_bias_reference_distribution_0/v3_four_channel_phase_distribution_0/phase_90 v3_four_channel_output_load_integration_0/v3_four_channel_shared_support_integration_0/v3_four_channel_bias_reference_distribution_0/v3_four_channel_phase_distribution_0/v3_four_channel_output_collection_0/v3_four_channel_placement_0/v3_channel_selector_late_promotion_0/v3_selector_route_pilot_0/G1_MUX_POS/a_218_47# VGND sky130_fd_pr__nfet_01v8 ad=0.09975 pd=0.895 as=0.0693 ps=0.75 w=0.42 l=0.15
X145 v3_four_channel_output_load_integration_0/v3_four_channel_shared_support_integration_0/v3_four_channel_bias_reference_distribution_0/v3_four_channel_phase_distribution_0/v3_four_channel_output_collection_0/v3_four_channel_placement_0/v3_channel_selector_late_promotion_0/v3_selector_route_pilot_0/G1_MUX_POS/a_218_47# v3_four_channel_output_load_integration_0/v3_four_channel_shared_support_integration_0/v3_four_channel_bias_reference_distribution_0/v3_four_channel_phase_distribution_0/v3_four_channel_output_collection_0/v3_four_channel_placement_0/v3_channel_selector_late_promotion_0/group1_bit0 VGND VGND sky130_fd_pr__nfet_01v8 ad=0.0693 pd=0.75 as=0.11285 ps=1.045 w=0.42 l=0.15
X146 VDPWR v3_four_channel_output_load_integration_0/v3_four_channel_shared_support_integration_0/v3_four_channel_bias_reference_distribution_0/v3_four_channel_phase_distribution_0/v3_four_channel_output_collection_0/v3_four_channel_placement_0/v3_channel_selector_late_promotion_0/v3_selector_route_pilot_0/G1_MUX_POS/a_76_199# v3_four_channel_output_load_integration_0/v3_four_channel_shared_support_integration_0/v3_four_channel_bias_reference_distribution_0/v3_four_channel_phase_distribution_0/v3_four_channel_output_collection_0/v3_four_channel_placement_0/v3_channel_selector_late_promotion_0/v3_selector_route_pilot_0/G1_MUX_POS/X VDPWR sky130_fd_pr__pfet_01v8_hvt ad=0.15835 pd=1.395 as=0.26 ps=2.52 w=1 l=0.15
X147 VGND v3_four_channel_output_load_integration_0/v3_four_channel_shared_support_integration_0/v3_four_channel_bias_reference_distribution_0/v3_four_channel_phase_distribution_0/v3_four_channel_output_collection_0/v3_four_channel_placement_0/v3_channel_selector_late_promotion_0/v3_selector_route_pilot_0/G1_MUX_POS/a_76_199# v3_four_channel_output_load_integration_0/v3_four_channel_shared_support_integration_0/v3_four_channel_bias_reference_distribution_0/v3_four_channel_phase_distribution_0/v3_four_channel_output_collection_0/v3_four_channel_placement_0/v3_channel_selector_late_promotion_0/v3_selector_route_pilot_0/G1_MUX_POS/X VGND sky130_fd_pr__nfet_01v8 ad=0.11285 pd=1.045 as=0.169 ps=1.82 w=0.65 l=0.15
X148 VDPWR v3_four_channel_output_load_integration_0/v3_four_channel_shared_support_integration_0/v3_four_channel_bias_reference_distribution_0/v3_four_channel_phase_distribution_0/v3_four_channel_output_collection_0/v3_four_channel_placement_0/v3_channel_selector_late_promotion_0/v3_selector_route_pilot_0/G3_MUX_AXIS/a_505_21# v3_four_channel_output_load_integration_0/v3_four_channel_shared_support_integration_0/v3_four_channel_bias_reference_distribution_0/v3_four_channel_phase_distribution_0/v3_four_channel_output_collection_0/v3_four_channel_placement_0/v3_channel_selector_late_promotion_0/v3_selector_route_pilot_0/G3_MUX_AXIS/a_535_374# VDPWR sky130_fd_pr__pfet_01v8_hvt ad=41.0376 pd=372.79999 as=0.0882 ps=1.26 w=0.42 l=0.15
X149 v3_four_channel_output_load_integration_0/v3_four_channel_shared_support_integration_0/v3_four_channel_bias_reference_distribution_0/v3_four_channel_phase_distribution_0/v3_four_channel_output_collection_0/v3_four_channel_placement_0/v3_channel_selector_late_promotion_0/v3_selector_route_pilot_0/G3_MUX_AXIS/a_505_21# v3_four_channel_output_load_integration_0/v3_four_channel_shared_support_integration_0/v3_four_channel_bias_reference_distribution_0/v3_four_channel_phase_distribution_0/v3_four_channel_output_collection_0/v3_four_channel_placement_0/v3_channel_selector_late_promotion_0/group3_bit1 VDPWR VDPWR sky130_fd_pr__pfet_01v8_hvt ad=0.1176 pd=1.4 as=0 ps=0 w=0.42 l=0.15
X150 v3_four_channel_output_load_integration_0/v3_four_channel_shared_support_integration_0/v3_four_channel_bias_reference_distribution_0/v3_four_channel_phase_distribution_0/v3_four_channel_output_collection_0/v3_four_channel_placement_0/v3_channel_selector_late_promotion_0/v3_selector_route_pilot_0/G3_MUX_AXIS/a_218_374# v3_four_channel_output_load_integration_0/v3_four_channel_shared_support_integration_0/v3_four_channel_bias_reference_distribution_0/v3_four_channel_phase_distribution_0/v3_four_channel_output_collection_0/v3_four_channel_placement_0/v3_channel_selector_late_promotion_0/group3_bit1 VDPWR VDPWR sky130_fd_pr__pfet_01v8_hvt ad=0.1533 pd=1.57 as=0 ps=0 w=0.42 l=0.15
X151 VGND v3_four_channel_output_load_integration_0/v3_four_channel_shared_support_integration_0/v3_four_channel_bias_reference_distribution_0/v3_four_channel_phase_distribution_0/v3_four_channel_output_collection_0/v3_four_channel_placement_0/v3_channel_selector_late_promotion_0/v3_selector_route_pilot_0/G3_MUX_AXIS/a_505_21# v3_four_channel_output_load_integration_0/v3_four_channel_shared_support_integration_0/v3_four_channel_bias_reference_distribution_0/v3_four_channel_phase_distribution_0/v3_four_channel_output_collection_0/v3_four_channel_placement_0/v3_channel_selector_late_promotion_0/v3_selector_route_pilot_0/G3_MUX_AXIS/a_439_47# VGND sky130_fd_pr__nfet_01v8 ad=0 pd=0 as=0.1386 ps=1.5 w=0.42 l=0.15
X152 v3_four_channel_output_load_integration_0/v3_four_channel_shared_support_integration_0/v3_four_channel_bias_reference_distribution_0/v3_four_channel_phase_distribution_0/v3_four_channel_output_collection_0/v3_four_channel_placement_0/v3_channel_selector_late_promotion_0/v3_selector_route_pilot_0/G3_MUX_AXIS/a_76_199# v3_four_channel_output_load_integration_0/v3_four_channel_shared_support_integration_0/v3_four_channel_bias_reference_distribution_0/v3_four_channel_phase_distribution_0/v3_four_channel_output_collection_0/v3_four_channel_placement_0/v3_channel_selector_late_promotion_0/v3_selector_route_pilot_0/G3_MUX_POS/X v3_four_channel_output_load_integration_0/v3_four_channel_shared_support_integration_0/v3_four_channel_bias_reference_distribution_0/v3_four_channel_phase_distribution_0/v3_four_channel_output_collection_0/v3_four_channel_placement_0/v3_channel_selector_late_promotion_0/v3_selector_route_pilot_0/G3_MUX_AXIS/a_218_374# VDPWR sky130_fd_pr__pfet_01v8_hvt ad=0.3864 pd=2.68 as=0 ps=0 w=0.42 l=0.15
X153 v3_four_channel_output_load_integration_0/v3_four_channel_shared_support_integration_0/v3_four_channel_bias_reference_distribution_0/v3_four_channel_phase_distribution_0/v3_four_channel_output_collection_0/v3_four_channel_placement_0/v3_channel_selector_late_promotion_0/v3_selector_route_pilot_0/G3_MUX_AXIS/a_505_21# v3_four_channel_output_load_integration_0/v3_four_channel_shared_support_integration_0/v3_four_channel_bias_reference_distribution_0/v3_four_channel_phase_distribution_0/v3_four_channel_output_collection_0/v3_four_channel_placement_0/v3_channel_selector_late_promotion_0/group3_bit1 VGND VGND sky130_fd_pr__nfet_01v8 ad=0.1092 pd=1.36 as=0 ps=0 w=0.42 l=0.15
X154 v3_four_channel_output_load_integration_0/v3_four_channel_shared_support_integration_0/v3_four_channel_bias_reference_distribution_0/v3_four_channel_phase_distribution_0/v3_four_channel_output_collection_0/v3_four_channel_placement_0/v3_channel_selector_late_promotion_0/v3_selector_route_pilot_0/G3_MUX_AXIS/a_439_47# v3_four_channel_output_load_integration_0/v3_four_channel_shared_support_integration_0/v3_four_channel_bias_reference_distribution_0/v3_four_channel_phase_distribution_0/v3_four_channel_output_collection_0/v3_four_channel_placement_0/v3_channel_selector_late_promotion_0/v3_selector_route_pilot_0/G3_MUX_POS/X v3_four_channel_output_load_integration_0/v3_four_channel_shared_support_integration_0/v3_four_channel_bias_reference_distribution_0/v3_four_channel_phase_distribution_0/v3_four_channel_output_collection_0/v3_four_channel_placement_0/v3_channel_selector_late_promotion_0/v3_selector_route_pilot_0/G3_MUX_AXIS/a_76_199# VGND sky130_fd_pr__nfet_01v8 ad=0 pd=0 as=0.1995 ps=1.79 w=0.42 l=0.15
X155 v3_four_channel_output_load_integration_0/v3_four_channel_shared_support_integration_0/v3_four_channel_bias_reference_distribution_0/v3_four_channel_phase_distribution_0/v3_four_channel_output_collection_0/v3_four_channel_placement_0/v3_channel_selector_late_promotion_0/v3_selector_route_pilot_0/G3_MUX_AXIS/a_535_374# v3_four_channel_output_load_integration_0/v3_four_channel_shared_support_integration_0/v3_four_channel_bias_reference_distribution_0/v3_four_channel_phase_distribution_0/v3_four_channel_output_collection_0/v3_four_channel_placement_0/v3_channel_selector_late_promotion_0/v3_selector_route_pilot_0/G3_MUX_NEG/X v3_four_channel_output_load_integration_0/v3_four_channel_shared_support_integration_0/v3_four_channel_bias_reference_distribution_0/v3_four_channel_phase_distribution_0/v3_four_channel_output_collection_0/v3_four_channel_placement_0/v3_channel_selector_late_promotion_0/v3_selector_route_pilot_0/G3_MUX_AXIS/a_76_199# VDPWR sky130_fd_pr__pfet_01v8_hvt ad=0 pd=0 as=0 ps=0 w=0.42 l=0.15
X156 v3_four_channel_output_load_integration_0/v3_four_channel_shared_support_integration_0/v3_four_channel_bias_reference_distribution_0/v3_four_channel_phase_distribution_0/v3_four_channel_output_collection_0/v3_four_channel_placement_0/v3_channel_selector_late_promotion_0/v3_selector_route_pilot_0/G3_MUX_AXIS/a_76_199# v3_four_channel_output_load_integration_0/v3_four_channel_shared_support_integration_0/v3_four_channel_bias_reference_distribution_0/v3_four_channel_phase_distribution_0/v3_four_channel_output_collection_0/v3_four_channel_placement_0/v3_channel_selector_late_promotion_0/v3_selector_route_pilot_0/G3_MUX_NEG/X v3_four_channel_output_load_integration_0/v3_four_channel_shared_support_integration_0/v3_four_channel_bias_reference_distribution_0/v3_four_channel_phase_distribution_0/v3_four_channel_output_collection_0/v3_four_channel_placement_0/v3_channel_selector_late_promotion_0/v3_selector_route_pilot_0/G3_MUX_AXIS/a_218_47# VGND sky130_fd_pr__nfet_01v8 ad=0 pd=0 as=0.1386 ps=1.5 w=0.42 l=0.15
X157 v3_four_channel_output_load_integration_0/v3_four_channel_shared_support_integration_0/v3_four_channel_bias_reference_distribution_0/v3_four_channel_phase_distribution_0/v3_four_channel_output_collection_0/v3_four_channel_placement_0/v3_channel_selector_late_promotion_0/v3_selector_route_pilot_0/G3_MUX_AXIS/a_218_47# v3_four_channel_output_load_integration_0/v3_four_channel_shared_support_integration_0/v3_four_channel_bias_reference_distribution_0/v3_four_channel_phase_distribution_0/v3_four_channel_output_collection_0/v3_four_channel_placement_0/v3_channel_selector_late_promotion_0/group3_bit1 VGND VGND sky130_fd_pr__nfet_01v8 ad=0 pd=0 as=0 ps=0 w=0.42 l=0.15
X158 VDPWR v3_four_channel_output_load_integration_0/v3_four_channel_shared_support_integration_0/v3_four_channel_bias_reference_distribution_0/v3_four_channel_phase_distribution_0/v3_four_channel_output_collection_0/v3_four_channel_placement_0/v3_channel_selector_late_promotion_0/v3_selector_route_pilot_0/G3_MUX_AXIS/a_76_199# v3_four_channel_output_load_integration_0/v3_four_channel_shared_support_integration_0/v3_four_channel_bias_reference_distribution_0/v3_four_channel_phase_distribution_0/v3_four_channel_output_collection_0/v3_four_channel_placement_0/v3_channel_selector_late_promotion_0/v3_selector_route_pilot_0/G3_MUX_AXIS/X VDPWR sky130_fd_pr__pfet_01v8_hvt ad=0 pd=0 as=0.26 ps=2.52 w=1 l=0.15
X159 VGND v3_four_channel_output_load_integration_0/v3_four_channel_shared_support_integration_0/v3_four_channel_bias_reference_distribution_0/v3_four_channel_phase_distribution_0/v3_four_channel_output_collection_0/v3_four_channel_placement_0/v3_channel_selector_late_promotion_0/v3_selector_route_pilot_0/G3_MUX_AXIS/a_76_199# v3_four_channel_output_load_integration_0/v3_four_channel_shared_support_integration_0/v3_four_channel_bias_reference_distribution_0/v3_four_channel_phase_distribution_0/v3_four_channel_output_collection_0/v3_four_channel_placement_0/v3_channel_selector_late_promotion_0/v3_selector_route_pilot_0/G3_MUX_AXIS/X VGND sky130_fd_pr__nfet_01v8 ad=0 pd=0 as=0.169 ps=1.82 w=0.65 l=0.15
X160 VDPWR v3_four_channel_output_load_integration_0/v3_four_channel_shared_support_integration_0/v3_four_channel_bias_reference_distribution_0/v3_four_channel_phase_distribution_0/v3_four_channel_output_collection_0/v3_four_channel_placement_0/v3_channel_selector_late_promotion_0/channel_enable v3_four_channel_output_load_integration_0/v3_four_channel_shared_support_integration_0/v3_four_channel_bias_reference_distribution_0/v3_four_channel_phase_distribution_0/v3_four_channel_output_collection_0/v3_four_channel_placement_0/v3_channel_selector_late_promotion_0/v3_selector_route_pilot_0/ENABLE_ANDNOT/a_207_413# VDPWR sky130_fd_pr__pfet_01v8_hvt ad=0.2279 pd=1.74 as=0.0609 ps=0.71 w=0.42 l=0.15
X161 v3_four_channel_output_load_integration_0/v3_four_channel_shared_support_integration_0/v3_four_channel_bias_reference_distribution_0/v3_four_channel_phase_distribution_0/v3_four_channel_output_collection_0/v3_four_channel_placement_0/v3_channel_selector_late_promotion_0/v3_selector_route_pilot_0/G3_LO_P_AND/B v3_four_channel_output_load_integration_0/v3_four_channel_shared_support_integration_0/v3_four_channel_bias_reference_distribution_0/v3_four_channel_phase_distribution_0/v3_four_channel_output_collection_0/v3_four_channel_placement_0/v3_channel_selector_late_promotion_0/v3_selector_route_pilot_0/ENABLE_ANDNOT/a_207_413# VDPWR VDPWR sky130_fd_pr__pfet_01v8_hvt ad=0.26 pd=2.52 as=0.2279 ps=1.74 w=1 l=0.15
X162 v3_four_channel_output_load_integration_0/v3_four_channel_shared_support_integration_0/v3_four_channel_bias_reference_distribution_0/v3_four_channel_phase_distribution_0/v3_four_channel_output_collection_0/v3_four_channel_placement_0/v3_channel_selector_late_promotion_0/v3_selector_route_pilot_0/ENABLE_ANDNOT/a_297_47# v3_four_channel_output_load_integration_0/v3_four_channel_shared_support_integration_0/v3_four_channel_bias_reference_distribution_0/v3_four_channel_phase_distribution_0/v3_four_channel_output_collection_0/v3_four_channel_placement_0/v3_channel_selector_late_promotion_0/v3_selector_route_pilot_0/ENABLE_ANDNOT/a_27_413# v3_four_channel_output_load_integration_0/v3_four_channel_shared_support_integration_0/v3_four_channel_bias_reference_distribution_0/v3_four_channel_phase_distribution_0/v3_four_channel_output_collection_0/v3_four_channel_placement_0/v3_channel_selector_late_promotion_0/v3_selector_route_pilot_0/ENABLE_ANDNOT/a_207_413# VGND sky130_fd_pr__nfet_01v8 ad=0.0504 pd=0.66 as=0.1092 ps=1.36 w=0.42 l=0.15
X163 v3_four_channel_output_load_integration_0/v3_four_channel_shared_support_integration_0/v3_four_channel_bias_reference_distribution_0/v3_four_channel_phase_distribution_0/v3_four_channel_output_collection_0/v3_four_channel_placement_0/v3_channel_selector_late_promotion_0/v3_selector_route_pilot_0/G3_LO_P_AND/B v3_four_channel_output_load_integration_0/v3_four_channel_shared_support_integration_0/v3_four_channel_bias_reference_distribution_0/v3_four_channel_phase_distribution_0/v3_four_channel_output_collection_0/v3_four_channel_placement_0/v3_channel_selector_late_promotion_0/v3_selector_route_pilot_0/ENABLE_ANDNOT/a_207_413# VGND VGND sky130_fd_pr__nfet_01v8 ad=0.169 pd=1.82 as=0.1013 ps=0.99 w=0.65 l=0.15
X164 v3_four_channel_output_load_integration_0/v3_four_channel_shared_support_integration_0/v3_four_channel_bias_reference_distribution_0/v3_four_channel_phase_distribution_0/v3_four_channel_output_collection_0/v3_four_channel_placement_0/v3_channel_selector_late_promotion_0/v3_selector_route_pilot_0/ENABLE_ANDNOT/a_207_413# v3_four_channel_output_load_integration_0/v3_four_channel_shared_support_integration_0/v3_four_channel_bias_reference_distribution_0/v3_four_channel_phase_distribution_0/v3_four_channel_output_collection_0/v3_four_channel_placement_0/v3_channel_selector_late_promotion_0/v3_selector_route_pilot_0/ENABLE_ANDNOT/a_27_413# VDPWR VDPWR sky130_fd_pr__pfet_01v8_hvt ad=0.0609 pd=0.71 as=0.0714 ps=0.76 w=0.42 l=0.15
X165 VDPWR v3_four_channel_output_load_integration_0/v3_four_channel_shared_support_integration_0/v3_four_channel_bias_reference_distribution_0/v3_four_channel_phase_distribution_0/v3_four_channel_output_collection_0/v3_four_channel_placement_0/v3_channel_selector_late_promotion_0/mixers_blank v3_four_channel_output_load_integration_0/v3_four_channel_shared_support_integration_0/v3_four_channel_bias_reference_distribution_0/v3_four_channel_phase_distribution_0/v3_four_channel_output_collection_0/v3_four_channel_placement_0/v3_channel_selector_late_promotion_0/v3_selector_route_pilot_0/ENABLE_ANDNOT/a_27_413# VDPWR sky130_fd_pr__pfet_01v8_hvt ad=0.0714 pd=0.76 as=0.1092 ps=1.36 w=0.42 l=0.15
X166 VGND v3_four_channel_output_load_integration_0/v3_four_channel_shared_support_integration_0/v3_four_channel_bias_reference_distribution_0/v3_four_channel_phase_distribution_0/v3_four_channel_output_collection_0/v3_four_channel_placement_0/v3_channel_selector_late_promotion_0/channel_enable v3_four_channel_output_load_integration_0/v3_four_channel_shared_support_integration_0/v3_four_channel_bias_reference_distribution_0/v3_four_channel_phase_distribution_0/v3_four_channel_output_collection_0/v3_four_channel_placement_0/v3_channel_selector_late_promotion_0/v3_selector_route_pilot_0/ENABLE_ANDNOT/a_297_47# VGND sky130_fd_pr__nfet_01v8 ad=0.1013 pd=0.99 as=0.0504 ps=0.66 w=0.42 l=0.15
X167 v3_four_channel_output_load_integration_0/v3_four_channel_shared_support_integration_0/v3_four_channel_bias_reference_distribution_0/v3_four_channel_phase_distribution_0/v3_four_channel_output_collection_0/v3_four_channel_placement_0/v3_channel_selector_late_promotion_0/v3_selector_route_pilot_0/ENABLE_ANDNOT/a_27_413# v3_four_channel_output_load_integration_0/v3_four_channel_shared_support_integration_0/v3_four_channel_bias_reference_distribution_0/v3_four_channel_phase_distribution_0/v3_four_channel_output_collection_0/v3_four_channel_placement_0/v3_channel_selector_late_promotion_0/mixers_blank VGND VGND sky130_fd_pr__nfet_01v8 ad=0.1092 pd=1.36 as=0.1092 ps=1.36 w=0.42 l=0.15
X168 VDPWR v3_four_channel_output_load_integration_0/v3_four_channel_shared_support_integration_0/v3_four_channel_bias_reference_distribution_0/v3_four_channel_phase_distribution_0/v3_four_channel_output_collection_0/v3_four_channel_placement_0/v3_channel_selector_late_promotion_0/v3_selector_route_pilot_0/G1_MUX_NEG/a_505_21# v3_four_channel_output_load_integration_0/v3_four_channel_shared_support_integration_0/v3_four_channel_bias_reference_distribution_0/v3_four_channel_phase_distribution_0/v3_four_channel_output_collection_0/v3_four_channel_placement_0/v3_channel_selector_late_promotion_0/v3_selector_route_pilot_0/G1_MUX_NEG/a_535_374# VDPWR sky130_fd_pr__pfet_01v8_hvt ad=0 pd=0 as=0.0882 ps=1.26 w=0.42 l=0.15
X169 v3_four_channel_output_load_integration_0/v3_four_channel_shared_support_integration_0/v3_four_channel_bias_reference_distribution_0/v3_four_channel_phase_distribution_0/v3_four_channel_output_collection_0/v3_four_channel_placement_0/v3_channel_selector_late_promotion_0/v3_selector_route_pilot_0/G1_MUX_NEG/a_505_21# v3_four_channel_output_load_integration_0/v3_four_channel_shared_support_integration_0/v3_four_channel_bias_reference_distribution_0/v3_four_channel_phase_distribution_0/v3_four_channel_output_collection_0/v3_four_channel_placement_0/v3_channel_selector_late_promotion_0/group1_bit0 VDPWR VDPWR sky130_fd_pr__pfet_01v8_hvt ad=0.1176 pd=1.4 as=0 ps=0 w=0.42 l=0.15
X170 v3_four_channel_output_load_integration_0/v3_four_channel_shared_support_integration_0/v3_four_channel_bias_reference_distribution_0/v3_four_channel_phase_distribution_0/v3_four_channel_output_collection_0/v3_four_channel_placement_0/v3_channel_selector_late_promotion_0/v3_selector_route_pilot_0/G1_MUX_NEG/a_218_374# v3_four_channel_output_load_integration_0/v3_four_channel_shared_support_integration_0/v3_four_channel_bias_reference_distribution_0/v3_four_channel_phase_distribution_0/v3_four_channel_output_collection_0/v3_four_channel_placement_0/v3_channel_selector_late_promotion_0/group1_bit0 VDPWR VDPWR sky130_fd_pr__pfet_01v8_hvt ad=0.1533 pd=1.57 as=0 ps=0 w=0.42 l=0.15
X171 VGND v3_four_channel_output_load_integration_0/v3_four_channel_shared_support_integration_0/v3_four_channel_bias_reference_distribution_0/v3_four_channel_phase_distribution_0/v3_four_channel_output_collection_0/v3_four_channel_placement_0/v3_channel_selector_late_promotion_0/v3_selector_route_pilot_0/G1_MUX_NEG/a_505_21# v3_four_channel_output_load_integration_0/v3_four_channel_shared_support_integration_0/v3_four_channel_bias_reference_distribution_0/v3_four_channel_phase_distribution_0/v3_four_channel_output_collection_0/v3_four_channel_placement_0/v3_channel_selector_late_promotion_0/v3_selector_route_pilot_0/G1_MUX_NEG/a_439_47# VGND sky130_fd_pr__nfet_01v8 ad=0 pd=0 as=0.1386 ps=1.5 w=0.42 l=0.15
X172 v3_four_channel_output_load_integration_0/v3_four_channel_shared_support_integration_0/v3_four_channel_bias_reference_distribution_0/v3_four_channel_phase_distribution_0/v3_four_channel_output_collection_0/v3_four_channel_placement_0/v3_channel_selector_late_promotion_0/v3_selector_route_pilot_0/G1_MUX_NEG/a_76_199# v3_four_channel_output_load_integration_0/v3_four_channel_shared_support_integration_0/v3_four_channel_bias_reference_distribution_0/v3_four_channel_phase_distribution_0/phase_180 v3_four_channel_output_load_integration_0/v3_four_channel_shared_support_integration_0/v3_four_channel_bias_reference_distribution_0/v3_four_channel_phase_distribution_0/v3_four_channel_output_collection_0/v3_four_channel_placement_0/v3_channel_selector_late_promotion_0/v3_selector_route_pilot_0/G1_MUX_NEG/a_218_374# VDPWR sky130_fd_pr__pfet_01v8_hvt ad=0.3864 pd=2.68 as=0 ps=0 w=0.42 l=0.15
X173 v3_four_channel_output_load_integration_0/v3_four_channel_shared_support_integration_0/v3_four_channel_bias_reference_distribution_0/v3_four_channel_phase_distribution_0/v3_four_channel_output_collection_0/v3_four_channel_placement_0/v3_channel_selector_late_promotion_0/v3_selector_route_pilot_0/G1_MUX_NEG/a_505_21# v3_four_channel_output_load_integration_0/v3_four_channel_shared_support_integration_0/v3_four_channel_bias_reference_distribution_0/v3_four_channel_phase_distribution_0/v3_four_channel_output_collection_0/v3_four_channel_placement_0/v3_channel_selector_late_promotion_0/group1_bit0 VGND VGND sky130_fd_pr__nfet_01v8 ad=0.1092 pd=1.36 as=0 ps=0 w=0.42 l=0.15
X174 v3_four_channel_output_load_integration_0/v3_four_channel_shared_support_integration_0/v3_four_channel_bias_reference_distribution_0/v3_four_channel_phase_distribution_0/v3_four_channel_output_collection_0/v3_four_channel_placement_0/v3_channel_selector_late_promotion_0/v3_selector_route_pilot_0/G1_MUX_NEG/a_439_47# v3_four_channel_output_load_integration_0/v3_four_channel_shared_support_integration_0/v3_four_channel_bias_reference_distribution_0/v3_four_channel_phase_distribution_0/phase_180 v3_four_channel_output_load_integration_0/v3_four_channel_shared_support_integration_0/v3_four_channel_bias_reference_distribution_0/v3_four_channel_phase_distribution_0/v3_four_channel_output_collection_0/v3_four_channel_placement_0/v3_channel_selector_late_promotion_0/v3_selector_route_pilot_0/G1_MUX_NEG/a_76_199# VGND sky130_fd_pr__nfet_01v8 ad=0 pd=0 as=0.1995 ps=1.79 w=0.42 l=0.15
X175 v3_four_channel_output_load_integration_0/v3_four_channel_shared_support_integration_0/v3_four_channel_bias_reference_distribution_0/v3_four_channel_phase_distribution_0/v3_four_channel_output_collection_0/v3_four_channel_placement_0/v3_channel_selector_late_promotion_0/v3_selector_route_pilot_0/G1_MUX_NEG/a_535_374# v3_four_channel_output_load_integration_0/v3_four_channel_shared_support_integration_0/v3_four_channel_bias_reference_distribution_0/v3_four_channel_phase_distribution_0/phase_270 v3_four_channel_output_load_integration_0/v3_four_channel_shared_support_integration_0/v3_four_channel_bias_reference_distribution_0/v3_four_channel_phase_distribution_0/v3_four_channel_output_collection_0/v3_four_channel_placement_0/v3_channel_selector_late_promotion_0/v3_selector_route_pilot_0/G1_MUX_NEG/a_76_199# VDPWR sky130_fd_pr__pfet_01v8_hvt ad=0 pd=0 as=0 ps=0 w=0.42 l=0.15
X176 v3_four_channel_output_load_integration_0/v3_four_channel_shared_support_integration_0/v3_four_channel_bias_reference_distribution_0/v3_four_channel_phase_distribution_0/v3_four_channel_output_collection_0/v3_four_channel_placement_0/v3_channel_selector_late_promotion_0/v3_selector_route_pilot_0/G1_MUX_NEG/a_76_199# v3_four_channel_output_load_integration_0/v3_four_channel_shared_support_integration_0/v3_four_channel_bias_reference_distribution_0/v3_four_channel_phase_distribution_0/phase_270 v3_four_channel_output_load_integration_0/v3_four_channel_shared_support_integration_0/v3_four_channel_bias_reference_distribution_0/v3_four_channel_phase_distribution_0/v3_four_channel_output_collection_0/v3_four_channel_placement_0/v3_channel_selector_late_promotion_0/v3_selector_route_pilot_0/G1_MUX_NEG/a_218_47# VGND sky130_fd_pr__nfet_01v8 ad=0 pd=0 as=0.1386 ps=1.5 w=0.42 l=0.15
X177 v3_four_channel_output_load_integration_0/v3_four_channel_shared_support_integration_0/v3_four_channel_bias_reference_distribution_0/v3_four_channel_phase_distribution_0/v3_four_channel_output_collection_0/v3_four_channel_placement_0/v3_channel_selector_late_promotion_0/v3_selector_route_pilot_0/G1_MUX_NEG/a_218_47# v3_four_channel_output_load_integration_0/v3_four_channel_shared_support_integration_0/v3_four_channel_bias_reference_distribution_0/v3_four_channel_phase_distribution_0/v3_four_channel_output_collection_0/v3_four_channel_placement_0/v3_channel_selector_late_promotion_0/group1_bit0 VGND VGND sky130_fd_pr__nfet_01v8 ad=0 pd=0 as=0 ps=0 w=0.42 l=0.15
X178 VDPWR v3_four_channel_output_load_integration_0/v3_four_channel_shared_support_integration_0/v3_four_channel_bias_reference_distribution_0/v3_four_channel_phase_distribution_0/v3_four_channel_output_collection_0/v3_four_channel_placement_0/v3_channel_selector_late_promotion_0/v3_selector_route_pilot_0/G1_MUX_NEG/a_76_199# v3_four_channel_output_load_integration_0/v3_four_channel_shared_support_integration_0/v3_four_channel_bias_reference_distribution_0/v3_four_channel_phase_distribution_0/v3_four_channel_output_collection_0/v3_four_channel_placement_0/v3_channel_selector_late_promotion_0/v3_selector_route_pilot_0/G1_MUX_NEG/X VDPWR sky130_fd_pr__pfet_01v8_hvt ad=0 pd=0 as=0.26 ps=2.52 w=1 l=0.15
X179 VGND v3_four_channel_output_load_integration_0/v3_four_channel_shared_support_integration_0/v3_four_channel_bias_reference_distribution_0/v3_four_channel_phase_distribution_0/v3_four_channel_output_collection_0/v3_four_channel_placement_0/v3_channel_selector_late_promotion_0/v3_selector_route_pilot_0/G1_MUX_NEG/a_76_199# v3_four_channel_output_load_integration_0/v3_four_channel_shared_support_integration_0/v3_four_channel_bias_reference_distribution_0/v3_four_channel_phase_distribution_0/v3_four_channel_output_collection_0/v3_four_channel_placement_0/v3_channel_selector_late_promotion_0/v3_selector_route_pilot_0/G1_MUX_NEG/X VGND sky130_fd_pr__nfet_01v8 ad=0 pd=0 as=0.169 ps=1.82 w=0.65 l=0.15
X180 VDPWR v3_four_channel_output_load_integration_0/v3_four_channel_shared_support_integration_0/v3_four_channel_bias_reference_distribution_0/v3_four_channel_phase_distribution_0/v3_four_channel_output_collection_0/v3_four_channel_placement_0/v3_channel_selector_late_promotion_0/v3_selector_route_pilot_0/G3_LO_P_AND/B v3_four_channel_output_load_integration_0/v3_four_channel_shared_support_integration_0/v3_four_channel_bias_reference_distribution_0/v3_four_channel_phase_distribution_0/v3_four_channel_output_collection_0/v3_four_channel_placement_0/v3_channel_selector_late_promotion_0/v3_selector_route_pilot_0/G1_LO_P_AND/a_59_75# VDPWR sky130_fd_pr__pfet_01v8_hvt ad=0.16655 pd=1.39 as=0.0567 ps=0.69 w=0.42 l=0.15
X181 v3_four_channel_output_load_integration_0/v3_four_channel_shared_support_integration_0/v3_four_channel_bias_reference_distribution_0/v3_four_channel_phase_distribution_0/v3_four_channel_output_collection_0/v3_four_channel_placement_0/v3_channel_selector_late_promotion_0/v3_selector_route_pilot_0/group1_lo_p v3_four_channel_output_load_integration_0/v3_four_channel_shared_support_integration_0/v3_four_channel_bias_reference_distribution_0/v3_four_channel_phase_distribution_0/v3_four_channel_output_collection_0/v3_four_channel_placement_0/v3_channel_selector_late_promotion_0/v3_selector_route_pilot_0/G1_LO_P_AND/a_59_75# VDPWR VDPWR sky130_fd_pr__pfet_01v8_hvt ad=0.475 pd=2.95 as=0.16655 ps=1.39 w=1 l=0.15
X182 VGND v3_four_channel_output_load_integration_0/v3_four_channel_shared_support_integration_0/v3_four_channel_bias_reference_distribution_0/v3_four_channel_phase_distribution_0/v3_four_channel_output_collection_0/v3_four_channel_placement_0/v3_channel_selector_late_promotion_0/v3_selector_route_pilot_0/G3_LO_P_AND/B v3_four_channel_output_load_integration_0/v3_four_channel_shared_support_integration_0/v3_four_channel_bias_reference_distribution_0/v3_four_channel_phase_distribution_0/v3_four_channel_output_collection_0/v3_four_channel_placement_0/v3_channel_selector_late_promotion_0/v3_selector_route_pilot_0/G1_LO_P_AND/a_145_75# VGND sky130_fd_pr__nfet_01v8 ad=0.1118 pd=1.04 as=0.0567 ps=0.69 w=0.42 l=0.15
X183 v3_four_channel_output_load_integration_0/v3_four_channel_shared_support_integration_0/v3_four_channel_bias_reference_distribution_0/v3_four_channel_phase_distribution_0/v3_four_channel_output_collection_0/v3_four_channel_placement_0/v3_channel_selector_late_promotion_0/v3_selector_route_pilot_0/G1_LO_P_AND/a_59_75# v3_four_channel_output_load_integration_0/v3_four_channel_shared_support_integration_0/v3_four_channel_bias_reference_distribution_0/v3_four_channel_phase_distribution_0/v3_four_channel_output_collection_0/v3_four_channel_placement_0/v3_channel_selector_late_promotion_0/v3_selector_route_pilot_0/G1_MUX_AXIS/X VDPWR VDPWR sky130_fd_pr__pfet_01v8_hvt ad=0.0567 pd=0.69 as=0.1176 ps=1.4 w=0.42 l=0.15
X184 v3_four_channel_output_load_integration_0/v3_four_channel_shared_support_integration_0/v3_four_channel_bias_reference_distribution_0/v3_four_channel_phase_distribution_0/v3_four_channel_output_collection_0/v3_four_channel_placement_0/v3_channel_selector_late_promotion_0/v3_selector_route_pilot_0/group1_lo_p v3_four_channel_output_load_integration_0/v3_four_channel_shared_support_integration_0/v3_four_channel_bias_reference_distribution_0/v3_four_channel_phase_distribution_0/v3_four_channel_output_collection_0/v3_four_channel_placement_0/v3_channel_selector_late_promotion_0/v3_selector_route_pilot_0/G1_LO_P_AND/a_59_75# VGND VGND sky130_fd_pr__nfet_01v8 ad=0.182 pd=1.86 as=0.1118 ps=1.04 w=0.65 l=0.15
X185 v3_four_channel_output_load_integration_0/v3_four_channel_shared_support_integration_0/v3_four_channel_bias_reference_distribution_0/v3_four_channel_phase_distribution_0/v3_four_channel_output_collection_0/v3_four_channel_placement_0/v3_channel_selector_late_promotion_0/v3_selector_route_pilot_0/G1_LO_P_AND/a_145_75# v3_four_channel_output_load_integration_0/v3_four_channel_shared_support_integration_0/v3_four_channel_bias_reference_distribution_0/v3_four_channel_phase_distribution_0/v3_four_channel_output_collection_0/v3_four_channel_placement_0/v3_channel_selector_late_promotion_0/v3_selector_route_pilot_0/G1_MUX_AXIS/X v3_four_channel_output_load_integration_0/v3_four_channel_shared_support_integration_0/v3_four_channel_bias_reference_distribution_0/v3_four_channel_phase_distribution_0/v3_four_channel_output_collection_0/v3_four_channel_placement_0/v3_channel_selector_late_promotion_0/v3_selector_route_pilot_0/G1_LO_P_AND/a_59_75# VGND sky130_fd_pr__nfet_01v8 ad=0.0567 pd=0.69 as=0.1176 ps=1.4 w=0.42 l=0.15
X186 VDPWR v3_four_channel_output_load_integration_0/v3_four_channel_shared_support_integration_0/v3_four_channel_bias_reference_distribution_0/v3_four_channel_phase_distribution_0/v3_four_channel_output_collection_0/v3_four_channel_placement_0/v3_channel_selector_late_promotion_0/v3_selector_route_pilot_0/G0_MUX_POS/a_505_21# v3_four_channel_output_load_integration_0/v3_four_channel_shared_support_integration_0/v3_four_channel_bias_reference_distribution_0/v3_four_channel_phase_distribution_0/v3_four_channel_output_collection_0/v3_four_channel_placement_0/v3_channel_selector_late_promotion_0/v3_selector_route_pilot_0/G0_MUX_POS/a_535_374# VDPWR sky130_fd_pr__pfet_01v8_hvt ad=0 pd=0 as=0.0882 ps=1.26 w=0.42 l=0.15
X187 v3_four_channel_output_load_integration_0/v3_four_channel_shared_support_integration_0/v3_four_channel_bias_reference_distribution_0/v3_four_channel_phase_distribution_0/v3_four_channel_output_collection_0/v3_four_channel_placement_0/v3_channel_selector_late_promotion_0/v3_selector_route_pilot_0/G0_MUX_POS/a_505_21# v3_four_channel_output_load_integration_0/v3_four_channel_shared_support_integration_0/v3_four_channel_bias_reference_distribution_0/v3_four_channel_phase_distribution_0/v3_four_channel_output_collection_0/v3_four_channel_placement_0/v3_channel_selector_late_promotion_0/group0_bit0 VDPWR VDPWR sky130_fd_pr__pfet_01v8_hvt ad=0.1176 pd=1.4 as=0 ps=0 w=0.42 l=0.15
X188 v3_four_channel_output_load_integration_0/v3_four_channel_shared_support_integration_0/v3_four_channel_bias_reference_distribution_0/v3_four_channel_phase_distribution_0/v3_four_channel_output_collection_0/v3_four_channel_placement_0/v3_channel_selector_late_promotion_0/v3_selector_route_pilot_0/G0_MUX_POS/a_218_374# v3_four_channel_output_load_integration_0/v3_four_channel_shared_support_integration_0/v3_four_channel_bias_reference_distribution_0/v3_four_channel_phase_distribution_0/v3_four_channel_output_collection_0/v3_four_channel_placement_0/v3_channel_selector_late_promotion_0/group0_bit0 VDPWR VDPWR sky130_fd_pr__pfet_01v8_hvt ad=0.1533 pd=1.57 as=0 ps=0 w=0.42 l=0.15
X189 VGND v3_four_channel_output_load_integration_0/v3_four_channel_shared_support_integration_0/v3_four_channel_bias_reference_distribution_0/v3_four_channel_phase_distribution_0/v3_four_channel_output_collection_0/v3_four_channel_placement_0/v3_channel_selector_late_promotion_0/v3_selector_route_pilot_0/G0_MUX_POS/a_505_21# v3_four_channel_output_load_integration_0/v3_four_channel_shared_support_integration_0/v3_four_channel_bias_reference_distribution_0/v3_four_channel_phase_distribution_0/v3_four_channel_output_collection_0/v3_four_channel_placement_0/v3_channel_selector_late_promotion_0/v3_selector_route_pilot_0/G0_MUX_POS/a_439_47# VGND sky130_fd_pr__nfet_01v8 ad=0 pd=0 as=0.1386 ps=1.5 w=0.42 l=0.15
X190 v3_four_channel_output_load_integration_0/v3_four_channel_shared_support_integration_0/v3_four_channel_bias_reference_distribution_0/v3_four_channel_phase_distribution_0/v3_four_channel_output_collection_0/v3_four_channel_placement_0/v3_channel_selector_late_promotion_0/v3_selector_route_pilot_0/G0_MUX_POS/a_76_199# v3_four_channel_output_load_integration_0/v3_four_channel_shared_support_integration_0/v3_four_channel_bias_reference_distribution_0/v3_four_channel_phase_distribution_0/phase_0 v3_four_channel_output_load_integration_0/v3_four_channel_shared_support_integration_0/v3_four_channel_bias_reference_distribution_0/v3_four_channel_phase_distribution_0/v3_four_channel_output_collection_0/v3_four_channel_placement_0/v3_channel_selector_late_promotion_0/v3_selector_route_pilot_0/G0_MUX_POS/a_218_374# VDPWR sky130_fd_pr__pfet_01v8_hvt ad=0.3864 pd=2.68 as=0 ps=0 w=0.42 l=0.15
X191 v3_four_channel_output_load_integration_0/v3_four_channel_shared_support_integration_0/v3_four_channel_bias_reference_distribution_0/v3_four_channel_phase_distribution_0/v3_four_channel_output_collection_0/v3_four_channel_placement_0/v3_channel_selector_late_promotion_0/v3_selector_route_pilot_0/G0_MUX_POS/a_505_21# v3_four_channel_output_load_integration_0/v3_four_channel_shared_support_integration_0/v3_four_channel_bias_reference_distribution_0/v3_four_channel_phase_distribution_0/v3_four_channel_output_collection_0/v3_four_channel_placement_0/v3_channel_selector_late_promotion_0/group0_bit0 VGND VGND sky130_fd_pr__nfet_01v8 ad=0.1092 pd=1.36 as=0 ps=0 w=0.42 l=0.15
X192 v3_four_channel_output_load_integration_0/v3_four_channel_shared_support_integration_0/v3_four_channel_bias_reference_distribution_0/v3_four_channel_phase_distribution_0/v3_four_channel_output_collection_0/v3_four_channel_placement_0/v3_channel_selector_late_promotion_0/v3_selector_route_pilot_0/G0_MUX_POS/a_439_47# v3_four_channel_output_load_integration_0/v3_four_channel_shared_support_integration_0/v3_four_channel_bias_reference_distribution_0/v3_four_channel_phase_distribution_0/phase_0 v3_four_channel_output_load_integration_0/v3_four_channel_shared_support_integration_0/v3_four_channel_bias_reference_distribution_0/v3_four_channel_phase_distribution_0/v3_four_channel_output_collection_0/v3_four_channel_placement_0/v3_channel_selector_late_promotion_0/v3_selector_route_pilot_0/G0_MUX_POS/a_76_199# VGND sky130_fd_pr__nfet_01v8 ad=0 pd=0 as=0.1995 ps=1.79 w=0.42 l=0.15
X193 v3_four_channel_output_load_integration_0/v3_four_channel_shared_support_integration_0/v3_four_channel_bias_reference_distribution_0/v3_four_channel_phase_distribution_0/v3_four_channel_output_collection_0/v3_four_channel_placement_0/v3_channel_selector_late_promotion_0/v3_selector_route_pilot_0/G0_MUX_POS/a_535_374# v3_four_channel_output_load_integration_0/v3_four_channel_shared_support_integration_0/v3_four_channel_bias_reference_distribution_0/v3_four_channel_phase_distribution_0/phase_90 v3_four_channel_output_load_integration_0/v3_four_channel_shared_support_integration_0/v3_four_channel_bias_reference_distribution_0/v3_four_channel_phase_distribution_0/v3_four_channel_output_collection_0/v3_four_channel_placement_0/v3_channel_selector_late_promotion_0/v3_selector_route_pilot_0/G0_MUX_POS/a_76_199# VDPWR sky130_fd_pr__pfet_01v8_hvt ad=0 pd=0 as=0 ps=0 w=0.42 l=0.15
X194 v3_four_channel_output_load_integration_0/v3_four_channel_shared_support_integration_0/v3_four_channel_bias_reference_distribution_0/v3_four_channel_phase_distribution_0/v3_four_channel_output_collection_0/v3_four_channel_placement_0/v3_channel_selector_late_promotion_0/v3_selector_route_pilot_0/G0_MUX_POS/a_76_199# v3_four_channel_output_load_integration_0/v3_four_channel_shared_support_integration_0/v3_four_channel_bias_reference_distribution_0/v3_four_channel_phase_distribution_0/phase_90 v3_four_channel_output_load_integration_0/v3_four_channel_shared_support_integration_0/v3_four_channel_bias_reference_distribution_0/v3_four_channel_phase_distribution_0/v3_four_channel_output_collection_0/v3_four_channel_placement_0/v3_channel_selector_late_promotion_0/v3_selector_route_pilot_0/G0_MUX_POS/a_218_47# VGND sky130_fd_pr__nfet_01v8 ad=0 pd=0 as=0.1386 ps=1.5 w=0.42 l=0.15
X195 v3_four_channel_output_load_integration_0/v3_four_channel_shared_support_integration_0/v3_four_channel_bias_reference_distribution_0/v3_four_channel_phase_distribution_0/v3_four_channel_output_collection_0/v3_four_channel_placement_0/v3_channel_selector_late_promotion_0/v3_selector_route_pilot_0/G0_MUX_POS/a_218_47# v3_four_channel_output_load_integration_0/v3_four_channel_shared_support_integration_0/v3_four_channel_bias_reference_distribution_0/v3_four_channel_phase_distribution_0/v3_four_channel_output_collection_0/v3_four_channel_placement_0/v3_channel_selector_late_promotion_0/group0_bit0 VGND VGND sky130_fd_pr__nfet_01v8 ad=0 pd=0 as=0 ps=0 w=0.42 l=0.15
X196 VDPWR v3_four_channel_output_load_integration_0/v3_four_channel_shared_support_integration_0/v3_four_channel_bias_reference_distribution_0/v3_four_channel_phase_distribution_0/v3_four_channel_output_collection_0/v3_four_channel_placement_0/v3_channel_selector_late_promotion_0/v3_selector_route_pilot_0/G0_MUX_POS/a_76_199# v3_four_channel_output_load_integration_0/v3_four_channel_shared_support_integration_0/v3_four_channel_bias_reference_distribution_0/v3_four_channel_phase_distribution_0/v3_four_channel_output_collection_0/v3_four_channel_placement_0/v3_channel_selector_late_promotion_0/v3_selector_route_pilot_0/G0_MUX_POS/X VDPWR sky130_fd_pr__pfet_01v8_hvt ad=0 pd=0 as=0.26 ps=2.52 w=1 l=0.15
X197 VGND v3_four_channel_output_load_integration_0/v3_four_channel_shared_support_integration_0/v3_four_channel_bias_reference_distribution_0/v3_four_channel_phase_distribution_0/v3_four_channel_output_collection_0/v3_four_channel_placement_0/v3_channel_selector_late_promotion_0/v3_selector_route_pilot_0/G0_MUX_POS/a_76_199# v3_four_channel_output_load_integration_0/v3_four_channel_shared_support_integration_0/v3_four_channel_bias_reference_distribution_0/v3_four_channel_phase_distribution_0/v3_four_channel_output_collection_0/v3_four_channel_placement_0/v3_channel_selector_late_promotion_0/v3_selector_route_pilot_0/G0_MUX_POS/X VGND sky130_fd_pr__nfet_01v8 ad=0 pd=0 as=0.169 ps=1.82 w=0.65 l=0.15
X198 VDPWR v3_four_channel_output_load_integration_0/v3_four_channel_shared_support_integration_0/v3_four_channel_bias_reference_distribution_0/v3_four_channel_phase_distribution_0/v3_four_channel_output_collection_0/v3_four_channel_placement_0/v3_channel_selector_late_promotion_0/v3_selector_route_pilot_0/G0_MUX_NEG/a_505_21# v3_four_channel_output_load_integration_0/v3_four_channel_shared_support_integration_0/v3_four_channel_bias_reference_distribution_0/v3_four_channel_phase_distribution_0/v3_four_channel_output_collection_0/v3_four_channel_placement_0/v3_channel_selector_late_promotion_0/v3_selector_route_pilot_0/G0_MUX_NEG/a_535_374# VDPWR sky130_fd_pr__pfet_01v8_hvt ad=0 pd=0 as=0.0882 ps=1.26 w=0.42 l=0.15
X199 v3_four_channel_output_load_integration_0/v3_four_channel_shared_support_integration_0/v3_four_channel_bias_reference_distribution_0/v3_four_channel_phase_distribution_0/v3_four_channel_output_collection_0/v3_four_channel_placement_0/v3_channel_selector_late_promotion_0/v3_selector_route_pilot_0/G0_MUX_NEG/a_505_21# v3_four_channel_output_load_integration_0/v3_four_channel_shared_support_integration_0/v3_four_channel_bias_reference_distribution_0/v3_four_channel_phase_distribution_0/v3_four_channel_output_collection_0/v3_four_channel_placement_0/v3_channel_selector_late_promotion_0/group0_bit0 VDPWR VDPWR sky130_fd_pr__pfet_01v8_hvt ad=0.1176 pd=1.4 as=0 ps=0 w=0.42 l=0.15
X200 v3_four_channel_output_load_integration_0/v3_four_channel_shared_support_integration_0/v3_four_channel_bias_reference_distribution_0/v3_four_channel_phase_distribution_0/v3_four_channel_output_collection_0/v3_four_channel_placement_0/v3_channel_selector_late_promotion_0/v3_selector_route_pilot_0/G0_MUX_NEG/a_218_374# v3_four_channel_output_load_integration_0/v3_four_channel_shared_support_integration_0/v3_four_channel_bias_reference_distribution_0/v3_four_channel_phase_distribution_0/v3_four_channel_output_collection_0/v3_four_channel_placement_0/v3_channel_selector_late_promotion_0/group0_bit0 VDPWR VDPWR sky130_fd_pr__pfet_01v8_hvt ad=0.1533 pd=1.57 as=0 ps=0 w=0.42 l=0.15
X201 VGND v3_four_channel_output_load_integration_0/v3_four_channel_shared_support_integration_0/v3_four_channel_bias_reference_distribution_0/v3_four_channel_phase_distribution_0/v3_four_channel_output_collection_0/v3_four_channel_placement_0/v3_channel_selector_late_promotion_0/v3_selector_route_pilot_0/G0_MUX_NEG/a_505_21# v3_four_channel_output_load_integration_0/v3_four_channel_shared_support_integration_0/v3_four_channel_bias_reference_distribution_0/v3_four_channel_phase_distribution_0/v3_four_channel_output_collection_0/v3_four_channel_placement_0/v3_channel_selector_late_promotion_0/v3_selector_route_pilot_0/G0_MUX_NEG/a_439_47# VGND sky130_fd_pr__nfet_01v8 ad=0 pd=0 as=0.1386 ps=1.5 w=0.42 l=0.15
X202 v3_four_channel_output_load_integration_0/v3_four_channel_shared_support_integration_0/v3_four_channel_bias_reference_distribution_0/v3_four_channel_phase_distribution_0/v3_four_channel_output_collection_0/v3_four_channel_placement_0/v3_channel_selector_late_promotion_0/v3_selector_route_pilot_0/G0_MUX_NEG/a_76_199# v3_four_channel_output_load_integration_0/v3_four_channel_shared_support_integration_0/v3_four_channel_bias_reference_distribution_0/v3_four_channel_phase_distribution_0/phase_180 v3_four_channel_output_load_integration_0/v3_four_channel_shared_support_integration_0/v3_four_channel_bias_reference_distribution_0/v3_four_channel_phase_distribution_0/v3_four_channel_output_collection_0/v3_four_channel_placement_0/v3_channel_selector_late_promotion_0/v3_selector_route_pilot_0/G0_MUX_NEG/a_218_374# VDPWR sky130_fd_pr__pfet_01v8_hvt ad=0.3864 pd=2.68 as=0 ps=0 w=0.42 l=0.15
X203 v3_four_channel_output_load_integration_0/v3_four_channel_shared_support_integration_0/v3_four_channel_bias_reference_distribution_0/v3_four_channel_phase_distribution_0/v3_four_channel_output_collection_0/v3_four_channel_placement_0/v3_channel_selector_late_promotion_0/v3_selector_route_pilot_0/G0_MUX_NEG/a_505_21# v3_four_channel_output_load_integration_0/v3_four_channel_shared_support_integration_0/v3_four_channel_bias_reference_distribution_0/v3_four_channel_phase_distribution_0/v3_four_channel_output_collection_0/v3_four_channel_placement_0/v3_channel_selector_late_promotion_0/group0_bit0 VGND VGND sky130_fd_pr__nfet_01v8 ad=0.1092 pd=1.36 as=0 ps=0 w=0.42 l=0.15
X204 v3_four_channel_output_load_integration_0/v3_four_channel_shared_support_integration_0/v3_four_channel_bias_reference_distribution_0/v3_four_channel_phase_distribution_0/v3_four_channel_output_collection_0/v3_four_channel_placement_0/v3_channel_selector_late_promotion_0/v3_selector_route_pilot_0/G0_MUX_NEG/a_439_47# v3_four_channel_output_load_integration_0/v3_four_channel_shared_support_integration_0/v3_four_channel_bias_reference_distribution_0/v3_four_channel_phase_distribution_0/phase_180 v3_four_channel_output_load_integration_0/v3_four_channel_shared_support_integration_0/v3_four_channel_bias_reference_distribution_0/v3_four_channel_phase_distribution_0/v3_four_channel_output_collection_0/v3_four_channel_placement_0/v3_channel_selector_late_promotion_0/v3_selector_route_pilot_0/G0_MUX_NEG/a_76_199# VGND sky130_fd_pr__nfet_01v8 ad=0 pd=0 as=0.1995 ps=1.79 w=0.42 l=0.15
X205 v3_four_channel_output_load_integration_0/v3_four_channel_shared_support_integration_0/v3_four_channel_bias_reference_distribution_0/v3_four_channel_phase_distribution_0/v3_four_channel_output_collection_0/v3_four_channel_placement_0/v3_channel_selector_late_promotion_0/v3_selector_route_pilot_0/G0_MUX_NEG/a_535_374# v3_four_channel_output_load_integration_0/v3_four_channel_shared_support_integration_0/v3_four_channel_bias_reference_distribution_0/v3_four_channel_phase_distribution_0/phase_270 v3_four_channel_output_load_integration_0/v3_four_channel_shared_support_integration_0/v3_four_channel_bias_reference_distribution_0/v3_four_channel_phase_distribution_0/v3_four_channel_output_collection_0/v3_four_channel_placement_0/v3_channel_selector_late_promotion_0/v3_selector_route_pilot_0/G0_MUX_NEG/a_76_199# VDPWR sky130_fd_pr__pfet_01v8_hvt ad=0 pd=0 as=0 ps=0 w=0.42 l=0.15
X206 v3_four_channel_output_load_integration_0/v3_four_channel_shared_support_integration_0/v3_four_channel_bias_reference_distribution_0/v3_four_channel_phase_distribution_0/v3_four_channel_output_collection_0/v3_four_channel_placement_0/v3_channel_selector_late_promotion_0/v3_selector_route_pilot_0/G0_MUX_NEG/a_76_199# v3_four_channel_output_load_integration_0/v3_four_channel_shared_support_integration_0/v3_four_channel_bias_reference_distribution_0/v3_four_channel_phase_distribution_0/phase_270 v3_four_channel_output_load_integration_0/v3_four_channel_shared_support_integration_0/v3_four_channel_bias_reference_distribution_0/v3_four_channel_phase_distribution_0/v3_four_channel_output_collection_0/v3_four_channel_placement_0/v3_channel_selector_late_promotion_0/v3_selector_route_pilot_0/G0_MUX_NEG/a_218_47# VGND sky130_fd_pr__nfet_01v8 ad=0 pd=0 as=0.1386 ps=1.5 w=0.42 l=0.15
X207 v3_four_channel_output_load_integration_0/v3_four_channel_shared_support_integration_0/v3_four_channel_bias_reference_distribution_0/v3_four_channel_phase_distribution_0/v3_four_channel_output_collection_0/v3_four_channel_placement_0/v3_channel_selector_late_promotion_0/v3_selector_route_pilot_0/G0_MUX_NEG/a_218_47# v3_four_channel_output_load_integration_0/v3_four_channel_shared_support_integration_0/v3_four_channel_bias_reference_distribution_0/v3_four_channel_phase_distribution_0/v3_four_channel_output_collection_0/v3_four_channel_placement_0/v3_channel_selector_late_promotion_0/group0_bit0 VGND VGND sky130_fd_pr__nfet_01v8 ad=0 pd=0 as=0 ps=0 w=0.42 l=0.15
X208 VDPWR v3_four_channel_output_load_integration_0/v3_four_channel_shared_support_integration_0/v3_four_channel_bias_reference_distribution_0/v3_four_channel_phase_distribution_0/v3_four_channel_output_collection_0/v3_four_channel_placement_0/v3_channel_selector_late_promotion_0/v3_selector_route_pilot_0/G0_MUX_NEG/a_76_199# v3_four_channel_output_load_integration_0/v3_four_channel_shared_support_integration_0/v3_four_channel_bias_reference_distribution_0/v3_four_channel_phase_distribution_0/v3_four_channel_output_collection_0/v3_four_channel_placement_0/v3_channel_selector_late_promotion_0/v3_selector_route_pilot_0/G0_MUX_NEG/X VDPWR sky130_fd_pr__pfet_01v8_hvt ad=0 pd=0 as=0.26 ps=2.52 w=1 l=0.15
X209 VGND v3_four_channel_output_load_integration_0/v3_four_channel_shared_support_integration_0/v3_four_channel_bias_reference_distribution_0/v3_four_channel_phase_distribution_0/v3_four_channel_output_collection_0/v3_four_channel_placement_0/v3_channel_selector_late_promotion_0/v3_selector_route_pilot_0/G0_MUX_NEG/a_76_199# v3_four_channel_output_load_integration_0/v3_four_channel_shared_support_integration_0/v3_four_channel_bias_reference_distribution_0/v3_four_channel_phase_distribution_0/v3_four_channel_output_collection_0/v3_four_channel_placement_0/v3_channel_selector_late_promotion_0/v3_selector_route_pilot_0/G0_MUX_NEG/X VGND sky130_fd_pr__nfet_01v8 ad=0 pd=0 as=0.169 ps=1.82 w=0.65 l=0.15
X210 VDPWR v3_four_channel_output_load_integration_0/v3_four_channel_shared_support_integration_0/v3_four_channel_bias_reference_distribution_0/v3_four_channel_phase_distribution_0/v3_four_channel_output_collection_0/v3_four_channel_placement_0/v3_channel_selector_late_promotion_0/v3_selector_route_pilot_0/G2_MUX_AXIS/a_505_21# v3_four_channel_output_load_integration_0/v3_four_channel_shared_support_integration_0/v3_four_channel_bias_reference_distribution_0/v3_four_channel_phase_distribution_0/v3_four_channel_output_collection_0/v3_four_channel_placement_0/v3_channel_selector_late_promotion_0/v3_selector_route_pilot_0/G2_MUX_AXIS/a_535_374# VDPWR sky130_fd_pr__pfet_01v8_hvt ad=0 pd=0 as=0.0882 ps=1.26 w=0.42 l=0.15
X211 v3_four_channel_output_load_integration_0/v3_four_channel_shared_support_integration_0/v3_four_channel_bias_reference_distribution_0/v3_four_channel_phase_distribution_0/v3_four_channel_output_collection_0/v3_four_channel_placement_0/v3_channel_selector_late_promotion_0/v3_selector_route_pilot_0/G2_MUX_AXIS/a_505_21# v3_four_channel_output_load_integration_0/v3_four_channel_shared_support_integration_0/v3_four_channel_bias_reference_distribution_0/v3_four_channel_phase_distribution_0/v3_four_channel_output_collection_0/v3_four_channel_placement_0/v3_channel_selector_late_promotion_0/group2_bit1 VDPWR VDPWR sky130_fd_pr__pfet_01v8_hvt ad=0.1176 pd=1.4 as=0 ps=0 w=0.42 l=0.15
X212 v3_four_channel_output_load_integration_0/v3_four_channel_shared_support_integration_0/v3_four_channel_bias_reference_distribution_0/v3_four_channel_phase_distribution_0/v3_four_channel_output_collection_0/v3_four_channel_placement_0/v3_channel_selector_late_promotion_0/v3_selector_route_pilot_0/G2_MUX_AXIS/a_218_374# v3_four_channel_output_load_integration_0/v3_four_channel_shared_support_integration_0/v3_four_channel_bias_reference_distribution_0/v3_four_channel_phase_distribution_0/v3_four_channel_output_collection_0/v3_four_channel_placement_0/v3_channel_selector_late_promotion_0/group2_bit1 VDPWR VDPWR sky130_fd_pr__pfet_01v8_hvt ad=0.1533 pd=1.57 as=0 ps=0 w=0.42 l=0.15
X213 VGND v3_four_channel_output_load_integration_0/v3_four_channel_shared_support_integration_0/v3_four_channel_bias_reference_distribution_0/v3_four_channel_phase_distribution_0/v3_four_channel_output_collection_0/v3_four_channel_placement_0/v3_channel_selector_late_promotion_0/v3_selector_route_pilot_0/G2_MUX_AXIS/a_505_21# v3_four_channel_output_load_integration_0/v3_four_channel_shared_support_integration_0/v3_four_channel_bias_reference_distribution_0/v3_four_channel_phase_distribution_0/v3_four_channel_output_collection_0/v3_four_channel_placement_0/v3_channel_selector_late_promotion_0/v3_selector_route_pilot_0/G2_MUX_AXIS/a_439_47# VGND sky130_fd_pr__nfet_01v8 ad=0 pd=0 as=0.1386 ps=1.5 w=0.42 l=0.15
X214 v3_four_channel_output_load_integration_0/v3_four_channel_shared_support_integration_0/v3_four_channel_bias_reference_distribution_0/v3_four_channel_phase_distribution_0/v3_four_channel_output_collection_0/v3_four_channel_placement_0/v3_channel_selector_late_promotion_0/v3_selector_route_pilot_0/G2_MUX_AXIS/a_76_199# v3_four_channel_output_load_integration_0/v3_four_channel_shared_support_integration_0/v3_four_channel_bias_reference_distribution_0/v3_four_channel_phase_distribution_0/v3_four_channel_output_collection_0/v3_four_channel_placement_0/v3_channel_selector_late_promotion_0/v3_selector_route_pilot_0/G2_MUX_POS/X v3_four_channel_output_load_integration_0/v3_four_channel_shared_support_integration_0/v3_four_channel_bias_reference_distribution_0/v3_four_channel_phase_distribution_0/v3_four_channel_output_collection_0/v3_four_channel_placement_0/v3_channel_selector_late_promotion_0/v3_selector_route_pilot_0/G2_MUX_AXIS/a_218_374# VDPWR sky130_fd_pr__pfet_01v8_hvt ad=0.3864 pd=2.68 as=0 ps=0 w=0.42 l=0.15
X215 v3_four_channel_output_load_integration_0/v3_four_channel_shared_support_integration_0/v3_four_channel_bias_reference_distribution_0/v3_four_channel_phase_distribution_0/v3_four_channel_output_collection_0/v3_four_channel_placement_0/v3_channel_selector_late_promotion_0/v3_selector_route_pilot_0/G2_MUX_AXIS/a_505_21# v3_four_channel_output_load_integration_0/v3_four_channel_shared_support_integration_0/v3_four_channel_bias_reference_distribution_0/v3_four_channel_phase_distribution_0/v3_four_channel_output_collection_0/v3_four_channel_placement_0/v3_channel_selector_late_promotion_0/group2_bit1 VGND VGND sky130_fd_pr__nfet_01v8 ad=0.1092 pd=1.36 as=0 ps=0 w=0.42 l=0.15
X216 v3_four_channel_output_load_integration_0/v3_four_channel_shared_support_integration_0/v3_four_channel_bias_reference_distribution_0/v3_four_channel_phase_distribution_0/v3_four_channel_output_collection_0/v3_four_channel_placement_0/v3_channel_selector_late_promotion_0/v3_selector_route_pilot_0/G2_MUX_AXIS/a_439_47# v3_four_channel_output_load_integration_0/v3_four_channel_shared_support_integration_0/v3_four_channel_bias_reference_distribution_0/v3_four_channel_phase_distribution_0/v3_four_channel_output_collection_0/v3_four_channel_placement_0/v3_channel_selector_late_promotion_0/v3_selector_route_pilot_0/G2_MUX_POS/X v3_four_channel_output_load_integration_0/v3_four_channel_shared_support_integration_0/v3_four_channel_bias_reference_distribution_0/v3_four_channel_phase_distribution_0/v3_four_channel_output_collection_0/v3_four_channel_placement_0/v3_channel_selector_late_promotion_0/v3_selector_route_pilot_0/G2_MUX_AXIS/a_76_199# VGND sky130_fd_pr__nfet_01v8 ad=0 pd=0 as=0.1995 ps=1.79 w=0.42 l=0.15
X217 v3_four_channel_output_load_integration_0/v3_four_channel_shared_support_integration_0/v3_four_channel_bias_reference_distribution_0/v3_four_channel_phase_distribution_0/v3_four_channel_output_collection_0/v3_four_channel_placement_0/v3_channel_selector_late_promotion_0/v3_selector_route_pilot_0/G2_MUX_AXIS/a_535_374# v3_four_channel_output_load_integration_0/v3_four_channel_shared_support_integration_0/v3_four_channel_bias_reference_distribution_0/v3_four_channel_phase_distribution_0/v3_four_channel_output_collection_0/v3_four_channel_placement_0/v3_channel_selector_late_promotion_0/v3_selector_route_pilot_0/G2_MUX_NEG/X v3_four_channel_output_load_integration_0/v3_four_channel_shared_support_integration_0/v3_four_channel_bias_reference_distribution_0/v3_four_channel_phase_distribution_0/v3_four_channel_output_collection_0/v3_four_channel_placement_0/v3_channel_selector_late_promotion_0/v3_selector_route_pilot_0/G2_MUX_AXIS/a_76_199# VDPWR sky130_fd_pr__pfet_01v8_hvt ad=0 pd=0 as=0 ps=0 w=0.42 l=0.15
X218 v3_four_channel_output_load_integration_0/v3_four_channel_shared_support_integration_0/v3_four_channel_bias_reference_distribution_0/v3_four_channel_phase_distribution_0/v3_four_channel_output_collection_0/v3_four_channel_placement_0/v3_channel_selector_late_promotion_0/v3_selector_route_pilot_0/G2_MUX_AXIS/a_76_199# v3_four_channel_output_load_integration_0/v3_four_channel_shared_support_integration_0/v3_four_channel_bias_reference_distribution_0/v3_four_channel_phase_distribution_0/v3_four_channel_output_collection_0/v3_four_channel_placement_0/v3_channel_selector_late_promotion_0/v3_selector_route_pilot_0/G2_MUX_NEG/X v3_four_channel_output_load_integration_0/v3_four_channel_shared_support_integration_0/v3_four_channel_bias_reference_distribution_0/v3_four_channel_phase_distribution_0/v3_four_channel_output_collection_0/v3_four_channel_placement_0/v3_channel_selector_late_promotion_0/v3_selector_route_pilot_0/G2_MUX_AXIS/a_218_47# VGND sky130_fd_pr__nfet_01v8 ad=0 pd=0 as=0.1386 ps=1.5 w=0.42 l=0.15
X219 v3_four_channel_output_load_integration_0/v3_four_channel_shared_support_integration_0/v3_four_channel_bias_reference_distribution_0/v3_four_channel_phase_distribution_0/v3_four_channel_output_collection_0/v3_four_channel_placement_0/v3_channel_selector_late_promotion_0/v3_selector_route_pilot_0/G2_MUX_AXIS/a_218_47# v3_four_channel_output_load_integration_0/v3_four_channel_shared_support_integration_0/v3_four_channel_bias_reference_distribution_0/v3_four_channel_phase_distribution_0/v3_four_channel_output_collection_0/v3_four_channel_placement_0/v3_channel_selector_late_promotion_0/group2_bit1 VGND VGND sky130_fd_pr__nfet_01v8 ad=0 pd=0 as=0 ps=0 w=0.42 l=0.15
X220 VDPWR v3_four_channel_output_load_integration_0/v3_four_channel_shared_support_integration_0/v3_four_channel_bias_reference_distribution_0/v3_four_channel_phase_distribution_0/v3_four_channel_output_collection_0/v3_four_channel_placement_0/v3_channel_selector_late_promotion_0/v3_selector_route_pilot_0/G2_MUX_AXIS/a_76_199# v3_four_channel_output_load_integration_0/v3_four_channel_shared_support_integration_0/v3_four_channel_bias_reference_distribution_0/v3_four_channel_phase_distribution_0/v3_four_channel_output_collection_0/v3_four_channel_placement_0/v3_channel_selector_late_promotion_0/v3_selector_route_pilot_0/G2_MUX_AXIS/X VDPWR sky130_fd_pr__pfet_01v8_hvt ad=0 pd=0 as=0.26 ps=2.52 w=1 l=0.15
X221 VGND v3_four_channel_output_load_integration_0/v3_four_channel_shared_support_integration_0/v3_four_channel_bias_reference_distribution_0/v3_four_channel_phase_distribution_0/v3_four_channel_output_collection_0/v3_four_channel_placement_0/v3_channel_selector_late_promotion_0/v3_selector_route_pilot_0/G2_MUX_AXIS/a_76_199# v3_four_channel_output_load_integration_0/v3_four_channel_shared_support_integration_0/v3_four_channel_bias_reference_distribution_0/v3_four_channel_phase_distribution_0/v3_four_channel_output_collection_0/v3_four_channel_placement_0/v3_channel_selector_late_promotion_0/v3_selector_route_pilot_0/G2_MUX_AXIS/X VGND sky130_fd_pr__nfet_01v8 ad=0 pd=0 as=0.169 ps=1.82 w=0.65 l=0.15
X222 VDPWR v3_four_channel_output_load_integration_0/v3_four_channel_shared_support_integration_0/v3_four_channel_bias_reference_distribution_0/v3_four_channel_phase_distribution_0/v3_four_channel_output_collection_0/v3_four_channel_placement_0/v3_channel_selector_late_promotion_0/v3_selector_route_pilot_0/G3_MUX_POS/a_505_21# v3_four_channel_output_load_integration_0/v3_four_channel_shared_support_integration_0/v3_four_channel_bias_reference_distribution_0/v3_four_channel_phase_distribution_0/v3_four_channel_output_collection_0/v3_four_channel_placement_0/v3_channel_selector_late_promotion_0/v3_selector_route_pilot_0/G3_MUX_POS/a_535_374# VDPWR sky130_fd_pr__pfet_01v8_hvt ad=0 pd=0 as=0.0882 ps=1.26 w=0.42 l=0.15
X223 v3_four_channel_output_load_integration_0/v3_four_channel_shared_support_integration_0/v3_four_channel_bias_reference_distribution_0/v3_four_channel_phase_distribution_0/v3_four_channel_output_collection_0/v3_four_channel_placement_0/v3_channel_selector_late_promotion_0/v3_selector_route_pilot_0/G3_MUX_POS/a_505_21# v3_four_channel_output_load_integration_0/v3_four_channel_shared_support_integration_0/v3_four_channel_bias_reference_distribution_0/v3_four_channel_phase_distribution_0/v3_four_channel_output_collection_0/v3_four_channel_placement_0/v3_channel_selector_late_promotion_0/group3_bit0 VDPWR VDPWR sky130_fd_pr__pfet_01v8_hvt ad=0.1176 pd=1.4 as=0 ps=0 w=0.42 l=0.15
X224 v3_four_channel_output_load_integration_0/v3_four_channel_shared_support_integration_0/v3_four_channel_bias_reference_distribution_0/v3_four_channel_phase_distribution_0/v3_four_channel_output_collection_0/v3_four_channel_placement_0/v3_channel_selector_late_promotion_0/v3_selector_route_pilot_0/G3_MUX_POS/a_218_374# v3_four_channel_output_load_integration_0/v3_four_channel_shared_support_integration_0/v3_four_channel_bias_reference_distribution_0/v3_four_channel_phase_distribution_0/v3_four_channel_output_collection_0/v3_four_channel_placement_0/v3_channel_selector_late_promotion_0/group3_bit0 VDPWR VDPWR sky130_fd_pr__pfet_01v8_hvt ad=0.1533 pd=1.57 as=0 ps=0 w=0.42 l=0.15
X225 VGND v3_four_channel_output_load_integration_0/v3_four_channel_shared_support_integration_0/v3_four_channel_bias_reference_distribution_0/v3_four_channel_phase_distribution_0/v3_four_channel_output_collection_0/v3_four_channel_placement_0/v3_channel_selector_late_promotion_0/v3_selector_route_pilot_0/G3_MUX_POS/a_505_21# v3_four_channel_output_load_integration_0/v3_four_channel_shared_support_integration_0/v3_four_channel_bias_reference_distribution_0/v3_four_channel_phase_distribution_0/v3_four_channel_output_collection_0/v3_four_channel_placement_0/v3_channel_selector_late_promotion_0/v3_selector_route_pilot_0/G3_MUX_POS/a_439_47# VGND sky130_fd_pr__nfet_01v8 ad=0 pd=0 as=0.1386 ps=1.5 w=0.42 l=0.15
X226 v3_four_channel_output_load_integration_0/v3_four_channel_shared_support_integration_0/v3_four_channel_bias_reference_distribution_0/v3_four_channel_phase_distribution_0/v3_four_channel_output_collection_0/v3_four_channel_placement_0/v3_channel_selector_late_promotion_0/v3_selector_route_pilot_0/G3_MUX_POS/a_76_199# v3_four_channel_output_load_integration_0/v3_four_channel_shared_support_integration_0/v3_four_channel_bias_reference_distribution_0/v3_four_channel_phase_distribution_0/phase_0 v3_four_channel_output_load_integration_0/v3_four_channel_shared_support_integration_0/v3_four_channel_bias_reference_distribution_0/v3_four_channel_phase_distribution_0/v3_four_channel_output_collection_0/v3_four_channel_placement_0/v3_channel_selector_late_promotion_0/v3_selector_route_pilot_0/G3_MUX_POS/a_218_374# VDPWR sky130_fd_pr__pfet_01v8_hvt ad=0.3864 pd=2.68 as=0 ps=0 w=0.42 l=0.15
X227 v3_four_channel_output_load_integration_0/v3_four_channel_shared_support_integration_0/v3_four_channel_bias_reference_distribution_0/v3_four_channel_phase_distribution_0/v3_four_channel_output_collection_0/v3_four_channel_placement_0/v3_channel_selector_late_promotion_0/v3_selector_route_pilot_0/G3_MUX_POS/a_505_21# v3_four_channel_output_load_integration_0/v3_four_channel_shared_support_integration_0/v3_four_channel_bias_reference_distribution_0/v3_four_channel_phase_distribution_0/v3_four_channel_output_collection_0/v3_four_channel_placement_0/v3_channel_selector_late_promotion_0/group3_bit0 VGND VGND sky130_fd_pr__nfet_01v8 ad=0.1092 pd=1.36 as=0 ps=0 w=0.42 l=0.15
X228 v3_four_channel_output_load_integration_0/v3_four_channel_shared_support_integration_0/v3_four_channel_bias_reference_distribution_0/v3_four_channel_phase_distribution_0/v3_four_channel_output_collection_0/v3_four_channel_placement_0/v3_channel_selector_late_promotion_0/v3_selector_route_pilot_0/G3_MUX_POS/a_439_47# v3_four_channel_output_load_integration_0/v3_four_channel_shared_support_integration_0/v3_four_channel_bias_reference_distribution_0/v3_four_channel_phase_distribution_0/phase_0 v3_four_channel_output_load_integration_0/v3_four_channel_shared_support_integration_0/v3_four_channel_bias_reference_distribution_0/v3_four_channel_phase_distribution_0/v3_four_channel_output_collection_0/v3_four_channel_placement_0/v3_channel_selector_late_promotion_0/v3_selector_route_pilot_0/G3_MUX_POS/a_76_199# VGND sky130_fd_pr__nfet_01v8 ad=0 pd=0 as=0.1995 ps=1.79 w=0.42 l=0.15
X229 v3_four_channel_output_load_integration_0/v3_four_channel_shared_support_integration_0/v3_four_channel_bias_reference_distribution_0/v3_four_channel_phase_distribution_0/v3_four_channel_output_collection_0/v3_four_channel_placement_0/v3_channel_selector_late_promotion_0/v3_selector_route_pilot_0/G3_MUX_POS/a_535_374# v3_four_channel_output_load_integration_0/v3_four_channel_shared_support_integration_0/v3_four_channel_bias_reference_distribution_0/v3_four_channel_phase_distribution_0/phase_90 v3_four_channel_output_load_integration_0/v3_four_channel_shared_support_integration_0/v3_four_channel_bias_reference_distribution_0/v3_four_channel_phase_distribution_0/v3_four_channel_output_collection_0/v3_four_channel_placement_0/v3_channel_selector_late_promotion_0/v3_selector_route_pilot_0/G3_MUX_POS/a_76_199# VDPWR sky130_fd_pr__pfet_01v8_hvt ad=0 pd=0 as=0 ps=0 w=0.42 l=0.15
X230 v3_four_channel_output_load_integration_0/v3_four_channel_shared_support_integration_0/v3_four_channel_bias_reference_distribution_0/v3_four_channel_phase_distribution_0/v3_four_channel_output_collection_0/v3_four_channel_placement_0/v3_channel_selector_late_promotion_0/v3_selector_route_pilot_0/G3_MUX_POS/a_76_199# v3_four_channel_output_load_integration_0/v3_four_channel_shared_support_integration_0/v3_four_channel_bias_reference_distribution_0/v3_four_channel_phase_distribution_0/phase_90 v3_four_channel_output_load_integration_0/v3_four_channel_shared_support_integration_0/v3_four_channel_bias_reference_distribution_0/v3_four_channel_phase_distribution_0/v3_four_channel_output_collection_0/v3_four_channel_placement_0/v3_channel_selector_late_promotion_0/v3_selector_route_pilot_0/G3_MUX_POS/a_218_47# VGND sky130_fd_pr__nfet_01v8 ad=0 pd=0 as=0.1386 ps=1.5 w=0.42 l=0.15
X231 v3_four_channel_output_load_integration_0/v3_four_channel_shared_support_integration_0/v3_four_channel_bias_reference_distribution_0/v3_four_channel_phase_distribution_0/v3_four_channel_output_collection_0/v3_four_channel_placement_0/v3_channel_selector_late_promotion_0/v3_selector_route_pilot_0/G3_MUX_POS/a_218_47# v3_four_channel_output_load_integration_0/v3_four_channel_shared_support_integration_0/v3_four_channel_bias_reference_distribution_0/v3_four_channel_phase_distribution_0/v3_four_channel_output_collection_0/v3_four_channel_placement_0/v3_channel_selector_late_promotion_0/group3_bit0 VGND VGND sky130_fd_pr__nfet_01v8 ad=0 pd=0 as=0 ps=0 w=0.42 l=0.15
X232 VDPWR v3_four_channel_output_load_integration_0/v3_four_channel_shared_support_integration_0/v3_four_channel_bias_reference_distribution_0/v3_four_channel_phase_distribution_0/v3_four_channel_output_collection_0/v3_four_channel_placement_0/v3_channel_selector_late_promotion_0/v3_selector_route_pilot_0/G3_MUX_POS/a_76_199# v3_four_channel_output_load_integration_0/v3_four_channel_shared_support_integration_0/v3_four_channel_bias_reference_distribution_0/v3_four_channel_phase_distribution_0/v3_four_channel_output_collection_0/v3_four_channel_placement_0/v3_channel_selector_late_promotion_0/v3_selector_route_pilot_0/G3_MUX_POS/X VDPWR sky130_fd_pr__pfet_01v8_hvt ad=0 pd=0 as=0.26 ps=2.52 w=1 l=0.15
X233 VGND v3_four_channel_output_load_integration_0/v3_four_channel_shared_support_integration_0/v3_four_channel_bias_reference_distribution_0/v3_four_channel_phase_distribution_0/v3_four_channel_output_collection_0/v3_four_channel_placement_0/v3_channel_selector_late_promotion_0/v3_selector_route_pilot_0/G3_MUX_POS/a_76_199# v3_four_channel_output_load_integration_0/v3_four_channel_shared_support_integration_0/v3_four_channel_bias_reference_distribution_0/v3_four_channel_phase_distribution_0/v3_four_channel_output_collection_0/v3_four_channel_placement_0/v3_channel_selector_late_promotion_0/v3_selector_route_pilot_0/G3_MUX_POS/X VGND sky130_fd_pr__nfet_01v8 ad=0 pd=0 as=0.169 ps=1.82 w=0.65 l=0.15
X234 VDPWR v3_four_channel_output_load_integration_0/v3_four_channel_shared_support_integration_0/v3_four_channel_bias_reference_distribution_0/v3_four_channel_phase_distribution_0/v3_four_channel_output_collection_0/v3_four_channel_placement_0/v3_channel_selector_late_promotion_0/v3_selector_route_pilot_0/G3_MUX_NEG/a_505_21# v3_four_channel_output_load_integration_0/v3_four_channel_shared_support_integration_0/v3_four_channel_bias_reference_distribution_0/v3_four_channel_phase_distribution_0/v3_four_channel_output_collection_0/v3_four_channel_placement_0/v3_channel_selector_late_promotion_0/v3_selector_route_pilot_0/G3_MUX_NEG/a_535_374# VDPWR sky130_fd_pr__pfet_01v8_hvt ad=0 pd=0 as=0.0882 ps=1.26 w=0.42 l=0.15
X235 v3_four_channel_output_load_integration_0/v3_four_channel_shared_support_integration_0/v3_four_channel_bias_reference_distribution_0/v3_four_channel_phase_distribution_0/v3_four_channel_output_collection_0/v3_four_channel_placement_0/v3_channel_selector_late_promotion_0/v3_selector_route_pilot_0/G3_MUX_NEG/a_505_21# v3_four_channel_output_load_integration_0/v3_four_channel_shared_support_integration_0/v3_four_channel_bias_reference_distribution_0/v3_four_channel_phase_distribution_0/v3_four_channel_output_collection_0/v3_four_channel_placement_0/v3_channel_selector_late_promotion_0/group3_bit0 VDPWR VDPWR sky130_fd_pr__pfet_01v8_hvt ad=0.1176 pd=1.4 as=0 ps=0 w=0.42 l=0.15
X236 v3_four_channel_output_load_integration_0/v3_four_channel_shared_support_integration_0/v3_four_channel_bias_reference_distribution_0/v3_four_channel_phase_distribution_0/v3_four_channel_output_collection_0/v3_four_channel_placement_0/v3_channel_selector_late_promotion_0/v3_selector_route_pilot_0/G3_MUX_NEG/a_218_374# v3_four_channel_output_load_integration_0/v3_four_channel_shared_support_integration_0/v3_four_channel_bias_reference_distribution_0/v3_four_channel_phase_distribution_0/v3_four_channel_output_collection_0/v3_four_channel_placement_0/v3_channel_selector_late_promotion_0/group3_bit0 VDPWR VDPWR sky130_fd_pr__pfet_01v8_hvt ad=0.1533 pd=1.57 as=0 ps=0 w=0.42 l=0.15
X237 VGND v3_four_channel_output_load_integration_0/v3_four_channel_shared_support_integration_0/v3_four_channel_bias_reference_distribution_0/v3_four_channel_phase_distribution_0/v3_four_channel_output_collection_0/v3_four_channel_placement_0/v3_channel_selector_late_promotion_0/v3_selector_route_pilot_0/G3_MUX_NEG/a_505_21# v3_four_channel_output_load_integration_0/v3_four_channel_shared_support_integration_0/v3_four_channel_bias_reference_distribution_0/v3_four_channel_phase_distribution_0/v3_four_channel_output_collection_0/v3_four_channel_placement_0/v3_channel_selector_late_promotion_0/v3_selector_route_pilot_0/G3_MUX_NEG/a_439_47# VGND sky130_fd_pr__nfet_01v8 ad=0 pd=0 as=0.1386 ps=1.5 w=0.42 l=0.15
X238 v3_four_channel_output_load_integration_0/v3_four_channel_shared_support_integration_0/v3_four_channel_bias_reference_distribution_0/v3_four_channel_phase_distribution_0/v3_four_channel_output_collection_0/v3_four_channel_placement_0/v3_channel_selector_late_promotion_0/v3_selector_route_pilot_0/G3_MUX_NEG/a_76_199# v3_four_channel_output_load_integration_0/v3_four_channel_shared_support_integration_0/v3_four_channel_bias_reference_distribution_0/v3_four_channel_phase_distribution_0/phase_180 v3_four_channel_output_load_integration_0/v3_four_channel_shared_support_integration_0/v3_four_channel_bias_reference_distribution_0/v3_four_channel_phase_distribution_0/v3_four_channel_output_collection_0/v3_four_channel_placement_0/v3_channel_selector_late_promotion_0/v3_selector_route_pilot_0/G3_MUX_NEG/a_218_374# VDPWR sky130_fd_pr__pfet_01v8_hvt ad=0.3864 pd=2.68 as=0 ps=0 w=0.42 l=0.15
X239 v3_four_channel_output_load_integration_0/v3_four_channel_shared_support_integration_0/v3_four_channel_bias_reference_distribution_0/v3_four_channel_phase_distribution_0/v3_four_channel_output_collection_0/v3_four_channel_placement_0/v3_channel_selector_late_promotion_0/v3_selector_route_pilot_0/G3_MUX_NEG/a_505_21# v3_four_channel_output_load_integration_0/v3_four_channel_shared_support_integration_0/v3_four_channel_bias_reference_distribution_0/v3_four_channel_phase_distribution_0/v3_four_channel_output_collection_0/v3_four_channel_placement_0/v3_channel_selector_late_promotion_0/group3_bit0 VGND VGND sky130_fd_pr__nfet_01v8 ad=0.1092 pd=1.36 as=0 ps=0 w=0.42 l=0.15
X240 v3_four_channel_output_load_integration_0/v3_four_channel_shared_support_integration_0/v3_four_channel_bias_reference_distribution_0/v3_four_channel_phase_distribution_0/v3_four_channel_output_collection_0/v3_four_channel_placement_0/v3_channel_selector_late_promotion_0/v3_selector_route_pilot_0/G3_MUX_NEG/a_439_47# v3_four_channel_output_load_integration_0/v3_four_channel_shared_support_integration_0/v3_four_channel_bias_reference_distribution_0/v3_four_channel_phase_distribution_0/phase_180 v3_four_channel_output_load_integration_0/v3_four_channel_shared_support_integration_0/v3_four_channel_bias_reference_distribution_0/v3_four_channel_phase_distribution_0/v3_four_channel_output_collection_0/v3_four_channel_placement_0/v3_channel_selector_late_promotion_0/v3_selector_route_pilot_0/G3_MUX_NEG/a_76_199# VGND sky130_fd_pr__nfet_01v8 ad=0 pd=0 as=0.1995 ps=1.79 w=0.42 l=0.15
X241 v3_four_channel_output_load_integration_0/v3_four_channel_shared_support_integration_0/v3_four_channel_bias_reference_distribution_0/v3_four_channel_phase_distribution_0/v3_four_channel_output_collection_0/v3_four_channel_placement_0/v3_channel_selector_late_promotion_0/v3_selector_route_pilot_0/G3_MUX_NEG/a_535_374# v3_four_channel_output_load_integration_0/v3_four_channel_shared_support_integration_0/v3_four_channel_bias_reference_distribution_0/v3_four_channel_phase_distribution_0/phase_270 v3_four_channel_output_load_integration_0/v3_four_channel_shared_support_integration_0/v3_four_channel_bias_reference_distribution_0/v3_four_channel_phase_distribution_0/v3_four_channel_output_collection_0/v3_four_channel_placement_0/v3_channel_selector_late_promotion_0/v3_selector_route_pilot_0/G3_MUX_NEG/a_76_199# VDPWR sky130_fd_pr__pfet_01v8_hvt ad=0 pd=0 as=0 ps=0 w=0.42 l=0.15
X242 v3_four_channel_output_load_integration_0/v3_four_channel_shared_support_integration_0/v3_four_channel_bias_reference_distribution_0/v3_four_channel_phase_distribution_0/v3_four_channel_output_collection_0/v3_four_channel_placement_0/v3_channel_selector_late_promotion_0/v3_selector_route_pilot_0/G3_MUX_NEG/a_76_199# v3_four_channel_output_load_integration_0/v3_four_channel_shared_support_integration_0/v3_four_channel_bias_reference_distribution_0/v3_four_channel_phase_distribution_0/phase_270 v3_four_channel_output_load_integration_0/v3_four_channel_shared_support_integration_0/v3_four_channel_bias_reference_distribution_0/v3_four_channel_phase_distribution_0/v3_four_channel_output_collection_0/v3_four_channel_placement_0/v3_channel_selector_late_promotion_0/v3_selector_route_pilot_0/G3_MUX_NEG/a_218_47# VGND sky130_fd_pr__nfet_01v8 ad=0 pd=0 as=0.1386 ps=1.5 w=0.42 l=0.15
X243 v3_four_channel_output_load_integration_0/v3_four_channel_shared_support_integration_0/v3_four_channel_bias_reference_distribution_0/v3_four_channel_phase_distribution_0/v3_four_channel_output_collection_0/v3_four_channel_placement_0/v3_channel_selector_late_promotion_0/v3_selector_route_pilot_0/G3_MUX_NEG/a_218_47# v3_four_channel_output_load_integration_0/v3_four_channel_shared_support_integration_0/v3_four_channel_bias_reference_distribution_0/v3_four_channel_phase_distribution_0/v3_four_channel_output_collection_0/v3_four_channel_placement_0/v3_channel_selector_late_promotion_0/group3_bit0 VGND VGND sky130_fd_pr__nfet_01v8 ad=0 pd=0 as=0 ps=0 w=0.42 l=0.15
X244 VDPWR v3_four_channel_output_load_integration_0/v3_four_channel_shared_support_integration_0/v3_four_channel_bias_reference_distribution_0/v3_four_channel_phase_distribution_0/v3_four_channel_output_collection_0/v3_four_channel_placement_0/v3_channel_selector_late_promotion_0/v3_selector_route_pilot_0/G3_MUX_NEG/a_76_199# v3_four_channel_output_load_integration_0/v3_four_channel_shared_support_integration_0/v3_four_channel_bias_reference_distribution_0/v3_four_channel_phase_distribution_0/v3_four_channel_output_collection_0/v3_four_channel_placement_0/v3_channel_selector_late_promotion_0/v3_selector_route_pilot_0/G3_MUX_NEG/X VDPWR sky130_fd_pr__pfet_01v8_hvt ad=0 pd=0 as=0.26 ps=2.52 w=1 l=0.15
X245 VGND v3_four_channel_output_load_integration_0/v3_four_channel_shared_support_integration_0/v3_four_channel_bias_reference_distribution_0/v3_four_channel_phase_distribution_0/v3_four_channel_output_collection_0/v3_four_channel_placement_0/v3_channel_selector_late_promotion_0/v3_selector_route_pilot_0/G3_MUX_NEG/a_76_199# v3_four_channel_output_load_integration_0/v3_four_channel_shared_support_integration_0/v3_four_channel_bias_reference_distribution_0/v3_four_channel_phase_distribution_0/v3_four_channel_output_collection_0/v3_four_channel_placement_0/v3_channel_selector_late_promotion_0/v3_selector_route_pilot_0/G3_MUX_NEG/X VGND sky130_fd_pr__nfet_01v8 ad=0 pd=0 as=0.169 ps=1.82 w=0.65 l=0.15
X246 VDPWR v3_four_channel_output_load_integration_0/v3_four_channel_shared_support_integration_0/v3_four_channel_bias_reference_distribution_0/v3_four_channel_phase_distribution_0/v3_four_channel_output_collection_0/v3_four_channel_placement_0/v3_channel_selector_late_promotion_0/v3_selector_route_pilot_0/G3_LO_P_AND/B v3_four_channel_output_load_integration_0/v3_four_channel_shared_support_integration_0/v3_four_channel_bias_reference_distribution_0/v3_four_channel_phase_distribution_0/v3_four_channel_output_collection_0/v3_four_channel_placement_0/v3_channel_selector_late_promotion_0/v3_selector_route_pilot_0/G0_LO_P_AND/a_59_75# VDPWR sky130_fd_pr__pfet_01v8_hvt ad=0 pd=0 as=0.1134 ps=1.38 w=0.42 l=0.15
X247 v3_four_channel_output_load_integration_0/v3_four_channel_shared_support_integration_0/v3_four_channel_bias_reference_distribution_0/v3_four_channel_phase_distribution_0/v3_four_channel_output_collection_0/v3_four_channel_placement_0/v3_channel_selector_late_promotion_0/v3_selector_route_pilot_0/group0_lo_p v3_four_channel_output_load_integration_0/v3_four_channel_shared_support_integration_0/v3_four_channel_bias_reference_distribution_0/v3_four_channel_phase_distribution_0/v3_four_channel_output_collection_0/v3_four_channel_placement_0/v3_channel_selector_late_promotion_0/v3_selector_route_pilot_0/G0_LO_P_AND/a_59_75# VDPWR VDPWR sky130_fd_pr__pfet_01v8_hvt ad=0.475 pd=2.95 as=0 ps=0 w=1 l=0.15
X248 VGND v3_four_channel_output_load_integration_0/v3_four_channel_shared_support_integration_0/v3_four_channel_bias_reference_distribution_0/v3_four_channel_phase_distribution_0/v3_four_channel_output_collection_0/v3_four_channel_placement_0/v3_channel_selector_late_promotion_0/v3_selector_route_pilot_0/G3_LO_P_AND/B v3_four_channel_output_load_integration_0/v3_four_channel_shared_support_integration_0/v3_four_channel_bias_reference_distribution_0/v3_four_channel_phase_distribution_0/v3_four_channel_output_collection_0/v3_four_channel_placement_0/v3_channel_selector_late_promotion_0/v3_selector_route_pilot_0/G0_LO_P_AND/a_145_75# VGND sky130_fd_pr__nfet_01v8 ad=0 pd=0 as=0.1134 ps=1.38 w=0.42 l=0.15
X249 v3_four_channel_output_load_integration_0/v3_four_channel_shared_support_integration_0/v3_four_channel_bias_reference_distribution_0/v3_four_channel_phase_distribution_0/v3_four_channel_output_collection_0/v3_four_channel_placement_0/v3_channel_selector_late_promotion_0/v3_selector_route_pilot_0/G0_LO_P_AND/a_59_75# v3_four_channel_output_load_integration_0/v3_four_channel_shared_support_integration_0/v3_four_channel_bias_reference_distribution_0/v3_four_channel_phase_distribution_0/v3_four_channel_output_collection_0/v3_four_channel_placement_0/v3_channel_selector_late_promotion_0/v3_selector_route_pilot_0/G0_MUX_AXIS/X VDPWR VDPWR sky130_fd_pr__pfet_01v8_hvt ad=0 pd=0 as=0 ps=0 w=0.42 l=0.15
X250 v3_four_channel_output_load_integration_0/v3_four_channel_shared_support_integration_0/v3_four_channel_bias_reference_distribution_0/v3_four_channel_phase_distribution_0/v3_four_channel_output_collection_0/v3_four_channel_placement_0/v3_channel_selector_late_promotion_0/v3_selector_route_pilot_0/group0_lo_p v3_four_channel_output_load_integration_0/v3_four_channel_shared_support_integration_0/v3_four_channel_bias_reference_distribution_0/v3_four_channel_phase_distribution_0/v3_four_channel_output_collection_0/v3_four_channel_placement_0/v3_channel_selector_late_promotion_0/v3_selector_route_pilot_0/G0_LO_P_AND/a_59_75# VGND VGND sky130_fd_pr__nfet_01v8 ad=0.182 pd=1.86 as=0 ps=0 w=0.65 l=0.15
X251 v3_four_channel_output_load_integration_0/v3_four_channel_shared_support_integration_0/v3_four_channel_bias_reference_distribution_0/v3_four_channel_phase_distribution_0/v3_four_channel_output_collection_0/v3_four_channel_placement_0/v3_channel_selector_late_promotion_0/v3_selector_route_pilot_0/G0_LO_P_AND/a_145_75# v3_four_channel_output_load_integration_0/v3_four_channel_shared_support_integration_0/v3_four_channel_bias_reference_distribution_0/v3_four_channel_phase_distribution_0/v3_four_channel_output_collection_0/v3_four_channel_placement_0/v3_channel_selector_late_promotion_0/v3_selector_route_pilot_0/G0_MUX_AXIS/X v3_four_channel_output_load_integration_0/v3_four_channel_shared_support_integration_0/v3_four_channel_bias_reference_distribution_0/v3_four_channel_phase_distribution_0/v3_four_channel_output_collection_0/v3_four_channel_placement_0/v3_channel_selector_late_promotion_0/v3_selector_route_pilot_0/G0_LO_P_AND/a_59_75# VGND sky130_fd_pr__nfet_01v8 ad=0 pd=0 as=0.1176 ps=1.4 w=0.42 l=0.15
X252 VDPWR v3_four_channel_output_load_integration_0/v3_four_channel_shared_support_integration_0/v3_four_channel_bias_reference_distribution_0/v3_four_channel_phase_distribution_0/v3_four_channel_output_collection_0/v3_four_channel_placement_0/v3_channel_selector_late_promotion_0/v3_selector_route_pilot_0/G3_LO_P_AND/B v3_four_channel_output_load_integration_0/v3_four_channel_shared_support_integration_0/v3_four_channel_bias_reference_distribution_0/v3_four_channel_phase_distribution_0/v3_four_channel_output_collection_0/v3_four_channel_placement_0/v3_channel_selector_late_promotion_0/v3_selector_route_pilot_0/G3_LO_N_ANDNOT/a_207_413# VDPWR sky130_fd_pr__pfet_01v8_hvt ad=0 pd=0 as=0.1218 ps=1.42 w=0.42 l=0.15
X253 v3_four_channel_output_load_integration_0/v3_four_channel_shared_support_integration_0/v3_four_channel_bias_reference_distribution_0/v3_four_channel_phase_distribution_0/v3_four_channel_output_collection_0/v3_four_channel_placement_0/v3_channel_selector_late_promotion_0/v3_selector_route_pilot_0/group3_lo_n v3_four_channel_output_load_integration_0/v3_four_channel_shared_support_integration_0/v3_four_channel_bias_reference_distribution_0/v3_four_channel_phase_distribution_0/v3_four_channel_output_collection_0/v3_four_channel_placement_0/v3_channel_selector_late_promotion_0/v3_selector_route_pilot_0/G3_LO_N_ANDNOT/a_207_413# VDPWR VDPWR sky130_fd_pr__pfet_01v8_hvt ad=0.26 pd=2.52 as=0 ps=0 w=1 l=0.15
X254 v3_four_channel_output_load_integration_0/v3_four_channel_shared_support_integration_0/v3_four_channel_bias_reference_distribution_0/v3_four_channel_phase_distribution_0/v3_four_channel_output_collection_0/v3_four_channel_placement_0/v3_channel_selector_late_promotion_0/v3_selector_route_pilot_0/G3_LO_N_ANDNOT/a_297_47# v3_four_channel_output_load_integration_0/v3_four_channel_shared_support_integration_0/v3_four_channel_bias_reference_distribution_0/v3_four_channel_phase_distribution_0/v3_four_channel_output_collection_0/v3_four_channel_placement_0/v3_channel_selector_late_promotion_0/v3_selector_route_pilot_0/G3_LO_N_ANDNOT/a_27_413# v3_four_channel_output_load_integration_0/v3_four_channel_shared_support_integration_0/v3_four_channel_bias_reference_distribution_0/v3_four_channel_phase_distribution_0/v3_four_channel_output_collection_0/v3_four_channel_placement_0/v3_channel_selector_late_promotion_0/v3_selector_route_pilot_0/G3_LO_N_ANDNOT/a_207_413# VGND sky130_fd_pr__nfet_01v8 ad=0.1008 pd=1.32 as=0.1092 ps=1.36 w=0.42 l=0.15
X255 v3_four_channel_output_load_integration_0/v3_four_channel_shared_support_integration_0/v3_four_channel_bias_reference_distribution_0/v3_four_channel_phase_distribution_0/v3_four_channel_output_collection_0/v3_four_channel_placement_0/v3_channel_selector_late_promotion_0/v3_selector_route_pilot_0/group3_lo_n v3_four_channel_output_load_integration_0/v3_four_channel_shared_support_integration_0/v3_four_channel_bias_reference_distribution_0/v3_four_channel_phase_distribution_0/v3_four_channel_output_collection_0/v3_four_channel_placement_0/v3_channel_selector_late_promotion_0/v3_selector_route_pilot_0/G3_LO_N_ANDNOT/a_207_413# VGND VGND sky130_fd_pr__nfet_01v8 ad=0.169 pd=1.82 as=0 ps=0 w=0.65 l=0.15
X256 v3_four_channel_output_load_integration_0/v3_four_channel_shared_support_integration_0/v3_four_channel_bias_reference_distribution_0/v3_four_channel_phase_distribution_0/v3_four_channel_output_collection_0/v3_four_channel_placement_0/v3_channel_selector_late_promotion_0/v3_selector_route_pilot_0/G3_LO_N_ANDNOT/a_207_413# v3_four_channel_output_load_integration_0/v3_four_channel_shared_support_integration_0/v3_four_channel_bias_reference_distribution_0/v3_four_channel_phase_distribution_0/v3_four_channel_output_collection_0/v3_four_channel_placement_0/v3_channel_selector_late_promotion_0/v3_selector_route_pilot_0/G3_LO_N_ANDNOT/a_27_413# VDPWR VDPWR sky130_fd_pr__pfet_01v8_hvt ad=0 pd=0 as=0 ps=0 w=0.42 l=0.15
X257 VDPWR v3_four_channel_output_load_integration_0/v3_four_channel_shared_support_integration_0/v3_four_channel_bias_reference_distribution_0/v3_four_channel_phase_distribution_0/v3_four_channel_output_collection_0/v3_four_channel_placement_0/v3_channel_selector_late_promotion_0/v3_selector_route_pilot_0/G3_MUX_AXIS/X v3_four_channel_output_load_integration_0/v3_four_channel_shared_support_integration_0/v3_four_channel_bias_reference_distribution_0/v3_four_channel_phase_distribution_0/v3_four_channel_output_collection_0/v3_four_channel_placement_0/v3_channel_selector_late_promotion_0/v3_selector_route_pilot_0/G3_LO_N_ANDNOT/a_27_413# VDPWR sky130_fd_pr__pfet_01v8_hvt ad=0 pd=0 as=0.1092 ps=1.36 w=0.42 l=0.15
X258 VGND v3_four_channel_output_load_integration_0/v3_four_channel_shared_support_integration_0/v3_four_channel_bias_reference_distribution_0/v3_four_channel_phase_distribution_0/v3_four_channel_output_collection_0/v3_four_channel_placement_0/v3_channel_selector_late_promotion_0/v3_selector_route_pilot_0/G3_LO_P_AND/B v3_four_channel_output_load_integration_0/v3_four_channel_shared_support_integration_0/v3_four_channel_bias_reference_distribution_0/v3_four_channel_phase_distribution_0/v3_four_channel_output_collection_0/v3_four_channel_placement_0/v3_channel_selector_late_promotion_0/v3_selector_route_pilot_0/G3_LO_N_ANDNOT/a_297_47# VGND sky130_fd_pr__nfet_01v8 ad=0 pd=0 as=0 ps=0 w=0.42 l=0.15
X259 v3_four_channel_output_load_integration_0/v3_four_channel_shared_support_integration_0/v3_four_channel_bias_reference_distribution_0/v3_four_channel_phase_distribution_0/v3_four_channel_output_collection_0/v3_four_channel_placement_0/v3_channel_selector_late_promotion_0/v3_selector_route_pilot_0/G3_LO_N_ANDNOT/a_27_413# v3_four_channel_output_load_integration_0/v3_four_channel_shared_support_integration_0/v3_four_channel_bias_reference_distribution_0/v3_four_channel_phase_distribution_0/v3_four_channel_output_collection_0/v3_four_channel_placement_0/v3_channel_selector_late_promotion_0/v3_selector_route_pilot_0/G3_MUX_AXIS/X VGND VGND sky130_fd_pr__nfet_01v8 ad=0.1092 pd=1.36 as=0 ps=0 w=0.42 l=0.15
X260 VDPWR v3_four_channel_output_load_integration_0/v3_four_channel_shared_support_integration_0/v3_four_channel_bias_reference_distribution_0/v3_four_channel_phase_distribution_0/v3_four_channel_output_collection_0/v3_four_channel_placement_0/v3_channel_selector_late_promotion_0/v3_selector_route_pilot_0/G3_LO_P_AND/B v3_four_channel_output_load_integration_0/v3_four_channel_shared_support_integration_0/v3_four_channel_bias_reference_distribution_0/v3_four_channel_phase_distribution_0/v3_four_channel_output_collection_0/v3_four_channel_placement_0/v3_channel_selector_late_promotion_0/v3_selector_route_pilot_0/G2_LO_N_ANDNOT/a_207_413# VDPWR sky130_fd_pr__pfet_01v8_hvt ad=0 pd=0 as=0.1218 ps=1.42 w=0.42 l=0.15
X261 v3_four_channel_output_load_integration_0/v3_four_channel_shared_support_integration_0/v3_four_channel_bias_reference_distribution_0/v3_four_channel_phase_distribution_0/v3_four_channel_output_collection_0/v3_four_channel_placement_0/v3_channel_selector_late_promotion_0/v3_selector_route_pilot_0/group2_lo_n v3_four_channel_output_load_integration_0/v3_four_channel_shared_support_integration_0/v3_four_channel_bias_reference_distribution_0/v3_four_channel_phase_distribution_0/v3_four_channel_output_collection_0/v3_four_channel_placement_0/v3_channel_selector_late_promotion_0/v3_selector_route_pilot_0/G2_LO_N_ANDNOT/a_207_413# VDPWR VDPWR sky130_fd_pr__pfet_01v8_hvt ad=0.26 pd=2.52 as=0 ps=0 w=1 l=0.15
X262 v3_four_channel_output_load_integration_0/v3_four_channel_shared_support_integration_0/v3_four_channel_bias_reference_distribution_0/v3_four_channel_phase_distribution_0/v3_four_channel_output_collection_0/v3_four_channel_placement_0/v3_channel_selector_late_promotion_0/v3_selector_route_pilot_0/G2_LO_N_ANDNOT/a_297_47# v3_four_channel_output_load_integration_0/v3_four_channel_shared_support_integration_0/v3_four_channel_bias_reference_distribution_0/v3_four_channel_phase_distribution_0/v3_four_channel_output_collection_0/v3_four_channel_placement_0/v3_channel_selector_late_promotion_0/v3_selector_route_pilot_0/G2_LO_N_ANDNOT/a_27_413# v3_four_channel_output_load_integration_0/v3_four_channel_shared_support_integration_0/v3_four_channel_bias_reference_distribution_0/v3_four_channel_phase_distribution_0/v3_four_channel_output_collection_0/v3_four_channel_placement_0/v3_channel_selector_late_promotion_0/v3_selector_route_pilot_0/G2_LO_N_ANDNOT/a_207_413# VGND sky130_fd_pr__nfet_01v8 ad=0.1008 pd=1.32 as=0.1092 ps=1.36 w=0.42 l=0.15
X263 v3_four_channel_output_load_integration_0/v3_four_channel_shared_support_integration_0/v3_four_channel_bias_reference_distribution_0/v3_four_channel_phase_distribution_0/v3_four_channel_output_collection_0/v3_four_channel_placement_0/v3_channel_selector_late_promotion_0/v3_selector_route_pilot_0/group2_lo_n v3_four_channel_output_load_integration_0/v3_four_channel_shared_support_integration_0/v3_four_channel_bias_reference_distribution_0/v3_four_channel_phase_distribution_0/v3_four_channel_output_collection_0/v3_four_channel_placement_0/v3_channel_selector_late_promotion_0/v3_selector_route_pilot_0/G2_LO_N_ANDNOT/a_207_413# VGND VGND sky130_fd_pr__nfet_01v8 ad=0.169 pd=1.82 as=0 ps=0 w=0.65 l=0.15
X264 v3_four_channel_output_load_integration_0/v3_four_channel_shared_support_integration_0/v3_four_channel_bias_reference_distribution_0/v3_four_channel_phase_distribution_0/v3_four_channel_output_collection_0/v3_four_channel_placement_0/v3_channel_selector_late_promotion_0/v3_selector_route_pilot_0/G2_LO_N_ANDNOT/a_207_413# v3_four_channel_output_load_integration_0/v3_four_channel_shared_support_integration_0/v3_four_channel_bias_reference_distribution_0/v3_four_channel_phase_distribution_0/v3_four_channel_output_collection_0/v3_four_channel_placement_0/v3_channel_selector_late_promotion_0/v3_selector_route_pilot_0/G2_LO_N_ANDNOT/a_27_413# VDPWR VDPWR sky130_fd_pr__pfet_01v8_hvt ad=0 pd=0 as=0 ps=0 w=0.42 l=0.15
X265 VDPWR v3_four_channel_output_load_integration_0/v3_four_channel_shared_support_integration_0/v3_four_channel_bias_reference_distribution_0/v3_four_channel_phase_distribution_0/v3_four_channel_output_collection_0/v3_four_channel_placement_0/v3_channel_selector_late_promotion_0/v3_selector_route_pilot_0/G2_MUX_AXIS/X v3_four_channel_output_load_integration_0/v3_four_channel_shared_support_integration_0/v3_four_channel_bias_reference_distribution_0/v3_four_channel_phase_distribution_0/v3_four_channel_output_collection_0/v3_four_channel_placement_0/v3_channel_selector_late_promotion_0/v3_selector_route_pilot_0/G2_LO_N_ANDNOT/a_27_413# VDPWR sky130_fd_pr__pfet_01v8_hvt ad=0 pd=0 as=0.1092 ps=1.36 w=0.42 l=0.15
X266 VGND v3_four_channel_output_load_integration_0/v3_four_channel_shared_support_integration_0/v3_four_channel_bias_reference_distribution_0/v3_four_channel_phase_distribution_0/v3_four_channel_output_collection_0/v3_four_channel_placement_0/v3_channel_selector_late_promotion_0/v3_selector_route_pilot_0/G3_LO_P_AND/B v3_four_channel_output_load_integration_0/v3_four_channel_shared_support_integration_0/v3_four_channel_bias_reference_distribution_0/v3_four_channel_phase_distribution_0/v3_four_channel_output_collection_0/v3_four_channel_placement_0/v3_channel_selector_late_promotion_0/v3_selector_route_pilot_0/G2_LO_N_ANDNOT/a_297_47# VGND sky130_fd_pr__nfet_01v8 ad=0 pd=0 as=0 ps=0 w=0.42 l=0.15
X267 v3_four_channel_output_load_integration_0/v3_four_channel_shared_support_integration_0/v3_four_channel_bias_reference_distribution_0/v3_four_channel_phase_distribution_0/v3_four_channel_output_collection_0/v3_four_channel_placement_0/v3_channel_selector_late_promotion_0/v3_selector_route_pilot_0/G2_LO_N_ANDNOT/a_27_413# v3_four_channel_output_load_integration_0/v3_four_channel_shared_support_integration_0/v3_four_channel_bias_reference_distribution_0/v3_four_channel_phase_distribution_0/v3_four_channel_output_collection_0/v3_four_channel_placement_0/v3_channel_selector_late_promotion_0/v3_selector_route_pilot_0/G2_MUX_AXIS/X VGND VGND sky130_fd_pr__nfet_01v8 ad=0.1092 pd=1.36 as=0 ps=0 w=0.42 l=0.15
X268 VDPWR v3_four_channel_output_load_integration_0/v3_four_channel_shared_support_integration_0/v3_four_channel_bias_reference_distribution_0/v3_four_channel_phase_distribution_0/v3_four_channel_output_collection_0/v3_four_channel_placement_0/v3_channel_selector_late_promotion_0/v3_selector_route_pilot_0/G3_LO_P_AND/B v3_four_channel_output_load_integration_0/v3_four_channel_shared_support_integration_0/v3_four_channel_bias_reference_distribution_0/v3_four_channel_phase_distribution_0/v3_four_channel_output_collection_0/v3_four_channel_placement_0/v3_channel_selector_late_promotion_0/v3_selector_route_pilot_0/G0_LO_N_ANDNOT/a_207_413# VDPWR sky130_fd_pr__pfet_01v8_hvt ad=0 pd=0 as=0.1218 ps=1.42 w=0.42 l=0.15
X269 v3_four_channel_output_load_integration_0/v3_four_channel_shared_support_integration_0/v3_four_channel_bias_reference_distribution_0/v3_four_channel_phase_distribution_0/v3_four_channel_output_collection_0/v3_four_channel_placement_0/v3_channel_selector_late_promotion_0/v3_selector_route_pilot_0/group0_lo_n v3_four_channel_output_load_integration_0/v3_four_channel_shared_support_integration_0/v3_four_channel_bias_reference_distribution_0/v3_four_channel_phase_distribution_0/v3_four_channel_output_collection_0/v3_four_channel_placement_0/v3_channel_selector_late_promotion_0/v3_selector_route_pilot_0/G0_LO_N_ANDNOT/a_207_413# VDPWR VDPWR sky130_fd_pr__pfet_01v8_hvt ad=0.26 pd=2.52 as=0 ps=0 w=1 l=0.15
X270 v3_four_channel_output_load_integration_0/v3_four_channel_shared_support_integration_0/v3_four_channel_bias_reference_distribution_0/v3_four_channel_phase_distribution_0/v3_four_channel_output_collection_0/v3_four_channel_placement_0/v3_channel_selector_late_promotion_0/v3_selector_route_pilot_0/G0_LO_N_ANDNOT/a_297_47# v3_four_channel_output_load_integration_0/v3_four_channel_shared_support_integration_0/v3_four_channel_bias_reference_distribution_0/v3_four_channel_phase_distribution_0/v3_four_channel_output_collection_0/v3_four_channel_placement_0/v3_channel_selector_late_promotion_0/v3_selector_route_pilot_0/G0_LO_N_ANDNOT/a_27_413# v3_four_channel_output_load_integration_0/v3_four_channel_shared_support_integration_0/v3_four_channel_bias_reference_distribution_0/v3_four_channel_phase_distribution_0/v3_four_channel_output_collection_0/v3_four_channel_placement_0/v3_channel_selector_late_promotion_0/v3_selector_route_pilot_0/G0_LO_N_ANDNOT/a_207_413# VGND sky130_fd_pr__nfet_01v8 ad=0.1008 pd=1.32 as=0.1092 ps=1.36 w=0.42 l=0.15
X271 v3_four_channel_output_load_integration_0/v3_four_channel_shared_support_integration_0/v3_four_channel_bias_reference_distribution_0/v3_four_channel_phase_distribution_0/v3_four_channel_output_collection_0/v3_four_channel_placement_0/v3_channel_selector_late_promotion_0/v3_selector_route_pilot_0/group0_lo_n v3_four_channel_output_load_integration_0/v3_four_channel_shared_support_integration_0/v3_four_channel_bias_reference_distribution_0/v3_four_channel_phase_distribution_0/v3_four_channel_output_collection_0/v3_four_channel_placement_0/v3_channel_selector_late_promotion_0/v3_selector_route_pilot_0/G0_LO_N_ANDNOT/a_207_413# VGND VGND sky130_fd_pr__nfet_01v8 ad=0.169 pd=1.82 as=0 ps=0 w=0.65 l=0.15
X272 v3_four_channel_output_load_integration_0/v3_four_channel_shared_support_integration_0/v3_four_channel_bias_reference_distribution_0/v3_four_channel_phase_distribution_0/v3_four_channel_output_collection_0/v3_four_channel_placement_0/v3_channel_selector_late_promotion_0/v3_selector_route_pilot_0/G0_LO_N_ANDNOT/a_207_413# v3_four_channel_output_load_integration_0/v3_four_channel_shared_support_integration_0/v3_four_channel_bias_reference_distribution_0/v3_four_channel_phase_distribution_0/v3_four_channel_output_collection_0/v3_four_channel_placement_0/v3_channel_selector_late_promotion_0/v3_selector_route_pilot_0/G0_LO_N_ANDNOT/a_27_413# VDPWR VDPWR sky130_fd_pr__pfet_01v8_hvt ad=0 pd=0 as=0 ps=0 w=0.42 l=0.15
X273 VDPWR v3_four_channel_output_load_integration_0/v3_four_channel_shared_support_integration_0/v3_four_channel_bias_reference_distribution_0/v3_four_channel_phase_distribution_0/v3_four_channel_output_collection_0/v3_four_channel_placement_0/v3_channel_selector_late_promotion_0/v3_selector_route_pilot_0/G0_MUX_AXIS/X v3_four_channel_output_load_integration_0/v3_four_channel_shared_support_integration_0/v3_four_channel_bias_reference_distribution_0/v3_four_channel_phase_distribution_0/v3_four_channel_output_collection_0/v3_four_channel_placement_0/v3_channel_selector_late_promotion_0/v3_selector_route_pilot_0/G0_LO_N_ANDNOT/a_27_413# VDPWR sky130_fd_pr__pfet_01v8_hvt ad=0 pd=0 as=0.1092 ps=1.36 w=0.42 l=0.15
X274 VGND v3_four_channel_output_load_integration_0/v3_four_channel_shared_support_integration_0/v3_four_channel_bias_reference_distribution_0/v3_four_channel_phase_distribution_0/v3_four_channel_output_collection_0/v3_four_channel_placement_0/v3_channel_selector_late_promotion_0/v3_selector_route_pilot_0/G3_LO_P_AND/B v3_four_channel_output_load_integration_0/v3_four_channel_shared_support_integration_0/v3_four_channel_bias_reference_distribution_0/v3_four_channel_phase_distribution_0/v3_four_channel_output_collection_0/v3_four_channel_placement_0/v3_channel_selector_late_promotion_0/v3_selector_route_pilot_0/G0_LO_N_ANDNOT/a_297_47# VGND sky130_fd_pr__nfet_01v8 ad=0 pd=0 as=0 ps=0 w=0.42 l=0.15
X275 v3_four_channel_output_load_integration_0/v3_four_channel_shared_support_integration_0/v3_four_channel_bias_reference_distribution_0/v3_four_channel_phase_distribution_0/v3_four_channel_output_collection_0/v3_four_channel_placement_0/v3_channel_selector_late_promotion_0/v3_selector_route_pilot_0/G0_LO_N_ANDNOT/a_27_413# v3_four_channel_output_load_integration_0/v3_four_channel_shared_support_integration_0/v3_four_channel_bias_reference_distribution_0/v3_four_channel_phase_distribution_0/v3_four_channel_output_collection_0/v3_four_channel_placement_0/v3_channel_selector_late_promotion_0/v3_selector_route_pilot_0/G0_MUX_AXIS/X VGND VGND sky130_fd_pr__nfet_01v8 ad=0.1092 pd=1.36 as=0 ps=0 w=0.42 l=0.15
X276 VDPWR v3_four_channel_output_load_integration_0/v3_four_channel_shared_support_integration_0/v3_four_channel_bias_reference_distribution_0/v3_four_channel_phase_distribution_0/v3_four_channel_output_collection_0/v3_four_channel_placement_0/v3_channel_selector_late_promotion_0/v3_selector_route_pilot_0/G1_MUX_AXIS/a_505_21# v3_four_channel_output_load_integration_0/v3_four_channel_shared_support_integration_0/v3_four_channel_bias_reference_distribution_0/v3_four_channel_phase_distribution_0/v3_four_channel_output_collection_0/v3_four_channel_placement_0/v3_channel_selector_late_promotion_0/v3_selector_route_pilot_0/G1_MUX_AXIS/a_535_374# VDPWR sky130_fd_pr__pfet_01v8_hvt ad=0 pd=0 as=0.0882 ps=1.26 w=0.42 l=0.15
X277 v3_four_channel_output_load_integration_0/v3_four_channel_shared_support_integration_0/v3_four_channel_bias_reference_distribution_0/v3_four_channel_phase_distribution_0/v3_four_channel_output_collection_0/v3_four_channel_placement_0/v3_channel_selector_late_promotion_0/v3_selector_route_pilot_0/G1_MUX_AXIS/a_505_21# v3_four_channel_output_load_integration_0/v3_four_channel_shared_support_integration_0/v3_four_channel_bias_reference_distribution_0/v3_four_channel_phase_distribution_0/v3_four_channel_output_collection_0/v3_four_channel_placement_0/v3_channel_selector_late_promotion_0/group1_bit1 VDPWR VDPWR sky130_fd_pr__pfet_01v8_hvt ad=0.1176 pd=1.4 as=0 ps=0 w=0.42 l=0.15
X278 v3_four_channel_output_load_integration_0/v3_four_channel_shared_support_integration_0/v3_four_channel_bias_reference_distribution_0/v3_four_channel_phase_distribution_0/v3_four_channel_output_collection_0/v3_four_channel_placement_0/v3_channel_selector_late_promotion_0/v3_selector_route_pilot_0/G1_MUX_AXIS/a_218_374# v3_four_channel_output_load_integration_0/v3_four_channel_shared_support_integration_0/v3_four_channel_bias_reference_distribution_0/v3_four_channel_phase_distribution_0/v3_four_channel_output_collection_0/v3_four_channel_placement_0/v3_channel_selector_late_promotion_0/group1_bit1 VDPWR VDPWR sky130_fd_pr__pfet_01v8_hvt ad=0.1533 pd=1.57 as=0 ps=0 w=0.42 l=0.15
X279 VGND v3_four_channel_output_load_integration_0/v3_four_channel_shared_support_integration_0/v3_four_channel_bias_reference_distribution_0/v3_four_channel_phase_distribution_0/v3_four_channel_output_collection_0/v3_four_channel_placement_0/v3_channel_selector_late_promotion_0/v3_selector_route_pilot_0/G1_MUX_AXIS/a_505_21# v3_four_channel_output_load_integration_0/v3_four_channel_shared_support_integration_0/v3_four_channel_bias_reference_distribution_0/v3_four_channel_phase_distribution_0/v3_four_channel_output_collection_0/v3_four_channel_placement_0/v3_channel_selector_late_promotion_0/v3_selector_route_pilot_0/G1_MUX_AXIS/a_439_47# VGND sky130_fd_pr__nfet_01v8 ad=0 pd=0 as=0.1386 ps=1.5 w=0.42 l=0.15
X280 v3_four_channel_output_load_integration_0/v3_four_channel_shared_support_integration_0/v3_four_channel_bias_reference_distribution_0/v3_four_channel_phase_distribution_0/v3_four_channel_output_collection_0/v3_four_channel_placement_0/v3_channel_selector_late_promotion_0/v3_selector_route_pilot_0/G1_MUX_AXIS/a_76_199# v3_four_channel_output_load_integration_0/v3_four_channel_shared_support_integration_0/v3_four_channel_bias_reference_distribution_0/v3_four_channel_phase_distribution_0/v3_four_channel_output_collection_0/v3_four_channel_placement_0/v3_channel_selector_late_promotion_0/v3_selector_route_pilot_0/G1_MUX_POS/X v3_four_channel_output_load_integration_0/v3_four_channel_shared_support_integration_0/v3_four_channel_bias_reference_distribution_0/v3_four_channel_phase_distribution_0/v3_four_channel_output_collection_0/v3_four_channel_placement_0/v3_channel_selector_late_promotion_0/v3_selector_route_pilot_0/G1_MUX_AXIS/a_218_374# VDPWR sky130_fd_pr__pfet_01v8_hvt ad=0.3864 pd=2.68 as=0 ps=0 w=0.42 l=0.15
X281 v3_four_channel_output_load_integration_0/v3_four_channel_shared_support_integration_0/v3_four_channel_bias_reference_distribution_0/v3_four_channel_phase_distribution_0/v3_four_channel_output_collection_0/v3_four_channel_placement_0/v3_channel_selector_late_promotion_0/v3_selector_route_pilot_0/G1_MUX_AXIS/a_505_21# v3_four_channel_output_load_integration_0/v3_four_channel_shared_support_integration_0/v3_four_channel_bias_reference_distribution_0/v3_four_channel_phase_distribution_0/v3_four_channel_output_collection_0/v3_four_channel_placement_0/v3_channel_selector_late_promotion_0/group1_bit1 VGND VGND sky130_fd_pr__nfet_01v8 ad=0.1092 pd=1.36 as=0 ps=0 w=0.42 l=0.15
X282 v3_four_channel_output_load_integration_0/v3_four_channel_shared_support_integration_0/v3_four_channel_bias_reference_distribution_0/v3_four_channel_phase_distribution_0/v3_four_channel_output_collection_0/v3_four_channel_placement_0/v3_channel_selector_late_promotion_0/v3_selector_route_pilot_0/G1_MUX_AXIS/a_439_47# v3_four_channel_output_load_integration_0/v3_four_channel_shared_support_integration_0/v3_four_channel_bias_reference_distribution_0/v3_four_channel_phase_distribution_0/v3_four_channel_output_collection_0/v3_four_channel_placement_0/v3_channel_selector_late_promotion_0/v3_selector_route_pilot_0/G1_MUX_POS/X v3_four_channel_output_load_integration_0/v3_four_channel_shared_support_integration_0/v3_four_channel_bias_reference_distribution_0/v3_four_channel_phase_distribution_0/v3_four_channel_output_collection_0/v3_four_channel_placement_0/v3_channel_selector_late_promotion_0/v3_selector_route_pilot_0/G1_MUX_AXIS/a_76_199# VGND sky130_fd_pr__nfet_01v8 ad=0 pd=0 as=0.1995 ps=1.79 w=0.42 l=0.15
X283 v3_four_channel_output_load_integration_0/v3_four_channel_shared_support_integration_0/v3_four_channel_bias_reference_distribution_0/v3_four_channel_phase_distribution_0/v3_four_channel_output_collection_0/v3_four_channel_placement_0/v3_channel_selector_late_promotion_0/v3_selector_route_pilot_0/G1_MUX_AXIS/a_535_374# v3_four_channel_output_load_integration_0/v3_four_channel_shared_support_integration_0/v3_four_channel_bias_reference_distribution_0/v3_four_channel_phase_distribution_0/v3_four_channel_output_collection_0/v3_four_channel_placement_0/v3_channel_selector_late_promotion_0/v3_selector_route_pilot_0/G1_MUX_NEG/X v3_four_channel_output_load_integration_0/v3_four_channel_shared_support_integration_0/v3_four_channel_bias_reference_distribution_0/v3_four_channel_phase_distribution_0/v3_four_channel_output_collection_0/v3_four_channel_placement_0/v3_channel_selector_late_promotion_0/v3_selector_route_pilot_0/G1_MUX_AXIS/a_76_199# VDPWR sky130_fd_pr__pfet_01v8_hvt ad=0 pd=0 as=0 ps=0 w=0.42 l=0.15
X284 v3_four_channel_output_load_integration_0/v3_four_channel_shared_support_integration_0/v3_four_channel_bias_reference_distribution_0/v3_four_channel_phase_distribution_0/v3_four_channel_output_collection_0/v3_four_channel_placement_0/v3_channel_selector_late_promotion_0/v3_selector_route_pilot_0/G1_MUX_AXIS/a_76_199# v3_four_channel_output_load_integration_0/v3_four_channel_shared_support_integration_0/v3_four_channel_bias_reference_distribution_0/v3_four_channel_phase_distribution_0/v3_four_channel_output_collection_0/v3_four_channel_placement_0/v3_channel_selector_late_promotion_0/v3_selector_route_pilot_0/G1_MUX_NEG/X v3_four_channel_output_load_integration_0/v3_four_channel_shared_support_integration_0/v3_four_channel_bias_reference_distribution_0/v3_four_channel_phase_distribution_0/v3_four_channel_output_collection_0/v3_four_channel_placement_0/v3_channel_selector_late_promotion_0/v3_selector_route_pilot_0/G1_MUX_AXIS/a_218_47# VGND sky130_fd_pr__nfet_01v8 ad=0 pd=0 as=0.1386 ps=1.5 w=0.42 l=0.15
X285 v3_four_channel_output_load_integration_0/v3_four_channel_shared_support_integration_0/v3_four_channel_bias_reference_distribution_0/v3_four_channel_phase_distribution_0/v3_four_channel_output_collection_0/v3_four_channel_placement_0/v3_channel_selector_late_promotion_0/v3_selector_route_pilot_0/G1_MUX_AXIS/a_218_47# v3_four_channel_output_load_integration_0/v3_four_channel_shared_support_integration_0/v3_four_channel_bias_reference_distribution_0/v3_four_channel_phase_distribution_0/v3_four_channel_output_collection_0/v3_four_channel_placement_0/v3_channel_selector_late_promotion_0/group1_bit1 VGND VGND sky130_fd_pr__nfet_01v8 ad=0 pd=0 as=0 ps=0 w=0.42 l=0.15
X286 VDPWR v3_four_channel_output_load_integration_0/v3_four_channel_shared_support_integration_0/v3_four_channel_bias_reference_distribution_0/v3_four_channel_phase_distribution_0/v3_four_channel_output_collection_0/v3_four_channel_placement_0/v3_channel_selector_late_promotion_0/v3_selector_route_pilot_0/G1_MUX_AXIS/a_76_199# v3_four_channel_output_load_integration_0/v3_four_channel_shared_support_integration_0/v3_four_channel_bias_reference_distribution_0/v3_four_channel_phase_distribution_0/v3_four_channel_output_collection_0/v3_four_channel_placement_0/v3_channel_selector_late_promotion_0/v3_selector_route_pilot_0/G1_MUX_AXIS/X VDPWR sky130_fd_pr__pfet_01v8_hvt ad=0 pd=0 as=0.26 ps=2.52 w=1 l=0.15
X287 VGND v3_four_channel_output_load_integration_0/v3_four_channel_shared_support_integration_0/v3_four_channel_bias_reference_distribution_0/v3_four_channel_phase_distribution_0/v3_four_channel_output_collection_0/v3_four_channel_placement_0/v3_channel_selector_late_promotion_0/v3_selector_route_pilot_0/G1_MUX_AXIS/a_76_199# v3_four_channel_output_load_integration_0/v3_four_channel_shared_support_integration_0/v3_four_channel_bias_reference_distribution_0/v3_four_channel_phase_distribution_0/v3_four_channel_output_collection_0/v3_four_channel_placement_0/v3_channel_selector_late_promotion_0/v3_selector_route_pilot_0/G1_MUX_AXIS/X VGND sky130_fd_pr__nfet_01v8 ad=0 pd=0 as=0.169 ps=1.82 w=0.65 l=0.15
X288 VDPWR v3_four_channel_output_load_integration_0/v3_four_channel_shared_support_integration_0/v3_four_channel_bias_reference_distribution_0/v3_four_channel_phase_distribution_0/v3_four_channel_output_collection_0/v3_four_channel_placement_0/v3_channel_selector_late_promotion_0/v3_selector_route_pilot_0/G3_LO_P_AND/B v3_four_channel_output_load_integration_0/v3_four_channel_shared_support_integration_0/v3_four_channel_bias_reference_distribution_0/v3_four_channel_phase_distribution_0/v3_four_channel_output_collection_0/v3_four_channel_placement_0/v3_channel_selector_late_promotion_0/v3_selector_route_pilot_0/G1_LO_N_ANDNOT/a_207_413# VDPWR sky130_fd_pr__pfet_01v8_hvt ad=0 pd=0 as=0.1218 ps=1.42 w=0.42 l=0.15
X289 v3_four_channel_output_load_integration_0/v3_four_channel_shared_support_integration_0/v3_four_channel_bias_reference_distribution_0/v3_four_channel_phase_distribution_0/v3_four_channel_output_collection_0/v3_four_channel_placement_0/v3_channel_selector_late_promotion_0/v3_selector_route_pilot_0/group1_lo_n v3_four_channel_output_load_integration_0/v3_four_channel_shared_support_integration_0/v3_four_channel_bias_reference_distribution_0/v3_four_channel_phase_distribution_0/v3_four_channel_output_collection_0/v3_four_channel_placement_0/v3_channel_selector_late_promotion_0/v3_selector_route_pilot_0/G1_LO_N_ANDNOT/a_207_413# VDPWR VDPWR sky130_fd_pr__pfet_01v8_hvt ad=0.26 pd=2.52 as=0 ps=0 w=1 l=0.15
X290 v3_four_channel_output_load_integration_0/v3_four_channel_shared_support_integration_0/v3_four_channel_bias_reference_distribution_0/v3_four_channel_phase_distribution_0/v3_four_channel_output_collection_0/v3_four_channel_placement_0/v3_channel_selector_late_promotion_0/v3_selector_route_pilot_0/G1_LO_N_ANDNOT/a_297_47# v3_four_channel_output_load_integration_0/v3_four_channel_shared_support_integration_0/v3_four_channel_bias_reference_distribution_0/v3_four_channel_phase_distribution_0/v3_four_channel_output_collection_0/v3_four_channel_placement_0/v3_channel_selector_late_promotion_0/v3_selector_route_pilot_0/G1_LO_N_ANDNOT/a_27_413# v3_four_channel_output_load_integration_0/v3_four_channel_shared_support_integration_0/v3_four_channel_bias_reference_distribution_0/v3_four_channel_phase_distribution_0/v3_four_channel_output_collection_0/v3_four_channel_placement_0/v3_channel_selector_late_promotion_0/v3_selector_route_pilot_0/G1_LO_N_ANDNOT/a_207_413# VGND sky130_fd_pr__nfet_01v8 ad=0.1008 pd=1.32 as=0.1092 ps=1.36 w=0.42 l=0.15
X291 v3_four_channel_output_load_integration_0/v3_four_channel_shared_support_integration_0/v3_four_channel_bias_reference_distribution_0/v3_four_channel_phase_distribution_0/v3_four_channel_output_collection_0/v3_four_channel_placement_0/v3_channel_selector_late_promotion_0/v3_selector_route_pilot_0/group1_lo_n v3_four_channel_output_load_integration_0/v3_four_channel_shared_support_integration_0/v3_four_channel_bias_reference_distribution_0/v3_four_channel_phase_distribution_0/v3_four_channel_output_collection_0/v3_four_channel_placement_0/v3_channel_selector_late_promotion_0/v3_selector_route_pilot_0/G1_LO_N_ANDNOT/a_207_413# VGND VGND sky130_fd_pr__nfet_01v8 ad=0.169 pd=1.82 as=0 ps=0 w=0.65 l=0.15
X292 v3_four_channel_output_load_integration_0/v3_four_channel_shared_support_integration_0/v3_four_channel_bias_reference_distribution_0/v3_four_channel_phase_distribution_0/v3_four_channel_output_collection_0/v3_four_channel_placement_0/v3_channel_selector_late_promotion_0/v3_selector_route_pilot_0/G1_LO_N_ANDNOT/a_207_413# v3_four_channel_output_load_integration_0/v3_four_channel_shared_support_integration_0/v3_four_channel_bias_reference_distribution_0/v3_four_channel_phase_distribution_0/v3_four_channel_output_collection_0/v3_four_channel_placement_0/v3_channel_selector_late_promotion_0/v3_selector_route_pilot_0/G1_LO_N_ANDNOT/a_27_413# VDPWR VDPWR sky130_fd_pr__pfet_01v8_hvt ad=0 pd=0 as=0 ps=0 w=0.42 l=0.15
X293 VDPWR v3_four_channel_output_load_integration_0/v3_four_channel_shared_support_integration_0/v3_four_channel_bias_reference_distribution_0/v3_four_channel_phase_distribution_0/v3_four_channel_output_collection_0/v3_four_channel_placement_0/v3_channel_selector_late_promotion_0/v3_selector_route_pilot_0/G1_MUX_AXIS/X v3_four_channel_output_load_integration_0/v3_four_channel_shared_support_integration_0/v3_four_channel_bias_reference_distribution_0/v3_four_channel_phase_distribution_0/v3_four_channel_output_collection_0/v3_four_channel_placement_0/v3_channel_selector_late_promotion_0/v3_selector_route_pilot_0/G1_LO_N_ANDNOT/a_27_413# VDPWR sky130_fd_pr__pfet_01v8_hvt ad=0 pd=0 as=0.1092 ps=1.36 w=0.42 l=0.15
X294 VGND v3_four_channel_output_load_integration_0/v3_four_channel_shared_support_integration_0/v3_four_channel_bias_reference_distribution_0/v3_four_channel_phase_distribution_0/v3_four_channel_output_collection_0/v3_four_channel_placement_0/v3_channel_selector_late_promotion_0/v3_selector_route_pilot_0/G3_LO_P_AND/B v3_four_channel_output_load_integration_0/v3_four_channel_shared_support_integration_0/v3_four_channel_bias_reference_distribution_0/v3_four_channel_phase_distribution_0/v3_four_channel_output_collection_0/v3_four_channel_placement_0/v3_channel_selector_late_promotion_0/v3_selector_route_pilot_0/G1_LO_N_ANDNOT/a_297_47# VGND sky130_fd_pr__nfet_01v8 ad=0 pd=0 as=0 ps=0 w=0.42 l=0.15
X295 v3_four_channel_output_load_integration_0/v3_four_channel_shared_support_integration_0/v3_four_channel_bias_reference_distribution_0/v3_four_channel_phase_distribution_0/v3_four_channel_output_collection_0/v3_four_channel_placement_0/v3_channel_selector_late_promotion_0/v3_selector_route_pilot_0/G1_LO_N_ANDNOT/a_27_413# v3_four_channel_output_load_integration_0/v3_four_channel_shared_support_integration_0/v3_four_channel_bias_reference_distribution_0/v3_four_channel_phase_distribution_0/v3_four_channel_output_collection_0/v3_four_channel_placement_0/v3_channel_selector_late_promotion_0/v3_selector_route_pilot_0/G1_MUX_AXIS/X VGND VGND sky130_fd_pr__nfet_01v8 ad=0.1092 pd=1.36 as=0 ps=0 w=0.42 l=0.15
X296 VDPWR v3_four_channel_output_load_integration_0/v3_four_channel_shared_support_integration_0/v3_four_channel_bias_reference_distribution_0/v3_four_channel_phase_distribution_0/v3_four_channel_output_collection_0/v3_four_channel_placement_0/v3_channel_selector_late_promotion_0/v3_selector_route_pilot_0/G3_LO_P_AND/B v3_four_channel_output_load_integration_0/v3_four_channel_shared_support_integration_0/v3_four_channel_bias_reference_distribution_0/v3_four_channel_phase_distribution_0/v3_four_channel_output_collection_0/v3_four_channel_placement_0/v3_channel_selector_late_promotion_0/v3_selector_route_pilot_0/G3_LO_P_AND/a_59_75# VDPWR sky130_fd_pr__pfet_01v8_hvt ad=0 pd=0 as=0.1134 ps=1.38 w=0.42 l=0.15
X297 v3_four_channel_output_load_integration_0/v3_four_channel_shared_support_integration_0/v3_four_channel_bias_reference_distribution_0/v3_four_channel_phase_distribution_0/v3_four_channel_output_collection_0/v3_four_channel_placement_0/v3_channel_selector_late_promotion_0/v3_selector_route_pilot_0/group3_lo_p v3_four_channel_output_load_integration_0/v3_four_channel_shared_support_integration_0/v3_four_channel_bias_reference_distribution_0/v3_four_channel_phase_distribution_0/v3_four_channel_output_collection_0/v3_four_channel_placement_0/v3_channel_selector_late_promotion_0/v3_selector_route_pilot_0/G3_LO_P_AND/a_59_75# VDPWR VDPWR sky130_fd_pr__pfet_01v8_hvt ad=0.475 pd=2.95 as=0 ps=0 w=1 l=0.15
X298 VGND v3_four_channel_output_load_integration_0/v3_four_channel_shared_support_integration_0/v3_four_channel_bias_reference_distribution_0/v3_four_channel_phase_distribution_0/v3_four_channel_output_collection_0/v3_four_channel_placement_0/v3_channel_selector_late_promotion_0/v3_selector_route_pilot_0/G3_LO_P_AND/B v3_four_channel_output_load_integration_0/v3_four_channel_shared_support_integration_0/v3_four_channel_bias_reference_distribution_0/v3_four_channel_phase_distribution_0/v3_four_channel_output_collection_0/v3_four_channel_placement_0/v3_channel_selector_late_promotion_0/v3_selector_route_pilot_0/G3_LO_P_AND/a_145_75# VGND sky130_fd_pr__nfet_01v8 ad=0 pd=0 as=0.1134 ps=1.38 w=0.42 l=0.15
X299 v3_four_channel_output_load_integration_0/v3_four_channel_shared_support_integration_0/v3_four_channel_bias_reference_distribution_0/v3_four_channel_phase_distribution_0/v3_four_channel_output_collection_0/v3_four_channel_placement_0/v3_channel_selector_late_promotion_0/v3_selector_route_pilot_0/G3_LO_P_AND/a_59_75# v3_four_channel_output_load_integration_0/v3_four_channel_shared_support_integration_0/v3_four_channel_bias_reference_distribution_0/v3_four_channel_phase_distribution_0/v3_four_channel_output_collection_0/v3_four_channel_placement_0/v3_channel_selector_late_promotion_0/v3_selector_route_pilot_0/G3_MUX_AXIS/X VDPWR VDPWR sky130_fd_pr__pfet_01v8_hvt ad=0 pd=0 as=0 ps=0 w=0.42 l=0.15
X300 v3_four_channel_output_load_integration_0/v3_four_channel_shared_support_integration_0/v3_four_channel_bias_reference_distribution_0/v3_four_channel_phase_distribution_0/v3_four_channel_output_collection_0/v3_four_channel_placement_0/v3_channel_selector_late_promotion_0/v3_selector_route_pilot_0/group3_lo_p v3_four_channel_output_load_integration_0/v3_four_channel_shared_support_integration_0/v3_four_channel_bias_reference_distribution_0/v3_four_channel_phase_distribution_0/v3_four_channel_output_collection_0/v3_four_channel_placement_0/v3_channel_selector_late_promotion_0/v3_selector_route_pilot_0/G3_LO_P_AND/a_59_75# VGND VGND sky130_fd_pr__nfet_01v8 ad=0.182 pd=1.86 as=0 ps=0 w=0.65 l=0.15
X301 v3_four_channel_output_load_integration_0/v3_four_channel_shared_support_integration_0/v3_four_channel_bias_reference_distribution_0/v3_four_channel_phase_distribution_0/v3_four_channel_output_collection_0/v3_four_channel_placement_0/v3_channel_selector_late_promotion_0/v3_selector_route_pilot_0/G3_LO_P_AND/a_145_75# v3_four_channel_output_load_integration_0/v3_four_channel_shared_support_integration_0/v3_four_channel_bias_reference_distribution_0/v3_four_channel_phase_distribution_0/v3_four_channel_output_collection_0/v3_four_channel_placement_0/v3_channel_selector_late_promotion_0/v3_selector_route_pilot_0/G3_MUX_AXIS/X v3_four_channel_output_load_integration_0/v3_four_channel_shared_support_integration_0/v3_four_channel_bias_reference_distribution_0/v3_four_channel_phase_distribution_0/v3_four_channel_output_collection_0/v3_four_channel_placement_0/v3_channel_selector_late_promotion_0/v3_selector_route_pilot_0/G3_LO_P_AND/a_59_75# VGND sky130_fd_pr__nfet_01v8 ad=0 pd=0 as=0.1176 ps=1.4 w=0.42 l=0.15
X302 VDPWR v3_four_channel_output_load_integration_0/v3_four_channel_shared_support_integration_0/v3_four_channel_bias_reference_distribution_0/v3_four_channel_phase_distribution_0/v3_four_channel_output_collection_0/v3_four_channel_placement_0/v3_channel_selector_late_promotion_0/v3_selector_route_pilot_0/G2_MUX_POS/a_505_21# v3_four_channel_output_load_integration_0/v3_four_channel_shared_support_integration_0/v3_four_channel_bias_reference_distribution_0/v3_four_channel_phase_distribution_0/v3_four_channel_output_collection_0/v3_four_channel_placement_0/v3_channel_selector_late_promotion_0/v3_selector_route_pilot_0/G2_MUX_POS/a_535_374# VDPWR sky130_fd_pr__pfet_01v8_hvt ad=0 pd=0 as=0.0882 ps=1.26 w=0.42 l=0.15
X303 v3_four_channel_output_load_integration_0/v3_four_channel_shared_support_integration_0/v3_four_channel_bias_reference_distribution_0/v3_four_channel_phase_distribution_0/v3_four_channel_output_collection_0/v3_four_channel_placement_0/v3_channel_selector_late_promotion_0/v3_selector_route_pilot_0/G2_MUX_POS/a_505_21# v3_four_channel_output_load_integration_0/v3_four_channel_shared_support_integration_0/v3_four_channel_bias_reference_distribution_0/v3_four_channel_phase_distribution_0/v3_four_channel_output_collection_0/v3_four_channel_placement_0/v3_channel_selector_late_promotion_0/group2_bit0 VDPWR VDPWR sky130_fd_pr__pfet_01v8_hvt ad=0.1176 pd=1.4 as=0 ps=0 w=0.42 l=0.15
X304 v3_four_channel_output_load_integration_0/v3_four_channel_shared_support_integration_0/v3_four_channel_bias_reference_distribution_0/v3_four_channel_phase_distribution_0/v3_four_channel_output_collection_0/v3_four_channel_placement_0/v3_channel_selector_late_promotion_0/v3_selector_route_pilot_0/G2_MUX_POS/a_218_374# v3_four_channel_output_load_integration_0/v3_four_channel_shared_support_integration_0/v3_four_channel_bias_reference_distribution_0/v3_four_channel_phase_distribution_0/v3_four_channel_output_collection_0/v3_four_channel_placement_0/v3_channel_selector_late_promotion_0/group2_bit0 VDPWR VDPWR sky130_fd_pr__pfet_01v8_hvt ad=0.1533 pd=1.57 as=0 ps=0 w=0.42 l=0.15
X305 VGND v3_four_channel_output_load_integration_0/v3_four_channel_shared_support_integration_0/v3_four_channel_bias_reference_distribution_0/v3_four_channel_phase_distribution_0/v3_four_channel_output_collection_0/v3_four_channel_placement_0/v3_channel_selector_late_promotion_0/v3_selector_route_pilot_0/G2_MUX_POS/a_505_21# v3_four_channel_output_load_integration_0/v3_four_channel_shared_support_integration_0/v3_four_channel_bias_reference_distribution_0/v3_four_channel_phase_distribution_0/v3_four_channel_output_collection_0/v3_four_channel_placement_0/v3_channel_selector_late_promotion_0/v3_selector_route_pilot_0/G2_MUX_POS/a_439_47# VGND sky130_fd_pr__nfet_01v8 ad=0 pd=0 as=0.1386 ps=1.5 w=0.42 l=0.15
X306 v3_four_channel_output_load_integration_0/v3_four_channel_shared_support_integration_0/v3_four_channel_bias_reference_distribution_0/v3_four_channel_phase_distribution_0/v3_four_channel_output_collection_0/v3_four_channel_placement_0/v3_channel_selector_late_promotion_0/v3_selector_route_pilot_0/G2_MUX_POS/a_76_199# v3_four_channel_output_load_integration_0/v3_four_channel_shared_support_integration_0/v3_four_channel_bias_reference_distribution_0/v3_four_channel_phase_distribution_0/phase_0 v3_four_channel_output_load_integration_0/v3_four_channel_shared_support_integration_0/v3_four_channel_bias_reference_distribution_0/v3_four_channel_phase_distribution_0/v3_four_channel_output_collection_0/v3_four_channel_placement_0/v3_channel_selector_late_promotion_0/v3_selector_route_pilot_0/G2_MUX_POS/a_218_374# VDPWR sky130_fd_pr__pfet_01v8_hvt ad=0.3864 pd=2.68 as=0 ps=0 w=0.42 l=0.15
X307 v3_four_channel_output_load_integration_0/v3_four_channel_shared_support_integration_0/v3_four_channel_bias_reference_distribution_0/v3_four_channel_phase_distribution_0/v3_four_channel_output_collection_0/v3_four_channel_placement_0/v3_channel_selector_late_promotion_0/v3_selector_route_pilot_0/G2_MUX_POS/a_505_21# v3_four_channel_output_load_integration_0/v3_four_channel_shared_support_integration_0/v3_four_channel_bias_reference_distribution_0/v3_four_channel_phase_distribution_0/v3_four_channel_output_collection_0/v3_four_channel_placement_0/v3_channel_selector_late_promotion_0/group2_bit0 VGND VGND sky130_fd_pr__nfet_01v8 ad=0.1092 pd=1.36 as=0 ps=0 w=0.42 l=0.15
X308 v3_four_channel_output_load_integration_0/v3_four_channel_shared_support_integration_0/v3_four_channel_bias_reference_distribution_0/v3_four_channel_phase_distribution_0/v3_four_channel_output_collection_0/v3_four_channel_placement_0/v3_channel_selector_late_promotion_0/v3_selector_route_pilot_0/G2_MUX_POS/a_439_47# v3_four_channel_output_load_integration_0/v3_four_channel_shared_support_integration_0/v3_four_channel_bias_reference_distribution_0/v3_four_channel_phase_distribution_0/phase_0 v3_four_channel_output_load_integration_0/v3_four_channel_shared_support_integration_0/v3_four_channel_bias_reference_distribution_0/v3_four_channel_phase_distribution_0/v3_four_channel_output_collection_0/v3_four_channel_placement_0/v3_channel_selector_late_promotion_0/v3_selector_route_pilot_0/G2_MUX_POS/a_76_199# VGND sky130_fd_pr__nfet_01v8 ad=0 pd=0 as=0.1995 ps=1.79 w=0.42 l=0.15
X309 v3_four_channel_output_load_integration_0/v3_four_channel_shared_support_integration_0/v3_four_channel_bias_reference_distribution_0/v3_four_channel_phase_distribution_0/v3_four_channel_output_collection_0/v3_four_channel_placement_0/v3_channel_selector_late_promotion_0/v3_selector_route_pilot_0/G2_MUX_POS/a_535_374# v3_four_channel_output_load_integration_0/v3_four_channel_shared_support_integration_0/v3_four_channel_bias_reference_distribution_0/v3_four_channel_phase_distribution_0/phase_90 v3_four_channel_output_load_integration_0/v3_four_channel_shared_support_integration_0/v3_four_channel_bias_reference_distribution_0/v3_four_channel_phase_distribution_0/v3_four_channel_output_collection_0/v3_four_channel_placement_0/v3_channel_selector_late_promotion_0/v3_selector_route_pilot_0/G2_MUX_POS/a_76_199# VDPWR sky130_fd_pr__pfet_01v8_hvt ad=0 pd=0 as=0 ps=0 w=0.42 l=0.15
X310 v3_four_channel_output_load_integration_0/v3_four_channel_shared_support_integration_0/v3_four_channel_bias_reference_distribution_0/v3_four_channel_phase_distribution_0/v3_four_channel_output_collection_0/v3_four_channel_placement_0/v3_channel_selector_late_promotion_0/v3_selector_route_pilot_0/G2_MUX_POS/a_76_199# v3_four_channel_output_load_integration_0/v3_four_channel_shared_support_integration_0/v3_four_channel_bias_reference_distribution_0/v3_four_channel_phase_distribution_0/phase_90 v3_four_channel_output_load_integration_0/v3_four_channel_shared_support_integration_0/v3_four_channel_bias_reference_distribution_0/v3_four_channel_phase_distribution_0/v3_four_channel_output_collection_0/v3_four_channel_placement_0/v3_channel_selector_late_promotion_0/v3_selector_route_pilot_0/G2_MUX_POS/a_218_47# VGND sky130_fd_pr__nfet_01v8 ad=0 pd=0 as=0.1386 ps=1.5 w=0.42 l=0.15
X311 v3_four_channel_output_load_integration_0/v3_four_channel_shared_support_integration_0/v3_four_channel_bias_reference_distribution_0/v3_four_channel_phase_distribution_0/v3_four_channel_output_collection_0/v3_four_channel_placement_0/v3_channel_selector_late_promotion_0/v3_selector_route_pilot_0/G2_MUX_POS/a_218_47# v3_four_channel_output_load_integration_0/v3_four_channel_shared_support_integration_0/v3_four_channel_bias_reference_distribution_0/v3_four_channel_phase_distribution_0/v3_four_channel_output_collection_0/v3_four_channel_placement_0/v3_channel_selector_late_promotion_0/group2_bit0 VGND VGND sky130_fd_pr__nfet_01v8 ad=0 pd=0 as=0 ps=0 w=0.42 l=0.15
X312 VDPWR v3_four_channel_output_load_integration_0/v3_four_channel_shared_support_integration_0/v3_four_channel_bias_reference_distribution_0/v3_four_channel_phase_distribution_0/v3_four_channel_output_collection_0/v3_four_channel_placement_0/v3_channel_selector_late_promotion_0/v3_selector_route_pilot_0/G2_MUX_POS/a_76_199# v3_four_channel_output_load_integration_0/v3_four_channel_shared_support_integration_0/v3_four_channel_bias_reference_distribution_0/v3_four_channel_phase_distribution_0/v3_four_channel_output_collection_0/v3_four_channel_placement_0/v3_channel_selector_late_promotion_0/v3_selector_route_pilot_0/G2_MUX_POS/X VDPWR sky130_fd_pr__pfet_01v8_hvt ad=0 pd=0 as=0.26 ps=2.52 w=1 l=0.15
X313 VGND v3_four_channel_output_load_integration_0/v3_four_channel_shared_support_integration_0/v3_four_channel_bias_reference_distribution_0/v3_four_channel_phase_distribution_0/v3_four_channel_output_collection_0/v3_four_channel_placement_0/v3_channel_selector_late_promotion_0/v3_selector_route_pilot_0/G2_MUX_POS/a_76_199# v3_four_channel_output_load_integration_0/v3_four_channel_shared_support_integration_0/v3_four_channel_bias_reference_distribution_0/v3_four_channel_phase_distribution_0/v3_four_channel_output_collection_0/v3_four_channel_placement_0/v3_channel_selector_late_promotion_0/v3_selector_route_pilot_0/G2_MUX_POS/X VGND sky130_fd_pr__nfet_01v8 ad=0 pd=0 as=0.169 ps=1.82 w=0.65 l=0.15
X314 VDPWR v3_four_channel_output_load_integration_0/v3_four_channel_shared_support_integration_0/v3_four_channel_bias_reference_distribution_0/v3_four_channel_phase_distribution_0/v3_four_channel_output_collection_0/v3_four_channel_placement_0/v3_channel_selector_late_promotion_0/v3_selector_route_pilot_0/G2_MUX_NEG/a_505_21# v3_four_channel_output_load_integration_0/v3_four_channel_shared_support_integration_0/v3_four_channel_bias_reference_distribution_0/v3_four_channel_phase_distribution_0/v3_four_channel_output_collection_0/v3_four_channel_placement_0/v3_channel_selector_late_promotion_0/v3_selector_route_pilot_0/G2_MUX_NEG/a_535_374# VDPWR sky130_fd_pr__pfet_01v8_hvt ad=0 pd=0 as=0.0882 ps=1.26 w=0.42 l=0.15
X315 v3_four_channel_output_load_integration_0/v3_four_channel_shared_support_integration_0/v3_four_channel_bias_reference_distribution_0/v3_four_channel_phase_distribution_0/v3_four_channel_output_collection_0/v3_four_channel_placement_0/v3_channel_selector_late_promotion_0/v3_selector_route_pilot_0/G2_MUX_NEG/a_505_21# v3_four_channel_output_load_integration_0/v3_four_channel_shared_support_integration_0/v3_four_channel_bias_reference_distribution_0/v3_four_channel_phase_distribution_0/v3_four_channel_output_collection_0/v3_four_channel_placement_0/v3_channel_selector_late_promotion_0/group2_bit0 VDPWR VDPWR sky130_fd_pr__pfet_01v8_hvt ad=0.1176 pd=1.4 as=0 ps=0 w=0.42 l=0.15
X316 v3_four_channel_output_load_integration_0/v3_four_channel_shared_support_integration_0/v3_four_channel_bias_reference_distribution_0/v3_four_channel_phase_distribution_0/v3_four_channel_output_collection_0/v3_four_channel_placement_0/v3_channel_selector_late_promotion_0/v3_selector_route_pilot_0/G2_MUX_NEG/a_218_374# v3_four_channel_output_load_integration_0/v3_four_channel_shared_support_integration_0/v3_four_channel_bias_reference_distribution_0/v3_four_channel_phase_distribution_0/v3_four_channel_output_collection_0/v3_four_channel_placement_0/v3_channel_selector_late_promotion_0/group2_bit0 VDPWR VDPWR sky130_fd_pr__pfet_01v8_hvt ad=0.1533 pd=1.57 as=0 ps=0 w=0.42 l=0.15
X317 VGND v3_four_channel_output_load_integration_0/v3_four_channel_shared_support_integration_0/v3_four_channel_bias_reference_distribution_0/v3_four_channel_phase_distribution_0/v3_four_channel_output_collection_0/v3_four_channel_placement_0/v3_channel_selector_late_promotion_0/v3_selector_route_pilot_0/G2_MUX_NEG/a_505_21# v3_four_channel_output_load_integration_0/v3_four_channel_shared_support_integration_0/v3_four_channel_bias_reference_distribution_0/v3_four_channel_phase_distribution_0/v3_four_channel_output_collection_0/v3_four_channel_placement_0/v3_channel_selector_late_promotion_0/v3_selector_route_pilot_0/G2_MUX_NEG/a_439_47# VGND sky130_fd_pr__nfet_01v8 ad=0 pd=0 as=0.1386 ps=1.5 w=0.42 l=0.15
X318 v3_four_channel_output_load_integration_0/v3_four_channel_shared_support_integration_0/v3_four_channel_bias_reference_distribution_0/v3_four_channel_phase_distribution_0/v3_four_channel_output_collection_0/v3_four_channel_placement_0/v3_channel_selector_late_promotion_0/v3_selector_route_pilot_0/G2_MUX_NEG/a_76_199# v3_four_channel_output_load_integration_0/v3_four_channel_shared_support_integration_0/v3_four_channel_bias_reference_distribution_0/v3_four_channel_phase_distribution_0/phase_180 v3_four_channel_output_load_integration_0/v3_four_channel_shared_support_integration_0/v3_four_channel_bias_reference_distribution_0/v3_four_channel_phase_distribution_0/v3_four_channel_output_collection_0/v3_four_channel_placement_0/v3_channel_selector_late_promotion_0/v3_selector_route_pilot_0/G2_MUX_NEG/a_218_374# VDPWR sky130_fd_pr__pfet_01v8_hvt ad=0.3864 pd=2.68 as=0 ps=0 w=0.42 l=0.15
X319 v3_four_channel_output_load_integration_0/v3_four_channel_shared_support_integration_0/v3_four_channel_bias_reference_distribution_0/v3_four_channel_phase_distribution_0/v3_four_channel_output_collection_0/v3_four_channel_placement_0/v3_channel_selector_late_promotion_0/v3_selector_route_pilot_0/G2_MUX_NEG/a_505_21# v3_four_channel_output_load_integration_0/v3_four_channel_shared_support_integration_0/v3_four_channel_bias_reference_distribution_0/v3_four_channel_phase_distribution_0/v3_four_channel_output_collection_0/v3_four_channel_placement_0/v3_channel_selector_late_promotion_0/group2_bit0 VGND VGND sky130_fd_pr__nfet_01v8 ad=0.1092 pd=1.36 as=0 ps=0 w=0.42 l=0.15
X320 v3_four_channel_output_load_integration_0/v3_four_channel_shared_support_integration_0/v3_four_channel_bias_reference_distribution_0/v3_four_channel_phase_distribution_0/v3_four_channel_output_collection_0/v3_four_channel_placement_0/v3_channel_selector_late_promotion_0/v3_selector_route_pilot_0/G2_MUX_NEG/a_439_47# v3_four_channel_output_load_integration_0/v3_four_channel_shared_support_integration_0/v3_four_channel_bias_reference_distribution_0/v3_four_channel_phase_distribution_0/phase_180 v3_four_channel_output_load_integration_0/v3_four_channel_shared_support_integration_0/v3_four_channel_bias_reference_distribution_0/v3_four_channel_phase_distribution_0/v3_four_channel_output_collection_0/v3_four_channel_placement_0/v3_channel_selector_late_promotion_0/v3_selector_route_pilot_0/G2_MUX_NEG/a_76_199# VGND sky130_fd_pr__nfet_01v8 ad=0 pd=0 as=0.1995 ps=1.79 w=0.42 l=0.15
X321 v3_four_channel_output_load_integration_0/v3_four_channel_shared_support_integration_0/v3_four_channel_bias_reference_distribution_0/v3_four_channel_phase_distribution_0/v3_four_channel_output_collection_0/v3_four_channel_placement_0/v3_channel_selector_late_promotion_0/v3_selector_route_pilot_0/G2_MUX_NEG/a_535_374# v3_four_channel_output_load_integration_0/v3_four_channel_shared_support_integration_0/v3_four_channel_bias_reference_distribution_0/v3_four_channel_phase_distribution_0/phase_270 v3_four_channel_output_load_integration_0/v3_four_channel_shared_support_integration_0/v3_four_channel_bias_reference_distribution_0/v3_four_channel_phase_distribution_0/v3_four_channel_output_collection_0/v3_four_channel_placement_0/v3_channel_selector_late_promotion_0/v3_selector_route_pilot_0/G2_MUX_NEG/a_76_199# VDPWR sky130_fd_pr__pfet_01v8_hvt ad=0 pd=0 as=0 ps=0 w=0.42 l=0.15
X322 v3_four_channel_output_load_integration_0/v3_four_channel_shared_support_integration_0/v3_four_channel_bias_reference_distribution_0/v3_four_channel_phase_distribution_0/v3_four_channel_output_collection_0/v3_four_channel_placement_0/v3_channel_selector_late_promotion_0/v3_selector_route_pilot_0/G2_MUX_NEG/a_76_199# v3_four_channel_output_load_integration_0/v3_four_channel_shared_support_integration_0/v3_four_channel_bias_reference_distribution_0/v3_four_channel_phase_distribution_0/phase_270 v3_four_channel_output_load_integration_0/v3_four_channel_shared_support_integration_0/v3_four_channel_bias_reference_distribution_0/v3_four_channel_phase_distribution_0/v3_four_channel_output_collection_0/v3_four_channel_placement_0/v3_channel_selector_late_promotion_0/v3_selector_route_pilot_0/G2_MUX_NEG/a_218_47# VGND sky130_fd_pr__nfet_01v8 ad=0 pd=0 as=0.1386 ps=1.5 w=0.42 l=0.15
X323 v3_four_channel_output_load_integration_0/v3_four_channel_shared_support_integration_0/v3_four_channel_bias_reference_distribution_0/v3_four_channel_phase_distribution_0/v3_four_channel_output_collection_0/v3_four_channel_placement_0/v3_channel_selector_late_promotion_0/v3_selector_route_pilot_0/G2_MUX_NEG/a_218_47# v3_four_channel_output_load_integration_0/v3_four_channel_shared_support_integration_0/v3_four_channel_bias_reference_distribution_0/v3_four_channel_phase_distribution_0/v3_four_channel_output_collection_0/v3_four_channel_placement_0/v3_channel_selector_late_promotion_0/group2_bit0 VGND VGND sky130_fd_pr__nfet_01v8 ad=0 pd=0 as=0 ps=0 w=0.42 l=0.15
X324 VDPWR v3_four_channel_output_load_integration_0/v3_four_channel_shared_support_integration_0/v3_four_channel_bias_reference_distribution_0/v3_four_channel_phase_distribution_0/v3_four_channel_output_collection_0/v3_four_channel_placement_0/v3_channel_selector_late_promotion_0/v3_selector_route_pilot_0/G2_MUX_NEG/a_76_199# v3_four_channel_output_load_integration_0/v3_four_channel_shared_support_integration_0/v3_four_channel_bias_reference_distribution_0/v3_four_channel_phase_distribution_0/v3_four_channel_output_collection_0/v3_four_channel_placement_0/v3_channel_selector_late_promotion_0/v3_selector_route_pilot_0/G2_MUX_NEG/X VDPWR sky130_fd_pr__pfet_01v8_hvt ad=0 pd=0 as=0.26 ps=2.52 w=1 l=0.15
X325 VGND v3_four_channel_output_load_integration_0/v3_four_channel_shared_support_integration_0/v3_four_channel_bias_reference_distribution_0/v3_four_channel_phase_distribution_0/v3_four_channel_output_collection_0/v3_four_channel_placement_0/v3_channel_selector_late_promotion_0/v3_selector_route_pilot_0/G2_MUX_NEG/a_76_199# v3_four_channel_output_load_integration_0/v3_four_channel_shared_support_integration_0/v3_four_channel_bias_reference_distribution_0/v3_four_channel_phase_distribution_0/v3_four_channel_output_collection_0/v3_four_channel_placement_0/v3_channel_selector_late_promotion_0/v3_selector_route_pilot_0/G2_MUX_NEG/X VGND sky130_fd_pr__nfet_01v8 ad=0 pd=0 as=0.169 ps=1.82 w=0.65 l=0.15
X326 VDPWR v3_four_channel_output_load_integration_0/v3_four_channel_shared_support_integration_0/v3_four_channel_bias_reference_distribution_0/v3_four_channel_phase_distribution_0/v3_four_channel_output_collection_0/v3_four_channel_placement_0/v3_channel_selector_late_promotion_0/v3_selector_route_pilot_0/G0_MUX_AXIS/a_505_21# v3_four_channel_output_load_integration_0/v3_four_channel_shared_support_integration_0/v3_four_channel_bias_reference_distribution_0/v3_four_channel_phase_distribution_0/v3_four_channel_output_collection_0/v3_four_channel_placement_0/v3_channel_selector_late_promotion_0/v3_selector_route_pilot_0/G0_MUX_AXIS/a_535_374# VDPWR sky130_fd_pr__pfet_01v8_hvt ad=0 pd=0 as=0.0882 ps=1.26 w=0.42 l=0.15
X327 v3_four_channel_output_load_integration_0/v3_four_channel_shared_support_integration_0/v3_four_channel_bias_reference_distribution_0/v3_four_channel_phase_distribution_0/v3_four_channel_output_collection_0/v3_four_channel_placement_0/v3_channel_selector_late_promotion_0/v3_selector_route_pilot_0/G0_MUX_AXIS/a_505_21# v3_four_channel_output_load_integration_0/v3_four_channel_shared_support_integration_0/v3_four_channel_bias_reference_distribution_0/v3_four_channel_phase_distribution_0/v3_four_channel_output_collection_0/v3_four_channel_placement_0/v3_channel_selector_late_promotion_0/group0_bit1 VDPWR VDPWR sky130_fd_pr__pfet_01v8_hvt ad=0.1176 pd=1.4 as=0 ps=0 w=0.42 l=0.15
X328 v3_four_channel_output_load_integration_0/v3_four_channel_shared_support_integration_0/v3_four_channel_bias_reference_distribution_0/v3_four_channel_phase_distribution_0/v3_four_channel_output_collection_0/v3_four_channel_placement_0/v3_channel_selector_late_promotion_0/v3_selector_route_pilot_0/G0_MUX_AXIS/a_218_374# v3_four_channel_output_load_integration_0/v3_four_channel_shared_support_integration_0/v3_four_channel_bias_reference_distribution_0/v3_four_channel_phase_distribution_0/v3_four_channel_output_collection_0/v3_four_channel_placement_0/v3_channel_selector_late_promotion_0/group0_bit1 VDPWR VDPWR sky130_fd_pr__pfet_01v8_hvt ad=0.1533 pd=1.57 as=0 ps=0 w=0.42 l=0.15
X329 VGND v3_four_channel_output_load_integration_0/v3_four_channel_shared_support_integration_0/v3_four_channel_bias_reference_distribution_0/v3_four_channel_phase_distribution_0/v3_four_channel_output_collection_0/v3_four_channel_placement_0/v3_channel_selector_late_promotion_0/v3_selector_route_pilot_0/G0_MUX_AXIS/a_505_21# v3_four_channel_output_load_integration_0/v3_four_channel_shared_support_integration_0/v3_four_channel_bias_reference_distribution_0/v3_four_channel_phase_distribution_0/v3_four_channel_output_collection_0/v3_four_channel_placement_0/v3_channel_selector_late_promotion_0/v3_selector_route_pilot_0/G0_MUX_AXIS/a_439_47# VGND sky130_fd_pr__nfet_01v8 ad=0 pd=0 as=0.1386 ps=1.5 w=0.42 l=0.15
X330 v3_four_channel_output_load_integration_0/v3_four_channel_shared_support_integration_0/v3_four_channel_bias_reference_distribution_0/v3_four_channel_phase_distribution_0/v3_four_channel_output_collection_0/v3_four_channel_placement_0/v3_channel_selector_late_promotion_0/v3_selector_route_pilot_0/G0_MUX_AXIS/a_76_199# v3_four_channel_output_load_integration_0/v3_four_channel_shared_support_integration_0/v3_four_channel_bias_reference_distribution_0/v3_four_channel_phase_distribution_0/v3_four_channel_output_collection_0/v3_four_channel_placement_0/v3_channel_selector_late_promotion_0/v3_selector_route_pilot_0/G0_MUX_POS/X v3_four_channel_output_load_integration_0/v3_four_channel_shared_support_integration_0/v3_four_channel_bias_reference_distribution_0/v3_four_channel_phase_distribution_0/v3_four_channel_output_collection_0/v3_four_channel_placement_0/v3_channel_selector_late_promotion_0/v3_selector_route_pilot_0/G0_MUX_AXIS/a_218_374# VDPWR sky130_fd_pr__pfet_01v8_hvt ad=0.3864 pd=2.68 as=0 ps=0 w=0.42 l=0.15
X331 v3_four_channel_output_load_integration_0/v3_four_channel_shared_support_integration_0/v3_four_channel_bias_reference_distribution_0/v3_four_channel_phase_distribution_0/v3_four_channel_output_collection_0/v3_four_channel_placement_0/v3_channel_selector_late_promotion_0/v3_selector_route_pilot_0/G0_MUX_AXIS/a_505_21# v3_four_channel_output_load_integration_0/v3_four_channel_shared_support_integration_0/v3_four_channel_bias_reference_distribution_0/v3_four_channel_phase_distribution_0/v3_four_channel_output_collection_0/v3_four_channel_placement_0/v3_channel_selector_late_promotion_0/group0_bit1 VGND VGND sky130_fd_pr__nfet_01v8 ad=0.1092 pd=1.36 as=0 ps=0 w=0.42 l=0.15
X332 v3_four_channel_output_load_integration_0/v3_four_channel_shared_support_integration_0/v3_four_channel_bias_reference_distribution_0/v3_four_channel_phase_distribution_0/v3_four_channel_output_collection_0/v3_four_channel_placement_0/v3_channel_selector_late_promotion_0/v3_selector_route_pilot_0/G0_MUX_AXIS/a_439_47# v3_four_channel_output_load_integration_0/v3_four_channel_shared_support_integration_0/v3_four_channel_bias_reference_distribution_0/v3_four_channel_phase_distribution_0/v3_four_channel_output_collection_0/v3_four_channel_placement_0/v3_channel_selector_late_promotion_0/v3_selector_route_pilot_0/G0_MUX_POS/X v3_four_channel_output_load_integration_0/v3_four_channel_shared_support_integration_0/v3_four_channel_bias_reference_distribution_0/v3_four_channel_phase_distribution_0/v3_four_channel_output_collection_0/v3_four_channel_placement_0/v3_channel_selector_late_promotion_0/v3_selector_route_pilot_0/G0_MUX_AXIS/a_76_199# VGND sky130_fd_pr__nfet_01v8 ad=0 pd=0 as=0.1995 ps=1.79 w=0.42 l=0.15
X333 v3_four_channel_output_load_integration_0/v3_four_channel_shared_support_integration_0/v3_four_channel_bias_reference_distribution_0/v3_four_channel_phase_distribution_0/v3_four_channel_output_collection_0/v3_four_channel_placement_0/v3_channel_selector_late_promotion_0/v3_selector_route_pilot_0/G0_MUX_AXIS/a_535_374# v3_four_channel_output_load_integration_0/v3_four_channel_shared_support_integration_0/v3_four_channel_bias_reference_distribution_0/v3_four_channel_phase_distribution_0/v3_four_channel_output_collection_0/v3_four_channel_placement_0/v3_channel_selector_late_promotion_0/v3_selector_route_pilot_0/G0_MUX_NEG/X v3_four_channel_output_load_integration_0/v3_four_channel_shared_support_integration_0/v3_four_channel_bias_reference_distribution_0/v3_four_channel_phase_distribution_0/v3_four_channel_output_collection_0/v3_four_channel_placement_0/v3_channel_selector_late_promotion_0/v3_selector_route_pilot_0/G0_MUX_AXIS/a_76_199# VDPWR sky130_fd_pr__pfet_01v8_hvt ad=0 pd=0 as=0 ps=0 w=0.42 l=0.15
X334 v3_four_channel_output_load_integration_0/v3_four_channel_shared_support_integration_0/v3_four_channel_bias_reference_distribution_0/v3_four_channel_phase_distribution_0/v3_four_channel_output_collection_0/v3_four_channel_placement_0/v3_channel_selector_late_promotion_0/v3_selector_route_pilot_0/G0_MUX_AXIS/a_76_199# v3_four_channel_output_load_integration_0/v3_four_channel_shared_support_integration_0/v3_four_channel_bias_reference_distribution_0/v3_four_channel_phase_distribution_0/v3_four_channel_output_collection_0/v3_four_channel_placement_0/v3_channel_selector_late_promotion_0/v3_selector_route_pilot_0/G0_MUX_NEG/X v3_four_channel_output_load_integration_0/v3_four_channel_shared_support_integration_0/v3_four_channel_bias_reference_distribution_0/v3_four_channel_phase_distribution_0/v3_four_channel_output_collection_0/v3_four_channel_placement_0/v3_channel_selector_late_promotion_0/v3_selector_route_pilot_0/G0_MUX_AXIS/a_218_47# VGND sky130_fd_pr__nfet_01v8 ad=0 pd=0 as=0.1386 ps=1.5 w=0.42 l=0.15
X335 v3_four_channel_output_load_integration_0/v3_four_channel_shared_support_integration_0/v3_four_channel_bias_reference_distribution_0/v3_four_channel_phase_distribution_0/v3_four_channel_output_collection_0/v3_four_channel_placement_0/v3_channel_selector_late_promotion_0/v3_selector_route_pilot_0/G0_MUX_AXIS/a_218_47# v3_four_channel_output_load_integration_0/v3_four_channel_shared_support_integration_0/v3_four_channel_bias_reference_distribution_0/v3_four_channel_phase_distribution_0/v3_four_channel_output_collection_0/v3_four_channel_placement_0/v3_channel_selector_late_promotion_0/group0_bit1 VGND VGND sky130_fd_pr__nfet_01v8 ad=0 pd=0 as=0 ps=0 w=0.42 l=0.15
X336 VDPWR v3_four_channel_output_load_integration_0/v3_four_channel_shared_support_integration_0/v3_four_channel_bias_reference_distribution_0/v3_four_channel_phase_distribution_0/v3_four_channel_output_collection_0/v3_four_channel_placement_0/v3_channel_selector_late_promotion_0/v3_selector_route_pilot_0/G0_MUX_AXIS/a_76_199# v3_four_channel_output_load_integration_0/v3_four_channel_shared_support_integration_0/v3_four_channel_bias_reference_distribution_0/v3_four_channel_phase_distribution_0/v3_four_channel_output_collection_0/v3_four_channel_placement_0/v3_channel_selector_late_promotion_0/v3_selector_route_pilot_0/G0_MUX_AXIS/X VDPWR sky130_fd_pr__pfet_01v8_hvt ad=0 pd=0 as=0.26 ps=2.52 w=1 l=0.15
X337 VGND v3_four_channel_output_load_integration_0/v3_four_channel_shared_support_integration_0/v3_four_channel_bias_reference_distribution_0/v3_four_channel_phase_distribution_0/v3_four_channel_output_collection_0/v3_four_channel_placement_0/v3_channel_selector_late_promotion_0/v3_selector_route_pilot_0/G0_MUX_AXIS/a_76_199# v3_four_channel_output_load_integration_0/v3_four_channel_shared_support_integration_0/v3_four_channel_bias_reference_distribution_0/v3_four_channel_phase_distribution_0/v3_four_channel_output_collection_0/v3_four_channel_placement_0/v3_channel_selector_late_promotion_0/v3_selector_route_pilot_0/G0_MUX_AXIS/X VGND sky130_fd_pr__nfet_01v8 ad=0 pd=0 as=0.169 ps=1.82 w=0.65 l=0.15
X338 VDPWR v3_four_channel_output_load_integration_0/v3_four_channel_shared_support_integration_0/v3_four_channel_bias_reference_distribution_0/v3_four_channel_phase_distribution_0/v3_four_channel_output_collection_0/v3_four_channel_placement_0/v3_channel_selector_late_promotion_0/v3_selector_route_pilot_0/G3_LO_P_AND/B v3_four_channel_output_load_integration_0/v3_four_channel_shared_support_integration_0/v3_four_channel_bias_reference_distribution_0/v3_four_channel_phase_distribution_0/v3_four_channel_output_collection_0/v3_four_channel_placement_0/v3_channel_selector_late_promotion_0/v3_selector_route_pilot_0/G2_LO_P_AND/a_59_75# VDPWR sky130_fd_pr__pfet_01v8_hvt ad=0 pd=0 as=0.1134 ps=1.38 w=0.42 l=0.15
X339 v3_four_channel_output_load_integration_0/v3_four_channel_shared_support_integration_0/v3_four_channel_bias_reference_distribution_0/v3_four_channel_phase_distribution_0/v3_four_channel_output_collection_0/v3_four_channel_placement_0/v3_channel_selector_late_promotion_0/v3_selector_route_pilot_0/group2_lo_p v3_four_channel_output_load_integration_0/v3_four_channel_shared_support_integration_0/v3_four_channel_bias_reference_distribution_0/v3_four_channel_phase_distribution_0/v3_four_channel_output_collection_0/v3_four_channel_placement_0/v3_channel_selector_late_promotion_0/v3_selector_route_pilot_0/G2_LO_P_AND/a_59_75# VDPWR VDPWR sky130_fd_pr__pfet_01v8_hvt ad=0.475 pd=2.95 as=0 ps=0 w=1 l=0.15
X340 VGND v3_four_channel_output_load_integration_0/v3_four_channel_shared_support_integration_0/v3_four_channel_bias_reference_distribution_0/v3_four_channel_phase_distribution_0/v3_four_channel_output_collection_0/v3_four_channel_placement_0/v3_channel_selector_late_promotion_0/v3_selector_route_pilot_0/G3_LO_P_AND/B v3_four_channel_output_load_integration_0/v3_four_channel_shared_support_integration_0/v3_four_channel_bias_reference_distribution_0/v3_four_channel_phase_distribution_0/v3_four_channel_output_collection_0/v3_four_channel_placement_0/v3_channel_selector_late_promotion_0/v3_selector_route_pilot_0/G2_LO_P_AND/a_145_75# VGND sky130_fd_pr__nfet_01v8 ad=0 pd=0 as=0.1134 ps=1.38 w=0.42 l=0.15
X341 v3_four_channel_output_load_integration_0/v3_four_channel_shared_support_integration_0/v3_four_channel_bias_reference_distribution_0/v3_four_channel_phase_distribution_0/v3_four_channel_output_collection_0/v3_four_channel_placement_0/v3_channel_selector_late_promotion_0/v3_selector_route_pilot_0/G2_LO_P_AND/a_59_75# v3_four_channel_output_load_integration_0/v3_four_channel_shared_support_integration_0/v3_four_channel_bias_reference_distribution_0/v3_four_channel_phase_distribution_0/v3_four_channel_output_collection_0/v3_four_channel_placement_0/v3_channel_selector_late_promotion_0/v3_selector_route_pilot_0/G2_MUX_AXIS/X VDPWR VDPWR sky130_fd_pr__pfet_01v8_hvt ad=0 pd=0 as=0 ps=0 w=0.42 l=0.15
X342 v3_four_channel_output_load_integration_0/v3_four_channel_shared_support_integration_0/v3_four_channel_bias_reference_distribution_0/v3_four_channel_phase_distribution_0/v3_four_channel_output_collection_0/v3_four_channel_placement_0/v3_channel_selector_late_promotion_0/v3_selector_route_pilot_0/group2_lo_p v3_four_channel_output_load_integration_0/v3_four_channel_shared_support_integration_0/v3_four_channel_bias_reference_distribution_0/v3_four_channel_phase_distribution_0/v3_four_channel_output_collection_0/v3_four_channel_placement_0/v3_channel_selector_late_promotion_0/v3_selector_route_pilot_0/G2_LO_P_AND/a_59_75# VGND VGND sky130_fd_pr__nfet_01v8 ad=0.182 pd=1.86 as=0 ps=0 w=0.65 l=0.15
X343 v3_four_channel_output_load_integration_0/v3_four_channel_shared_support_integration_0/v3_four_channel_bias_reference_distribution_0/v3_four_channel_phase_distribution_0/v3_four_channel_output_collection_0/v3_four_channel_placement_0/v3_channel_selector_late_promotion_0/v3_selector_route_pilot_0/G2_LO_P_AND/a_145_75# v3_four_channel_output_load_integration_0/v3_four_channel_shared_support_integration_0/v3_four_channel_bias_reference_distribution_0/v3_four_channel_phase_distribution_0/v3_four_channel_output_collection_0/v3_four_channel_placement_0/v3_channel_selector_late_promotion_0/v3_selector_route_pilot_0/G2_MUX_AXIS/X v3_four_channel_output_load_integration_0/v3_four_channel_shared_support_integration_0/v3_four_channel_bias_reference_distribution_0/v3_four_channel_phase_distribution_0/v3_four_channel_output_collection_0/v3_four_channel_placement_0/v3_channel_selector_late_promotion_0/v3_selector_route_pilot_0/G2_LO_P_AND/a_59_75# VGND sky130_fd_pr__nfet_01v8 ad=0 pd=0 as=0.1176 ps=1.4 w=0.42 l=0.15
X344 v3_four_channel_output_load_integration_0/v3_four_channel_shared_support_integration_0/v3_four_channel_bias_reference_distribution_0/v3_four_channel_phase_distribution_0/v3_four_channel_output_collection_0/v3_four_channel_placement_0/v3_channel_selector_late_promotion_1/v3_channel_input_bias_late_promotion_0/a_4678_23422# v3_four_channel_output_load_integration_0/v3_four_channel_shared_support_integration_0/v3_four_channel_bias_reference_distribution_0/v3_four_channel_phase_distribution_0/v3_four_channel_output_collection_0/v3_four_channel_placement_0/v3_channel_selector_late_promotion_1/v3_selector_route_pilot_0/group3_lo_p v3_four_channel_output_load_integration_0/combined_n VGND sky130_fd_pr__nfet_01v8 ad=0.6206 pd=6.02 as=22.62 ps=225.60001 w=0.65 l=0.15
X345 v3_four_channel_output_load_integration_0/combined_n v3_four_channel_output_load_integration_0/v3_four_channel_shared_support_integration_0/v3_four_channel_bias_reference_distribution_0/v3_four_channel_phase_distribution_0/v3_four_channel_output_collection_0/v3_four_channel_placement_0/v3_channel_selector_late_promotion_1/v3_selector_route_pilot_0/group3_lo_p v3_four_channel_output_load_integration_0/v3_four_channel_shared_support_integration_0/v3_four_channel_bias_reference_distribution_0/v3_four_channel_phase_distribution_0/v3_four_channel_output_collection_0/v3_four_channel_placement_0/v3_channel_selector_late_promotion_1/v3_channel_input_bias_late_promotion_0/a_4254_6978# VGND sky130_fd_pr__nfet_01v8 ad=0 pd=0 as=0.6206 ps=6.02 w=0.65 l=0.15
X346 v3_four_channel_output_load_integration_0/v3_four_channel_shared_support_integration_0/v3_four_channel_bias_reference_distribution_0/v3_four_channel_phase_distribution_0/v3_four_channel_output_collection_0/v3_four_channel_placement_0/v3_channel_selector_late_promotion_1/v3_channel_input_bias_late_promotion_0/a_4678_23422# v3_four_channel_output_load_integration_0/v3_four_channel_shared_support_integration_0/v3_vcm_support_block_0/ref v3_four_channel_output_load_integration_0/v3_four_channel_shared_support_integration_0/v3_four_channel_bias_reference_distribution_0/v3_four_channel_phase_distribution_0/v3_four_channel_output_collection_0/v3_four_channel_placement_0/v3_channel_selector_late_promotion_1/v3_channel_input_bias_late_promotion_0/a_4382_21688# VGND sky130_fd_pr__nfet_01v8 ad=0 pd=0 as=1.9575 ps=15.24 w=0.84 l=0.6
X347 v3_four_channel_output_load_integration_0/combined_n v3_four_channel_output_load_integration_0/v3_four_channel_shared_support_integration_0/v3_four_channel_bias_reference_distribution_0/v3_four_channel_phase_distribution_0/v3_four_channel_output_collection_0/v3_four_channel_placement_0/v3_channel_selector_late_promotion_1/v3_selector_route_pilot_0/group3_lo_n v3_four_channel_output_load_integration_0/v3_four_channel_shared_support_integration_0/v3_four_channel_bias_reference_distribution_0/v3_four_channel_phase_distribution_0/v3_four_channel_output_collection_0/v3_four_channel_placement_0/v3_channel_selector_late_promotion_1/v3_channel_input_bias_late_promotion_0/a_7038_22978# VGND sky130_fd_pr__nfet_01v8 ad=0 pd=0 as=0.6206 ps=6.02 w=0.65 l=0.15
X348 v3_four_channel_output_load_integration_0/combined_n v3_four_channel_output_load_integration_0/v3_four_channel_shared_support_integration_0/v3_four_channel_bias_reference_distribution_0/v3_four_channel_phase_distribution_0/v3_four_channel_output_collection_0/v3_four_channel_placement_0/v3_channel_selector_late_promotion_1/v3_selector_route_pilot_0/group3_lo_p v3_four_channel_output_load_integration_0/v3_four_channel_shared_support_integration_0/v3_four_channel_bias_reference_distribution_0/v3_four_channel_phase_distribution_0/v3_four_channel_output_collection_0/v3_four_channel_placement_0/v3_channel_selector_late_promotion_1/v3_channel_input_bias_late_promotion_0/a_7038_6978# VGND sky130_fd_pr__nfet_01v8 ad=0 pd=0 as=0.6206 ps=6.02 w=0.65 l=0.15
X349 v3_four_channel_output_load_integration_0/v3_four_channel_shared_support_integration_0/v3_four_channel_bias_reference_distribution_0/v3_four_channel_phase_distribution_0/v3_four_channel_output_collection_0/v3_four_channel_placement_0/v3_channel_selector_late_promotion_1/v3_channel_input_bias_late_promotion_0/a_7462_11422# v3_four_channel_output_load_integration_0/v3_four_channel_shared_support_integration_0/v3_four_channel_bias_reference_distribution_0/v3_four_channel_phase_distribution_0/v3_four_channel_output_collection_0/v3_four_channel_placement_0/v3_channel_selector_late_promotion_1/element_input v3_four_channel_output_load_integration_0/v3_four_channel_shared_support_integration_0/v3_four_channel_bias_reference_distribution_0/v3_four_channel_phase_distribution_0/v3_four_channel_output_collection_0/v3_four_channel_placement_0/v3_channel_selector_late_promotion_1/v3_channel_input_bias_late_promotion_0/a_7216_10978# VGND sky130_fd_pr__nfet_01v8 ad=0.6206 pd=6.02 as=1.9575 ps=15.24 w=0.84 l=0.6
X350 v3_four_channel_output_load_integration_0/v3_four_channel_shared_support_integration_0/v3_four_channel_bias_reference_distribution_0/v3_four_channel_phase_distribution_0/v3_four_channel_output_collection_0/v3_four_channel_placement_0/v3_channel_selector_late_promotion_1/v3_channel_input_bias_late_promotion_0/a_7462_11422# v3_four_channel_output_load_integration_0/v3_four_channel_shared_support_integration_0/v3_four_channel_bias_reference_distribution_0/v3_four_channel_phase_distribution_0/v3_four_channel_output_collection_0/v3_four_channel_placement_0/v3_channel_selector_late_promotion_1/v3_selector_route_pilot_0/group2_lo_n v3_four_channel_output_load_integration_0/combined_n VGND sky130_fd_pr__nfet_01v8 ad=0 pd=0 as=0 ps=0 w=0.65 l=0.15
X351 v3_four_channel_output_load_integration_0/v3_four_channel_shared_support_integration_0/v3_four_channel_bias_reference_distribution_0/v3_four_channel_phase_distribution_0/v3_four_channel_output_collection_0/v3_four_channel_placement_0/v3_channel_selector_late_promotion_1/v3_channel_input_bias_late_promotion_0/a_5774_21688# v3_four_channel_output_load_integration_0/v3_four_channel_shared_support_integration_0/v3_four_channel_bias_reference_distribution_0/v3_four_channel_phase_distribution_0/v3_four_channel_output_collection_0/v3_four_channel_placement_0/v3_channel_selector_late_promotion_1/element_input v3_four_channel_output_load_integration_0/v3_four_channel_shared_support_integration_0/v3_four_channel_bias_reference_distribution_0/v3_four_channel_phase_distribution_0/v3_four_channel_output_collection_0/v3_four_channel_placement_0/v3_channel_selector_late_promotion_1/v3_channel_input_bias_late_promotion_0/a_5646_22978# VGND sky130_fd_pr__nfet_01v8 ad=1.9575 pd=15.24 as=0.6206 ps=6.02 w=0.84 l=0.6
X352 VGND v3_four_channel_output_load_integration_0/v3_four_channel_shared_support_integration_0/v3_tail_bias_support_block_0/vbias v3_four_channel_output_load_integration_0/v3_four_channel_shared_support_integration_0/v3_four_channel_bias_reference_distribution_0/v3_four_channel_phase_distribution_0/v3_four_channel_output_collection_0/v3_four_channel_placement_0/v3_channel_selector_late_promotion_1/v3_channel_input_bias_late_promotion_0/a_5774_17688# VGND sky130_fd_pr__nfet_01v8 ad=0 pd=0 as=1.9575 ps=15.24 w=5.07 l=1
X353 v3_four_channel_output_load_integration_0/v3_four_channel_shared_support_integration_0/v3_four_channel_bias_reference_distribution_0/v3_four_channel_phase_distribution_0/v3_four_channel_output_collection_0/v3_four_channel_placement_0/v3_channel_selector_late_promotion_1/v3_channel_input_bias_late_promotion_0/a_6070_7422# v3_four_channel_output_load_integration_0/v3_four_channel_shared_support_integration_0/v3_four_channel_bias_reference_distribution_0/v3_four_channel_phase_distribution_0/v3_four_channel_output_collection_0/v3_four_channel_placement_0/v3_channel_selector_late_promotion_1/element_input v3_four_channel_output_load_integration_0/v3_four_channel_shared_support_integration_0/v3_four_channel_bias_reference_distribution_0/v3_four_channel_phase_distribution_0/v3_four_channel_output_collection_0/v3_four_channel_placement_0/v3_channel_selector_late_promotion_1/v3_channel_input_bias_late_promotion_0/a_5824_6978# VGND sky130_fd_pr__nfet_01v8 ad=0.6206 pd=6.02 as=1.9575 ps=15.24 w=0.84 l=0.6
X354 v3_four_channel_output_load_integration_0/v3_four_channel_shared_support_integration_0/v3_four_channel_bias_reference_distribution_0/v3_four_channel_phase_distribution_0/v3_four_channel_output_collection_0/v3_four_channel_placement_0/v3_channel_selector_late_promotion_1/v3_channel_input_bias_late_promotion_0/a_6070_7422# v3_four_channel_output_load_integration_0/v3_four_channel_shared_support_integration_0/v3_four_channel_bias_reference_distribution_0/v3_four_channel_phase_distribution_0/v3_four_channel_output_collection_0/v3_four_channel_placement_0/v3_channel_selector_late_promotion_1/v3_selector_route_pilot_0/group3_lo_n v3_four_channel_output_load_integration_0/combined_n VGND sky130_fd_pr__nfet_01v8 ad=0 pd=0 as=0 ps=0 w=0.65 l=0.15
X355 v3_four_channel_output_load_integration_0/v3_four_channel_shared_support_integration_0/v3_vcm_support_block_0/ref v3_four_channel_output_load_integration_0/v3_four_channel_shared_support_integration_0/v3_four_channel_bias_reference_distribution_0/v3_four_channel_phase_distribution_0/v3_four_channel_output_collection_0/v3_four_channel_placement_0/v3_channel_selector_late_promotion_1/element_input VGND sky130_fd_pr__res_xhigh_po_0p35 l=17.36
X356 v3_four_channel_output_load_integration_0/v3_four_channel_shared_support_integration_0/v3_four_channel_bias_reference_distribution_0/v3_four_channel_phase_distribution_0/v3_four_channel_output_collection_0/v3_four_channel_placement_0/v3_channel_selector_late_promotion_1/v3_channel_input_bias_late_promotion_0/a_7462_23422# v3_four_channel_output_load_integration_0/v3_four_channel_shared_support_integration_0/v3_vcm_support_block_0/ref v3_four_channel_output_load_integration_0/v3_four_channel_shared_support_integration_0/v3_four_channel_bias_reference_distribution_0/v3_four_channel_phase_distribution_0/v3_four_channel_output_collection_0/v3_four_channel_placement_0/v3_channel_selector_late_promotion_1/v3_channel_input_bias_late_promotion_0/a_7166_21688# VGND sky130_fd_pr__nfet_01v8 ad=0.6206 pd=6.02 as=1.9575 ps=15.24 w=0.84 l=0.6
X357 v3_four_channel_output_load_integration_0/v3_four_channel_shared_support_integration_0/v3_four_channel_bias_reference_distribution_0/v3_four_channel_phase_distribution_0/v3_four_channel_output_collection_0/v3_four_channel_placement_0/v3_channel_selector_late_promotion_1/v3_channel_input_bias_late_promotion_0/a_7462_23422# v3_four_channel_output_load_integration_0/v3_four_channel_shared_support_integration_0/v3_four_channel_bias_reference_distribution_0/v3_four_channel_phase_distribution_0/v3_four_channel_output_collection_0/v3_four_channel_placement_0/v3_channel_selector_late_promotion_1/v3_selector_route_pilot_0/group3_lo_p v3_four_channel_output_load_integration_0/combined_n VGND sky130_fd_pr__nfet_01v8 ad=0 pd=0 as=0 ps=0 w=0.65 l=0.15
X358 VGND v3_four_channel_output_load_integration_0/v3_four_channel_shared_support_integration_0/v3_tail_bias_support_block_0/vbias v3_four_channel_output_load_integration_0/v3_four_channel_shared_support_integration_0/v3_four_channel_bias_reference_distribution_0/v3_four_channel_phase_distribution_0/v3_four_channel_output_collection_0/v3_four_channel_placement_0/v3_channel_selector_late_promotion_1/v3_channel_input_bias_late_promotion_0/a_4382_21688# VGND sky130_fd_pr__nfet_01v8 ad=0 pd=0 as=0 ps=0 w=5.07 l=1
X359 VGND v3_four_channel_output_load_integration_0/v3_four_channel_shared_support_integration_0/v3_tail_bias_support_block_0/vbias v3_four_channel_output_load_integration_0/v3_four_channel_shared_support_integration_0/v3_four_channel_bias_reference_distribution_0/v3_four_channel_phase_distribution_0/v3_four_channel_output_collection_0/v3_four_channel_placement_0/v3_channel_selector_late_promotion_1/v3_channel_input_bias_late_promotion_0/a_5774_13688# VGND sky130_fd_pr__nfet_01v8 ad=0 pd=0 as=1.9575 ps=15.24 w=5.07 l=1
X360 VGND v3_four_channel_output_load_integration_0/v3_four_channel_shared_support_integration_0/v3_tail_bias_support_block_0/vbias v3_four_channel_output_load_integration_0/v3_four_channel_shared_support_integration_0/v3_four_channel_bias_reference_distribution_0/v3_four_channel_phase_distribution_0/v3_four_channel_output_collection_0/v3_four_channel_placement_0/v3_channel_selector_late_promotion_1/v3_channel_input_bias_late_promotion_0/a_7166_17688# VGND sky130_fd_pr__nfet_01v8 ad=0 pd=0 as=1.9575 ps=15.24 w=5.07 l=1
X361 VGND VGND VGND VGND sky130_fd_pr__nfet_01v8 ad=0 pd=0 as=0 ps=0 w=0.65 l=0.15
X362 v3_four_channel_output_load_integration_0/combined_p v3_four_channel_output_load_integration_0/v3_four_channel_shared_support_integration_0/v3_four_channel_bias_reference_distribution_0/v3_four_channel_phase_distribution_0/v3_four_channel_output_collection_0/v3_four_channel_placement_0/v3_channel_selector_late_promotion_1/v3_selector_route_pilot_0/group3_lo_p v3_four_channel_output_load_integration_0/v3_four_channel_shared_support_integration_0/v3_four_channel_bias_reference_distribution_0/v3_four_channel_phase_distribution_0/v3_four_channel_output_collection_0/v3_four_channel_placement_0/v3_channel_selector_late_promotion_1/v3_channel_input_bias_late_promotion_0/a_5646_18978# VGND sky130_fd_pr__nfet_01v8 ad=22.62 pd=225.60001 as=0.6206 ps=6.02 w=0.65 l=0.15
X363 VGND VGND VGND VGND sky130_fd_pr__nfet_01v8 ad=0 pd=0 as=0 ps=0 w=0.65 l=0.15
X364 v3_four_channel_output_load_integration_0/v3_four_channel_shared_support_integration_0/v3_four_channel_bias_reference_distribution_0/v3_four_channel_phase_distribution_0/v3_four_channel_output_collection_0/v3_four_channel_placement_0/v3_channel_selector_late_promotion_1/v3_channel_input_bias_late_promotion_0/a_6070_19422# v3_four_channel_output_load_integration_0/v3_four_channel_shared_support_integration_0/v3_four_channel_bias_reference_distribution_0/v3_four_channel_phase_distribution_0/v3_four_channel_output_collection_0/v3_four_channel_placement_0/v3_channel_selector_late_promotion_1/v3_selector_route_pilot_0/group3_lo_n v3_four_channel_output_load_integration_0/combined_p VGND sky130_fd_pr__nfet_01v8 ad=0.6206 pd=6.02 as=0 ps=0 w=0.65 l=0.15
X365 VGND VGND VGND VGND sky130_fd_pr__nfet_01v8 ad=0 pd=0 as=0 ps=0 w=0.65 l=0.15
X366 v3_four_channel_output_load_integration_0/combined_p v3_four_channel_output_load_integration_0/v3_four_channel_shared_support_integration_0/v3_four_channel_bias_reference_distribution_0/v3_four_channel_phase_distribution_0/v3_four_channel_output_collection_0/v3_four_channel_placement_0/v3_channel_selector_late_promotion_1/v3_selector_route_pilot_0/group2_lo_p v3_four_channel_output_load_integration_0/v3_four_channel_shared_support_integration_0/v3_four_channel_bias_reference_distribution_0/v3_four_channel_phase_distribution_0/v3_four_channel_output_collection_0/v3_four_channel_placement_0/v3_channel_selector_late_promotion_1/v3_channel_input_bias_late_promotion_0/a_4254_18978# VGND sky130_fd_pr__nfet_01v8 ad=0 pd=0 as=0.6206 ps=6.02 w=0.65 l=0.15
X367 v3_four_channel_output_load_integration_0/v3_four_channel_shared_support_integration_0/v3_four_channel_bias_reference_distribution_0/v3_four_channel_phase_distribution_0/v3_four_channel_output_collection_0/v3_four_channel_placement_0/v3_channel_selector_late_promotion_1/v3_channel_input_bias_late_promotion_0/a_7216_14978# v3_four_channel_output_load_integration_0/v3_four_channel_shared_support_integration_0/v3_tail_bias_support_block_0/vbias VGND VGND sky130_fd_pr__nfet_01v8 ad=1.9575 pd=15.24 as=0 ps=0 w=5.07 l=1
X368 VGND VGND VGND VGND sky130_fd_pr__nfet_01v8 ad=0 pd=0 as=0 ps=0 w=0.65 l=0.15
X369 VGND VGND VGND VGND sky130_fd_pr__nfet_01v8 ad=0 pd=0 as=0 ps=0 w=0.65 l=0.15
X370 v3_four_channel_output_load_integration_0/v3_four_channel_shared_support_integration_0/v3_four_channel_bias_reference_distribution_0/v3_four_channel_phase_distribution_0/v3_four_channel_output_collection_0/v3_four_channel_placement_0/v3_channel_selector_late_promotion_1/v3_channel_input_bias_late_promotion_0/a_4382_17688# v3_four_channel_output_load_integration_0/v3_four_channel_shared_support_integration_0/v3_four_channel_bias_reference_distribution_0/v3_four_channel_phase_distribution_0/v3_four_channel_output_collection_0/v3_four_channel_placement_0/v3_channel_selector_late_promotion_1/element_input v3_four_channel_output_load_integration_0/v3_four_channel_shared_support_integration_0/v3_four_channel_bias_reference_distribution_0/v3_four_channel_phase_distribution_0/v3_four_channel_output_collection_0/v3_four_channel_placement_0/v3_channel_selector_late_promotion_1/v3_channel_input_bias_late_promotion_0/a_4254_18978# VGND sky130_fd_pr__nfet_01v8 ad=1.9575 pd=15.24 as=0 ps=0 w=0.84 l=0.6
X371 v3_four_channel_output_load_integration_0/v3_four_channel_shared_support_integration_0/v3_four_channel_bias_reference_distribution_0/v3_four_channel_phase_distribution_0/v3_four_channel_output_collection_0/v3_four_channel_placement_0/v3_channel_selector_late_promotion_1/v3_channel_input_bias_late_promotion_0/a_4678_19422# v3_four_channel_output_load_integration_0/v3_four_channel_shared_support_integration_0/v3_four_channel_bias_reference_distribution_0/v3_four_channel_phase_distribution_0/v3_four_channel_output_collection_0/v3_four_channel_placement_0/v3_channel_selector_late_promotion_1/v3_selector_route_pilot_0/group2_lo_n v3_four_channel_output_load_integration_0/combined_p VGND sky130_fd_pr__nfet_01v8 ad=0.6206 pd=6.02 as=0 ps=0 w=0.65 l=0.15
X372 v3_four_channel_output_load_integration_0/combined_p v3_four_channel_output_load_integration_0/v3_four_channel_shared_support_integration_0/v3_four_channel_bias_reference_distribution_0/v3_four_channel_phase_distribution_0/v3_four_channel_output_collection_0/v3_four_channel_placement_0/v3_channel_selector_late_promotion_1/v3_selector_route_pilot_0/group0_lo_p v3_four_channel_output_load_integration_0/v3_four_channel_shared_support_integration_0/v3_four_channel_bias_reference_distribution_0/v3_four_channel_phase_distribution_0/v3_four_channel_output_collection_0/v3_four_channel_placement_0/v3_channel_selector_late_promotion_1/v3_channel_input_bias_late_promotion_0/a_5646_14978# VGND sky130_fd_pr__nfet_01v8 ad=0 pd=0 as=0.6206 ps=6.02 w=0.65 l=0.15
X373 v3_four_channel_output_load_integration_0/combined_p v3_four_channel_output_load_integration_0/v3_four_channel_shared_support_integration_0/v3_four_channel_bias_reference_distribution_0/v3_four_channel_phase_distribution_0/v3_four_channel_output_collection_0/v3_four_channel_placement_0/v3_channel_selector_late_promotion_1/v3_selector_route_pilot_0/group2_lo_p v3_four_channel_output_load_integration_0/v3_four_channel_shared_support_integration_0/v3_four_channel_bias_reference_distribution_0/v3_four_channel_phase_distribution_0/v3_four_channel_output_collection_0/v3_four_channel_placement_0/v3_channel_selector_late_promotion_1/v3_channel_input_bias_late_promotion_0/a_7038_18978# VGND sky130_fd_pr__nfet_01v8 ad=0 pd=0 as=0.6206 ps=6.02 w=0.65 l=0.15
X374 VGND VGND VGND VGND sky130_fd_pr__nfet_01v8 ad=0 pd=0 as=0 ps=0 w=5.07 l=1
X375 v3_four_channel_output_load_integration_0/v3_four_channel_shared_support_integration_0/v3_four_channel_bias_reference_distribution_0/v3_four_channel_phase_distribution_0/v3_four_channel_output_collection_0/v3_four_channel_placement_0/v3_channel_selector_late_promotion_1/v3_channel_input_bias_late_promotion_0/a_6070_15422# v3_four_channel_output_load_integration_0/v3_four_channel_shared_support_integration_0/v3_four_channel_bias_reference_distribution_0/v3_four_channel_phase_distribution_0/v3_four_channel_output_collection_0/v3_four_channel_placement_0/v3_channel_selector_late_promotion_1/v3_selector_route_pilot_0/group0_lo_n v3_four_channel_output_load_integration_0/combined_p VGND sky130_fd_pr__nfet_01v8 ad=0.6206 pd=6.02 as=0 ps=0 w=0.65 l=0.15
X376 v3_four_channel_output_load_integration_0/v3_four_channel_shared_support_integration_0/v3_four_channel_bias_reference_distribution_0/v3_four_channel_phase_distribution_0/v3_four_channel_output_collection_0/v3_four_channel_placement_0/v3_channel_selector_late_promotion_1/v3_channel_input_bias_late_promotion_0/a_7166_17688# v3_four_channel_output_load_integration_0/v3_four_channel_shared_support_integration_0/v3_four_channel_bias_reference_distribution_0/v3_four_channel_phase_distribution_0/v3_four_channel_output_collection_0/v3_four_channel_placement_0/v3_channel_selector_late_promotion_1/element_input v3_four_channel_output_load_integration_0/v3_four_channel_shared_support_integration_0/v3_four_channel_bias_reference_distribution_0/v3_four_channel_phase_distribution_0/v3_four_channel_output_collection_0/v3_four_channel_placement_0/v3_channel_selector_late_promotion_1/v3_channel_input_bias_late_promotion_0/a_7038_18978# VGND sky130_fd_pr__nfet_01v8 ad=0 pd=0 as=0 ps=0 w=0.84 l=0.6
X377 v3_four_channel_output_load_integration_0/combined_n v3_four_channel_output_load_integration_0/v3_four_channel_shared_support_integration_0/v3_four_channel_bias_reference_distribution_0/v3_four_channel_phase_distribution_0/v3_four_channel_output_collection_0/v3_four_channel_placement_0/v3_channel_selector_late_promotion_1/v3_selector_route_pilot_0/group3_lo_n v3_four_channel_output_load_integration_0/v3_four_channel_shared_support_integration_0/v3_four_channel_bias_reference_distribution_0/v3_four_channel_phase_distribution_0/v3_four_channel_output_collection_0/v3_four_channel_placement_0/v3_channel_selector_late_promotion_1/v3_channel_input_bias_late_promotion_0/a_5646_18978# VGND sky130_fd_pr__nfet_01v8 ad=0 pd=0 as=0 ps=0 w=0.65 l=0.15
X378 VGND v3_four_channel_output_load_integration_0/v3_four_channel_shared_support_integration_0/v3_tail_bias_support_block_0/vbias v3_four_channel_output_load_integration_0/v3_four_channel_shared_support_integration_0/v3_four_channel_bias_reference_distribution_0/v3_four_channel_phase_distribution_0/v3_four_channel_output_collection_0/v3_four_channel_placement_0/v3_channel_selector_late_promotion_1/v3_channel_input_bias_late_promotion_0/a_5774_21688# VGND sky130_fd_pr__nfet_01v8 ad=0 pd=0 as=0 ps=0 w=5.07 l=1
X379 v3_four_channel_output_load_integration_0/v3_four_channel_shared_support_integration_0/v3_four_channel_bias_reference_distribution_0/v3_four_channel_phase_distribution_0/v3_four_channel_output_collection_0/v3_four_channel_placement_0/v3_channel_selector_late_promotion_1/v3_channel_input_bias_late_promotion_0/a_6070_19422# v3_four_channel_output_load_integration_0/v3_four_channel_shared_support_integration_0/v3_vcm_support_block_0/ref v3_four_channel_output_load_integration_0/v3_four_channel_shared_support_integration_0/v3_four_channel_bias_reference_distribution_0/v3_four_channel_phase_distribution_0/v3_four_channel_output_collection_0/v3_four_channel_placement_0/v3_channel_selector_late_promotion_1/v3_channel_input_bias_late_promotion_0/a_5774_17688# VGND sky130_fd_pr__nfet_01v8 ad=0 pd=0 as=0 ps=0 w=0.84 l=0.6
X380 VGND VGND VGND VGND sky130_fd_pr__nfet_01v8 ad=0 pd=0 as=0 ps=0 w=5.07 l=1
X381 v3_four_channel_output_load_integration_0/combined_p v3_four_channel_output_load_integration_0/v3_four_channel_shared_support_integration_0/v3_four_channel_bias_reference_distribution_0/v3_four_channel_phase_distribution_0/v3_four_channel_output_collection_0/v3_four_channel_placement_0/v3_channel_selector_late_promotion_1/v3_selector_route_pilot_0/group1_lo_p v3_four_channel_output_load_integration_0/v3_four_channel_shared_support_integration_0/v3_four_channel_bias_reference_distribution_0/v3_four_channel_phase_distribution_0/v3_four_channel_output_collection_0/v3_four_channel_placement_0/v3_channel_selector_late_promotion_1/v3_channel_input_bias_late_promotion_0/a_4254_14978# VGND sky130_fd_pr__nfet_01v8 ad=0 pd=0 as=0.6206 ps=6.02 w=0.65 l=0.15
X382 v3_four_channel_output_load_integration_0/v3_four_channel_shared_support_integration_0/v3_four_channel_bias_reference_distribution_0/v3_four_channel_phase_distribution_0/v3_four_channel_output_collection_0/v3_four_channel_placement_0/v3_channel_selector_late_promotion_1/v3_channel_input_bias_late_promotion_0/a_6070_19422# v3_four_channel_output_load_integration_0/v3_four_channel_shared_support_integration_0/v3_four_channel_bias_reference_distribution_0/v3_four_channel_phase_distribution_0/v3_four_channel_output_collection_0/v3_four_channel_placement_0/v3_channel_selector_late_promotion_1/v3_selector_route_pilot_0/group3_lo_p v3_four_channel_output_load_integration_0/combined_n VGND sky130_fd_pr__nfet_01v8 ad=0 pd=0 as=0 ps=0 w=0.65 l=0.15
X383 VGND VGND VGND VGND sky130_fd_pr__nfet_01v8 ad=0 pd=0 as=0 ps=0 w=0.65 l=0.15
X384 v3_four_channel_output_load_integration_0/v3_four_channel_shared_support_integration_0/v3_four_channel_bias_reference_distribution_0/v3_four_channel_phase_distribution_0/v3_four_channel_output_collection_0/v3_four_channel_placement_0/v3_channel_selector_late_promotion_1/v3_channel_input_bias_late_promotion_0/a_5824_10978# v3_four_channel_output_load_integration_0/v3_four_channel_shared_support_integration_0/v3_tail_bias_support_block_0/vbias VGND VGND sky130_fd_pr__nfet_01v8 ad=1.9575 pd=15.24 as=0 ps=0 w=5.07 l=1
X385 v3_four_channel_output_load_integration_0/v3_four_channel_shared_support_integration_0/v3_four_channel_bias_reference_distribution_0/v3_four_channel_phase_distribution_0/v3_four_channel_output_collection_0/v3_four_channel_placement_0/v3_channel_selector_late_promotion_1/v3_channel_input_bias_late_promotion_0/a_4382_13688# v3_four_channel_output_load_integration_0/v3_four_channel_shared_support_integration_0/v3_four_channel_bias_reference_distribution_0/v3_four_channel_phase_distribution_0/v3_four_channel_output_collection_0/v3_four_channel_placement_0/v3_channel_selector_late_promotion_1/element_input v3_four_channel_output_load_integration_0/v3_four_channel_shared_support_integration_0/v3_four_channel_bias_reference_distribution_0/v3_four_channel_phase_distribution_0/v3_four_channel_output_collection_0/v3_four_channel_placement_0/v3_channel_selector_late_promotion_1/v3_channel_input_bias_late_promotion_0/a_4254_14978# VGND sky130_fd_pr__nfet_01v8 ad=1.9575 pd=15.24 as=0 ps=0 w=0.84 l=0.6
X386 v3_four_channel_output_load_integration_0/v3_four_channel_shared_support_integration_0/v3_four_channel_bias_reference_distribution_0/v3_four_channel_phase_distribution_0/v3_four_channel_output_collection_0/v3_four_channel_placement_0/v3_channel_selector_late_promotion_1/v3_channel_input_bias_late_promotion_0/a_4678_15422# v3_four_channel_output_load_integration_0/v3_four_channel_shared_support_integration_0/v3_four_channel_bias_reference_distribution_0/v3_four_channel_phase_distribution_0/v3_four_channel_output_collection_0/v3_four_channel_placement_0/v3_channel_selector_late_promotion_1/v3_selector_route_pilot_0/group1_lo_n v3_four_channel_output_load_integration_0/combined_p VGND sky130_fd_pr__nfet_01v8 ad=0.6206 pd=6.02 as=0 ps=0 w=0.65 l=0.15
X387 v3_four_channel_output_load_integration_0/combined_n v3_four_channel_output_load_integration_0/v3_four_channel_shared_support_integration_0/v3_four_channel_bias_reference_distribution_0/v3_four_channel_phase_distribution_0/v3_four_channel_output_collection_0/v3_four_channel_placement_0/v3_channel_selector_late_promotion_1/v3_selector_route_pilot_0/group2_lo_n v3_four_channel_output_load_integration_0/v3_four_channel_shared_support_integration_0/v3_four_channel_bias_reference_distribution_0/v3_four_channel_phase_distribution_0/v3_four_channel_output_collection_0/v3_four_channel_placement_0/v3_channel_selector_late_promotion_1/v3_channel_input_bias_late_promotion_0/a_4254_18978# VGND sky130_fd_pr__nfet_01v8 ad=0 pd=0 as=0 ps=0 w=0.65 l=0.15
X388 v3_four_channel_output_load_integration_0/combined_p v3_four_channel_output_load_integration_0/v3_four_channel_shared_support_integration_0/v3_four_channel_bias_reference_distribution_0/v3_four_channel_phase_distribution_0/v3_four_channel_output_collection_0/v3_four_channel_placement_0/v3_channel_selector_late_promotion_1/v3_selector_route_pilot_0/group3_lo_n v3_four_channel_output_load_integration_0/v3_four_channel_shared_support_integration_0/v3_four_channel_bias_reference_distribution_0/v3_four_channel_phase_distribution_0/v3_four_channel_output_collection_0/v3_four_channel_placement_0/v3_channel_selector_late_promotion_1/v3_channel_input_bias_late_promotion_0/a_5646_10978# VGND sky130_fd_pr__nfet_01v8 ad=0 pd=0 as=0.6206 ps=6.02 w=0.65 l=0.15
X389 v3_four_channel_output_load_integration_0/combined_p v3_four_channel_output_load_integration_0/v3_four_channel_shared_support_integration_0/v3_four_channel_bias_reference_distribution_0/v3_four_channel_phase_distribution_0/v3_four_channel_output_collection_0/v3_four_channel_placement_0/v3_channel_selector_late_promotion_1/v3_selector_route_pilot_0/group1_lo_n v3_four_channel_output_load_integration_0/v3_four_channel_shared_support_integration_0/v3_four_channel_bias_reference_distribution_0/v3_four_channel_phase_distribution_0/v3_four_channel_output_collection_0/v3_four_channel_placement_0/v3_channel_selector_late_promotion_1/v3_channel_input_bias_late_promotion_0/a_7038_14978# VGND sky130_fd_pr__nfet_01v8 ad=0 pd=0 as=0.6206 ps=6.02 w=0.65 l=0.15
X390 v3_four_channel_output_load_integration_0/v3_four_channel_shared_support_integration_0/v3_four_channel_bias_reference_distribution_0/v3_four_channel_phase_distribution_0/v3_four_channel_output_collection_0/v3_four_channel_placement_0/v3_channel_selector_late_promotion_1/v3_channel_input_bias_late_promotion_0/a_7462_19422# v3_four_channel_output_load_integration_0/v3_four_channel_shared_support_integration_0/v3_four_channel_bias_reference_distribution_0/v3_four_channel_phase_distribution_0/v3_four_channel_output_collection_0/v3_four_channel_placement_0/v3_channel_selector_late_promotion_1/v3_selector_route_pilot_0/group2_lo_n v3_four_channel_output_load_integration_0/combined_p VGND sky130_fd_pr__nfet_01v8 ad=0.6206 pd=6.02 as=0 ps=0 w=0.65 l=0.15
X391 v3_four_channel_output_load_integration_0/v3_four_channel_shared_support_integration_0/v3_four_channel_bias_reference_distribution_0/v3_four_channel_phase_distribution_0/v3_four_channel_output_collection_0/v3_four_channel_placement_0/v3_channel_selector_late_promotion_1/v3_channel_input_bias_late_promotion_0/a_4678_7422# v3_four_channel_output_load_integration_0/v3_four_channel_shared_support_integration_0/v3_four_channel_bias_reference_distribution_0/v3_four_channel_phase_distribution_0/v3_four_channel_output_collection_0/v3_four_channel_placement_0/v3_channel_selector_late_promotion_1/v3_selector_route_pilot_0/group3_lo_p v3_four_channel_output_load_integration_0/combined_p VGND sky130_fd_pr__nfet_01v8 ad=0.6206 pd=6.02 as=0 ps=0 w=0.65 l=0.15
X392 v3_four_channel_output_load_integration_0/v3_four_channel_shared_support_integration_0/v3_four_channel_bias_reference_distribution_0/v3_four_channel_phase_distribution_0/v3_four_channel_output_collection_0/v3_four_channel_placement_0/v3_channel_selector_late_promotion_1/v3_channel_input_bias_late_promotion_0/a_6070_11422# v3_four_channel_output_load_integration_0/v3_four_channel_shared_support_integration_0/v3_four_channel_bias_reference_distribution_0/v3_four_channel_phase_distribution_0/v3_four_channel_output_collection_0/v3_four_channel_placement_0/v3_channel_selector_late_promotion_1/v3_selector_route_pilot_0/group3_lo_p v3_four_channel_output_load_integration_0/combined_p VGND sky130_fd_pr__nfet_01v8 ad=0.6206 pd=6.02 as=0 ps=0 w=0.65 l=0.15
X393 v3_four_channel_output_load_integration_0/v3_four_channel_shared_support_integration_0/v3_four_channel_bias_reference_distribution_0/v3_four_channel_phase_distribution_0/v3_four_channel_output_collection_0/v3_four_channel_placement_0/v3_channel_selector_late_promotion_1/v3_channel_input_bias_late_promotion_0/a_7216_10978# v3_four_channel_output_load_integration_0/v3_four_channel_shared_support_integration_0/v3_tail_bias_support_block_0/vbias VGND VGND sky130_fd_pr__nfet_01v8 ad=0 pd=0 as=0 ps=0 w=5.07 l=1
X394 v3_four_channel_output_load_integration_0/v3_four_channel_shared_support_integration_0/v3_four_channel_bias_reference_distribution_0/v3_four_channel_phase_distribution_0/v3_four_channel_output_collection_0/v3_four_channel_placement_0/v3_channel_selector_late_promotion_1/v3_channel_input_bias_late_promotion_0/a_7216_14978# v3_four_channel_output_load_integration_0/v3_four_channel_shared_support_integration_0/v3_vcm_support_block_0/ref v3_four_channel_output_load_integration_0/v3_four_channel_shared_support_integration_0/v3_four_channel_bias_reference_distribution_0/v3_four_channel_phase_distribution_0/v3_four_channel_output_collection_0/v3_four_channel_placement_0/v3_channel_selector_late_promotion_1/v3_channel_input_bias_late_promotion_0/a_7038_14978# VGND sky130_fd_pr__nfet_01v8 ad=0 pd=0 as=0 ps=0 w=0.84 l=0.6
X395 v3_four_channel_output_load_integration_0/v3_four_channel_shared_support_integration_0/v3_four_channel_bias_reference_distribution_0/v3_four_channel_phase_distribution_0/v3_four_channel_output_collection_0/v3_four_channel_placement_0/v3_channel_selector_late_promotion_1/v3_channel_input_bias_late_promotion_0/a_4678_19422# v3_four_channel_output_load_integration_0/v3_four_channel_shared_support_integration_0/v3_vcm_support_block_0/ref v3_four_channel_output_load_integration_0/v3_four_channel_shared_support_integration_0/v3_four_channel_bias_reference_distribution_0/v3_four_channel_phase_distribution_0/v3_four_channel_output_collection_0/v3_four_channel_placement_0/v3_channel_selector_late_promotion_1/v3_channel_input_bias_late_promotion_0/a_4382_17688# VGND sky130_fd_pr__nfet_01v8 ad=0 pd=0 as=0 ps=0 w=0.84 l=0.6
X396 v3_four_channel_output_load_integration_0/v3_four_channel_shared_support_integration_0/v3_four_channel_bias_reference_distribution_0/v3_four_channel_phase_distribution_0/v3_four_channel_output_collection_0/v3_four_channel_placement_0/v3_channel_selector_late_promotion_1/v3_channel_input_bias_late_promotion_0/a_4678_19422# v3_four_channel_output_load_integration_0/v3_four_channel_shared_support_integration_0/v3_four_channel_bias_reference_distribution_0/v3_four_channel_phase_distribution_0/v3_four_channel_output_collection_0/v3_four_channel_placement_0/v3_channel_selector_late_promotion_1/v3_selector_route_pilot_0/group2_lo_p v3_four_channel_output_load_integration_0/combined_n VGND sky130_fd_pr__nfet_01v8 ad=0 pd=0 as=0 ps=0 w=0.65 l=0.15
X397 v3_four_channel_output_load_integration_0/combined_n v3_four_channel_output_load_integration_0/v3_four_channel_shared_support_integration_0/v3_four_channel_bias_reference_distribution_0/v3_four_channel_phase_distribution_0/v3_four_channel_output_collection_0/v3_four_channel_placement_0/v3_channel_selector_late_promotion_1/v3_selector_route_pilot_0/group0_lo_n v3_four_channel_output_load_integration_0/v3_four_channel_shared_support_integration_0/v3_four_channel_bias_reference_distribution_0/v3_four_channel_phase_distribution_0/v3_four_channel_output_collection_0/v3_four_channel_placement_0/v3_channel_selector_late_promotion_1/v3_channel_input_bias_late_promotion_0/a_5646_14978# VGND sky130_fd_pr__nfet_01v8 ad=0 pd=0 as=0 ps=0 w=0.65 l=0.15
X398 v3_four_channel_output_load_integration_0/combined_n v3_four_channel_output_load_integration_0/v3_four_channel_shared_support_integration_0/v3_four_channel_bias_reference_distribution_0/v3_four_channel_phase_distribution_0/v3_four_channel_output_collection_0/v3_four_channel_placement_0/v3_channel_selector_late_promotion_1/v3_selector_route_pilot_0/group2_lo_n v3_four_channel_output_load_integration_0/v3_four_channel_shared_support_integration_0/v3_four_channel_bias_reference_distribution_0/v3_four_channel_phase_distribution_0/v3_four_channel_output_collection_0/v3_four_channel_placement_0/v3_channel_selector_late_promotion_1/v3_channel_input_bias_late_promotion_0/a_7038_18978# VGND sky130_fd_pr__nfet_01v8 ad=0 pd=0 as=0 ps=0 w=0.65 l=0.15
X399 v3_four_channel_output_load_integration_0/v3_four_channel_shared_support_integration_0/v3_four_channel_bias_reference_distribution_0/v3_four_channel_phase_distribution_0/v3_four_channel_output_collection_0/v3_four_channel_placement_0/v3_channel_selector_late_promotion_1/v3_channel_input_bias_late_promotion_0/a_7462_7422# v3_four_channel_output_load_integration_0/v3_four_channel_shared_support_integration_0/v3_four_channel_bias_reference_distribution_0/v3_four_channel_phase_distribution_0/v3_four_channel_output_collection_0/v3_four_channel_placement_0/v3_channel_selector_late_promotion_1/v3_selector_route_pilot_0/group3_lo_p v3_four_channel_output_load_integration_0/combined_p VGND sky130_fd_pr__nfet_01v8 ad=0.6206 pd=6.02 as=0 ps=0 w=0.65 l=0.15
X400 VGND v3_four_channel_output_load_integration_0/v3_four_channel_shared_support_integration_0/v3_tail_bias_support_block_0/vbias v3_four_channel_output_load_integration_0/v3_four_channel_shared_support_integration_0/v3_four_channel_bias_reference_distribution_0/v3_four_channel_phase_distribution_0/v3_four_channel_output_collection_0/v3_four_channel_placement_0/v3_channel_selector_late_promotion_1/v3_channel_input_bias_late_promotion_0/a_7166_21688# VGND sky130_fd_pr__nfet_01v8 ad=0 pd=0 as=0 ps=0 w=5.07 l=1
X401 v3_four_channel_output_load_integration_0/v3_four_channel_shared_support_integration_0/v3_four_channel_bias_reference_distribution_0/v3_four_channel_phase_distribution_0/v3_four_channel_output_collection_0/v3_four_channel_placement_0/v3_channel_selector_late_promotion_1/v3_channel_input_bias_late_promotion_0/a_6070_15422# v3_four_channel_output_load_integration_0/v3_four_channel_shared_support_integration_0/v3_vcm_support_block_0/ref v3_four_channel_output_load_integration_0/v3_four_channel_shared_support_integration_0/v3_four_channel_bias_reference_distribution_0/v3_four_channel_phase_distribution_0/v3_four_channel_output_collection_0/v3_four_channel_placement_0/v3_channel_selector_late_promotion_1/v3_channel_input_bias_late_promotion_0/a_5774_13688# VGND sky130_fd_pr__nfet_01v8 ad=0 pd=0 as=0 ps=0 w=0.84 l=0.6
X402 v3_four_channel_output_load_integration_0/combined_p v3_four_channel_output_load_integration_0/v3_four_channel_shared_support_integration_0/v3_four_channel_bias_reference_distribution_0/v3_four_channel_phase_distribution_0/v3_four_channel_output_collection_0/v3_four_channel_placement_0/v3_channel_selector_late_promotion_1/v3_selector_route_pilot_0/group2_lo_n v3_four_channel_output_load_integration_0/v3_four_channel_shared_support_integration_0/v3_four_channel_bias_reference_distribution_0/v3_four_channel_phase_distribution_0/v3_four_channel_output_collection_0/v3_four_channel_placement_0/v3_channel_selector_late_promotion_1/v3_channel_input_bias_late_promotion_0/a_4254_10978# VGND sky130_fd_pr__nfet_01v8 ad=0 pd=0 as=0.6206 ps=6.02 w=0.65 l=0.15
X403 v3_four_channel_output_load_integration_0/v3_four_channel_shared_support_integration_0/v3_four_channel_bias_reference_distribution_0/v3_four_channel_phase_distribution_0/v3_four_channel_output_collection_0/v3_four_channel_placement_0/v3_channel_selector_late_promotion_1/v3_channel_input_bias_late_promotion_0/a_6070_15422# v3_four_channel_output_load_integration_0/v3_four_channel_shared_support_integration_0/v3_four_channel_bias_reference_distribution_0/v3_four_channel_phase_distribution_0/v3_four_channel_output_collection_0/v3_four_channel_placement_0/v3_channel_selector_late_promotion_1/v3_selector_route_pilot_0/group0_lo_p v3_four_channel_output_load_integration_0/combined_n VGND sky130_fd_pr__nfet_01v8 ad=0 pd=0 as=0 ps=0 w=0.65 l=0.15
X404 v3_four_channel_output_load_integration_0/v3_four_channel_shared_support_integration_0/v3_four_channel_bias_reference_distribution_0/v3_four_channel_phase_distribution_0/v3_four_channel_output_collection_0/v3_four_channel_placement_0/v3_channel_selector_late_promotion_1/v3_channel_input_bias_late_promotion_0/a_5824_6978# v3_four_channel_output_load_integration_0/v3_four_channel_shared_support_integration_0/v3_vcm_support_block_0/ref v3_four_channel_output_load_integration_0/v3_four_channel_shared_support_integration_0/v3_four_channel_bias_reference_distribution_0/v3_four_channel_phase_distribution_0/v3_four_channel_output_collection_0/v3_four_channel_placement_0/v3_channel_selector_late_promotion_1/v3_channel_input_bias_late_promotion_0/a_5646_6978# VGND sky130_fd_pr__nfet_01v8 ad=0 pd=0 as=0.6206 ps=6.02 w=0.84 l=0.6
X405 v3_four_channel_output_load_integration_0/v3_four_channel_shared_support_integration_0/v3_four_channel_bias_reference_distribution_0/v3_four_channel_phase_distribution_0/v3_four_channel_output_collection_0/v3_four_channel_placement_0/v3_channel_selector_late_promotion_1/v3_channel_input_bias_late_promotion_0/a_5774_17688# v3_four_channel_output_load_integration_0/v3_four_channel_shared_support_integration_0/v3_four_channel_bias_reference_distribution_0/v3_four_channel_phase_distribution_0/v3_four_channel_output_collection_0/v3_four_channel_placement_0/v3_channel_selector_late_promotion_1/element_input v3_four_channel_output_load_integration_0/v3_four_channel_shared_support_integration_0/v3_four_channel_bias_reference_distribution_0/v3_four_channel_phase_distribution_0/v3_four_channel_output_collection_0/v3_four_channel_placement_0/v3_channel_selector_late_promotion_1/v3_channel_input_bias_late_promotion_0/a_5646_18978# VGND sky130_fd_pr__nfet_01v8 ad=0 pd=0 as=0 ps=0 w=0.84 l=0.6
X406 v3_four_channel_output_load_integration_0/combined_p v3_four_channel_output_load_integration_0/v3_four_channel_shared_support_integration_0/v3_four_channel_bias_reference_distribution_0/v3_four_channel_phase_distribution_0/v3_four_channel_output_collection_0/v3_four_channel_placement_0/v3_channel_selector_late_promotion_1/v3_selector_route_pilot_0/group3_lo_p v3_four_channel_output_load_integration_0/v3_four_channel_shared_support_integration_0/v3_four_channel_bias_reference_distribution_0/v3_four_channel_phase_distribution_0/v3_four_channel_output_collection_0/v3_four_channel_placement_0/v3_channel_selector_late_promotion_1/v3_channel_input_bias_late_promotion_0/a_5646_22978# VGND sky130_fd_pr__nfet_01v8 ad=0 pd=0 as=0 ps=0 w=0.65 l=0.15
X407 v3_four_channel_output_load_integration_0/v3_four_channel_shared_support_integration_0/v3_four_channel_bias_reference_distribution_0/v3_four_channel_phase_distribution_0/v3_four_channel_output_collection_0/v3_four_channel_placement_0/v3_channel_selector_late_promotion_1/v3_channel_input_bias_late_promotion_0/a_5824_6978# v3_four_channel_output_load_integration_0/v3_four_channel_shared_support_integration_0/v3_tail_bias_support_block_0/vbias VGND VGND sky130_fd_pr__nfet_01v8 ad=0 pd=0 as=0 ps=0 w=5.07 l=1
X408 v3_four_channel_output_load_integration_0/v3_four_channel_shared_support_integration_0/v3_four_channel_bias_reference_distribution_0/v3_four_channel_phase_distribution_0/v3_four_channel_output_collection_0/v3_four_channel_placement_0/v3_channel_selector_late_promotion_1/v3_channel_input_bias_late_promotion_0/a_4432_10978# v3_four_channel_output_load_integration_0/v3_four_channel_shared_support_integration_0/v3_vcm_support_block_0/ref v3_four_channel_output_load_integration_0/v3_four_channel_shared_support_integration_0/v3_four_channel_bias_reference_distribution_0/v3_four_channel_phase_distribution_0/v3_four_channel_output_collection_0/v3_four_channel_placement_0/v3_channel_selector_late_promotion_1/v3_channel_input_bias_late_promotion_0/a_4254_10978# VGND sky130_fd_pr__nfet_01v8 ad=1.9575 pd=15.24 as=0 ps=0 w=0.84 l=0.6
X409 v3_four_channel_output_load_integration_0/v3_four_channel_shared_support_integration_0/v3_four_channel_bias_reference_distribution_0/v3_four_channel_phase_distribution_0/v3_four_channel_output_collection_0/v3_four_channel_placement_0/v3_channel_selector_late_promotion_1/v3_channel_input_bias_late_promotion_0/a_4678_11422# v3_four_channel_output_load_integration_0/v3_four_channel_shared_support_integration_0/v3_four_channel_bias_reference_distribution_0/v3_four_channel_phase_distribution_0/v3_four_channel_output_collection_0/v3_four_channel_placement_0/v3_channel_selector_late_promotion_1/v3_selector_route_pilot_0/group2_lo_p v3_four_channel_output_load_integration_0/combined_p VGND sky130_fd_pr__nfet_01v8 ad=0.6206 pd=6.02 as=0 ps=0 w=0.65 l=0.15
X410 v3_four_channel_output_load_integration_0/v3_four_channel_shared_support_integration_0/v3_four_channel_bias_reference_distribution_0/v3_four_channel_phase_distribution_0/v3_four_channel_output_collection_0/v3_four_channel_placement_0/v3_channel_selector_late_promotion_1/v3_channel_input_bias_late_promotion_0/a_6070_23422# v3_four_channel_output_load_integration_0/v3_four_channel_shared_support_integration_0/v3_four_channel_bias_reference_distribution_0/v3_four_channel_phase_distribution_0/v3_four_channel_output_collection_0/v3_four_channel_placement_0/v3_channel_selector_late_promotion_1/v3_selector_route_pilot_0/group3_lo_n v3_four_channel_output_load_integration_0/combined_p VGND sky130_fd_pr__nfet_01v8 ad=0.6206 pd=6.02 as=0 ps=0 w=0.65 l=0.15
X411 v3_four_channel_output_load_integration_0/combined_n v3_four_channel_output_load_integration_0/v3_four_channel_shared_support_integration_0/v3_four_channel_bias_reference_distribution_0/v3_four_channel_phase_distribution_0/v3_four_channel_output_collection_0/v3_four_channel_placement_0/v3_channel_selector_late_promotion_1/v3_selector_route_pilot_0/group1_lo_n v3_four_channel_output_load_integration_0/v3_four_channel_shared_support_integration_0/v3_four_channel_bias_reference_distribution_0/v3_four_channel_phase_distribution_0/v3_four_channel_output_collection_0/v3_four_channel_placement_0/v3_channel_selector_late_promotion_1/v3_channel_input_bias_late_promotion_0/a_4254_14978# VGND sky130_fd_pr__nfet_01v8 ad=0 pd=0 as=0 ps=0 w=0.65 l=0.15
X412 v3_four_channel_output_load_integration_0/combined_p v3_four_channel_output_load_integration_0/v3_four_channel_shared_support_integration_0/v3_four_channel_bias_reference_distribution_0/v3_four_channel_phase_distribution_0/v3_four_channel_output_collection_0/v3_four_channel_placement_0/v3_channel_selector_late_promotion_1/v3_selector_route_pilot_0/group2_lo_n v3_four_channel_output_load_integration_0/v3_four_channel_shared_support_integration_0/v3_four_channel_bias_reference_distribution_0/v3_four_channel_phase_distribution_0/v3_four_channel_output_collection_0/v3_four_channel_placement_0/v3_channel_selector_late_promotion_1/v3_channel_input_bias_late_promotion_0/a_7038_10978# VGND sky130_fd_pr__nfet_01v8 ad=0 pd=0 as=0.6206 ps=6.02 w=0.65 l=0.15
X413 v3_four_channel_output_load_integration_0/v3_four_channel_shared_support_integration_0/v3_four_channel_bias_reference_distribution_0/v3_four_channel_phase_distribution_0/v3_four_channel_output_collection_0/v3_four_channel_placement_0/v3_channel_selector_late_promotion_1/v3_channel_input_bias_late_promotion_0/a_7462_15422# v3_four_channel_output_load_integration_0/v3_four_channel_shared_support_integration_0/v3_four_channel_bias_reference_distribution_0/v3_four_channel_phase_distribution_0/v3_four_channel_output_collection_0/v3_four_channel_placement_0/v3_channel_selector_late_promotion_1/v3_selector_route_pilot_0/group1_lo_p v3_four_channel_output_load_integration_0/combined_p VGND sky130_fd_pr__nfet_01v8 ad=0.6206 pd=6.02 as=0 ps=0 w=0.65 l=0.15
X414 VGND VGND VGND VGND sky130_fd_pr__nfet_01v8 ad=0 pd=0 as=0 ps=0 w=5.07 l=1
X415 v3_four_channel_output_load_integration_0/v3_four_channel_shared_support_integration_0/v3_four_channel_bias_reference_distribution_0/v3_four_channel_phase_distribution_0/v3_four_channel_output_collection_0/v3_four_channel_placement_0/v3_channel_selector_late_promotion_1/v3_channel_input_bias_late_promotion_0/a_7216_6978# v3_four_channel_output_load_integration_0/v3_four_channel_shared_support_integration_0/v3_tail_bias_support_block_0/vbias VGND VGND sky130_fd_pr__nfet_01v8 ad=1.9575 pd=15.24 as=0 ps=0 w=5.07 l=1
X416 v3_four_channel_output_load_integration_0/v3_four_channel_shared_support_integration_0/v3_four_channel_bias_reference_distribution_0/v3_four_channel_phase_distribution_0/v3_four_channel_output_collection_0/v3_four_channel_placement_0/v3_channel_selector_late_promotion_1/v3_channel_input_bias_late_promotion_0/a_7216_10978# v3_four_channel_output_load_integration_0/v3_four_channel_shared_support_integration_0/v3_vcm_support_block_0/ref v3_four_channel_output_load_integration_0/v3_four_channel_shared_support_integration_0/v3_four_channel_bias_reference_distribution_0/v3_four_channel_phase_distribution_0/v3_four_channel_output_collection_0/v3_four_channel_placement_0/v3_channel_selector_late_promotion_1/v3_channel_input_bias_late_promotion_0/a_7038_10978# VGND sky130_fd_pr__nfet_01v8 ad=0 pd=0 as=0 ps=0 w=0.84 l=0.6
X417 v3_four_channel_output_load_integration_0/v3_four_channel_shared_support_integration_0/v3_four_channel_bias_reference_distribution_0/v3_four_channel_phase_distribution_0/v3_four_channel_output_collection_0/v3_four_channel_placement_0/v3_channel_selector_late_promotion_1/v3_channel_input_bias_late_promotion_0/a_4678_15422# v3_four_channel_output_load_integration_0/v3_four_channel_shared_support_integration_0/v3_vcm_support_block_0/ref v3_four_channel_output_load_integration_0/v3_four_channel_shared_support_integration_0/v3_four_channel_bias_reference_distribution_0/v3_four_channel_phase_distribution_0/v3_four_channel_output_collection_0/v3_four_channel_placement_0/v3_channel_selector_late_promotion_1/v3_channel_input_bias_late_promotion_0/a_4382_13688# VGND sky130_fd_pr__nfet_01v8 ad=0 pd=0 as=0 ps=0 w=0.84 l=0.6
X418 v3_four_channel_output_load_integration_0/v3_four_channel_shared_support_integration_0/v3_four_channel_bias_reference_distribution_0/v3_four_channel_phase_distribution_0/v3_four_channel_output_collection_0/v3_four_channel_placement_0/v3_channel_selector_late_promotion_1/v3_channel_input_bias_late_promotion_0/a_4678_15422# v3_four_channel_output_load_integration_0/v3_four_channel_shared_support_integration_0/v3_four_channel_bias_reference_distribution_0/v3_four_channel_phase_distribution_0/v3_four_channel_output_collection_0/v3_four_channel_placement_0/v3_channel_selector_late_promotion_1/v3_selector_route_pilot_0/group1_lo_p v3_four_channel_output_load_integration_0/combined_n VGND sky130_fd_pr__nfet_01v8 ad=0 pd=0 as=0 ps=0 w=0.65 l=0.15
X419 v3_four_channel_output_load_integration_0/combined_p v3_four_channel_output_load_integration_0/v3_four_channel_shared_support_integration_0/v3_four_channel_bias_reference_distribution_0/v3_four_channel_phase_distribution_0/v3_four_channel_output_collection_0/v3_four_channel_placement_0/v3_channel_selector_late_promotion_1/v3_selector_route_pilot_0/group3_lo_p v3_four_channel_output_load_integration_0/v3_four_channel_shared_support_integration_0/v3_four_channel_bias_reference_distribution_0/v3_four_channel_phase_distribution_0/v3_four_channel_output_collection_0/v3_four_channel_placement_0/v3_channel_selector_late_promotion_1/v3_channel_input_bias_late_promotion_0/a_4254_22978# VGND sky130_fd_pr__nfet_01v8 ad=0 pd=0 as=0.6206 ps=6.02 w=0.65 l=0.15
X420 v3_four_channel_output_load_integration_0/v3_four_channel_shared_support_integration_0/v3_four_channel_bias_reference_distribution_0/v3_four_channel_phase_distribution_0/v3_four_channel_output_collection_0/v3_four_channel_placement_0/v3_channel_selector_late_promotion_1/v3_channel_input_bias_late_promotion_0/a_7462_19422# v3_four_channel_output_load_integration_0/v3_four_channel_shared_support_integration_0/v3_vcm_support_block_0/ref v3_four_channel_output_load_integration_0/v3_four_channel_shared_support_integration_0/v3_four_channel_bias_reference_distribution_0/v3_four_channel_phase_distribution_0/v3_four_channel_output_collection_0/v3_four_channel_placement_0/v3_channel_selector_late_promotion_1/v3_channel_input_bias_late_promotion_0/a_7166_17688# VGND sky130_fd_pr__nfet_01v8 ad=0 pd=0 as=0 ps=0 w=0.84 l=0.6
X421 v3_four_channel_output_load_integration_0/combined_n v3_four_channel_output_load_integration_0/v3_four_channel_shared_support_integration_0/v3_four_channel_bias_reference_distribution_0/v3_four_channel_phase_distribution_0/v3_four_channel_output_collection_0/v3_four_channel_placement_0/v3_channel_selector_late_promotion_1/v3_selector_route_pilot_0/group3_lo_p v3_four_channel_output_load_integration_0/v3_four_channel_shared_support_integration_0/v3_four_channel_bias_reference_distribution_0/v3_four_channel_phase_distribution_0/v3_four_channel_output_collection_0/v3_four_channel_placement_0/v3_channel_selector_late_promotion_1/v3_channel_input_bias_late_promotion_0/a_5646_10978# VGND sky130_fd_pr__nfet_01v8 ad=0 pd=0 as=0 ps=0 w=0.65 l=0.15
X422 v3_four_channel_output_load_integration_0/combined_n v3_four_channel_output_load_integration_0/v3_four_channel_shared_support_integration_0/v3_four_channel_bias_reference_distribution_0/v3_four_channel_phase_distribution_0/v3_four_channel_output_collection_0/v3_four_channel_placement_0/v3_channel_selector_late_promotion_1/v3_selector_route_pilot_0/group1_lo_p v3_four_channel_output_load_integration_0/v3_four_channel_shared_support_integration_0/v3_four_channel_bias_reference_distribution_0/v3_four_channel_phase_distribution_0/v3_four_channel_output_collection_0/v3_four_channel_placement_0/v3_channel_selector_late_promotion_1/v3_channel_input_bias_late_promotion_0/a_7038_14978# VGND sky130_fd_pr__nfet_01v8 ad=0 pd=0 as=0 ps=0 w=0.65 l=0.15
X423 v3_four_channel_output_load_integration_0/v3_four_channel_shared_support_integration_0/v3_four_channel_bias_reference_distribution_0/v3_four_channel_phase_distribution_0/v3_four_channel_output_collection_0/v3_four_channel_placement_0/v3_channel_selector_late_promotion_1/v3_channel_input_bias_late_promotion_0/a_7462_19422# v3_four_channel_output_load_integration_0/v3_four_channel_shared_support_integration_0/v3_four_channel_bias_reference_distribution_0/v3_four_channel_phase_distribution_0/v3_four_channel_output_collection_0/v3_four_channel_placement_0/v3_channel_selector_late_promotion_1/v3_selector_route_pilot_0/group2_lo_p v3_four_channel_output_load_integration_0/combined_n VGND sky130_fd_pr__nfet_01v8 ad=0 pd=0 as=0 ps=0 w=0.65 l=0.15
X424 v3_four_channel_output_load_integration_0/v3_four_channel_shared_support_integration_0/v3_four_channel_bias_reference_distribution_0/v3_four_channel_phase_distribution_0/v3_four_channel_output_collection_0/v3_four_channel_placement_0/v3_channel_selector_late_promotion_1/v3_channel_input_bias_late_promotion_0/a_4678_7422# v3_four_channel_output_load_integration_0/v3_four_channel_shared_support_integration_0/v3_four_channel_bias_reference_distribution_0/v3_four_channel_phase_distribution_0/v3_four_channel_output_collection_0/v3_four_channel_placement_0/v3_channel_selector_late_promotion_1/element_input v3_four_channel_output_load_integration_0/v3_four_channel_shared_support_integration_0/v3_four_channel_bias_reference_distribution_0/v3_four_channel_phase_distribution_0/v3_four_channel_output_collection_0/v3_four_channel_placement_0/v3_channel_selector_late_promotion_1/v3_channel_input_bias_late_promotion_0/a_4432_6978# VGND sky130_fd_pr__nfet_01v8 ad=0 pd=0 as=1.9575 ps=15.24 w=0.84 l=0.6
X425 v3_four_channel_output_load_integration_0/combined_p v3_four_channel_output_load_integration_0/v3_four_channel_shared_support_integration_0/v3_four_channel_bias_reference_distribution_0/v3_four_channel_phase_distribution_0/v3_four_channel_output_collection_0/v3_four_channel_placement_0/v3_channel_selector_late_promotion_1/v3_selector_route_pilot_0/group3_lo_n v3_four_channel_output_load_integration_0/v3_four_channel_shared_support_integration_0/v3_four_channel_bias_reference_distribution_0/v3_four_channel_phase_distribution_0/v3_four_channel_output_collection_0/v3_four_channel_placement_0/v3_channel_selector_late_promotion_1/v3_channel_input_bias_late_promotion_0/a_5646_6978# VGND sky130_fd_pr__nfet_01v8 ad=0 pd=0 as=0 ps=0 w=0.65 l=0.15
X426 v3_four_channel_output_load_integration_0/v3_four_channel_shared_support_integration_0/v3_four_channel_bias_reference_distribution_0/v3_four_channel_phase_distribution_0/v3_four_channel_output_collection_0/v3_four_channel_placement_0/v3_channel_selector_late_promotion_1/v3_channel_input_bias_late_promotion_0/a_4678_7422# v3_four_channel_output_load_integration_0/v3_four_channel_shared_support_integration_0/v3_four_channel_bias_reference_distribution_0/v3_four_channel_phase_distribution_0/v3_four_channel_output_collection_0/v3_four_channel_placement_0/v3_channel_selector_late_promotion_1/v3_selector_route_pilot_0/group3_lo_n v3_four_channel_output_load_integration_0/combined_n VGND sky130_fd_pr__nfet_01v8 ad=0 pd=0 as=0 ps=0 w=0.65 l=0.15
X427 v3_four_channel_output_load_integration_0/v3_four_channel_shared_support_integration_0/v3_four_channel_bias_reference_distribution_0/v3_four_channel_phase_distribution_0/v3_four_channel_output_collection_0/v3_four_channel_placement_0/v3_channel_selector_late_promotion_1/v3_channel_input_bias_late_promotion_0/a_6070_11422# v3_four_channel_output_load_integration_0/v3_four_channel_shared_support_integration_0/v3_four_channel_bias_reference_distribution_0/v3_four_channel_phase_distribution_0/v3_four_channel_output_collection_0/v3_four_channel_placement_0/v3_channel_selector_late_promotion_1/element_input v3_four_channel_output_load_integration_0/v3_four_channel_shared_support_integration_0/v3_four_channel_bias_reference_distribution_0/v3_four_channel_phase_distribution_0/v3_four_channel_output_collection_0/v3_four_channel_placement_0/v3_channel_selector_late_promotion_1/v3_channel_input_bias_late_promotion_0/a_5824_10978# VGND sky130_fd_pr__nfet_01v8 ad=0 pd=0 as=0 ps=0 w=0.84 l=0.6
X428 v3_four_channel_output_load_integration_0/v3_four_channel_shared_support_integration_0/v3_four_channel_bias_reference_distribution_0/v3_four_channel_phase_distribution_0/v3_four_channel_output_collection_0/v3_four_channel_placement_0/v3_channel_selector_late_promotion_1/v3_channel_input_bias_late_promotion_0/a_6070_11422# v3_four_channel_output_load_integration_0/v3_four_channel_shared_support_integration_0/v3_four_channel_bias_reference_distribution_0/v3_four_channel_phase_distribution_0/v3_four_channel_output_collection_0/v3_four_channel_placement_0/v3_channel_selector_late_promotion_1/v3_selector_route_pilot_0/group3_lo_n v3_four_channel_output_load_integration_0/combined_n VGND sky130_fd_pr__nfet_01v8 ad=0 pd=0 as=0 ps=0 w=0.65 l=0.15
X429 v3_four_channel_output_load_integration_0/v3_four_channel_shared_support_integration_0/v3_four_channel_bias_reference_distribution_0/v3_four_channel_phase_distribution_0/v3_four_channel_output_collection_0/v3_four_channel_placement_0/v3_channel_selector_late_promotion_1/v3_channel_input_bias_late_promotion_0/a_4382_21688# v3_four_channel_output_load_integration_0/v3_four_channel_shared_support_integration_0/v3_four_channel_bias_reference_distribution_0/v3_four_channel_phase_distribution_0/v3_four_channel_output_collection_0/v3_four_channel_placement_0/v3_channel_selector_late_promotion_1/element_input v3_four_channel_output_load_integration_0/v3_four_channel_shared_support_integration_0/v3_four_channel_bias_reference_distribution_0/v3_four_channel_phase_distribution_0/v3_four_channel_output_collection_0/v3_four_channel_placement_0/v3_channel_selector_late_promotion_1/v3_channel_input_bias_late_promotion_0/a_4254_22978# VGND sky130_fd_pr__nfet_01v8 ad=0 pd=0 as=0 ps=0 w=0.84 l=0.6
X430 v3_four_channel_output_load_integration_0/v3_four_channel_shared_support_integration_0/v3_four_channel_bias_reference_distribution_0/v3_four_channel_phase_distribution_0/v3_four_channel_output_collection_0/v3_four_channel_placement_0/v3_channel_selector_late_promotion_1/v3_channel_input_bias_late_promotion_0/a_4678_23422# v3_four_channel_output_load_integration_0/v3_four_channel_shared_support_integration_0/v3_four_channel_bias_reference_distribution_0/v3_four_channel_phase_distribution_0/v3_four_channel_output_collection_0/v3_four_channel_placement_0/v3_channel_selector_late_promotion_1/v3_selector_route_pilot_0/group3_lo_n v3_four_channel_output_load_integration_0/combined_p VGND sky130_fd_pr__nfet_01v8 ad=0 pd=0 as=0 ps=0 w=0.65 l=0.15
X431 v3_four_channel_output_load_integration_0/combined_p v3_four_channel_output_load_integration_0/v3_four_channel_shared_support_integration_0/v3_four_channel_bias_reference_distribution_0/v3_four_channel_phase_distribution_0/v3_four_channel_output_collection_0/v3_four_channel_placement_0/v3_channel_selector_late_promotion_1/v3_selector_route_pilot_0/group3_lo_n v3_four_channel_output_load_integration_0/v3_four_channel_shared_support_integration_0/v3_four_channel_bias_reference_distribution_0/v3_four_channel_phase_distribution_0/v3_four_channel_output_collection_0/v3_four_channel_placement_0/v3_channel_selector_late_promotion_1/v3_channel_input_bias_late_promotion_0/a_4254_6978# VGND sky130_fd_pr__nfet_01v8 ad=0 pd=0 as=0 ps=0 w=0.65 l=0.15
X432 v3_four_channel_output_load_integration_0/v3_four_channel_shared_support_integration_0/v3_four_channel_bias_reference_distribution_0/v3_four_channel_phase_distribution_0/v3_four_channel_output_collection_0/v3_four_channel_placement_0/v3_channel_selector_late_promotion_1/v3_channel_input_bias_late_promotion_0/a_5774_13688# v3_four_channel_output_load_integration_0/v3_four_channel_shared_support_integration_0/v3_four_channel_bias_reference_distribution_0/v3_four_channel_phase_distribution_0/v3_four_channel_output_collection_0/v3_four_channel_placement_0/v3_channel_selector_late_promotion_1/element_input v3_four_channel_output_load_integration_0/v3_four_channel_shared_support_integration_0/v3_four_channel_bias_reference_distribution_0/v3_four_channel_phase_distribution_0/v3_four_channel_output_collection_0/v3_four_channel_placement_0/v3_channel_selector_late_promotion_1/v3_channel_input_bias_late_promotion_0/a_5646_14978# VGND sky130_fd_pr__nfet_01v8 ad=0 pd=0 as=0 ps=0 w=0.84 l=0.6
X433 v3_four_channel_output_load_integration_0/combined_p v3_four_channel_output_load_integration_0/v3_four_channel_shared_support_integration_0/v3_four_channel_bias_reference_distribution_0/v3_four_channel_phase_distribution_0/v3_four_channel_output_collection_0/v3_four_channel_placement_0/v3_channel_selector_late_promotion_1/v3_selector_route_pilot_0/group3_lo_p v3_four_channel_output_load_integration_0/v3_four_channel_shared_support_integration_0/v3_four_channel_bias_reference_distribution_0/v3_four_channel_phase_distribution_0/v3_four_channel_output_collection_0/v3_four_channel_placement_0/v3_channel_selector_late_promotion_1/v3_channel_input_bias_late_promotion_0/a_7038_22978# VGND sky130_fd_pr__nfet_01v8 ad=0 pd=0 as=0 ps=0 w=0.65 l=0.15
X434 v3_four_channel_output_load_integration_0/v3_four_channel_shared_support_integration_0/v3_four_channel_bias_reference_distribution_0/v3_four_channel_phase_distribution_0/v3_four_channel_output_collection_0/v3_four_channel_placement_0/v3_channel_selector_late_promotion_1/v3_channel_input_bias_late_promotion_0/a_7462_7422# v3_four_channel_output_load_integration_0/v3_four_channel_shared_support_integration_0/v3_four_channel_bias_reference_distribution_0/v3_four_channel_phase_distribution_0/v3_four_channel_output_collection_0/v3_four_channel_placement_0/v3_channel_selector_late_promotion_1/element_input v3_four_channel_output_load_integration_0/v3_four_channel_shared_support_integration_0/v3_four_channel_bias_reference_distribution_0/v3_four_channel_phase_distribution_0/v3_four_channel_output_collection_0/v3_four_channel_placement_0/v3_channel_selector_late_promotion_1/v3_channel_input_bias_late_promotion_0/a_7216_6978# VGND sky130_fd_pr__nfet_01v8 ad=0 pd=0 as=0 ps=0 w=0.84 l=0.6
X435 v3_four_channel_output_load_integration_0/v3_four_channel_shared_support_integration_0/v3_four_channel_bias_reference_distribution_0/v3_four_channel_phase_distribution_0/v3_four_channel_output_collection_0/v3_four_channel_placement_0/v3_channel_selector_late_promotion_1/v3_channel_input_bias_late_promotion_0/a_4432_10978# v3_four_channel_output_load_integration_0/v3_four_channel_shared_support_integration_0/v3_tail_bias_support_block_0/vbias VGND VGND sky130_fd_pr__nfet_01v8 ad=0 pd=0 as=0 ps=0 w=5.07 l=1
X436 v3_four_channel_output_load_integration_0/v3_four_channel_shared_support_integration_0/v3_four_channel_bias_reference_distribution_0/v3_four_channel_phase_distribution_0/v3_four_channel_output_collection_0/v3_four_channel_placement_0/v3_channel_selector_late_promotion_1/v3_channel_input_bias_late_promotion_0/a_7462_7422# v3_four_channel_output_load_integration_0/v3_four_channel_shared_support_integration_0/v3_four_channel_bias_reference_distribution_0/v3_four_channel_phase_distribution_0/v3_four_channel_output_collection_0/v3_four_channel_placement_0/v3_channel_selector_late_promotion_1/v3_selector_route_pilot_0/group3_lo_n v3_four_channel_output_load_integration_0/combined_n VGND sky130_fd_pr__nfet_01v8 ad=0 pd=0 as=0 ps=0 w=0.65 l=0.15
X437 VGND v3_four_channel_output_load_integration_0/v3_four_channel_shared_support_integration_0/v3_tail_bias_support_block_0/vbias v3_four_channel_output_load_integration_0/v3_four_channel_shared_support_integration_0/v3_four_channel_bias_reference_distribution_0/v3_four_channel_phase_distribution_0/v3_four_channel_output_collection_0/v3_four_channel_placement_0/v3_channel_selector_late_promotion_1/v3_channel_input_bias_late_promotion_0/a_4382_17688# VGND sky130_fd_pr__nfet_01v8 ad=0 pd=0 as=0 ps=0 w=5.07 l=1
X438 v3_four_channel_output_load_integration_0/combined_p v3_four_channel_output_load_integration_0/v3_four_channel_shared_support_integration_0/v3_four_channel_bias_reference_distribution_0/v3_four_channel_phase_distribution_0/v3_four_channel_output_collection_0/v3_four_channel_placement_0/v3_channel_selector_late_promotion_1/v3_selector_route_pilot_0/group3_lo_n v3_four_channel_output_load_integration_0/v3_four_channel_shared_support_integration_0/v3_four_channel_bias_reference_distribution_0/v3_four_channel_phase_distribution_0/v3_four_channel_output_collection_0/v3_four_channel_placement_0/v3_channel_selector_late_promotion_1/v3_channel_input_bias_late_promotion_0/a_7038_6978# VGND sky130_fd_pr__nfet_01v8 ad=0 pd=0 as=0 ps=0 w=0.65 l=0.15
X439 v3_four_channel_output_load_integration_0/combined_n v3_four_channel_output_load_integration_0/v3_four_channel_shared_support_integration_0/v3_four_channel_bias_reference_distribution_0/v3_four_channel_phase_distribution_0/v3_four_channel_output_collection_0/v3_four_channel_placement_0/v3_channel_selector_late_promotion_1/v3_selector_route_pilot_0/group2_lo_p v3_four_channel_output_load_integration_0/v3_four_channel_shared_support_integration_0/v3_four_channel_bias_reference_distribution_0/v3_four_channel_phase_distribution_0/v3_four_channel_output_collection_0/v3_four_channel_placement_0/v3_channel_selector_late_promotion_1/v3_channel_input_bias_late_promotion_0/a_4254_10978# VGND sky130_fd_pr__nfet_01v8 ad=0 pd=0 as=0 ps=0 w=0.65 l=0.15
X440 v3_four_channel_output_load_integration_0/v3_four_channel_shared_support_integration_0/v3_four_channel_bias_reference_distribution_0/v3_four_channel_phase_distribution_0/v3_four_channel_output_collection_0/v3_four_channel_placement_0/v3_channel_selector_late_promotion_1/v3_channel_input_bias_late_promotion_0/a_7462_11422# v3_four_channel_output_load_integration_0/v3_four_channel_shared_support_integration_0/v3_four_channel_bias_reference_distribution_0/v3_four_channel_phase_distribution_0/v3_four_channel_output_collection_0/v3_four_channel_placement_0/v3_channel_selector_late_promotion_1/v3_selector_route_pilot_0/group2_lo_p v3_four_channel_output_load_integration_0/combined_p VGND sky130_fd_pr__nfet_01v8 ad=0 pd=0 as=0 ps=0 w=0.65 l=0.15
X441 v3_four_channel_output_load_integration_0/v3_four_channel_shared_support_integration_0/v3_four_channel_bias_reference_distribution_0/v3_four_channel_phase_distribution_0/v3_four_channel_output_collection_0/v3_four_channel_placement_0/v3_channel_selector_late_promotion_1/v3_channel_input_bias_late_promotion_0/a_7166_21688# v3_four_channel_output_load_integration_0/v3_four_channel_shared_support_integration_0/v3_four_channel_bias_reference_distribution_0/v3_four_channel_phase_distribution_0/v3_four_channel_output_collection_0/v3_four_channel_placement_0/v3_channel_selector_late_promotion_1/element_input v3_four_channel_output_load_integration_0/v3_four_channel_shared_support_integration_0/v3_four_channel_bias_reference_distribution_0/v3_four_channel_phase_distribution_0/v3_four_channel_output_collection_0/v3_four_channel_placement_0/v3_channel_selector_late_promotion_1/v3_channel_input_bias_late_promotion_0/a_7038_22978# VGND sky130_fd_pr__nfet_01v8 ad=0 pd=0 as=0 ps=0 w=0.84 l=0.6
X442 v3_four_channel_output_load_integration_0/combined_n v3_four_channel_output_load_integration_0/v3_four_channel_shared_support_integration_0/v3_four_channel_bias_reference_distribution_0/v3_four_channel_phase_distribution_0/v3_four_channel_output_collection_0/v3_four_channel_placement_0/v3_channel_selector_late_promotion_1/v3_selector_route_pilot_0/group3_lo_n v3_four_channel_output_load_integration_0/v3_four_channel_shared_support_integration_0/v3_four_channel_bias_reference_distribution_0/v3_four_channel_phase_distribution_0/v3_four_channel_output_collection_0/v3_four_channel_placement_0/v3_channel_selector_late_promotion_1/v3_channel_input_bias_late_promotion_0/a_5646_22978# VGND sky130_fd_pr__nfet_01v8 ad=0 pd=0 as=0 ps=0 w=0.65 l=0.15
X443 v3_four_channel_output_load_integration_0/v3_four_channel_shared_support_integration_0/v3_four_channel_bias_reference_distribution_0/v3_four_channel_phase_distribution_0/v3_four_channel_output_collection_0/v3_four_channel_placement_0/v3_channel_selector_late_promotion_1/v3_channel_input_bias_late_promotion_0/a_4678_11422# v3_four_channel_output_load_integration_0/v3_four_channel_shared_support_integration_0/v3_four_channel_bias_reference_distribution_0/v3_four_channel_phase_distribution_0/v3_four_channel_output_collection_0/v3_four_channel_placement_0/v3_channel_selector_late_promotion_1/element_input v3_four_channel_output_load_integration_0/v3_four_channel_shared_support_integration_0/v3_four_channel_bias_reference_distribution_0/v3_four_channel_phase_distribution_0/v3_four_channel_output_collection_0/v3_four_channel_placement_0/v3_channel_selector_late_promotion_1/v3_channel_input_bias_late_promotion_0/a_4432_10978# VGND sky130_fd_pr__nfet_01v8 ad=0 pd=0 as=0 ps=0 w=0.84 l=0.6
X444 v3_four_channel_output_load_integration_0/v3_four_channel_shared_support_integration_0/v3_four_channel_bias_reference_distribution_0/v3_four_channel_phase_distribution_0/v3_four_channel_output_collection_0/v3_four_channel_placement_0/v3_channel_selector_late_promotion_1/v3_channel_input_bias_late_promotion_0/a_6070_23422# v3_four_channel_output_load_integration_0/v3_four_channel_shared_support_integration_0/v3_vcm_support_block_0/ref v3_four_channel_output_load_integration_0/v3_four_channel_shared_support_integration_0/v3_four_channel_bias_reference_distribution_0/v3_four_channel_phase_distribution_0/v3_four_channel_output_collection_0/v3_four_channel_placement_0/v3_channel_selector_late_promotion_1/v3_channel_input_bias_late_promotion_0/a_5774_21688# VGND sky130_fd_pr__nfet_01v8 ad=0 pd=0 as=0 ps=0 w=0.84 l=0.6
X445 v3_four_channel_output_load_integration_0/v3_four_channel_shared_support_integration_0/v3_four_channel_bias_reference_distribution_0/v3_four_channel_phase_distribution_0/v3_four_channel_output_collection_0/v3_four_channel_placement_0/v3_channel_selector_late_promotion_1/v3_channel_input_bias_late_promotion_0/a_6070_23422# v3_four_channel_output_load_integration_0/v3_four_channel_shared_support_integration_0/v3_four_channel_bias_reference_distribution_0/v3_four_channel_phase_distribution_0/v3_four_channel_output_collection_0/v3_four_channel_placement_0/v3_channel_selector_late_promotion_1/v3_selector_route_pilot_0/group3_lo_p v3_four_channel_output_load_integration_0/combined_n VGND sky130_fd_pr__nfet_01v8 ad=0 pd=0 as=0 ps=0 w=0.65 l=0.15
X446 v3_four_channel_output_load_integration_0/v3_four_channel_shared_support_integration_0/v3_four_channel_bias_reference_distribution_0/v3_four_channel_phase_distribution_0/v3_four_channel_output_collection_0/v3_four_channel_placement_0/v3_channel_selector_late_promotion_1/v3_channel_input_bias_late_promotion_0/a_4678_11422# v3_four_channel_output_load_integration_0/v3_four_channel_shared_support_integration_0/v3_four_channel_bias_reference_distribution_0/v3_four_channel_phase_distribution_0/v3_four_channel_output_collection_0/v3_four_channel_placement_0/v3_channel_selector_late_promotion_1/v3_selector_route_pilot_0/group2_lo_n v3_four_channel_output_load_integration_0/combined_n VGND sky130_fd_pr__nfet_01v8 ad=0 pd=0 as=0 ps=0 w=0.65 l=0.15
X447 v3_four_channel_output_load_integration_0/v3_four_channel_shared_support_integration_0/v3_four_channel_bias_reference_distribution_0/v3_four_channel_phase_distribution_0/v3_four_channel_output_collection_0/v3_four_channel_placement_0/v3_channel_selector_late_promotion_1/v3_channel_input_bias_late_promotion_0/a_7462_15422# v3_four_channel_output_load_integration_0/v3_four_channel_shared_support_integration_0/v3_four_channel_bias_reference_distribution_0/v3_four_channel_phase_distribution_0/v3_four_channel_output_collection_0/v3_four_channel_placement_0/v3_channel_selector_late_promotion_1/element_input v3_four_channel_output_load_integration_0/v3_four_channel_shared_support_integration_0/v3_four_channel_bias_reference_distribution_0/v3_four_channel_phase_distribution_0/v3_four_channel_output_collection_0/v3_four_channel_placement_0/v3_channel_selector_late_promotion_1/v3_channel_input_bias_late_promotion_0/a_7216_14978# VGND sky130_fd_pr__nfet_01v8 ad=0 pd=0 as=0 ps=0 w=0.84 l=0.6
X448 v3_four_channel_output_load_integration_0/v3_four_channel_shared_support_integration_0/v3_four_channel_bias_reference_distribution_0/v3_four_channel_phase_distribution_0/v3_four_channel_output_collection_0/v3_four_channel_placement_0/v3_channel_selector_late_promotion_1/v3_channel_input_bias_late_promotion_0/a_6070_7422# v3_four_channel_output_load_integration_0/v3_four_channel_shared_support_integration_0/v3_four_channel_bias_reference_distribution_0/v3_four_channel_phase_distribution_0/v3_four_channel_output_collection_0/v3_four_channel_placement_0/v3_channel_selector_late_promotion_1/v3_selector_route_pilot_0/group3_lo_p v3_four_channel_output_load_integration_0/combined_p VGND sky130_fd_pr__nfet_01v8 ad=0 pd=0 as=0 ps=0 w=0.65 l=0.15
X449 v3_four_channel_output_load_integration_0/combined_n v3_four_channel_output_load_integration_0/v3_four_channel_shared_support_integration_0/v3_four_channel_bias_reference_distribution_0/v3_four_channel_phase_distribution_0/v3_four_channel_output_collection_0/v3_four_channel_placement_0/v3_channel_selector_late_promotion_1/v3_selector_route_pilot_0/group2_lo_p v3_four_channel_output_load_integration_0/v3_four_channel_shared_support_integration_0/v3_four_channel_bias_reference_distribution_0/v3_four_channel_phase_distribution_0/v3_four_channel_output_collection_0/v3_four_channel_placement_0/v3_channel_selector_late_promotion_1/v3_channel_input_bias_late_promotion_0/a_7038_10978# VGND sky130_fd_pr__nfet_01v8 ad=0 pd=0 as=0 ps=0 w=0.65 l=0.15
X450 v3_four_channel_output_load_integration_0/v3_four_channel_shared_support_integration_0/v3_four_channel_bias_reference_distribution_0/v3_four_channel_phase_distribution_0/v3_four_channel_output_collection_0/v3_four_channel_placement_0/v3_channel_selector_late_promotion_1/v3_channel_input_bias_late_promotion_0/a_7462_15422# v3_four_channel_output_load_integration_0/v3_four_channel_shared_support_integration_0/v3_four_channel_bias_reference_distribution_0/v3_four_channel_phase_distribution_0/v3_four_channel_output_collection_0/v3_four_channel_placement_0/v3_channel_selector_late_promotion_1/v3_selector_route_pilot_0/group1_lo_n v3_four_channel_output_load_integration_0/combined_n VGND sky130_fd_pr__nfet_01v8 ad=0 pd=0 as=0 ps=0 w=0.65 l=0.15
X451 v3_four_channel_output_load_integration_0/v3_four_channel_shared_support_integration_0/v3_four_channel_bias_reference_distribution_0/v3_four_channel_phase_distribution_0/v3_four_channel_output_collection_0/v3_four_channel_placement_0/v3_channel_selector_late_promotion_1/v3_channel_input_bias_late_promotion_0/a_4432_6978# v3_four_channel_output_load_integration_0/v3_four_channel_shared_support_integration_0/v3_vcm_support_block_0/ref v3_four_channel_output_load_integration_0/v3_four_channel_shared_support_integration_0/v3_four_channel_bias_reference_distribution_0/v3_four_channel_phase_distribution_0/v3_four_channel_output_collection_0/v3_four_channel_placement_0/v3_channel_selector_late_promotion_1/v3_channel_input_bias_late_promotion_0/a_4254_6978# VGND sky130_fd_pr__nfet_01v8 ad=0 pd=0 as=0 ps=0 w=0.84 l=0.6
X452 v3_four_channel_output_load_integration_0/v3_four_channel_shared_support_integration_0/v3_four_channel_bias_reference_distribution_0/v3_four_channel_phase_distribution_0/v3_four_channel_output_collection_0/v3_four_channel_placement_0/v3_channel_selector_late_promotion_1/v3_channel_input_bias_late_promotion_0/a_5824_10978# v3_four_channel_output_load_integration_0/v3_four_channel_shared_support_integration_0/v3_vcm_support_block_0/ref v3_four_channel_output_load_integration_0/v3_four_channel_shared_support_integration_0/v3_four_channel_bias_reference_distribution_0/v3_four_channel_phase_distribution_0/v3_four_channel_output_collection_0/v3_four_channel_placement_0/v3_channel_selector_late_promotion_1/v3_channel_input_bias_late_promotion_0/a_5646_10978# VGND sky130_fd_pr__nfet_01v8 ad=0 pd=0 as=0 ps=0 w=0.84 l=0.6
X453 v3_four_channel_output_load_integration_0/combined_n v3_four_channel_output_load_integration_0/v3_four_channel_shared_support_integration_0/v3_four_channel_bias_reference_distribution_0/v3_four_channel_phase_distribution_0/v3_four_channel_output_collection_0/v3_four_channel_placement_0/v3_channel_selector_late_promotion_1/v3_selector_route_pilot_0/group3_lo_n v3_four_channel_output_load_integration_0/v3_four_channel_shared_support_integration_0/v3_four_channel_bias_reference_distribution_0/v3_four_channel_phase_distribution_0/v3_four_channel_output_collection_0/v3_four_channel_placement_0/v3_channel_selector_late_promotion_1/v3_channel_input_bias_late_promotion_0/a_4254_22978# VGND sky130_fd_pr__nfet_01v8 ad=0 pd=0 as=0 ps=0 w=0.65 l=0.15
X454 v3_four_channel_output_load_integration_0/v3_four_channel_shared_support_integration_0/v3_four_channel_bias_reference_distribution_0/v3_four_channel_phase_distribution_0/v3_four_channel_output_collection_0/v3_four_channel_placement_0/v3_channel_selector_late_promotion_1/v3_channel_input_bias_late_promotion_0/a_7462_23422# v3_four_channel_output_load_integration_0/v3_four_channel_shared_support_integration_0/v3_four_channel_bias_reference_distribution_0/v3_four_channel_phase_distribution_0/v3_four_channel_output_collection_0/v3_four_channel_placement_0/v3_channel_selector_late_promotion_1/v3_selector_route_pilot_0/group3_lo_n v3_four_channel_output_load_integration_0/combined_p VGND sky130_fd_pr__nfet_01v8 ad=0 pd=0 as=0 ps=0 w=0.65 l=0.15
X455 v3_four_channel_output_load_integration_0/v3_four_channel_shared_support_integration_0/v3_four_channel_bias_reference_distribution_0/v3_four_channel_phase_distribution_0/v3_four_channel_output_collection_0/v3_four_channel_placement_0/v3_channel_selector_late_promotion_1/v3_channel_input_bias_late_promotion_0/a_4432_6978# v3_four_channel_output_load_integration_0/v3_four_channel_shared_support_integration_0/v3_tail_bias_support_block_0/vbias VGND VGND sky130_fd_pr__nfet_01v8 ad=0 pd=0 as=0 ps=0 w=5.07 l=1
X456 v3_four_channel_output_load_integration_0/v3_four_channel_shared_support_integration_0/v3_four_channel_bias_reference_distribution_0/v3_four_channel_phase_distribution_0/v3_four_channel_output_collection_0/v3_four_channel_placement_0/v3_channel_selector_late_promotion_1/v3_channel_input_bias_late_promotion_0/a_7216_6978# v3_four_channel_output_load_integration_0/v3_four_channel_shared_support_integration_0/v3_vcm_support_block_0/ref v3_four_channel_output_load_integration_0/v3_four_channel_shared_support_integration_0/v3_four_channel_bias_reference_distribution_0/v3_four_channel_phase_distribution_0/v3_four_channel_output_collection_0/v3_four_channel_placement_0/v3_channel_selector_late_promotion_1/v3_channel_input_bias_late_promotion_0/a_7038_6978# VGND sky130_fd_pr__nfet_01v8 ad=0 pd=0 as=0 ps=0 w=0.84 l=0.6
X457 v3_four_channel_output_load_integration_0/combined_n v3_four_channel_output_load_integration_0/v3_four_channel_shared_support_integration_0/v3_four_channel_bias_reference_distribution_0/v3_four_channel_phase_distribution_0/v3_four_channel_output_collection_0/v3_four_channel_placement_0/v3_channel_selector_late_promotion_1/v3_selector_route_pilot_0/group3_lo_p v3_four_channel_output_load_integration_0/v3_four_channel_shared_support_integration_0/v3_four_channel_bias_reference_distribution_0/v3_four_channel_phase_distribution_0/v3_four_channel_output_collection_0/v3_four_channel_placement_0/v3_channel_selector_late_promotion_1/v3_channel_input_bias_late_promotion_0/a_5646_6978# VGND sky130_fd_pr__nfet_01v8 ad=0 pd=0 as=0 ps=0 w=0.65 l=0.15
X458 VGND v3_four_channel_output_load_integration_0/v3_four_channel_shared_support_integration_0/v3_tail_bias_support_block_0/vbias v3_four_channel_output_load_integration_0/v3_four_channel_shared_support_integration_0/v3_four_channel_bias_reference_distribution_0/v3_four_channel_phase_distribution_0/v3_four_channel_output_collection_0/v3_four_channel_placement_0/v3_channel_selector_late_promotion_1/v3_channel_input_bias_late_promotion_0/a_4382_13688# VGND sky130_fd_pr__nfet_01v8 ad=0 pd=0 as=0 ps=0 w=5.07 l=1
X459 VDPWR v3_four_channel_output_load_integration_0/v3_four_channel_shared_support_integration_0/v3_four_channel_bias_reference_distribution_0/v3_four_channel_phase_distribution_0/v3_four_channel_output_collection_0/v3_four_channel_placement_0/v3_channel_selector_late_promotion_1/v3_selector_route_pilot_0/G1_MUX_POS/a_505_21# v3_four_channel_output_load_integration_0/v3_four_channel_shared_support_integration_0/v3_four_channel_bias_reference_distribution_0/v3_four_channel_phase_distribution_0/v3_four_channel_output_collection_0/v3_four_channel_placement_0/v3_channel_selector_late_promotion_1/v3_selector_route_pilot_0/G1_MUX_POS/a_535_374# VDPWR sky130_fd_pr__pfet_01v8_hvt ad=0 pd=0 as=0.0882 ps=1.26 w=0.42 l=0.15
X460 v3_four_channel_output_load_integration_0/v3_four_channel_shared_support_integration_0/v3_four_channel_bias_reference_distribution_0/v3_four_channel_phase_distribution_0/v3_four_channel_output_collection_0/v3_four_channel_placement_0/v3_channel_selector_late_promotion_1/v3_selector_route_pilot_0/G1_MUX_POS/a_505_21# v3_four_channel_output_load_integration_0/v3_four_channel_shared_support_integration_0/v3_four_channel_bias_reference_distribution_0/v3_four_channel_phase_distribution_0/v3_four_channel_output_collection_0/v3_four_channel_placement_0/v3_channel_selector_late_promotion_1/group1_bit0 VDPWR VDPWR sky130_fd_pr__pfet_01v8_hvt ad=0.1176 pd=1.4 as=0 ps=0 w=0.42 l=0.15
X461 v3_four_channel_output_load_integration_0/v3_four_channel_shared_support_integration_0/v3_four_channel_bias_reference_distribution_0/v3_four_channel_phase_distribution_0/v3_four_channel_output_collection_0/v3_four_channel_placement_0/v3_channel_selector_late_promotion_1/v3_selector_route_pilot_0/G1_MUX_POS/a_218_374# v3_four_channel_output_load_integration_0/v3_four_channel_shared_support_integration_0/v3_four_channel_bias_reference_distribution_0/v3_four_channel_phase_distribution_0/v3_four_channel_output_collection_0/v3_four_channel_placement_0/v3_channel_selector_late_promotion_1/group1_bit0 VDPWR VDPWR sky130_fd_pr__pfet_01v8_hvt ad=0.1533 pd=1.57 as=0 ps=0 w=0.42 l=0.15
X462 VGND v3_four_channel_output_load_integration_0/v3_four_channel_shared_support_integration_0/v3_four_channel_bias_reference_distribution_0/v3_four_channel_phase_distribution_0/v3_four_channel_output_collection_0/v3_four_channel_placement_0/v3_channel_selector_late_promotion_1/v3_selector_route_pilot_0/G1_MUX_POS/a_505_21# v3_four_channel_output_load_integration_0/v3_four_channel_shared_support_integration_0/v3_four_channel_bias_reference_distribution_0/v3_four_channel_phase_distribution_0/v3_four_channel_output_collection_0/v3_four_channel_placement_0/v3_channel_selector_late_promotion_1/v3_selector_route_pilot_0/G1_MUX_POS/a_439_47# VGND sky130_fd_pr__nfet_01v8 ad=0 pd=0 as=0.1386 ps=1.5 w=0.42 l=0.15
X463 v3_four_channel_output_load_integration_0/v3_four_channel_shared_support_integration_0/v3_four_channel_bias_reference_distribution_0/v3_four_channel_phase_distribution_0/v3_four_channel_output_collection_0/v3_four_channel_placement_0/v3_channel_selector_late_promotion_1/v3_selector_route_pilot_0/G1_MUX_POS/a_76_199# v3_four_channel_output_load_integration_0/v3_four_channel_shared_support_integration_0/v3_four_channel_bias_reference_distribution_0/v3_four_channel_phase_distribution_0/phase_0 v3_four_channel_output_load_integration_0/v3_four_channel_shared_support_integration_0/v3_four_channel_bias_reference_distribution_0/v3_four_channel_phase_distribution_0/v3_four_channel_output_collection_0/v3_four_channel_placement_0/v3_channel_selector_late_promotion_1/v3_selector_route_pilot_0/G1_MUX_POS/a_218_374# VDPWR sky130_fd_pr__pfet_01v8_hvt ad=0.3864 pd=2.68 as=0 ps=0 w=0.42 l=0.15
X464 v3_four_channel_output_load_integration_0/v3_four_channel_shared_support_integration_0/v3_four_channel_bias_reference_distribution_0/v3_four_channel_phase_distribution_0/v3_four_channel_output_collection_0/v3_four_channel_placement_0/v3_channel_selector_late_promotion_1/v3_selector_route_pilot_0/G1_MUX_POS/a_505_21# v3_four_channel_output_load_integration_0/v3_four_channel_shared_support_integration_0/v3_four_channel_bias_reference_distribution_0/v3_four_channel_phase_distribution_0/v3_four_channel_output_collection_0/v3_four_channel_placement_0/v3_channel_selector_late_promotion_1/group1_bit0 VGND VGND sky130_fd_pr__nfet_01v8 ad=0.1092 pd=1.36 as=0 ps=0 w=0.42 l=0.15
X465 v3_four_channel_output_load_integration_0/v3_four_channel_shared_support_integration_0/v3_four_channel_bias_reference_distribution_0/v3_four_channel_phase_distribution_0/v3_four_channel_output_collection_0/v3_four_channel_placement_0/v3_channel_selector_late_promotion_1/v3_selector_route_pilot_0/G1_MUX_POS/a_439_47# v3_four_channel_output_load_integration_0/v3_four_channel_shared_support_integration_0/v3_four_channel_bias_reference_distribution_0/v3_four_channel_phase_distribution_0/phase_0 v3_four_channel_output_load_integration_0/v3_four_channel_shared_support_integration_0/v3_four_channel_bias_reference_distribution_0/v3_four_channel_phase_distribution_0/v3_four_channel_output_collection_0/v3_four_channel_placement_0/v3_channel_selector_late_promotion_1/v3_selector_route_pilot_0/G1_MUX_POS/a_76_199# VGND sky130_fd_pr__nfet_01v8 ad=0 pd=0 as=0.1995 ps=1.79 w=0.42 l=0.15
X466 v3_four_channel_output_load_integration_0/v3_four_channel_shared_support_integration_0/v3_four_channel_bias_reference_distribution_0/v3_four_channel_phase_distribution_0/v3_four_channel_output_collection_0/v3_four_channel_placement_0/v3_channel_selector_late_promotion_1/v3_selector_route_pilot_0/G1_MUX_POS/a_535_374# v3_four_channel_output_load_integration_0/v3_four_channel_shared_support_integration_0/v3_four_channel_bias_reference_distribution_0/v3_four_channel_phase_distribution_0/phase_90 v3_four_channel_output_load_integration_0/v3_four_channel_shared_support_integration_0/v3_four_channel_bias_reference_distribution_0/v3_four_channel_phase_distribution_0/v3_four_channel_output_collection_0/v3_four_channel_placement_0/v3_channel_selector_late_promotion_1/v3_selector_route_pilot_0/G1_MUX_POS/a_76_199# VDPWR sky130_fd_pr__pfet_01v8_hvt ad=0 pd=0 as=0 ps=0 w=0.42 l=0.15
X467 v3_four_channel_output_load_integration_0/v3_four_channel_shared_support_integration_0/v3_four_channel_bias_reference_distribution_0/v3_four_channel_phase_distribution_0/v3_four_channel_output_collection_0/v3_four_channel_placement_0/v3_channel_selector_late_promotion_1/v3_selector_route_pilot_0/G1_MUX_POS/a_76_199# v3_four_channel_output_load_integration_0/v3_four_channel_shared_support_integration_0/v3_four_channel_bias_reference_distribution_0/v3_four_channel_phase_distribution_0/phase_90 v3_four_channel_output_load_integration_0/v3_four_channel_shared_support_integration_0/v3_four_channel_bias_reference_distribution_0/v3_four_channel_phase_distribution_0/v3_four_channel_output_collection_0/v3_four_channel_placement_0/v3_channel_selector_late_promotion_1/v3_selector_route_pilot_0/G1_MUX_POS/a_218_47# VGND sky130_fd_pr__nfet_01v8 ad=0 pd=0 as=0.1386 ps=1.5 w=0.42 l=0.15
X468 v3_four_channel_output_load_integration_0/v3_four_channel_shared_support_integration_0/v3_four_channel_bias_reference_distribution_0/v3_four_channel_phase_distribution_0/v3_four_channel_output_collection_0/v3_four_channel_placement_0/v3_channel_selector_late_promotion_1/v3_selector_route_pilot_0/G1_MUX_POS/a_218_47# v3_four_channel_output_load_integration_0/v3_four_channel_shared_support_integration_0/v3_four_channel_bias_reference_distribution_0/v3_four_channel_phase_distribution_0/v3_four_channel_output_collection_0/v3_four_channel_placement_0/v3_channel_selector_late_promotion_1/group1_bit0 VGND VGND sky130_fd_pr__nfet_01v8 ad=0 pd=0 as=0 ps=0 w=0.42 l=0.15
X469 VDPWR v3_four_channel_output_load_integration_0/v3_four_channel_shared_support_integration_0/v3_four_channel_bias_reference_distribution_0/v3_four_channel_phase_distribution_0/v3_four_channel_output_collection_0/v3_four_channel_placement_0/v3_channel_selector_late_promotion_1/v3_selector_route_pilot_0/G1_MUX_POS/a_76_199# v3_four_channel_output_load_integration_0/v3_four_channel_shared_support_integration_0/v3_four_channel_bias_reference_distribution_0/v3_four_channel_phase_distribution_0/v3_four_channel_output_collection_0/v3_four_channel_placement_0/v3_channel_selector_late_promotion_1/v3_selector_route_pilot_0/G1_MUX_POS/X VDPWR sky130_fd_pr__pfet_01v8_hvt ad=0 pd=0 as=0.26 ps=2.52 w=1 l=0.15
X470 VGND v3_four_channel_output_load_integration_0/v3_four_channel_shared_support_integration_0/v3_four_channel_bias_reference_distribution_0/v3_four_channel_phase_distribution_0/v3_four_channel_output_collection_0/v3_four_channel_placement_0/v3_channel_selector_late_promotion_1/v3_selector_route_pilot_0/G1_MUX_POS/a_76_199# v3_four_channel_output_load_integration_0/v3_four_channel_shared_support_integration_0/v3_four_channel_bias_reference_distribution_0/v3_four_channel_phase_distribution_0/v3_four_channel_output_collection_0/v3_four_channel_placement_0/v3_channel_selector_late_promotion_1/v3_selector_route_pilot_0/G1_MUX_POS/X VGND sky130_fd_pr__nfet_01v8 ad=0 pd=0 as=0.169 ps=1.82 w=0.65 l=0.15
X471 VDPWR v3_four_channel_output_load_integration_0/v3_four_channel_shared_support_integration_0/v3_four_channel_bias_reference_distribution_0/v3_four_channel_phase_distribution_0/v3_four_channel_output_collection_0/v3_four_channel_placement_0/v3_channel_selector_late_promotion_1/v3_selector_route_pilot_0/G3_MUX_AXIS/a_505_21# v3_four_channel_output_load_integration_0/v3_four_channel_shared_support_integration_0/v3_four_channel_bias_reference_distribution_0/v3_four_channel_phase_distribution_0/v3_four_channel_output_collection_0/v3_four_channel_placement_0/v3_channel_selector_late_promotion_1/v3_selector_route_pilot_0/G3_MUX_AXIS/a_535_374# VDPWR sky130_fd_pr__pfet_01v8_hvt ad=0 pd=0 as=0.0882 ps=1.26 w=0.42 l=0.15
X472 v3_four_channel_output_load_integration_0/v3_four_channel_shared_support_integration_0/v3_four_channel_bias_reference_distribution_0/v3_four_channel_phase_distribution_0/v3_four_channel_output_collection_0/v3_four_channel_placement_0/v3_channel_selector_late_promotion_1/v3_selector_route_pilot_0/G3_MUX_AXIS/a_505_21# v3_four_channel_output_load_integration_0/v3_four_channel_shared_support_integration_0/v3_four_channel_bias_reference_distribution_0/v3_four_channel_phase_distribution_0/v3_four_channel_output_collection_0/v3_four_channel_placement_0/v3_channel_selector_late_promotion_1/group3_bit1 VDPWR VDPWR sky130_fd_pr__pfet_01v8_hvt ad=0.1176 pd=1.4 as=0 ps=0 w=0.42 l=0.15
X473 v3_four_channel_output_load_integration_0/v3_four_channel_shared_support_integration_0/v3_four_channel_bias_reference_distribution_0/v3_four_channel_phase_distribution_0/v3_four_channel_output_collection_0/v3_four_channel_placement_0/v3_channel_selector_late_promotion_1/v3_selector_route_pilot_0/G3_MUX_AXIS/a_218_374# v3_four_channel_output_load_integration_0/v3_four_channel_shared_support_integration_0/v3_four_channel_bias_reference_distribution_0/v3_four_channel_phase_distribution_0/v3_four_channel_output_collection_0/v3_four_channel_placement_0/v3_channel_selector_late_promotion_1/group3_bit1 VDPWR VDPWR sky130_fd_pr__pfet_01v8_hvt ad=0.1533 pd=1.57 as=0 ps=0 w=0.42 l=0.15
X474 VGND v3_four_channel_output_load_integration_0/v3_four_channel_shared_support_integration_0/v3_four_channel_bias_reference_distribution_0/v3_four_channel_phase_distribution_0/v3_four_channel_output_collection_0/v3_four_channel_placement_0/v3_channel_selector_late_promotion_1/v3_selector_route_pilot_0/G3_MUX_AXIS/a_505_21# v3_four_channel_output_load_integration_0/v3_four_channel_shared_support_integration_0/v3_four_channel_bias_reference_distribution_0/v3_four_channel_phase_distribution_0/v3_four_channel_output_collection_0/v3_four_channel_placement_0/v3_channel_selector_late_promotion_1/v3_selector_route_pilot_0/G3_MUX_AXIS/a_439_47# VGND sky130_fd_pr__nfet_01v8 ad=0 pd=0 as=0.1386 ps=1.5 w=0.42 l=0.15
X475 v3_four_channel_output_load_integration_0/v3_four_channel_shared_support_integration_0/v3_four_channel_bias_reference_distribution_0/v3_four_channel_phase_distribution_0/v3_four_channel_output_collection_0/v3_four_channel_placement_0/v3_channel_selector_late_promotion_1/v3_selector_route_pilot_0/G3_MUX_AXIS/a_76_199# v3_four_channel_output_load_integration_0/v3_four_channel_shared_support_integration_0/v3_four_channel_bias_reference_distribution_0/v3_four_channel_phase_distribution_0/v3_four_channel_output_collection_0/v3_four_channel_placement_0/v3_channel_selector_late_promotion_1/v3_selector_route_pilot_0/G3_MUX_POS/X v3_four_channel_output_load_integration_0/v3_four_channel_shared_support_integration_0/v3_four_channel_bias_reference_distribution_0/v3_four_channel_phase_distribution_0/v3_four_channel_output_collection_0/v3_four_channel_placement_0/v3_channel_selector_late_promotion_1/v3_selector_route_pilot_0/G3_MUX_AXIS/a_218_374# VDPWR sky130_fd_pr__pfet_01v8_hvt ad=0.3864 pd=2.68 as=0 ps=0 w=0.42 l=0.15
X476 v3_four_channel_output_load_integration_0/v3_four_channel_shared_support_integration_0/v3_four_channel_bias_reference_distribution_0/v3_four_channel_phase_distribution_0/v3_four_channel_output_collection_0/v3_four_channel_placement_0/v3_channel_selector_late_promotion_1/v3_selector_route_pilot_0/G3_MUX_AXIS/a_505_21# v3_four_channel_output_load_integration_0/v3_four_channel_shared_support_integration_0/v3_four_channel_bias_reference_distribution_0/v3_four_channel_phase_distribution_0/v3_four_channel_output_collection_0/v3_four_channel_placement_0/v3_channel_selector_late_promotion_1/group3_bit1 VGND VGND sky130_fd_pr__nfet_01v8 ad=0.1092 pd=1.36 as=0 ps=0 w=0.42 l=0.15
X477 v3_four_channel_output_load_integration_0/v3_four_channel_shared_support_integration_0/v3_four_channel_bias_reference_distribution_0/v3_four_channel_phase_distribution_0/v3_four_channel_output_collection_0/v3_four_channel_placement_0/v3_channel_selector_late_promotion_1/v3_selector_route_pilot_0/G3_MUX_AXIS/a_439_47# v3_four_channel_output_load_integration_0/v3_four_channel_shared_support_integration_0/v3_four_channel_bias_reference_distribution_0/v3_four_channel_phase_distribution_0/v3_four_channel_output_collection_0/v3_four_channel_placement_0/v3_channel_selector_late_promotion_1/v3_selector_route_pilot_0/G3_MUX_POS/X v3_four_channel_output_load_integration_0/v3_four_channel_shared_support_integration_0/v3_four_channel_bias_reference_distribution_0/v3_four_channel_phase_distribution_0/v3_four_channel_output_collection_0/v3_four_channel_placement_0/v3_channel_selector_late_promotion_1/v3_selector_route_pilot_0/G3_MUX_AXIS/a_76_199# VGND sky130_fd_pr__nfet_01v8 ad=0 pd=0 as=0.1995 ps=1.79 w=0.42 l=0.15
X478 v3_four_channel_output_load_integration_0/v3_four_channel_shared_support_integration_0/v3_four_channel_bias_reference_distribution_0/v3_four_channel_phase_distribution_0/v3_four_channel_output_collection_0/v3_four_channel_placement_0/v3_channel_selector_late_promotion_1/v3_selector_route_pilot_0/G3_MUX_AXIS/a_535_374# v3_four_channel_output_load_integration_0/v3_four_channel_shared_support_integration_0/v3_four_channel_bias_reference_distribution_0/v3_four_channel_phase_distribution_0/v3_four_channel_output_collection_0/v3_four_channel_placement_0/v3_channel_selector_late_promotion_1/v3_selector_route_pilot_0/G3_MUX_NEG/X v3_four_channel_output_load_integration_0/v3_four_channel_shared_support_integration_0/v3_four_channel_bias_reference_distribution_0/v3_four_channel_phase_distribution_0/v3_four_channel_output_collection_0/v3_four_channel_placement_0/v3_channel_selector_late_promotion_1/v3_selector_route_pilot_0/G3_MUX_AXIS/a_76_199# VDPWR sky130_fd_pr__pfet_01v8_hvt ad=0 pd=0 as=0 ps=0 w=0.42 l=0.15
X479 v3_four_channel_output_load_integration_0/v3_four_channel_shared_support_integration_0/v3_four_channel_bias_reference_distribution_0/v3_four_channel_phase_distribution_0/v3_four_channel_output_collection_0/v3_four_channel_placement_0/v3_channel_selector_late_promotion_1/v3_selector_route_pilot_0/G3_MUX_AXIS/a_76_199# v3_four_channel_output_load_integration_0/v3_four_channel_shared_support_integration_0/v3_four_channel_bias_reference_distribution_0/v3_four_channel_phase_distribution_0/v3_four_channel_output_collection_0/v3_four_channel_placement_0/v3_channel_selector_late_promotion_1/v3_selector_route_pilot_0/G3_MUX_NEG/X v3_four_channel_output_load_integration_0/v3_four_channel_shared_support_integration_0/v3_four_channel_bias_reference_distribution_0/v3_four_channel_phase_distribution_0/v3_four_channel_output_collection_0/v3_four_channel_placement_0/v3_channel_selector_late_promotion_1/v3_selector_route_pilot_0/G3_MUX_AXIS/a_218_47# VGND sky130_fd_pr__nfet_01v8 ad=0 pd=0 as=0.1386 ps=1.5 w=0.42 l=0.15
X480 v3_four_channel_output_load_integration_0/v3_four_channel_shared_support_integration_0/v3_four_channel_bias_reference_distribution_0/v3_four_channel_phase_distribution_0/v3_four_channel_output_collection_0/v3_four_channel_placement_0/v3_channel_selector_late_promotion_1/v3_selector_route_pilot_0/G3_MUX_AXIS/a_218_47# v3_four_channel_output_load_integration_0/v3_four_channel_shared_support_integration_0/v3_four_channel_bias_reference_distribution_0/v3_four_channel_phase_distribution_0/v3_four_channel_output_collection_0/v3_four_channel_placement_0/v3_channel_selector_late_promotion_1/group3_bit1 VGND VGND sky130_fd_pr__nfet_01v8 ad=0 pd=0 as=0 ps=0 w=0.42 l=0.15
X481 VDPWR v3_four_channel_output_load_integration_0/v3_four_channel_shared_support_integration_0/v3_four_channel_bias_reference_distribution_0/v3_four_channel_phase_distribution_0/v3_four_channel_output_collection_0/v3_four_channel_placement_0/v3_channel_selector_late_promotion_1/v3_selector_route_pilot_0/G3_MUX_AXIS/a_76_199# v3_four_channel_output_load_integration_0/v3_four_channel_shared_support_integration_0/v3_four_channel_bias_reference_distribution_0/v3_four_channel_phase_distribution_0/v3_four_channel_output_collection_0/v3_four_channel_placement_0/v3_channel_selector_late_promotion_1/v3_selector_route_pilot_0/G3_MUX_AXIS/X VDPWR sky130_fd_pr__pfet_01v8_hvt ad=0 pd=0 as=0.26 ps=2.52 w=1 l=0.15
X482 VGND v3_four_channel_output_load_integration_0/v3_four_channel_shared_support_integration_0/v3_four_channel_bias_reference_distribution_0/v3_four_channel_phase_distribution_0/v3_four_channel_output_collection_0/v3_four_channel_placement_0/v3_channel_selector_late_promotion_1/v3_selector_route_pilot_0/G3_MUX_AXIS/a_76_199# v3_four_channel_output_load_integration_0/v3_four_channel_shared_support_integration_0/v3_four_channel_bias_reference_distribution_0/v3_four_channel_phase_distribution_0/v3_four_channel_output_collection_0/v3_four_channel_placement_0/v3_channel_selector_late_promotion_1/v3_selector_route_pilot_0/G3_MUX_AXIS/X VGND sky130_fd_pr__nfet_01v8 ad=0 pd=0 as=0.169 ps=1.82 w=0.65 l=0.15
X483 VDPWR v3_four_channel_output_load_integration_0/v3_four_channel_shared_support_integration_0/v3_four_channel_bias_reference_distribution_0/v3_four_channel_phase_distribution_0/v3_four_channel_output_collection_0/v3_four_channel_placement_0/v3_channel_selector_late_promotion_1/channel_enable v3_four_channel_output_load_integration_0/v3_four_channel_shared_support_integration_0/v3_four_channel_bias_reference_distribution_0/v3_four_channel_phase_distribution_0/v3_four_channel_output_collection_0/v3_four_channel_placement_0/v3_channel_selector_late_promotion_1/v3_selector_route_pilot_0/ENABLE_ANDNOT/a_207_413# VDPWR sky130_fd_pr__pfet_01v8_hvt ad=0 pd=0 as=0.1218 ps=1.42 w=0.42 l=0.15
X484 v3_four_channel_output_load_integration_0/v3_four_channel_shared_support_integration_0/v3_four_channel_bias_reference_distribution_0/v3_four_channel_phase_distribution_0/v3_four_channel_output_collection_0/v3_four_channel_placement_0/v3_channel_selector_late_promotion_1/v3_selector_route_pilot_0/G3_LO_P_AND/B v3_four_channel_output_load_integration_0/v3_four_channel_shared_support_integration_0/v3_four_channel_bias_reference_distribution_0/v3_four_channel_phase_distribution_0/v3_four_channel_output_collection_0/v3_four_channel_placement_0/v3_channel_selector_late_promotion_1/v3_selector_route_pilot_0/ENABLE_ANDNOT/a_207_413# VDPWR VDPWR sky130_fd_pr__pfet_01v8_hvt ad=0.26 pd=2.52 as=0 ps=0 w=1 l=0.15
X485 v3_four_channel_output_load_integration_0/v3_four_channel_shared_support_integration_0/v3_four_channel_bias_reference_distribution_0/v3_four_channel_phase_distribution_0/v3_four_channel_output_collection_0/v3_four_channel_placement_0/v3_channel_selector_late_promotion_1/v3_selector_route_pilot_0/ENABLE_ANDNOT/a_297_47# v3_four_channel_output_load_integration_0/v3_four_channel_shared_support_integration_0/v3_four_channel_bias_reference_distribution_0/v3_four_channel_phase_distribution_0/v3_four_channel_output_collection_0/v3_four_channel_placement_0/v3_channel_selector_late_promotion_1/v3_selector_route_pilot_0/ENABLE_ANDNOT/a_27_413# v3_four_channel_output_load_integration_0/v3_four_channel_shared_support_integration_0/v3_four_channel_bias_reference_distribution_0/v3_four_channel_phase_distribution_0/v3_four_channel_output_collection_0/v3_four_channel_placement_0/v3_channel_selector_late_promotion_1/v3_selector_route_pilot_0/ENABLE_ANDNOT/a_207_413# VGND sky130_fd_pr__nfet_01v8 ad=0.1008 pd=1.32 as=0.1092 ps=1.36 w=0.42 l=0.15
X486 v3_four_channel_output_load_integration_0/v3_four_channel_shared_support_integration_0/v3_four_channel_bias_reference_distribution_0/v3_four_channel_phase_distribution_0/v3_four_channel_output_collection_0/v3_four_channel_placement_0/v3_channel_selector_late_promotion_1/v3_selector_route_pilot_0/G3_LO_P_AND/B v3_four_channel_output_load_integration_0/v3_four_channel_shared_support_integration_0/v3_four_channel_bias_reference_distribution_0/v3_four_channel_phase_distribution_0/v3_four_channel_output_collection_0/v3_four_channel_placement_0/v3_channel_selector_late_promotion_1/v3_selector_route_pilot_0/ENABLE_ANDNOT/a_207_413# VGND VGND sky130_fd_pr__nfet_01v8 ad=0.169 pd=1.82 as=0 ps=0 w=0.65 l=0.15
X487 v3_four_channel_output_load_integration_0/v3_four_channel_shared_support_integration_0/v3_four_channel_bias_reference_distribution_0/v3_four_channel_phase_distribution_0/v3_four_channel_output_collection_0/v3_four_channel_placement_0/v3_channel_selector_late_promotion_1/v3_selector_route_pilot_0/ENABLE_ANDNOT/a_207_413# v3_four_channel_output_load_integration_0/v3_four_channel_shared_support_integration_0/v3_four_channel_bias_reference_distribution_0/v3_four_channel_phase_distribution_0/v3_four_channel_output_collection_0/v3_four_channel_placement_0/v3_channel_selector_late_promotion_1/v3_selector_route_pilot_0/ENABLE_ANDNOT/a_27_413# VDPWR VDPWR sky130_fd_pr__pfet_01v8_hvt ad=0 pd=0 as=0 ps=0 w=0.42 l=0.15
X488 VDPWR v3_four_channel_output_load_integration_0/v3_four_channel_shared_support_integration_0/v3_four_channel_bias_reference_distribution_0/v3_four_channel_phase_distribution_0/v3_four_channel_output_collection_0/v3_four_channel_placement_0/v3_channel_selector_late_promotion_1/mixers_blank v3_four_channel_output_load_integration_0/v3_four_channel_shared_support_integration_0/v3_four_channel_bias_reference_distribution_0/v3_four_channel_phase_distribution_0/v3_four_channel_output_collection_0/v3_four_channel_placement_0/v3_channel_selector_late_promotion_1/v3_selector_route_pilot_0/ENABLE_ANDNOT/a_27_413# VDPWR sky130_fd_pr__pfet_01v8_hvt ad=0 pd=0 as=0.1092 ps=1.36 w=0.42 l=0.15
X489 VGND v3_four_channel_output_load_integration_0/v3_four_channel_shared_support_integration_0/v3_four_channel_bias_reference_distribution_0/v3_four_channel_phase_distribution_0/v3_four_channel_output_collection_0/v3_four_channel_placement_0/v3_channel_selector_late_promotion_1/channel_enable v3_four_channel_output_load_integration_0/v3_four_channel_shared_support_integration_0/v3_four_channel_bias_reference_distribution_0/v3_four_channel_phase_distribution_0/v3_four_channel_output_collection_0/v3_four_channel_placement_0/v3_channel_selector_late_promotion_1/v3_selector_route_pilot_0/ENABLE_ANDNOT/a_297_47# VGND sky130_fd_pr__nfet_01v8 ad=0 pd=0 as=0 ps=0 w=0.42 l=0.15
X490 v3_four_channel_output_load_integration_0/v3_four_channel_shared_support_integration_0/v3_four_channel_bias_reference_distribution_0/v3_four_channel_phase_distribution_0/v3_four_channel_output_collection_0/v3_four_channel_placement_0/v3_channel_selector_late_promotion_1/v3_selector_route_pilot_0/ENABLE_ANDNOT/a_27_413# v3_four_channel_output_load_integration_0/v3_four_channel_shared_support_integration_0/v3_four_channel_bias_reference_distribution_0/v3_four_channel_phase_distribution_0/v3_four_channel_output_collection_0/v3_four_channel_placement_0/v3_channel_selector_late_promotion_1/mixers_blank VGND VGND sky130_fd_pr__nfet_01v8 ad=0.1092 pd=1.36 as=0 ps=0 w=0.42 l=0.15
X491 VDPWR v3_four_channel_output_load_integration_0/v3_four_channel_shared_support_integration_0/v3_four_channel_bias_reference_distribution_0/v3_four_channel_phase_distribution_0/v3_four_channel_output_collection_0/v3_four_channel_placement_0/v3_channel_selector_late_promotion_1/v3_selector_route_pilot_0/G1_MUX_NEG/a_505_21# v3_four_channel_output_load_integration_0/v3_four_channel_shared_support_integration_0/v3_four_channel_bias_reference_distribution_0/v3_four_channel_phase_distribution_0/v3_four_channel_output_collection_0/v3_four_channel_placement_0/v3_channel_selector_late_promotion_1/v3_selector_route_pilot_0/G1_MUX_NEG/a_535_374# VDPWR sky130_fd_pr__pfet_01v8_hvt ad=0 pd=0 as=0.0882 ps=1.26 w=0.42 l=0.15
X492 v3_four_channel_output_load_integration_0/v3_four_channel_shared_support_integration_0/v3_four_channel_bias_reference_distribution_0/v3_four_channel_phase_distribution_0/v3_four_channel_output_collection_0/v3_four_channel_placement_0/v3_channel_selector_late_promotion_1/v3_selector_route_pilot_0/G1_MUX_NEG/a_505_21# v3_four_channel_output_load_integration_0/v3_four_channel_shared_support_integration_0/v3_four_channel_bias_reference_distribution_0/v3_four_channel_phase_distribution_0/v3_four_channel_output_collection_0/v3_four_channel_placement_0/v3_channel_selector_late_promotion_1/group1_bit0 VDPWR VDPWR sky130_fd_pr__pfet_01v8_hvt ad=0.1176 pd=1.4 as=0 ps=0 w=0.42 l=0.15
X493 v3_four_channel_output_load_integration_0/v3_four_channel_shared_support_integration_0/v3_four_channel_bias_reference_distribution_0/v3_four_channel_phase_distribution_0/v3_four_channel_output_collection_0/v3_four_channel_placement_0/v3_channel_selector_late_promotion_1/v3_selector_route_pilot_0/G1_MUX_NEG/a_218_374# v3_four_channel_output_load_integration_0/v3_four_channel_shared_support_integration_0/v3_four_channel_bias_reference_distribution_0/v3_four_channel_phase_distribution_0/v3_four_channel_output_collection_0/v3_four_channel_placement_0/v3_channel_selector_late_promotion_1/group1_bit0 VDPWR VDPWR sky130_fd_pr__pfet_01v8_hvt ad=0.1533 pd=1.57 as=0 ps=0 w=0.42 l=0.15
X494 VGND v3_four_channel_output_load_integration_0/v3_four_channel_shared_support_integration_0/v3_four_channel_bias_reference_distribution_0/v3_four_channel_phase_distribution_0/v3_four_channel_output_collection_0/v3_four_channel_placement_0/v3_channel_selector_late_promotion_1/v3_selector_route_pilot_0/G1_MUX_NEG/a_505_21# v3_four_channel_output_load_integration_0/v3_four_channel_shared_support_integration_0/v3_four_channel_bias_reference_distribution_0/v3_four_channel_phase_distribution_0/v3_four_channel_output_collection_0/v3_four_channel_placement_0/v3_channel_selector_late_promotion_1/v3_selector_route_pilot_0/G1_MUX_NEG/a_439_47# VGND sky130_fd_pr__nfet_01v8 ad=0 pd=0 as=0.1386 ps=1.5 w=0.42 l=0.15
X495 v3_four_channel_output_load_integration_0/v3_four_channel_shared_support_integration_0/v3_four_channel_bias_reference_distribution_0/v3_four_channel_phase_distribution_0/v3_four_channel_output_collection_0/v3_four_channel_placement_0/v3_channel_selector_late_promotion_1/v3_selector_route_pilot_0/G1_MUX_NEG/a_76_199# v3_four_channel_output_load_integration_0/v3_four_channel_shared_support_integration_0/v3_four_channel_bias_reference_distribution_0/v3_four_channel_phase_distribution_0/phase_180 v3_four_channel_output_load_integration_0/v3_four_channel_shared_support_integration_0/v3_four_channel_bias_reference_distribution_0/v3_four_channel_phase_distribution_0/v3_four_channel_output_collection_0/v3_four_channel_placement_0/v3_channel_selector_late_promotion_1/v3_selector_route_pilot_0/G1_MUX_NEG/a_218_374# VDPWR sky130_fd_pr__pfet_01v8_hvt ad=0.3864 pd=2.68 as=0 ps=0 w=0.42 l=0.15
X496 v3_four_channel_output_load_integration_0/v3_four_channel_shared_support_integration_0/v3_four_channel_bias_reference_distribution_0/v3_four_channel_phase_distribution_0/v3_four_channel_output_collection_0/v3_four_channel_placement_0/v3_channel_selector_late_promotion_1/v3_selector_route_pilot_0/G1_MUX_NEG/a_505_21# v3_four_channel_output_load_integration_0/v3_four_channel_shared_support_integration_0/v3_four_channel_bias_reference_distribution_0/v3_four_channel_phase_distribution_0/v3_four_channel_output_collection_0/v3_four_channel_placement_0/v3_channel_selector_late_promotion_1/group1_bit0 VGND VGND sky130_fd_pr__nfet_01v8 ad=0.1092 pd=1.36 as=0 ps=0 w=0.42 l=0.15
X497 v3_four_channel_output_load_integration_0/v3_four_channel_shared_support_integration_0/v3_four_channel_bias_reference_distribution_0/v3_four_channel_phase_distribution_0/v3_four_channel_output_collection_0/v3_four_channel_placement_0/v3_channel_selector_late_promotion_1/v3_selector_route_pilot_0/G1_MUX_NEG/a_439_47# v3_four_channel_output_load_integration_0/v3_four_channel_shared_support_integration_0/v3_four_channel_bias_reference_distribution_0/v3_four_channel_phase_distribution_0/phase_180 v3_four_channel_output_load_integration_0/v3_four_channel_shared_support_integration_0/v3_four_channel_bias_reference_distribution_0/v3_four_channel_phase_distribution_0/v3_four_channel_output_collection_0/v3_four_channel_placement_0/v3_channel_selector_late_promotion_1/v3_selector_route_pilot_0/G1_MUX_NEG/a_76_199# VGND sky130_fd_pr__nfet_01v8 ad=0 pd=0 as=0.1995 ps=1.79 w=0.42 l=0.15
X498 v3_four_channel_output_load_integration_0/v3_four_channel_shared_support_integration_0/v3_four_channel_bias_reference_distribution_0/v3_four_channel_phase_distribution_0/v3_four_channel_output_collection_0/v3_four_channel_placement_0/v3_channel_selector_late_promotion_1/v3_selector_route_pilot_0/G1_MUX_NEG/a_535_374# v3_four_channel_output_load_integration_0/v3_four_channel_shared_support_integration_0/v3_four_channel_bias_reference_distribution_0/v3_four_channel_phase_distribution_0/phase_270 v3_four_channel_output_load_integration_0/v3_four_channel_shared_support_integration_0/v3_four_channel_bias_reference_distribution_0/v3_four_channel_phase_distribution_0/v3_four_channel_output_collection_0/v3_four_channel_placement_0/v3_channel_selector_late_promotion_1/v3_selector_route_pilot_0/G1_MUX_NEG/a_76_199# VDPWR sky130_fd_pr__pfet_01v8_hvt ad=0 pd=0 as=0 ps=0 w=0.42 l=0.15
X499 v3_four_channel_output_load_integration_0/v3_four_channel_shared_support_integration_0/v3_four_channel_bias_reference_distribution_0/v3_four_channel_phase_distribution_0/v3_four_channel_output_collection_0/v3_four_channel_placement_0/v3_channel_selector_late_promotion_1/v3_selector_route_pilot_0/G1_MUX_NEG/a_76_199# v3_four_channel_output_load_integration_0/v3_four_channel_shared_support_integration_0/v3_four_channel_bias_reference_distribution_0/v3_four_channel_phase_distribution_0/phase_270 v3_four_channel_output_load_integration_0/v3_four_channel_shared_support_integration_0/v3_four_channel_bias_reference_distribution_0/v3_four_channel_phase_distribution_0/v3_four_channel_output_collection_0/v3_four_channel_placement_0/v3_channel_selector_late_promotion_1/v3_selector_route_pilot_0/G1_MUX_NEG/a_218_47# VGND sky130_fd_pr__nfet_01v8 ad=0 pd=0 as=0.1386 ps=1.5 w=0.42 l=0.15
X500 v3_four_channel_output_load_integration_0/v3_four_channel_shared_support_integration_0/v3_four_channel_bias_reference_distribution_0/v3_four_channel_phase_distribution_0/v3_four_channel_output_collection_0/v3_four_channel_placement_0/v3_channel_selector_late_promotion_1/v3_selector_route_pilot_0/G1_MUX_NEG/a_218_47# v3_four_channel_output_load_integration_0/v3_four_channel_shared_support_integration_0/v3_four_channel_bias_reference_distribution_0/v3_four_channel_phase_distribution_0/v3_four_channel_output_collection_0/v3_four_channel_placement_0/v3_channel_selector_late_promotion_1/group1_bit0 VGND VGND sky130_fd_pr__nfet_01v8 ad=0 pd=0 as=0 ps=0 w=0.42 l=0.15
X501 VDPWR v3_four_channel_output_load_integration_0/v3_four_channel_shared_support_integration_0/v3_four_channel_bias_reference_distribution_0/v3_four_channel_phase_distribution_0/v3_four_channel_output_collection_0/v3_four_channel_placement_0/v3_channel_selector_late_promotion_1/v3_selector_route_pilot_0/G1_MUX_NEG/a_76_199# v3_four_channel_output_load_integration_0/v3_four_channel_shared_support_integration_0/v3_four_channel_bias_reference_distribution_0/v3_four_channel_phase_distribution_0/v3_four_channel_output_collection_0/v3_four_channel_placement_0/v3_channel_selector_late_promotion_1/v3_selector_route_pilot_0/G1_MUX_NEG/X VDPWR sky130_fd_pr__pfet_01v8_hvt ad=0 pd=0 as=0.26 ps=2.52 w=1 l=0.15
X502 VGND v3_four_channel_output_load_integration_0/v3_four_channel_shared_support_integration_0/v3_four_channel_bias_reference_distribution_0/v3_four_channel_phase_distribution_0/v3_four_channel_output_collection_0/v3_four_channel_placement_0/v3_channel_selector_late_promotion_1/v3_selector_route_pilot_0/G1_MUX_NEG/a_76_199# v3_four_channel_output_load_integration_0/v3_four_channel_shared_support_integration_0/v3_four_channel_bias_reference_distribution_0/v3_four_channel_phase_distribution_0/v3_four_channel_output_collection_0/v3_four_channel_placement_0/v3_channel_selector_late_promotion_1/v3_selector_route_pilot_0/G1_MUX_NEG/X VGND sky130_fd_pr__nfet_01v8 ad=0 pd=0 as=0.169 ps=1.82 w=0.65 l=0.15
X503 VDPWR v3_four_channel_output_load_integration_0/v3_four_channel_shared_support_integration_0/v3_four_channel_bias_reference_distribution_0/v3_four_channel_phase_distribution_0/v3_four_channel_output_collection_0/v3_four_channel_placement_0/v3_channel_selector_late_promotion_1/v3_selector_route_pilot_0/G3_LO_P_AND/B v3_four_channel_output_load_integration_0/v3_four_channel_shared_support_integration_0/v3_four_channel_bias_reference_distribution_0/v3_four_channel_phase_distribution_0/v3_four_channel_output_collection_0/v3_four_channel_placement_0/v3_channel_selector_late_promotion_1/v3_selector_route_pilot_0/G1_LO_P_AND/a_59_75# VDPWR sky130_fd_pr__pfet_01v8_hvt ad=0 pd=0 as=0.1134 ps=1.38 w=0.42 l=0.15
X504 v3_four_channel_output_load_integration_0/v3_four_channel_shared_support_integration_0/v3_four_channel_bias_reference_distribution_0/v3_four_channel_phase_distribution_0/v3_four_channel_output_collection_0/v3_four_channel_placement_0/v3_channel_selector_late_promotion_1/v3_selector_route_pilot_0/group1_lo_p v3_four_channel_output_load_integration_0/v3_four_channel_shared_support_integration_0/v3_four_channel_bias_reference_distribution_0/v3_four_channel_phase_distribution_0/v3_four_channel_output_collection_0/v3_four_channel_placement_0/v3_channel_selector_late_promotion_1/v3_selector_route_pilot_0/G1_LO_P_AND/a_59_75# VDPWR VDPWR sky130_fd_pr__pfet_01v8_hvt ad=0.475 pd=2.95 as=0 ps=0 w=1 l=0.15
X505 VGND v3_four_channel_output_load_integration_0/v3_four_channel_shared_support_integration_0/v3_four_channel_bias_reference_distribution_0/v3_four_channel_phase_distribution_0/v3_four_channel_output_collection_0/v3_four_channel_placement_0/v3_channel_selector_late_promotion_1/v3_selector_route_pilot_0/G3_LO_P_AND/B v3_four_channel_output_load_integration_0/v3_four_channel_shared_support_integration_0/v3_four_channel_bias_reference_distribution_0/v3_four_channel_phase_distribution_0/v3_four_channel_output_collection_0/v3_four_channel_placement_0/v3_channel_selector_late_promotion_1/v3_selector_route_pilot_0/G1_LO_P_AND/a_145_75# VGND sky130_fd_pr__nfet_01v8 ad=0 pd=0 as=0.1134 ps=1.38 w=0.42 l=0.15
X506 v3_four_channel_output_load_integration_0/v3_four_channel_shared_support_integration_0/v3_four_channel_bias_reference_distribution_0/v3_four_channel_phase_distribution_0/v3_four_channel_output_collection_0/v3_four_channel_placement_0/v3_channel_selector_late_promotion_1/v3_selector_route_pilot_0/G1_LO_P_AND/a_59_75# v3_four_channel_output_load_integration_0/v3_four_channel_shared_support_integration_0/v3_four_channel_bias_reference_distribution_0/v3_four_channel_phase_distribution_0/v3_four_channel_output_collection_0/v3_four_channel_placement_0/v3_channel_selector_late_promotion_1/v3_selector_route_pilot_0/G1_MUX_AXIS/X VDPWR VDPWR sky130_fd_pr__pfet_01v8_hvt ad=0 pd=0 as=0 ps=0 w=0.42 l=0.15
X507 v3_four_channel_output_load_integration_0/v3_four_channel_shared_support_integration_0/v3_four_channel_bias_reference_distribution_0/v3_four_channel_phase_distribution_0/v3_four_channel_output_collection_0/v3_four_channel_placement_0/v3_channel_selector_late_promotion_1/v3_selector_route_pilot_0/group1_lo_p v3_four_channel_output_load_integration_0/v3_four_channel_shared_support_integration_0/v3_four_channel_bias_reference_distribution_0/v3_four_channel_phase_distribution_0/v3_four_channel_output_collection_0/v3_four_channel_placement_0/v3_channel_selector_late_promotion_1/v3_selector_route_pilot_0/G1_LO_P_AND/a_59_75# VGND VGND sky130_fd_pr__nfet_01v8 ad=0.182 pd=1.86 as=0 ps=0 w=0.65 l=0.15
X508 v3_four_channel_output_load_integration_0/v3_four_channel_shared_support_integration_0/v3_four_channel_bias_reference_distribution_0/v3_four_channel_phase_distribution_0/v3_four_channel_output_collection_0/v3_four_channel_placement_0/v3_channel_selector_late_promotion_1/v3_selector_route_pilot_0/G1_LO_P_AND/a_145_75# v3_four_channel_output_load_integration_0/v3_four_channel_shared_support_integration_0/v3_four_channel_bias_reference_distribution_0/v3_four_channel_phase_distribution_0/v3_four_channel_output_collection_0/v3_four_channel_placement_0/v3_channel_selector_late_promotion_1/v3_selector_route_pilot_0/G1_MUX_AXIS/X v3_four_channel_output_load_integration_0/v3_four_channel_shared_support_integration_0/v3_four_channel_bias_reference_distribution_0/v3_four_channel_phase_distribution_0/v3_four_channel_output_collection_0/v3_four_channel_placement_0/v3_channel_selector_late_promotion_1/v3_selector_route_pilot_0/G1_LO_P_AND/a_59_75# VGND sky130_fd_pr__nfet_01v8 ad=0 pd=0 as=0.1176 ps=1.4 w=0.42 l=0.15
X509 VDPWR v3_four_channel_output_load_integration_0/v3_four_channel_shared_support_integration_0/v3_four_channel_bias_reference_distribution_0/v3_four_channel_phase_distribution_0/v3_four_channel_output_collection_0/v3_four_channel_placement_0/v3_channel_selector_late_promotion_1/v3_selector_route_pilot_0/G0_MUX_POS/a_505_21# v3_four_channel_output_load_integration_0/v3_four_channel_shared_support_integration_0/v3_four_channel_bias_reference_distribution_0/v3_four_channel_phase_distribution_0/v3_four_channel_output_collection_0/v3_four_channel_placement_0/v3_channel_selector_late_promotion_1/v3_selector_route_pilot_0/G0_MUX_POS/a_535_374# VDPWR sky130_fd_pr__pfet_01v8_hvt ad=0 pd=0 as=0.0882 ps=1.26 w=0.42 l=0.15
X510 v3_four_channel_output_load_integration_0/v3_four_channel_shared_support_integration_0/v3_four_channel_bias_reference_distribution_0/v3_four_channel_phase_distribution_0/v3_four_channel_output_collection_0/v3_four_channel_placement_0/v3_channel_selector_late_promotion_1/v3_selector_route_pilot_0/G0_MUX_POS/a_505_21# v3_four_channel_output_load_integration_0/v3_four_channel_shared_support_integration_0/v3_four_channel_bias_reference_distribution_0/v3_four_channel_phase_distribution_0/v3_four_channel_output_collection_0/v3_four_channel_placement_0/v3_channel_selector_late_promotion_1/group0_bit0 VDPWR VDPWR sky130_fd_pr__pfet_01v8_hvt ad=0.1176 pd=1.4 as=0 ps=0 w=0.42 l=0.15
X511 v3_four_channel_output_load_integration_0/v3_four_channel_shared_support_integration_0/v3_four_channel_bias_reference_distribution_0/v3_four_channel_phase_distribution_0/v3_four_channel_output_collection_0/v3_four_channel_placement_0/v3_channel_selector_late_promotion_1/v3_selector_route_pilot_0/G0_MUX_POS/a_218_374# v3_four_channel_output_load_integration_0/v3_four_channel_shared_support_integration_0/v3_four_channel_bias_reference_distribution_0/v3_four_channel_phase_distribution_0/v3_four_channel_output_collection_0/v3_four_channel_placement_0/v3_channel_selector_late_promotion_1/group0_bit0 VDPWR VDPWR sky130_fd_pr__pfet_01v8_hvt ad=0.1533 pd=1.57 as=0 ps=0 w=0.42 l=0.15
X512 VGND v3_four_channel_output_load_integration_0/v3_four_channel_shared_support_integration_0/v3_four_channel_bias_reference_distribution_0/v3_four_channel_phase_distribution_0/v3_four_channel_output_collection_0/v3_four_channel_placement_0/v3_channel_selector_late_promotion_1/v3_selector_route_pilot_0/G0_MUX_POS/a_505_21# v3_four_channel_output_load_integration_0/v3_four_channel_shared_support_integration_0/v3_four_channel_bias_reference_distribution_0/v3_four_channel_phase_distribution_0/v3_four_channel_output_collection_0/v3_four_channel_placement_0/v3_channel_selector_late_promotion_1/v3_selector_route_pilot_0/G0_MUX_POS/a_439_47# VGND sky130_fd_pr__nfet_01v8 ad=0 pd=0 as=0.1386 ps=1.5 w=0.42 l=0.15
X513 v3_four_channel_output_load_integration_0/v3_four_channel_shared_support_integration_0/v3_four_channel_bias_reference_distribution_0/v3_four_channel_phase_distribution_0/v3_four_channel_output_collection_0/v3_four_channel_placement_0/v3_channel_selector_late_promotion_1/v3_selector_route_pilot_0/G0_MUX_POS/a_76_199# v3_four_channel_output_load_integration_0/v3_four_channel_shared_support_integration_0/v3_four_channel_bias_reference_distribution_0/v3_four_channel_phase_distribution_0/phase_0 v3_four_channel_output_load_integration_0/v3_four_channel_shared_support_integration_0/v3_four_channel_bias_reference_distribution_0/v3_four_channel_phase_distribution_0/v3_four_channel_output_collection_0/v3_four_channel_placement_0/v3_channel_selector_late_promotion_1/v3_selector_route_pilot_0/G0_MUX_POS/a_218_374# VDPWR sky130_fd_pr__pfet_01v8_hvt ad=0.3864 pd=2.68 as=0 ps=0 w=0.42 l=0.15
X514 v3_four_channel_output_load_integration_0/v3_four_channel_shared_support_integration_0/v3_four_channel_bias_reference_distribution_0/v3_four_channel_phase_distribution_0/v3_four_channel_output_collection_0/v3_four_channel_placement_0/v3_channel_selector_late_promotion_1/v3_selector_route_pilot_0/G0_MUX_POS/a_505_21# v3_four_channel_output_load_integration_0/v3_four_channel_shared_support_integration_0/v3_four_channel_bias_reference_distribution_0/v3_four_channel_phase_distribution_0/v3_four_channel_output_collection_0/v3_four_channel_placement_0/v3_channel_selector_late_promotion_1/group0_bit0 VGND VGND sky130_fd_pr__nfet_01v8 ad=0.1092 pd=1.36 as=0 ps=0 w=0.42 l=0.15
X515 v3_four_channel_output_load_integration_0/v3_four_channel_shared_support_integration_0/v3_four_channel_bias_reference_distribution_0/v3_four_channel_phase_distribution_0/v3_four_channel_output_collection_0/v3_four_channel_placement_0/v3_channel_selector_late_promotion_1/v3_selector_route_pilot_0/G0_MUX_POS/a_439_47# v3_four_channel_output_load_integration_0/v3_four_channel_shared_support_integration_0/v3_four_channel_bias_reference_distribution_0/v3_four_channel_phase_distribution_0/phase_0 v3_four_channel_output_load_integration_0/v3_four_channel_shared_support_integration_0/v3_four_channel_bias_reference_distribution_0/v3_four_channel_phase_distribution_0/v3_four_channel_output_collection_0/v3_four_channel_placement_0/v3_channel_selector_late_promotion_1/v3_selector_route_pilot_0/G0_MUX_POS/a_76_199# VGND sky130_fd_pr__nfet_01v8 ad=0 pd=0 as=0.1995 ps=1.79 w=0.42 l=0.15
X516 v3_four_channel_output_load_integration_0/v3_four_channel_shared_support_integration_0/v3_four_channel_bias_reference_distribution_0/v3_four_channel_phase_distribution_0/v3_four_channel_output_collection_0/v3_four_channel_placement_0/v3_channel_selector_late_promotion_1/v3_selector_route_pilot_0/G0_MUX_POS/a_535_374# v3_four_channel_output_load_integration_0/v3_four_channel_shared_support_integration_0/v3_four_channel_bias_reference_distribution_0/v3_four_channel_phase_distribution_0/phase_90 v3_four_channel_output_load_integration_0/v3_four_channel_shared_support_integration_0/v3_four_channel_bias_reference_distribution_0/v3_four_channel_phase_distribution_0/v3_four_channel_output_collection_0/v3_four_channel_placement_0/v3_channel_selector_late_promotion_1/v3_selector_route_pilot_0/G0_MUX_POS/a_76_199# VDPWR sky130_fd_pr__pfet_01v8_hvt ad=0 pd=0 as=0 ps=0 w=0.42 l=0.15
X517 v3_four_channel_output_load_integration_0/v3_four_channel_shared_support_integration_0/v3_four_channel_bias_reference_distribution_0/v3_four_channel_phase_distribution_0/v3_four_channel_output_collection_0/v3_four_channel_placement_0/v3_channel_selector_late_promotion_1/v3_selector_route_pilot_0/G0_MUX_POS/a_76_199# v3_four_channel_output_load_integration_0/v3_four_channel_shared_support_integration_0/v3_four_channel_bias_reference_distribution_0/v3_four_channel_phase_distribution_0/phase_90 v3_four_channel_output_load_integration_0/v3_four_channel_shared_support_integration_0/v3_four_channel_bias_reference_distribution_0/v3_four_channel_phase_distribution_0/v3_four_channel_output_collection_0/v3_four_channel_placement_0/v3_channel_selector_late_promotion_1/v3_selector_route_pilot_0/G0_MUX_POS/a_218_47# VGND sky130_fd_pr__nfet_01v8 ad=0 pd=0 as=0.1386 ps=1.5 w=0.42 l=0.15
X518 v3_four_channel_output_load_integration_0/v3_four_channel_shared_support_integration_0/v3_four_channel_bias_reference_distribution_0/v3_four_channel_phase_distribution_0/v3_four_channel_output_collection_0/v3_four_channel_placement_0/v3_channel_selector_late_promotion_1/v3_selector_route_pilot_0/G0_MUX_POS/a_218_47# v3_four_channel_output_load_integration_0/v3_four_channel_shared_support_integration_0/v3_four_channel_bias_reference_distribution_0/v3_four_channel_phase_distribution_0/v3_four_channel_output_collection_0/v3_four_channel_placement_0/v3_channel_selector_late_promotion_1/group0_bit0 VGND VGND sky130_fd_pr__nfet_01v8 ad=0 pd=0 as=0 ps=0 w=0.42 l=0.15
X519 VDPWR v3_four_channel_output_load_integration_0/v3_four_channel_shared_support_integration_0/v3_four_channel_bias_reference_distribution_0/v3_four_channel_phase_distribution_0/v3_four_channel_output_collection_0/v3_four_channel_placement_0/v3_channel_selector_late_promotion_1/v3_selector_route_pilot_0/G0_MUX_POS/a_76_199# v3_four_channel_output_load_integration_0/v3_four_channel_shared_support_integration_0/v3_four_channel_bias_reference_distribution_0/v3_four_channel_phase_distribution_0/v3_four_channel_output_collection_0/v3_four_channel_placement_0/v3_channel_selector_late_promotion_1/v3_selector_route_pilot_0/G0_MUX_POS/X VDPWR sky130_fd_pr__pfet_01v8_hvt ad=0 pd=0 as=0.26 ps=2.52 w=1 l=0.15
X520 VGND v3_four_channel_output_load_integration_0/v3_four_channel_shared_support_integration_0/v3_four_channel_bias_reference_distribution_0/v3_four_channel_phase_distribution_0/v3_four_channel_output_collection_0/v3_four_channel_placement_0/v3_channel_selector_late_promotion_1/v3_selector_route_pilot_0/G0_MUX_POS/a_76_199# v3_four_channel_output_load_integration_0/v3_four_channel_shared_support_integration_0/v3_four_channel_bias_reference_distribution_0/v3_four_channel_phase_distribution_0/v3_four_channel_output_collection_0/v3_four_channel_placement_0/v3_channel_selector_late_promotion_1/v3_selector_route_pilot_0/G0_MUX_POS/X VGND sky130_fd_pr__nfet_01v8 ad=0 pd=0 as=0.169 ps=1.82 w=0.65 l=0.15
X521 VDPWR v3_four_channel_output_load_integration_0/v3_four_channel_shared_support_integration_0/v3_four_channel_bias_reference_distribution_0/v3_four_channel_phase_distribution_0/v3_four_channel_output_collection_0/v3_four_channel_placement_0/v3_channel_selector_late_promotion_1/v3_selector_route_pilot_0/G0_MUX_NEG/a_505_21# v3_four_channel_output_load_integration_0/v3_four_channel_shared_support_integration_0/v3_four_channel_bias_reference_distribution_0/v3_four_channel_phase_distribution_0/v3_four_channel_output_collection_0/v3_four_channel_placement_0/v3_channel_selector_late_promotion_1/v3_selector_route_pilot_0/G0_MUX_NEG/a_535_374# VDPWR sky130_fd_pr__pfet_01v8_hvt ad=0 pd=0 as=0.0882 ps=1.26 w=0.42 l=0.15
X522 v3_four_channel_output_load_integration_0/v3_four_channel_shared_support_integration_0/v3_four_channel_bias_reference_distribution_0/v3_four_channel_phase_distribution_0/v3_four_channel_output_collection_0/v3_four_channel_placement_0/v3_channel_selector_late_promotion_1/v3_selector_route_pilot_0/G0_MUX_NEG/a_505_21# v3_four_channel_output_load_integration_0/v3_four_channel_shared_support_integration_0/v3_four_channel_bias_reference_distribution_0/v3_four_channel_phase_distribution_0/v3_four_channel_output_collection_0/v3_four_channel_placement_0/v3_channel_selector_late_promotion_1/group0_bit0 VDPWR VDPWR sky130_fd_pr__pfet_01v8_hvt ad=0.1176 pd=1.4 as=0 ps=0 w=0.42 l=0.15
X523 v3_four_channel_output_load_integration_0/v3_four_channel_shared_support_integration_0/v3_four_channel_bias_reference_distribution_0/v3_four_channel_phase_distribution_0/v3_four_channel_output_collection_0/v3_four_channel_placement_0/v3_channel_selector_late_promotion_1/v3_selector_route_pilot_0/G0_MUX_NEG/a_218_374# v3_four_channel_output_load_integration_0/v3_four_channel_shared_support_integration_0/v3_four_channel_bias_reference_distribution_0/v3_four_channel_phase_distribution_0/v3_four_channel_output_collection_0/v3_four_channel_placement_0/v3_channel_selector_late_promotion_1/group0_bit0 VDPWR VDPWR sky130_fd_pr__pfet_01v8_hvt ad=0.1533 pd=1.57 as=0 ps=0 w=0.42 l=0.15
X524 VGND v3_four_channel_output_load_integration_0/v3_four_channel_shared_support_integration_0/v3_four_channel_bias_reference_distribution_0/v3_four_channel_phase_distribution_0/v3_four_channel_output_collection_0/v3_four_channel_placement_0/v3_channel_selector_late_promotion_1/v3_selector_route_pilot_0/G0_MUX_NEG/a_505_21# v3_four_channel_output_load_integration_0/v3_four_channel_shared_support_integration_0/v3_four_channel_bias_reference_distribution_0/v3_four_channel_phase_distribution_0/v3_four_channel_output_collection_0/v3_four_channel_placement_0/v3_channel_selector_late_promotion_1/v3_selector_route_pilot_0/G0_MUX_NEG/a_439_47# VGND sky130_fd_pr__nfet_01v8 ad=0 pd=0 as=0.1386 ps=1.5 w=0.42 l=0.15
X525 v3_four_channel_output_load_integration_0/v3_four_channel_shared_support_integration_0/v3_four_channel_bias_reference_distribution_0/v3_four_channel_phase_distribution_0/v3_four_channel_output_collection_0/v3_four_channel_placement_0/v3_channel_selector_late_promotion_1/v3_selector_route_pilot_0/G0_MUX_NEG/a_76_199# v3_four_channel_output_load_integration_0/v3_four_channel_shared_support_integration_0/v3_four_channel_bias_reference_distribution_0/v3_four_channel_phase_distribution_0/phase_180 v3_four_channel_output_load_integration_0/v3_four_channel_shared_support_integration_0/v3_four_channel_bias_reference_distribution_0/v3_four_channel_phase_distribution_0/v3_four_channel_output_collection_0/v3_four_channel_placement_0/v3_channel_selector_late_promotion_1/v3_selector_route_pilot_0/G0_MUX_NEG/a_218_374# VDPWR sky130_fd_pr__pfet_01v8_hvt ad=0.3864 pd=2.68 as=0 ps=0 w=0.42 l=0.15
X526 v3_four_channel_output_load_integration_0/v3_four_channel_shared_support_integration_0/v3_four_channel_bias_reference_distribution_0/v3_four_channel_phase_distribution_0/v3_four_channel_output_collection_0/v3_four_channel_placement_0/v3_channel_selector_late_promotion_1/v3_selector_route_pilot_0/G0_MUX_NEG/a_505_21# v3_four_channel_output_load_integration_0/v3_four_channel_shared_support_integration_0/v3_four_channel_bias_reference_distribution_0/v3_four_channel_phase_distribution_0/v3_four_channel_output_collection_0/v3_four_channel_placement_0/v3_channel_selector_late_promotion_1/group0_bit0 VGND VGND sky130_fd_pr__nfet_01v8 ad=0.1092 pd=1.36 as=0 ps=0 w=0.42 l=0.15
X527 v3_four_channel_output_load_integration_0/v3_four_channel_shared_support_integration_0/v3_four_channel_bias_reference_distribution_0/v3_four_channel_phase_distribution_0/v3_four_channel_output_collection_0/v3_four_channel_placement_0/v3_channel_selector_late_promotion_1/v3_selector_route_pilot_0/G0_MUX_NEG/a_439_47# v3_four_channel_output_load_integration_0/v3_four_channel_shared_support_integration_0/v3_four_channel_bias_reference_distribution_0/v3_four_channel_phase_distribution_0/phase_180 v3_four_channel_output_load_integration_0/v3_four_channel_shared_support_integration_0/v3_four_channel_bias_reference_distribution_0/v3_four_channel_phase_distribution_0/v3_four_channel_output_collection_0/v3_four_channel_placement_0/v3_channel_selector_late_promotion_1/v3_selector_route_pilot_0/G0_MUX_NEG/a_76_199# VGND sky130_fd_pr__nfet_01v8 ad=0 pd=0 as=0.1995 ps=1.79 w=0.42 l=0.15
X528 v3_four_channel_output_load_integration_0/v3_four_channel_shared_support_integration_0/v3_four_channel_bias_reference_distribution_0/v3_four_channel_phase_distribution_0/v3_four_channel_output_collection_0/v3_four_channel_placement_0/v3_channel_selector_late_promotion_1/v3_selector_route_pilot_0/G0_MUX_NEG/a_535_374# v3_four_channel_output_load_integration_0/v3_four_channel_shared_support_integration_0/v3_four_channel_bias_reference_distribution_0/v3_four_channel_phase_distribution_0/phase_270 v3_four_channel_output_load_integration_0/v3_four_channel_shared_support_integration_0/v3_four_channel_bias_reference_distribution_0/v3_four_channel_phase_distribution_0/v3_four_channel_output_collection_0/v3_four_channel_placement_0/v3_channel_selector_late_promotion_1/v3_selector_route_pilot_0/G0_MUX_NEG/a_76_199# VDPWR sky130_fd_pr__pfet_01v8_hvt ad=0 pd=0 as=0 ps=0 w=0.42 l=0.15
X529 v3_four_channel_output_load_integration_0/v3_four_channel_shared_support_integration_0/v3_four_channel_bias_reference_distribution_0/v3_four_channel_phase_distribution_0/v3_four_channel_output_collection_0/v3_four_channel_placement_0/v3_channel_selector_late_promotion_1/v3_selector_route_pilot_0/G0_MUX_NEG/a_76_199# v3_four_channel_output_load_integration_0/v3_four_channel_shared_support_integration_0/v3_four_channel_bias_reference_distribution_0/v3_four_channel_phase_distribution_0/phase_270 v3_four_channel_output_load_integration_0/v3_four_channel_shared_support_integration_0/v3_four_channel_bias_reference_distribution_0/v3_four_channel_phase_distribution_0/v3_four_channel_output_collection_0/v3_four_channel_placement_0/v3_channel_selector_late_promotion_1/v3_selector_route_pilot_0/G0_MUX_NEG/a_218_47# VGND sky130_fd_pr__nfet_01v8 ad=0 pd=0 as=0.1386 ps=1.5 w=0.42 l=0.15
X530 v3_four_channel_output_load_integration_0/v3_four_channel_shared_support_integration_0/v3_four_channel_bias_reference_distribution_0/v3_four_channel_phase_distribution_0/v3_four_channel_output_collection_0/v3_four_channel_placement_0/v3_channel_selector_late_promotion_1/v3_selector_route_pilot_0/G0_MUX_NEG/a_218_47# v3_four_channel_output_load_integration_0/v3_four_channel_shared_support_integration_0/v3_four_channel_bias_reference_distribution_0/v3_four_channel_phase_distribution_0/v3_four_channel_output_collection_0/v3_four_channel_placement_0/v3_channel_selector_late_promotion_1/group0_bit0 VGND VGND sky130_fd_pr__nfet_01v8 ad=0 pd=0 as=0 ps=0 w=0.42 l=0.15
X531 VDPWR v3_four_channel_output_load_integration_0/v3_four_channel_shared_support_integration_0/v3_four_channel_bias_reference_distribution_0/v3_four_channel_phase_distribution_0/v3_four_channel_output_collection_0/v3_four_channel_placement_0/v3_channel_selector_late_promotion_1/v3_selector_route_pilot_0/G0_MUX_NEG/a_76_199# v3_four_channel_output_load_integration_0/v3_four_channel_shared_support_integration_0/v3_four_channel_bias_reference_distribution_0/v3_four_channel_phase_distribution_0/v3_four_channel_output_collection_0/v3_four_channel_placement_0/v3_channel_selector_late_promotion_1/v3_selector_route_pilot_0/G0_MUX_NEG/X VDPWR sky130_fd_pr__pfet_01v8_hvt ad=0 pd=0 as=0.26 ps=2.52 w=1 l=0.15
X532 VGND v3_four_channel_output_load_integration_0/v3_four_channel_shared_support_integration_0/v3_four_channel_bias_reference_distribution_0/v3_four_channel_phase_distribution_0/v3_four_channel_output_collection_0/v3_four_channel_placement_0/v3_channel_selector_late_promotion_1/v3_selector_route_pilot_0/G0_MUX_NEG/a_76_199# v3_four_channel_output_load_integration_0/v3_four_channel_shared_support_integration_0/v3_four_channel_bias_reference_distribution_0/v3_four_channel_phase_distribution_0/v3_four_channel_output_collection_0/v3_four_channel_placement_0/v3_channel_selector_late_promotion_1/v3_selector_route_pilot_0/G0_MUX_NEG/X VGND sky130_fd_pr__nfet_01v8 ad=0 pd=0 as=0.169 ps=1.82 w=0.65 l=0.15
X533 VDPWR v3_four_channel_output_load_integration_0/v3_four_channel_shared_support_integration_0/v3_four_channel_bias_reference_distribution_0/v3_four_channel_phase_distribution_0/v3_four_channel_output_collection_0/v3_four_channel_placement_0/v3_channel_selector_late_promotion_1/v3_selector_route_pilot_0/G2_MUX_AXIS/a_505_21# v3_four_channel_output_load_integration_0/v3_four_channel_shared_support_integration_0/v3_four_channel_bias_reference_distribution_0/v3_four_channel_phase_distribution_0/v3_four_channel_output_collection_0/v3_four_channel_placement_0/v3_channel_selector_late_promotion_1/v3_selector_route_pilot_0/G2_MUX_AXIS/a_535_374# VDPWR sky130_fd_pr__pfet_01v8_hvt ad=0 pd=0 as=0.0882 ps=1.26 w=0.42 l=0.15
X534 v3_four_channel_output_load_integration_0/v3_four_channel_shared_support_integration_0/v3_four_channel_bias_reference_distribution_0/v3_four_channel_phase_distribution_0/v3_four_channel_output_collection_0/v3_four_channel_placement_0/v3_channel_selector_late_promotion_1/v3_selector_route_pilot_0/G2_MUX_AXIS/a_505_21# v3_four_channel_output_load_integration_0/v3_four_channel_shared_support_integration_0/v3_four_channel_bias_reference_distribution_0/v3_four_channel_phase_distribution_0/v3_four_channel_output_collection_0/v3_four_channel_placement_0/v3_channel_selector_late_promotion_1/group2_bit1 VDPWR VDPWR sky130_fd_pr__pfet_01v8_hvt ad=0.1176 pd=1.4 as=0 ps=0 w=0.42 l=0.15
X535 v3_four_channel_output_load_integration_0/v3_four_channel_shared_support_integration_0/v3_four_channel_bias_reference_distribution_0/v3_four_channel_phase_distribution_0/v3_four_channel_output_collection_0/v3_four_channel_placement_0/v3_channel_selector_late_promotion_1/v3_selector_route_pilot_0/G2_MUX_AXIS/a_218_374# v3_four_channel_output_load_integration_0/v3_four_channel_shared_support_integration_0/v3_four_channel_bias_reference_distribution_0/v3_four_channel_phase_distribution_0/v3_four_channel_output_collection_0/v3_four_channel_placement_0/v3_channel_selector_late_promotion_1/group2_bit1 VDPWR VDPWR sky130_fd_pr__pfet_01v8_hvt ad=0.1533 pd=1.57 as=0 ps=0 w=0.42 l=0.15
X536 VGND v3_four_channel_output_load_integration_0/v3_four_channel_shared_support_integration_0/v3_four_channel_bias_reference_distribution_0/v3_four_channel_phase_distribution_0/v3_four_channel_output_collection_0/v3_four_channel_placement_0/v3_channel_selector_late_promotion_1/v3_selector_route_pilot_0/G2_MUX_AXIS/a_505_21# v3_four_channel_output_load_integration_0/v3_four_channel_shared_support_integration_0/v3_four_channel_bias_reference_distribution_0/v3_four_channel_phase_distribution_0/v3_four_channel_output_collection_0/v3_four_channel_placement_0/v3_channel_selector_late_promotion_1/v3_selector_route_pilot_0/G2_MUX_AXIS/a_439_47# VGND sky130_fd_pr__nfet_01v8 ad=0 pd=0 as=0.1386 ps=1.5 w=0.42 l=0.15
X537 v3_four_channel_output_load_integration_0/v3_four_channel_shared_support_integration_0/v3_four_channel_bias_reference_distribution_0/v3_four_channel_phase_distribution_0/v3_four_channel_output_collection_0/v3_four_channel_placement_0/v3_channel_selector_late_promotion_1/v3_selector_route_pilot_0/G2_MUX_AXIS/a_76_199# v3_four_channel_output_load_integration_0/v3_four_channel_shared_support_integration_0/v3_four_channel_bias_reference_distribution_0/v3_four_channel_phase_distribution_0/v3_four_channel_output_collection_0/v3_four_channel_placement_0/v3_channel_selector_late_promotion_1/v3_selector_route_pilot_0/G2_MUX_POS/X v3_four_channel_output_load_integration_0/v3_four_channel_shared_support_integration_0/v3_four_channel_bias_reference_distribution_0/v3_four_channel_phase_distribution_0/v3_four_channel_output_collection_0/v3_four_channel_placement_0/v3_channel_selector_late_promotion_1/v3_selector_route_pilot_0/G2_MUX_AXIS/a_218_374# VDPWR sky130_fd_pr__pfet_01v8_hvt ad=0.3864 pd=2.68 as=0 ps=0 w=0.42 l=0.15
X538 v3_four_channel_output_load_integration_0/v3_four_channel_shared_support_integration_0/v3_four_channel_bias_reference_distribution_0/v3_four_channel_phase_distribution_0/v3_four_channel_output_collection_0/v3_four_channel_placement_0/v3_channel_selector_late_promotion_1/v3_selector_route_pilot_0/G2_MUX_AXIS/a_505_21# v3_four_channel_output_load_integration_0/v3_four_channel_shared_support_integration_0/v3_four_channel_bias_reference_distribution_0/v3_four_channel_phase_distribution_0/v3_four_channel_output_collection_0/v3_four_channel_placement_0/v3_channel_selector_late_promotion_1/group2_bit1 VGND VGND sky130_fd_pr__nfet_01v8 ad=0.1092 pd=1.36 as=0 ps=0 w=0.42 l=0.15
X539 v3_four_channel_output_load_integration_0/v3_four_channel_shared_support_integration_0/v3_four_channel_bias_reference_distribution_0/v3_four_channel_phase_distribution_0/v3_four_channel_output_collection_0/v3_four_channel_placement_0/v3_channel_selector_late_promotion_1/v3_selector_route_pilot_0/G2_MUX_AXIS/a_439_47# v3_four_channel_output_load_integration_0/v3_four_channel_shared_support_integration_0/v3_four_channel_bias_reference_distribution_0/v3_four_channel_phase_distribution_0/v3_four_channel_output_collection_0/v3_four_channel_placement_0/v3_channel_selector_late_promotion_1/v3_selector_route_pilot_0/G2_MUX_POS/X v3_four_channel_output_load_integration_0/v3_four_channel_shared_support_integration_0/v3_four_channel_bias_reference_distribution_0/v3_four_channel_phase_distribution_0/v3_four_channel_output_collection_0/v3_four_channel_placement_0/v3_channel_selector_late_promotion_1/v3_selector_route_pilot_0/G2_MUX_AXIS/a_76_199# VGND sky130_fd_pr__nfet_01v8 ad=0 pd=0 as=0.1995 ps=1.79 w=0.42 l=0.15
X540 v3_four_channel_output_load_integration_0/v3_four_channel_shared_support_integration_0/v3_four_channel_bias_reference_distribution_0/v3_four_channel_phase_distribution_0/v3_four_channel_output_collection_0/v3_four_channel_placement_0/v3_channel_selector_late_promotion_1/v3_selector_route_pilot_0/G2_MUX_AXIS/a_535_374# v3_four_channel_output_load_integration_0/v3_four_channel_shared_support_integration_0/v3_four_channel_bias_reference_distribution_0/v3_four_channel_phase_distribution_0/v3_four_channel_output_collection_0/v3_four_channel_placement_0/v3_channel_selector_late_promotion_1/v3_selector_route_pilot_0/G2_MUX_NEG/X v3_four_channel_output_load_integration_0/v3_four_channel_shared_support_integration_0/v3_four_channel_bias_reference_distribution_0/v3_four_channel_phase_distribution_0/v3_four_channel_output_collection_0/v3_four_channel_placement_0/v3_channel_selector_late_promotion_1/v3_selector_route_pilot_0/G2_MUX_AXIS/a_76_199# VDPWR sky130_fd_pr__pfet_01v8_hvt ad=0 pd=0 as=0 ps=0 w=0.42 l=0.15
X541 v3_four_channel_output_load_integration_0/v3_four_channel_shared_support_integration_0/v3_four_channel_bias_reference_distribution_0/v3_four_channel_phase_distribution_0/v3_four_channel_output_collection_0/v3_four_channel_placement_0/v3_channel_selector_late_promotion_1/v3_selector_route_pilot_0/G2_MUX_AXIS/a_76_199# v3_four_channel_output_load_integration_0/v3_four_channel_shared_support_integration_0/v3_four_channel_bias_reference_distribution_0/v3_four_channel_phase_distribution_0/v3_four_channel_output_collection_0/v3_four_channel_placement_0/v3_channel_selector_late_promotion_1/v3_selector_route_pilot_0/G2_MUX_NEG/X v3_four_channel_output_load_integration_0/v3_four_channel_shared_support_integration_0/v3_four_channel_bias_reference_distribution_0/v3_four_channel_phase_distribution_0/v3_four_channel_output_collection_0/v3_four_channel_placement_0/v3_channel_selector_late_promotion_1/v3_selector_route_pilot_0/G2_MUX_AXIS/a_218_47# VGND sky130_fd_pr__nfet_01v8 ad=0 pd=0 as=0.1386 ps=1.5 w=0.42 l=0.15
X542 v3_four_channel_output_load_integration_0/v3_four_channel_shared_support_integration_0/v3_four_channel_bias_reference_distribution_0/v3_four_channel_phase_distribution_0/v3_four_channel_output_collection_0/v3_four_channel_placement_0/v3_channel_selector_late_promotion_1/v3_selector_route_pilot_0/G2_MUX_AXIS/a_218_47# v3_four_channel_output_load_integration_0/v3_four_channel_shared_support_integration_0/v3_four_channel_bias_reference_distribution_0/v3_four_channel_phase_distribution_0/v3_four_channel_output_collection_0/v3_four_channel_placement_0/v3_channel_selector_late_promotion_1/group2_bit1 VGND VGND sky130_fd_pr__nfet_01v8 ad=0 pd=0 as=0 ps=0 w=0.42 l=0.15
X543 VDPWR v3_four_channel_output_load_integration_0/v3_four_channel_shared_support_integration_0/v3_four_channel_bias_reference_distribution_0/v3_four_channel_phase_distribution_0/v3_four_channel_output_collection_0/v3_four_channel_placement_0/v3_channel_selector_late_promotion_1/v3_selector_route_pilot_0/G2_MUX_AXIS/a_76_199# v3_four_channel_output_load_integration_0/v3_four_channel_shared_support_integration_0/v3_four_channel_bias_reference_distribution_0/v3_four_channel_phase_distribution_0/v3_four_channel_output_collection_0/v3_four_channel_placement_0/v3_channel_selector_late_promotion_1/v3_selector_route_pilot_0/G2_MUX_AXIS/X VDPWR sky130_fd_pr__pfet_01v8_hvt ad=0 pd=0 as=0.26 ps=2.52 w=1 l=0.15
X544 VGND v3_four_channel_output_load_integration_0/v3_four_channel_shared_support_integration_0/v3_four_channel_bias_reference_distribution_0/v3_four_channel_phase_distribution_0/v3_four_channel_output_collection_0/v3_four_channel_placement_0/v3_channel_selector_late_promotion_1/v3_selector_route_pilot_0/G2_MUX_AXIS/a_76_199# v3_four_channel_output_load_integration_0/v3_four_channel_shared_support_integration_0/v3_four_channel_bias_reference_distribution_0/v3_four_channel_phase_distribution_0/v3_four_channel_output_collection_0/v3_four_channel_placement_0/v3_channel_selector_late_promotion_1/v3_selector_route_pilot_0/G2_MUX_AXIS/X VGND sky130_fd_pr__nfet_01v8 ad=0 pd=0 as=0.169 ps=1.82 w=0.65 l=0.15
X545 VDPWR v3_four_channel_output_load_integration_0/v3_four_channel_shared_support_integration_0/v3_four_channel_bias_reference_distribution_0/v3_four_channel_phase_distribution_0/v3_four_channel_output_collection_0/v3_four_channel_placement_0/v3_channel_selector_late_promotion_1/v3_selector_route_pilot_0/G3_MUX_POS/a_505_21# v3_four_channel_output_load_integration_0/v3_four_channel_shared_support_integration_0/v3_four_channel_bias_reference_distribution_0/v3_four_channel_phase_distribution_0/v3_four_channel_output_collection_0/v3_four_channel_placement_0/v3_channel_selector_late_promotion_1/v3_selector_route_pilot_0/G3_MUX_POS/a_535_374# VDPWR sky130_fd_pr__pfet_01v8_hvt ad=0 pd=0 as=0.0882 ps=1.26 w=0.42 l=0.15
X546 v3_four_channel_output_load_integration_0/v3_four_channel_shared_support_integration_0/v3_four_channel_bias_reference_distribution_0/v3_four_channel_phase_distribution_0/v3_four_channel_output_collection_0/v3_four_channel_placement_0/v3_channel_selector_late_promotion_1/v3_selector_route_pilot_0/G3_MUX_POS/a_505_21# v3_four_channel_output_load_integration_0/v3_four_channel_shared_support_integration_0/v3_four_channel_bias_reference_distribution_0/v3_four_channel_phase_distribution_0/v3_four_channel_output_collection_0/v3_four_channel_placement_0/v3_channel_selector_late_promotion_1/group3_bit0 VDPWR VDPWR sky130_fd_pr__pfet_01v8_hvt ad=0.1176 pd=1.4 as=0 ps=0 w=0.42 l=0.15
X547 v3_four_channel_output_load_integration_0/v3_four_channel_shared_support_integration_0/v3_four_channel_bias_reference_distribution_0/v3_four_channel_phase_distribution_0/v3_four_channel_output_collection_0/v3_four_channel_placement_0/v3_channel_selector_late_promotion_1/v3_selector_route_pilot_0/G3_MUX_POS/a_218_374# v3_four_channel_output_load_integration_0/v3_four_channel_shared_support_integration_0/v3_four_channel_bias_reference_distribution_0/v3_four_channel_phase_distribution_0/v3_four_channel_output_collection_0/v3_four_channel_placement_0/v3_channel_selector_late_promotion_1/group3_bit0 VDPWR VDPWR sky130_fd_pr__pfet_01v8_hvt ad=0.1533 pd=1.57 as=0 ps=0 w=0.42 l=0.15
X548 VGND v3_four_channel_output_load_integration_0/v3_four_channel_shared_support_integration_0/v3_four_channel_bias_reference_distribution_0/v3_four_channel_phase_distribution_0/v3_four_channel_output_collection_0/v3_four_channel_placement_0/v3_channel_selector_late_promotion_1/v3_selector_route_pilot_0/G3_MUX_POS/a_505_21# v3_four_channel_output_load_integration_0/v3_four_channel_shared_support_integration_0/v3_four_channel_bias_reference_distribution_0/v3_four_channel_phase_distribution_0/v3_four_channel_output_collection_0/v3_four_channel_placement_0/v3_channel_selector_late_promotion_1/v3_selector_route_pilot_0/G3_MUX_POS/a_439_47# VGND sky130_fd_pr__nfet_01v8 ad=0 pd=0 as=0.1386 ps=1.5 w=0.42 l=0.15
X549 v3_four_channel_output_load_integration_0/v3_four_channel_shared_support_integration_0/v3_four_channel_bias_reference_distribution_0/v3_four_channel_phase_distribution_0/v3_four_channel_output_collection_0/v3_four_channel_placement_0/v3_channel_selector_late_promotion_1/v3_selector_route_pilot_0/G3_MUX_POS/a_76_199# v3_four_channel_output_load_integration_0/v3_four_channel_shared_support_integration_0/v3_four_channel_bias_reference_distribution_0/v3_four_channel_phase_distribution_0/phase_0 v3_four_channel_output_load_integration_0/v3_four_channel_shared_support_integration_0/v3_four_channel_bias_reference_distribution_0/v3_four_channel_phase_distribution_0/v3_four_channel_output_collection_0/v3_four_channel_placement_0/v3_channel_selector_late_promotion_1/v3_selector_route_pilot_0/G3_MUX_POS/a_218_374# VDPWR sky130_fd_pr__pfet_01v8_hvt ad=0.3864 pd=2.68 as=0 ps=0 w=0.42 l=0.15
X550 v3_four_channel_output_load_integration_0/v3_four_channel_shared_support_integration_0/v3_four_channel_bias_reference_distribution_0/v3_four_channel_phase_distribution_0/v3_four_channel_output_collection_0/v3_four_channel_placement_0/v3_channel_selector_late_promotion_1/v3_selector_route_pilot_0/G3_MUX_POS/a_505_21# v3_four_channel_output_load_integration_0/v3_four_channel_shared_support_integration_0/v3_four_channel_bias_reference_distribution_0/v3_four_channel_phase_distribution_0/v3_four_channel_output_collection_0/v3_four_channel_placement_0/v3_channel_selector_late_promotion_1/group3_bit0 VGND VGND sky130_fd_pr__nfet_01v8 ad=0.1092 pd=1.36 as=0 ps=0 w=0.42 l=0.15
X551 v3_four_channel_output_load_integration_0/v3_four_channel_shared_support_integration_0/v3_four_channel_bias_reference_distribution_0/v3_four_channel_phase_distribution_0/v3_four_channel_output_collection_0/v3_four_channel_placement_0/v3_channel_selector_late_promotion_1/v3_selector_route_pilot_0/G3_MUX_POS/a_439_47# v3_four_channel_output_load_integration_0/v3_four_channel_shared_support_integration_0/v3_four_channel_bias_reference_distribution_0/v3_four_channel_phase_distribution_0/phase_0 v3_four_channel_output_load_integration_0/v3_four_channel_shared_support_integration_0/v3_four_channel_bias_reference_distribution_0/v3_four_channel_phase_distribution_0/v3_four_channel_output_collection_0/v3_four_channel_placement_0/v3_channel_selector_late_promotion_1/v3_selector_route_pilot_0/G3_MUX_POS/a_76_199# VGND sky130_fd_pr__nfet_01v8 ad=0 pd=0 as=0.1995 ps=1.79 w=0.42 l=0.15
X552 v3_four_channel_output_load_integration_0/v3_four_channel_shared_support_integration_0/v3_four_channel_bias_reference_distribution_0/v3_four_channel_phase_distribution_0/v3_four_channel_output_collection_0/v3_four_channel_placement_0/v3_channel_selector_late_promotion_1/v3_selector_route_pilot_0/G3_MUX_POS/a_535_374# v3_four_channel_output_load_integration_0/v3_four_channel_shared_support_integration_0/v3_four_channel_bias_reference_distribution_0/v3_four_channel_phase_distribution_0/phase_90 v3_four_channel_output_load_integration_0/v3_four_channel_shared_support_integration_0/v3_four_channel_bias_reference_distribution_0/v3_four_channel_phase_distribution_0/v3_four_channel_output_collection_0/v3_four_channel_placement_0/v3_channel_selector_late_promotion_1/v3_selector_route_pilot_0/G3_MUX_POS/a_76_199# VDPWR sky130_fd_pr__pfet_01v8_hvt ad=0 pd=0 as=0 ps=0 w=0.42 l=0.15
X553 v3_four_channel_output_load_integration_0/v3_four_channel_shared_support_integration_0/v3_four_channel_bias_reference_distribution_0/v3_four_channel_phase_distribution_0/v3_four_channel_output_collection_0/v3_four_channel_placement_0/v3_channel_selector_late_promotion_1/v3_selector_route_pilot_0/G3_MUX_POS/a_76_199# v3_four_channel_output_load_integration_0/v3_four_channel_shared_support_integration_0/v3_four_channel_bias_reference_distribution_0/v3_four_channel_phase_distribution_0/phase_90 v3_four_channel_output_load_integration_0/v3_four_channel_shared_support_integration_0/v3_four_channel_bias_reference_distribution_0/v3_four_channel_phase_distribution_0/v3_four_channel_output_collection_0/v3_four_channel_placement_0/v3_channel_selector_late_promotion_1/v3_selector_route_pilot_0/G3_MUX_POS/a_218_47# VGND sky130_fd_pr__nfet_01v8 ad=0 pd=0 as=0.1386 ps=1.5 w=0.42 l=0.15
X554 v3_four_channel_output_load_integration_0/v3_four_channel_shared_support_integration_0/v3_four_channel_bias_reference_distribution_0/v3_four_channel_phase_distribution_0/v3_four_channel_output_collection_0/v3_four_channel_placement_0/v3_channel_selector_late_promotion_1/v3_selector_route_pilot_0/G3_MUX_POS/a_218_47# v3_four_channel_output_load_integration_0/v3_four_channel_shared_support_integration_0/v3_four_channel_bias_reference_distribution_0/v3_four_channel_phase_distribution_0/v3_four_channel_output_collection_0/v3_four_channel_placement_0/v3_channel_selector_late_promotion_1/group3_bit0 VGND VGND sky130_fd_pr__nfet_01v8 ad=0 pd=0 as=0 ps=0 w=0.42 l=0.15
X555 VDPWR v3_four_channel_output_load_integration_0/v3_four_channel_shared_support_integration_0/v3_four_channel_bias_reference_distribution_0/v3_four_channel_phase_distribution_0/v3_four_channel_output_collection_0/v3_four_channel_placement_0/v3_channel_selector_late_promotion_1/v3_selector_route_pilot_0/G3_MUX_POS/a_76_199# v3_four_channel_output_load_integration_0/v3_four_channel_shared_support_integration_0/v3_four_channel_bias_reference_distribution_0/v3_four_channel_phase_distribution_0/v3_four_channel_output_collection_0/v3_four_channel_placement_0/v3_channel_selector_late_promotion_1/v3_selector_route_pilot_0/G3_MUX_POS/X VDPWR sky130_fd_pr__pfet_01v8_hvt ad=0 pd=0 as=0.26 ps=2.52 w=1 l=0.15
X556 VGND v3_four_channel_output_load_integration_0/v3_four_channel_shared_support_integration_0/v3_four_channel_bias_reference_distribution_0/v3_four_channel_phase_distribution_0/v3_four_channel_output_collection_0/v3_four_channel_placement_0/v3_channel_selector_late_promotion_1/v3_selector_route_pilot_0/G3_MUX_POS/a_76_199# v3_four_channel_output_load_integration_0/v3_four_channel_shared_support_integration_0/v3_four_channel_bias_reference_distribution_0/v3_four_channel_phase_distribution_0/v3_four_channel_output_collection_0/v3_four_channel_placement_0/v3_channel_selector_late_promotion_1/v3_selector_route_pilot_0/G3_MUX_POS/X VGND sky130_fd_pr__nfet_01v8 ad=0 pd=0 as=0.169 ps=1.82 w=0.65 l=0.15
X557 VDPWR v3_four_channel_output_load_integration_0/v3_four_channel_shared_support_integration_0/v3_four_channel_bias_reference_distribution_0/v3_four_channel_phase_distribution_0/v3_four_channel_output_collection_0/v3_four_channel_placement_0/v3_channel_selector_late_promotion_1/v3_selector_route_pilot_0/G3_MUX_NEG/a_505_21# v3_four_channel_output_load_integration_0/v3_four_channel_shared_support_integration_0/v3_four_channel_bias_reference_distribution_0/v3_four_channel_phase_distribution_0/v3_four_channel_output_collection_0/v3_four_channel_placement_0/v3_channel_selector_late_promotion_1/v3_selector_route_pilot_0/G3_MUX_NEG/a_535_374# VDPWR sky130_fd_pr__pfet_01v8_hvt ad=0 pd=0 as=0.0882 ps=1.26 w=0.42 l=0.15
X558 v3_four_channel_output_load_integration_0/v3_four_channel_shared_support_integration_0/v3_four_channel_bias_reference_distribution_0/v3_four_channel_phase_distribution_0/v3_four_channel_output_collection_0/v3_four_channel_placement_0/v3_channel_selector_late_promotion_1/v3_selector_route_pilot_0/G3_MUX_NEG/a_505_21# v3_four_channel_output_load_integration_0/v3_four_channel_shared_support_integration_0/v3_four_channel_bias_reference_distribution_0/v3_four_channel_phase_distribution_0/v3_four_channel_output_collection_0/v3_four_channel_placement_0/v3_channel_selector_late_promotion_1/group3_bit0 VDPWR VDPWR sky130_fd_pr__pfet_01v8_hvt ad=0.1176 pd=1.4 as=0 ps=0 w=0.42 l=0.15
X559 v3_four_channel_output_load_integration_0/v3_four_channel_shared_support_integration_0/v3_four_channel_bias_reference_distribution_0/v3_four_channel_phase_distribution_0/v3_four_channel_output_collection_0/v3_four_channel_placement_0/v3_channel_selector_late_promotion_1/v3_selector_route_pilot_0/G3_MUX_NEG/a_218_374# v3_four_channel_output_load_integration_0/v3_four_channel_shared_support_integration_0/v3_four_channel_bias_reference_distribution_0/v3_four_channel_phase_distribution_0/v3_four_channel_output_collection_0/v3_four_channel_placement_0/v3_channel_selector_late_promotion_1/group3_bit0 VDPWR VDPWR sky130_fd_pr__pfet_01v8_hvt ad=0.1533 pd=1.57 as=0 ps=0 w=0.42 l=0.15
X560 VGND v3_four_channel_output_load_integration_0/v3_four_channel_shared_support_integration_0/v3_four_channel_bias_reference_distribution_0/v3_four_channel_phase_distribution_0/v3_four_channel_output_collection_0/v3_four_channel_placement_0/v3_channel_selector_late_promotion_1/v3_selector_route_pilot_0/G3_MUX_NEG/a_505_21# v3_four_channel_output_load_integration_0/v3_four_channel_shared_support_integration_0/v3_four_channel_bias_reference_distribution_0/v3_four_channel_phase_distribution_0/v3_four_channel_output_collection_0/v3_four_channel_placement_0/v3_channel_selector_late_promotion_1/v3_selector_route_pilot_0/G3_MUX_NEG/a_439_47# VGND sky130_fd_pr__nfet_01v8 ad=0 pd=0 as=0.1386 ps=1.5 w=0.42 l=0.15
X561 v3_four_channel_output_load_integration_0/v3_four_channel_shared_support_integration_0/v3_four_channel_bias_reference_distribution_0/v3_four_channel_phase_distribution_0/v3_four_channel_output_collection_0/v3_four_channel_placement_0/v3_channel_selector_late_promotion_1/v3_selector_route_pilot_0/G3_MUX_NEG/a_76_199# v3_four_channel_output_load_integration_0/v3_four_channel_shared_support_integration_0/v3_four_channel_bias_reference_distribution_0/v3_four_channel_phase_distribution_0/phase_180 v3_four_channel_output_load_integration_0/v3_four_channel_shared_support_integration_0/v3_four_channel_bias_reference_distribution_0/v3_four_channel_phase_distribution_0/v3_four_channel_output_collection_0/v3_four_channel_placement_0/v3_channel_selector_late_promotion_1/v3_selector_route_pilot_0/G3_MUX_NEG/a_218_374# VDPWR sky130_fd_pr__pfet_01v8_hvt ad=0.3864 pd=2.68 as=0 ps=0 w=0.42 l=0.15
X562 v3_four_channel_output_load_integration_0/v3_four_channel_shared_support_integration_0/v3_four_channel_bias_reference_distribution_0/v3_four_channel_phase_distribution_0/v3_four_channel_output_collection_0/v3_four_channel_placement_0/v3_channel_selector_late_promotion_1/v3_selector_route_pilot_0/G3_MUX_NEG/a_505_21# v3_four_channel_output_load_integration_0/v3_four_channel_shared_support_integration_0/v3_four_channel_bias_reference_distribution_0/v3_four_channel_phase_distribution_0/v3_four_channel_output_collection_0/v3_four_channel_placement_0/v3_channel_selector_late_promotion_1/group3_bit0 VGND VGND sky130_fd_pr__nfet_01v8 ad=0.1092 pd=1.36 as=0 ps=0 w=0.42 l=0.15
X563 v3_four_channel_output_load_integration_0/v3_four_channel_shared_support_integration_0/v3_four_channel_bias_reference_distribution_0/v3_four_channel_phase_distribution_0/v3_four_channel_output_collection_0/v3_four_channel_placement_0/v3_channel_selector_late_promotion_1/v3_selector_route_pilot_0/G3_MUX_NEG/a_439_47# v3_four_channel_output_load_integration_0/v3_four_channel_shared_support_integration_0/v3_four_channel_bias_reference_distribution_0/v3_four_channel_phase_distribution_0/phase_180 v3_four_channel_output_load_integration_0/v3_four_channel_shared_support_integration_0/v3_four_channel_bias_reference_distribution_0/v3_four_channel_phase_distribution_0/v3_four_channel_output_collection_0/v3_four_channel_placement_0/v3_channel_selector_late_promotion_1/v3_selector_route_pilot_0/G3_MUX_NEG/a_76_199# VGND sky130_fd_pr__nfet_01v8 ad=0 pd=0 as=0.1995 ps=1.79 w=0.42 l=0.15
X564 v3_four_channel_output_load_integration_0/v3_four_channel_shared_support_integration_0/v3_four_channel_bias_reference_distribution_0/v3_four_channel_phase_distribution_0/v3_four_channel_output_collection_0/v3_four_channel_placement_0/v3_channel_selector_late_promotion_1/v3_selector_route_pilot_0/G3_MUX_NEG/a_535_374# v3_four_channel_output_load_integration_0/v3_four_channel_shared_support_integration_0/v3_four_channel_bias_reference_distribution_0/v3_four_channel_phase_distribution_0/phase_270 v3_four_channel_output_load_integration_0/v3_four_channel_shared_support_integration_0/v3_four_channel_bias_reference_distribution_0/v3_four_channel_phase_distribution_0/v3_four_channel_output_collection_0/v3_four_channel_placement_0/v3_channel_selector_late_promotion_1/v3_selector_route_pilot_0/G3_MUX_NEG/a_76_199# VDPWR sky130_fd_pr__pfet_01v8_hvt ad=0 pd=0 as=0 ps=0 w=0.42 l=0.15
X565 v3_four_channel_output_load_integration_0/v3_four_channel_shared_support_integration_0/v3_four_channel_bias_reference_distribution_0/v3_four_channel_phase_distribution_0/v3_four_channel_output_collection_0/v3_four_channel_placement_0/v3_channel_selector_late_promotion_1/v3_selector_route_pilot_0/G3_MUX_NEG/a_76_199# v3_four_channel_output_load_integration_0/v3_four_channel_shared_support_integration_0/v3_four_channel_bias_reference_distribution_0/v3_four_channel_phase_distribution_0/phase_270 v3_four_channel_output_load_integration_0/v3_four_channel_shared_support_integration_0/v3_four_channel_bias_reference_distribution_0/v3_four_channel_phase_distribution_0/v3_four_channel_output_collection_0/v3_four_channel_placement_0/v3_channel_selector_late_promotion_1/v3_selector_route_pilot_0/G3_MUX_NEG/a_218_47# VGND sky130_fd_pr__nfet_01v8 ad=0 pd=0 as=0.1386 ps=1.5 w=0.42 l=0.15
X566 v3_four_channel_output_load_integration_0/v3_four_channel_shared_support_integration_0/v3_four_channel_bias_reference_distribution_0/v3_four_channel_phase_distribution_0/v3_four_channel_output_collection_0/v3_four_channel_placement_0/v3_channel_selector_late_promotion_1/v3_selector_route_pilot_0/G3_MUX_NEG/a_218_47# v3_four_channel_output_load_integration_0/v3_four_channel_shared_support_integration_0/v3_four_channel_bias_reference_distribution_0/v3_four_channel_phase_distribution_0/v3_four_channel_output_collection_0/v3_four_channel_placement_0/v3_channel_selector_late_promotion_1/group3_bit0 VGND VGND sky130_fd_pr__nfet_01v8 ad=0 pd=0 as=0 ps=0 w=0.42 l=0.15
X567 VDPWR v3_four_channel_output_load_integration_0/v3_four_channel_shared_support_integration_0/v3_four_channel_bias_reference_distribution_0/v3_four_channel_phase_distribution_0/v3_four_channel_output_collection_0/v3_four_channel_placement_0/v3_channel_selector_late_promotion_1/v3_selector_route_pilot_0/G3_MUX_NEG/a_76_199# v3_four_channel_output_load_integration_0/v3_four_channel_shared_support_integration_0/v3_four_channel_bias_reference_distribution_0/v3_four_channel_phase_distribution_0/v3_four_channel_output_collection_0/v3_four_channel_placement_0/v3_channel_selector_late_promotion_1/v3_selector_route_pilot_0/G3_MUX_NEG/X VDPWR sky130_fd_pr__pfet_01v8_hvt ad=0 pd=0 as=0.26 ps=2.52 w=1 l=0.15
X568 VGND v3_four_channel_output_load_integration_0/v3_four_channel_shared_support_integration_0/v3_four_channel_bias_reference_distribution_0/v3_four_channel_phase_distribution_0/v3_four_channel_output_collection_0/v3_four_channel_placement_0/v3_channel_selector_late_promotion_1/v3_selector_route_pilot_0/G3_MUX_NEG/a_76_199# v3_four_channel_output_load_integration_0/v3_four_channel_shared_support_integration_0/v3_four_channel_bias_reference_distribution_0/v3_four_channel_phase_distribution_0/v3_four_channel_output_collection_0/v3_four_channel_placement_0/v3_channel_selector_late_promotion_1/v3_selector_route_pilot_0/G3_MUX_NEG/X VGND sky130_fd_pr__nfet_01v8 ad=0 pd=0 as=0.169 ps=1.82 w=0.65 l=0.15
X569 VDPWR v3_four_channel_output_load_integration_0/v3_four_channel_shared_support_integration_0/v3_four_channel_bias_reference_distribution_0/v3_four_channel_phase_distribution_0/v3_four_channel_output_collection_0/v3_four_channel_placement_0/v3_channel_selector_late_promotion_1/v3_selector_route_pilot_0/G3_LO_P_AND/B v3_four_channel_output_load_integration_0/v3_four_channel_shared_support_integration_0/v3_four_channel_bias_reference_distribution_0/v3_four_channel_phase_distribution_0/v3_four_channel_output_collection_0/v3_four_channel_placement_0/v3_channel_selector_late_promotion_1/v3_selector_route_pilot_0/G0_LO_P_AND/a_59_75# VDPWR sky130_fd_pr__pfet_01v8_hvt ad=0 pd=0 as=0.1134 ps=1.38 w=0.42 l=0.15
X570 v3_four_channel_output_load_integration_0/v3_four_channel_shared_support_integration_0/v3_four_channel_bias_reference_distribution_0/v3_four_channel_phase_distribution_0/v3_four_channel_output_collection_0/v3_four_channel_placement_0/v3_channel_selector_late_promotion_1/v3_selector_route_pilot_0/group0_lo_p v3_four_channel_output_load_integration_0/v3_four_channel_shared_support_integration_0/v3_four_channel_bias_reference_distribution_0/v3_four_channel_phase_distribution_0/v3_four_channel_output_collection_0/v3_four_channel_placement_0/v3_channel_selector_late_promotion_1/v3_selector_route_pilot_0/G0_LO_P_AND/a_59_75# VDPWR VDPWR sky130_fd_pr__pfet_01v8_hvt ad=0.475 pd=2.95 as=0 ps=0 w=1 l=0.15
X571 VGND v3_four_channel_output_load_integration_0/v3_four_channel_shared_support_integration_0/v3_four_channel_bias_reference_distribution_0/v3_four_channel_phase_distribution_0/v3_four_channel_output_collection_0/v3_four_channel_placement_0/v3_channel_selector_late_promotion_1/v3_selector_route_pilot_0/G3_LO_P_AND/B v3_four_channel_output_load_integration_0/v3_four_channel_shared_support_integration_0/v3_four_channel_bias_reference_distribution_0/v3_four_channel_phase_distribution_0/v3_four_channel_output_collection_0/v3_four_channel_placement_0/v3_channel_selector_late_promotion_1/v3_selector_route_pilot_0/G0_LO_P_AND/a_145_75# VGND sky130_fd_pr__nfet_01v8 ad=0 pd=0 as=0.1134 ps=1.38 w=0.42 l=0.15
X572 v3_four_channel_output_load_integration_0/v3_four_channel_shared_support_integration_0/v3_four_channel_bias_reference_distribution_0/v3_four_channel_phase_distribution_0/v3_four_channel_output_collection_0/v3_four_channel_placement_0/v3_channel_selector_late_promotion_1/v3_selector_route_pilot_0/G0_LO_P_AND/a_59_75# v3_four_channel_output_load_integration_0/v3_four_channel_shared_support_integration_0/v3_four_channel_bias_reference_distribution_0/v3_four_channel_phase_distribution_0/v3_four_channel_output_collection_0/v3_four_channel_placement_0/v3_channel_selector_late_promotion_1/v3_selector_route_pilot_0/G0_MUX_AXIS/X VDPWR VDPWR sky130_fd_pr__pfet_01v8_hvt ad=0 pd=0 as=0 ps=0 w=0.42 l=0.15
X573 v3_four_channel_output_load_integration_0/v3_four_channel_shared_support_integration_0/v3_four_channel_bias_reference_distribution_0/v3_four_channel_phase_distribution_0/v3_four_channel_output_collection_0/v3_four_channel_placement_0/v3_channel_selector_late_promotion_1/v3_selector_route_pilot_0/group0_lo_p v3_four_channel_output_load_integration_0/v3_four_channel_shared_support_integration_0/v3_four_channel_bias_reference_distribution_0/v3_four_channel_phase_distribution_0/v3_four_channel_output_collection_0/v3_four_channel_placement_0/v3_channel_selector_late_promotion_1/v3_selector_route_pilot_0/G0_LO_P_AND/a_59_75# VGND VGND sky130_fd_pr__nfet_01v8 ad=0.182 pd=1.86 as=0 ps=0 w=0.65 l=0.15
X574 v3_four_channel_output_load_integration_0/v3_four_channel_shared_support_integration_0/v3_four_channel_bias_reference_distribution_0/v3_four_channel_phase_distribution_0/v3_four_channel_output_collection_0/v3_four_channel_placement_0/v3_channel_selector_late_promotion_1/v3_selector_route_pilot_0/G0_LO_P_AND/a_145_75# v3_four_channel_output_load_integration_0/v3_four_channel_shared_support_integration_0/v3_four_channel_bias_reference_distribution_0/v3_four_channel_phase_distribution_0/v3_four_channel_output_collection_0/v3_four_channel_placement_0/v3_channel_selector_late_promotion_1/v3_selector_route_pilot_0/G0_MUX_AXIS/X v3_four_channel_output_load_integration_0/v3_four_channel_shared_support_integration_0/v3_four_channel_bias_reference_distribution_0/v3_four_channel_phase_distribution_0/v3_four_channel_output_collection_0/v3_four_channel_placement_0/v3_channel_selector_late_promotion_1/v3_selector_route_pilot_0/G0_LO_P_AND/a_59_75# VGND sky130_fd_pr__nfet_01v8 ad=0 pd=0 as=0.1176 ps=1.4 w=0.42 l=0.15
X575 VDPWR v3_four_channel_output_load_integration_0/v3_four_channel_shared_support_integration_0/v3_four_channel_bias_reference_distribution_0/v3_four_channel_phase_distribution_0/v3_four_channel_output_collection_0/v3_four_channel_placement_0/v3_channel_selector_late_promotion_1/v3_selector_route_pilot_0/G3_LO_P_AND/B v3_four_channel_output_load_integration_0/v3_four_channel_shared_support_integration_0/v3_four_channel_bias_reference_distribution_0/v3_four_channel_phase_distribution_0/v3_four_channel_output_collection_0/v3_four_channel_placement_0/v3_channel_selector_late_promotion_1/v3_selector_route_pilot_0/G3_LO_N_ANDNOT/a_207_413# VDPWR sky130_fd_pr__pfet_01v8_hvt ad=0 pd=0 as=0.1218 ps=1.42 w=0.42 l=0.15
X576 v3_four_channel_output_load_integration_0/v3_four_channel_shared_support_integration_0/v3_four_channel_bias_reference_distribution_0/v3_four_channel_phase_distribution_0/v3_four_channel_output_collection_0/v3_four_channel_placement_0/v3_channel_selector_late_promotion_1/v3_selector_route_pilot_0/group3_lo_n v3_four_channel_output_load_integration_0/v3_four_channel_shared_support_integration_0/v3_four_channel_bias_reference_distribution_0/v3_four_channel_phase_distribution_0/v3_four_channel_output_collection_0/v3_four_channel_placement_0/v3_channel_selector_late_promotion_1/v3_selector_route_pilot_0/G3_LO_N_ANDNOT/a_207_413# VDPWR VDPWR sky130_fd_pr__pfet_01v8_hvt ad=0.26 pd=2.52 as=0 ps=0 w=1 l=0.15
X577 v3_four_channel_output_load_integration_0/v3_four_channel_shared_support_integration_0/v3_four_channel_bias_reference_distribution_0/v3_four_channel_phase_distribution_0/v3_four_channel_output_collection_0/v3_four_channel_placement_0/v3_channel_selector_late_promotion_1/v3_selector_route_pilot_0/G3_LO_N_ANDNOT/a_297_47# v3_four_channel_output_load_integration_0/v3_four_channel_shared_support_integration_0/v3_four_channel_bias_reference_distribution_0/v3_four_channel_phase_distribution_0/v3_four_channel_output_collection_0/v3_four_channel_placement_0/v3_channel_selector_late_promotion_1/v3_selector_route_pilot_0/G3_LO_N_ANDNOT/a_27_413# v3_four_channel_output_load_integration_0/v3_four_channel_shared_support_integration_0/v3_four_channel_bias_reference_distribution_0/v3_four_channel_phase_distribution_0/v3_four_channel_output_collection_0/v3_four_channel_placement_0/v3_channel_selector_late_promotion_1/v3_selector_route_pilot_0/G3_LO_N_ANDNOT/a_207_413# VGND sky130_fd_pr__nfet_01v8 ad=0.1008 pd=1.32 as=0.1092 ps=1.36 w=0.42 l=0.15
X578 v3_four_channel_output_load_integration_0/v3_four_channel_shared_support_integration_0/v3_four_channel_bias_reference_distribution_0/v3_four_channel_phase_distribution_0/v3_four_channel_output_collection_0/v3_four_channel_placement_0/v3_channel_selector_late_promotion_1/v3_selector_route_pilot_0/group3_lo_n v3_four_channel_output_load_integration_0/v3_four_channel_shared_support_integration_0/v3_four_channel_bias_reference_distribution_0/v3_four_channel_phase_distribution_0/v3_four_channel_output_collection_0/v3_four_channel_placement_0/v3_channel_selector_late_promotion_1/v3_selector_route_pilot_0/G3_LO_N_ANDNOT/a_207_413# VGND VGND sky130_fd_pr__nfet_01v8 ad=0.169 pd=1.82 as=0 ps=0 w=0.65 l=0.15
X579 v3_four_channel_output_load_integration_0/v3_four_channel_shared_support_integration_0/v3_four_channel_bias_reference_distribution_0/v3_four_channel_phase_distribution_0/v3_four_channel_output_collection_0/v3_four_channel_placement_0/v3_channel_selector_late_promotion_1/v3_selector_route_pilot_0/G3_LO_N_ANDNOT/a_207_413# v3_four_channel_output_load_integration_0/v3_four_channel_shared_support_integration_0/v3_four_channel_bias_reference_distribution_0/v3_four_channel_phase_distribution_0/v3_four_channel_output_collection_0/v3_four_channel_placement_0/v3_channel_selector_late_promotion_1/v3_selector_route_pilot_0/G3_LO_N_ANDNOT/a_27_413# VDPWR VDPWR sky130_fd_pr__pfet_01v8_hvt ad=0 pd=0 as=0 ps=0 w=0.42 l=0.15
X580 VDPWR v3_four_channel_output_load_integration_0/v3_four_channel_shared_support_integration_0/v3_four_channel_bias_reference_distribution_0/v3_four_channel_phase_distribution_0/v3_four_channel_output_collection_0/v3_four_channel_placement_0/v3_channel_selector_late_promotion_1/v3_selector_route_pilot_0/G3_MUX_AXIS/X v3_four_channel_output_load_integration_0/v3_four_channel_shared_support_integration_0/v3_four_channel_bias_reference_distribution_0/v3_four_channel_phase_distribution_0/v3_four_channel_output_collection_0/v3_four_channel_placement_0/v3_channel_selector_late_promotion_1/v3_selector_route_pilot_0/G3_LO_N_ANDNOT/a_27_413# VDPWR sky130_fd_pr__pfet_01v8_hvt ad=0 pd=0 as=0.1092 ps=1.36 w=0.42 l=0.15
X581 VGND v3_four_channel_output_load_integration_0/v3_four_channel_shared_support_integration_0/v3_four_channel_bias_reference_distribution_0/v3_four_channel_phase_distribution_0/v3_four_channel_output_collection_0/v3_four_channel_placement_0/v3_channel_selector_late_promotion_1/v3_selector_route_pilot_0/G3_LO_P_AND/B v3_four_channel_output_load_integration_0/v3_four_channel_shared_support_integration_0/v3_four_channel_bias_reference_distribution_0/v3_four_channel_phase_distribution_0/v3_four_channel_output_collection_0/v3_four_channel_placement_0/v3_channel_selector_late_promotion_1/v3_selector_route_pilot_0/G3_LO_N_ANDNOT/a_297_47# VGND sky130_fd_pr__nfet_01v8 ad=0 pd=0 as=0 ps=0 w=0.42 l=0.15
X582 v3_four_channel_output_load_integration_0/v3_four_channel_shared_support_integration_0/v3_four_channel_bias_reference_distribution_0/v3_four_channel_phase_distribution_0/v3_four_channel_output_collection_0/v3_four_channel_placement_0/v3_channel_selector_late_promotion_1/v3_selector_route_pilot_0/G3_LO_N_ANDNOT/a_27_413# v3_four_channel_output_load_integration_0/v3_four_channel_shared_support_integration_0/v3_four_channel_bias_reference_distribution_0/v3_four_channel_phase_distribution_0/v3_four_channel_output_collection_0/v3_four_channel_placement_0/v3_channel_selector_late_promotion_1/v3_selector_route_pilot_0/G3_MUX_AXIS/X VGND VGND sky130_fd_pr__nfet_01v8 ad=0.1092 pd=1.36 as=0 ps=0 w=0.42 l=0.15
X583 VDPWR v3_four_channel_output_load_integration_0/v3_four_channel_shared_support_integration_0/v3_four_channel_bias_reference_distribution_0/v3_four_channel_phase_distribution_0/v3_four_channel_output_collection_0/v3_four_channel_placement_0/v3_channel_selector_late_promotion_1/v3_selector_route_pilot_0/G3_LO_P_AND/B v3_four_channel_output_load_integration_0/v3_four_channel_shared_support_integration_0/v3_four_channel_bias_reference_distribution_0/v3_four_channel_phase_distribution_0/v3_four_channel_output_collection_0/v3_four_channel_placement_0/v3_channel_selector_late_promotion_1/v3_selector_route_pilot_0/G2_LO_N_ANDNOT/a_207_413# VDPWR sky130_fd_pr__pfet_01v8_hvt ad=0 pd=0 as=0.1218 ps=1.42 w=0.42 l=0.15
X584 v3_four_channel_output_load_integration_0/v3_four_channel_shared_support_integration_0/v3_four_channel_bias_reference_distribution_0/v3_four_channel_phase_distribution_0/v3_four_channel_output_collection_0/v3_four_channel_placement_0/v3_channel_selector_late_promotion_1/v3_selector_route_pilot_0/group2_lo_n v3_four_channel_output_load_integration_0/v3_four_channel_shared_support_integration_0/v3_four_channel_bias_reference_distribution_0/v3_four_channel_phase_distribution_0/v3_four_channel_output_collection_0/v3_four_channel_placement_0/v3_channel_selector_late_promotion_1/v3_selector_route_pilot_0/G2_LO_N_ANDNOT/a_207_413# VDPWR VDPWR sky130_fd_pr__pfet_01v8_hvt ad=0.26 pd=2.52 as=0 ps=0 w=1 l=0.15
X585 v3_four_channel_output_load_integration_0/v3_four_channel_shared_support_integration_0/v3_four_channel_bias_reference_distribution_0/v3_four_channel_phase_distribution_0/v3_four_channel_output_collection_0/v3_four_channel_placement_0/v3_channel_selector_late_promotion_1/v3_selector_route_pilot_0/G2_LO_N_ANDNOT/a_297_47# v3_four_channel_output_load_integration_0/v3_four_channel_shared_support_integration_0/v3_four_channel_bias_reference_distribution_0/v3_four_channel_phase_distribution_0/v3_four_channel_output_collection_0/v3_four_channel_placement_0/v3_channel_selector_late_promotion_1/v3_selector_route_pilot_0/G2_LO_N_ANDNOT/a_27_413# v3_four_channel_output_load_integration_0/v3_four_channel_shared_support_integration_0/v3_four_channel_bias_reference_distribution_0/v3_four_channel_phase_distribution_0/v3_four_channel_output_collection_0/v3_four_channel_placement_0/v3_channel_selector_late_promotion_1/v3_selector_route_pilot_0/G2_LO_N_ANDNOT/a_207_413# VGND sky130_fd_pr__nfet_01v8 ad=0.1008 pd=1.32 as=0.1092 ps=1.36 w=0.42 l=0.15
X586 v3_four_channel_output_load_integration_0/v3_four_channel_shared_support_integration_0/v3_four_channel_bias_reference_distribution_0/v3_four_channel_phase_distribution_0/v3_four_channel_output_collection_0/v3_four_channel_placement_0/v3_channel_selector_late_promotion_1/v3_selector_route_pilot_0/group2_lo_n v3_four_channel_output_load_integration_0/v3_four_channel_shared_support_integration_0/v3_four_channel_bias_reference_distribution_0/v3_four_channel_phase_distribution_0/v3_four_channel_output_collection_0/v3_four_channel_placement_0/v3_channel_selector_late_promotion_1/v3_selector_route_pilot_0/G2_LO_N_ANDNOT/a_207_413# VGND VGND sky130_fd_pr__nfet_01v8 ad=0.169 pd=1.82 as=0 ps=0 w=0.65 l=0.15
X587 v3_four_channel_output_load_integration_0/v3_four_channel_shared_support_integration_0/v3_four_channel_bias_reference_distribution_0/v3_four_channel_phase_distribution_0/v3_four_channel_output_collection_0/v3_four_channel_placement_0/v3_channel_selector_late_promotion_1/v3_selector_route_pilot_0/G2_LO_N_ANDNOT/a_207_413# v3_four_channel_output_load_integration_0/v3_four_channel_shared_support_integration_0/v3_four_channel_bias_reference_distribution_0/v3_four_channel_phase_distribution_0/v3_four_channel_output_collection_0/v3_four_channel_placement_0/v3_channel_selector_late_promotion_1/v3_selector_route_pilot_0/G2_LO_N_ANDNOT/a_27_413# VDPWR VDPWR sky130_fd_pr__pfet_01v8_hvt ad=0 pd=0 as=0 ps=0 w=0.42 l=0.15
X588 VDPWR v3_four_channel_output_load_integration_0/v3_four_channel_shared_support_integration_0/v3_four_channel_bias_reference_distribution_0/v3_four_channel_phase_distribution_0/v3_four_channel_output_collection_0/v3_four_channel_placement_0/v3_channel_selector_late_promotion_1/v3_selector_route_pilot_0/G2_MUX_AXIS/X v3_four_channel_output_load_integration_0/v3_four_channel_shared_support_integration_0/v3_four_channel_bias_reference_distribution_0/v3_four_channel_phase_distribution_0/v3_four_channel_output_collection_0/v3_four_channel_placement_0/v3_channel_selector_late_promotion_1/v3_selector_route_pilot_0/G2_LO_N_ANDNOT/a_27_413# VDPWR sky130_fd_pr__pfet_01v8_hvt ad=0 pd=0 as=0.1092 ps=1.36 w=0.42 l=0.15
X589 VGND v3_four_channel_output_load_integration_0/v3_four_channel_shared_support_integration_0/v3_four_channel_bias_reference_distribution_0/v3_four_channel_phase_distribution_0/v3_four_channel_output_collection_0/v3_four_channel_placement_0/v3_channel_selector_late_promotion_1/v3_selector_route_pilot_0/G3_LO_P_AND/B v3_four_channel_output_load_integration_0/v3_four_channel_shared_support_integration_0/v3_four_channel_bias_reference_distribution_0/v3_four_channel_phase_distribution_0/v3_four_channel_output_collection_0/v3_four_channel_placement_0/v3_channel_selector_late_promotion_1/v3_selector_route_pilot_0/G2_LO_N_ANDNOT/a_297_47# VGND sky130_fd_pr__nfet_01v8 ad=0 pd=0 as=0 ps=0 w=0.42 l=0.15
X590 v3_four_channel_output_load_integration_0/v3_four_channel_shared_support_integration_0/v3_four_channel_bias_reference_distribution_0/v3_four_channel_phase_distribution_0/v3_four_channel_output_collection_0/v3_four_channel_placement_0/v3_channel_selector_late_promotion_1/v3_selector_route_pilot_0/G2_LO_N_ANDNOT/a_27_413# v3_four_channel_output_load_integration_0/v3_four_channel_shared_support_integration_0/v3_four_channel_bias_reference_distribution_0/v3_four_channel_phase_distribution_0/v3_four_channel_output_collection_0/v3_four_channel_placement_0/v3_channel_selector_late_promotion_1/v3_selector_route_pilot_0/G2_MUX_AXIS/X VGND VGND sky130_fd_pr__nfet_01v8 ad=0.1092 pd=1.36 as=0 ps=0 w=0.42 l=0.15
X591 VDPWR v3_four_channel_output_load_integration_0/v3_four_channel_shared_support_integration_0/v3_four_channel_bias_reference_distribution_0/v3_four_channel_phase_distribution_0/v3_four_channel_output_collection_0/v3_four_channel_placement_0/v3_channel_selector_late_promotion_1/v3_selector_route_pilot_0/G3_LO_P_AND/B v3_four_channel_output_load_integration_0/v3_four_channel_shared_support_integration_0/v3_four_channel_bias_reference_distribution_0/v3_four_channel_phase_distribution_0/v3_four_channel_output_collection_0/v3_four_channel_placement_0/v3_channel_selector_late_promotion_1/v3_selector_route_pilot_0/G0_LO_N_ANDNOT/a_207_413# VDPWR sky130_fd_pr__pfet_01v8_hvt ad=0 pd=0 as=0.1218 ps=1.42 w=0.42 l=0.15
X592 v3_four_channel_output_load_integration_0/v3_four_channel_shared_support_integration_0/v3_four_channel_bias_reference_distribution_0/v3_four_channel_phase_distribution_0/v3_four_channel_output_collection_0/v3_four_channel_placement_0/v3_channel_selector_late_promotion_1/v3_selector_route_pilot_0/group0_lo_n v3_four_channel_output_load_integration_0/v3_four_channel_shared_support_integration_0/v3_four_channel_bias_reference_distribution_0/v3_four_channel_phase_distribution_0/v3_four_channel_output_collection_0/v3_four_channel_placement_0/v3_channel_selector_late_promotion_1/v3_selector_route_pilot_0/G0_LO_N_ANDNOT/a_207_413# VDPWR VDPWR sky130_fd_pr__pfet_01v8_hvt ad=0.26 pd=2.52 as=0 ps=0 w=1 l=0.15
X593 v3_four_channel_output_load_integration_0/v3_four_channel_shared_support_integration_0/v3_four_channel_bias_reference_distribution_0/v3_four_channel_phase_distribution_0/v3_four_channel_output_collection_0/v3_four_channel_placement_0/v3_channel_selector_late_promotion_1/v3_selector_route_pilot_0/G0_LO_N_ANDNOT/a_297_47# v3_four_channel_output_load_integration_0/v3_four_channel_shared_support_integration_0/v3_four_channel_bias_reference_distribution_0/v3_four_channel_phase_distribution_0/v3_four_channel_output_collection_0/v3_four_channel_placement_0/v3_channel_selector_late_promotion_1/v3_selector_route_pilot_0/G0_LO_N_ANDNOT/a_27_413# v3_four_channel_output_load_integration_0/v3_four_channel_shared_support_integration_0/v3_four_channel_bias_reference_distribution_0/v3_four_channel_phase_distribution_0/v3_four_channel_output_collection_0/v3_four_channel_placement_0/v3_channel_selector_late_promotion_1/v3_selector_route_pilot_0/G0_LO_N_ANDNOT/a_207_413# VGND sky130_fd_pr__nfet_01v8 ad=0.1008 pd=1.32 as=0.1092 ps=1.36 w=0.42 l=0.15
X594 v3_four_channel_output_load_integration_0/v3_four_channel_shared_support_integration_0/v3_four_channel_bias_reference_distribution_0/v3_four_channel_phase_distribution_0/v3_four_channel_output_collection_0/v3_four_channel_placement_0/v3_channel_selector_late_promotion_1/v3_selector_route_pilot_0/group0_lo_n v3_four_channel_output_load_integration_0/v3_four_channel_shared_support_integration_0/v3_four_channel_bias_reference_distribution_0/v3_four_channel_phase_distribution_0/v3_four_channel_output_collection_0/v3_four_channel_placement_0/v3_channel_selector_late_promotion_1/v3_selector_route_pilot_0/G0_LO_N_ANDNOT/a_207_413# VGND VGND sky130_fd_pr__nfet_01v8 ad=0.169 pd=1.82 as=0 ps=0 w=0.65 l=0.15
X595 v3_four_channel_output_load_integration_0/v3_four_channel_shared_support_integration_0/v3_four_channel_bias_reference_distribution_0/v3_four_channel_phase_distribution_0/v3_four_channel_output_collection_0/v3_four_channel_placement_0/v3_channel_selector_late_promotion_1/v3_selector_route_pilot_0/G0_LO_N_ANDNOT/a_207_413# v3_four_channel_output_load_integration_0/v3_four_channel_shared_support_integration_0/v3_four_channel_bias_reference_distribution_0/v3_four_channel_phase_distribution_0/v3_four_channel_output_collection_0/v3_four_channel_placement_0/v3_channel_selector_late_promotion_1/v3_selector_route_pilot_0/G0_LO_N_ANDNOT/a_27_413# VDPWR VDPWR sky130_fd_pr__pfet_01v8_hvt ad=0 pd=0 as=0 ps=0 w=0.42 l=0.15
X596 VDPWR v3_four_channel_output_load_integration_0/v3_four_channel_shared_support_integration_0/v3_four_channel_bias_reference_distribution_0/v3_four_channel_phase_distribution_0/v3_four_channel_output_collection_0/v3_four_channel_placement_0/v3_channel_selector_late_promotion_1/v3_selector_route_pilot_0/G0_MUX_AXIS/X v3_four_channel_output_load_integration_0/v3_four_channel_shared_support_integration_0/v3_four_channel_bias_reference_distribution_0/v3_four_channel_phase_distribution_0/v3_four_channel_output_collection_0/v3_four_channel_placement_0/v3_channel_selector_late_promotion_1/v3_selector_route_pilot_0/G0_LO_N_ANDNOT/a_27_413# VDPWR sky130_fd_pr__pfet_01v8_hvt ad=0 pd=0 as=0.1092 ps=1.36 w=0.42 l=0.15
X597 VGND v3_four_channel_output_load_integration_0/v3_four_channel_shared_support_integration_0/v3_four_channel_bias_reference_distribution_0/v3_four_channel_phase_distribution_0/v3_four_channel_output_collection_0/v3_four_channel_placement_0/v3_channel_selector_late_promotion_1/v3_selector_route_pilot_0/G3_LO_P_AND/B v3_four_channel_output_load_integration_0/v3_four_channel_shared_support_integration_0/v3_four_channel_bias_reference_distribution_0/v3_four_channel_phase_distribution_0/v3_four_channel_output_collection_0/v3_four_channel_placement_0/v3_channel_selector_late_promotion_1/v3_selector_route_pilot_0/G0_LO_N_ANDNOT/a_297_47# VGND sky130_fd_pr__nfet_01v8 ad=0 pd=0 as=0 ps=0 w=0.42 l=0.15
X598 v3_four_channel_output_load_integration_0/v3_four_channel_shared_support_integration_0/v3_four_channel_bias_reference_distribution_0/v3_four_channel_phase_distribution_0/v3_four_channel_output_collection_0/v3_four_channel_placement_0/v3_channel_selector_late_promotion_1/v3_selector_route_pilot_0/G0_LO_N_ANDNOT/a_27_413# v3_four_channel_output_load_integration_0/v3_four_channel_shared_support_integration_0/v3_four_channel_bias_reference_distribution_0/v3_four_channel_phase_distribution_0/v3_four_channel_output_collection_0/v3_four_channel_placement_0/v3_channel_selector_late_promotion_1/v3_selector_route_pilot_0/G0_MUX_AXIS/X VGND VGND sky130_fd_pr__nfet_01v8 ad=0.1092 pd=1.36 as=0 ps=0 w=0.42 l=0.15
X599 VDPWR v3_four_channel_output_load_integration_0/v3_four_channel_shared_support_integration_0/v3_four_channel_bias_reference_distribution_0/v3_four_channel_phase_distribution_0/v3_four_channel_output_collection_0/v3_four_channel_placement_0/v3_channel_selector_late_promotion_1/v3_selector_route_pilot_0/G1_MUX_AXIS/a_505_21# v3_four_channel_output_load_integration_0/v3_four_channel_shared_support_integration_0/v3_four_channel_bias_reference_distribution_0/v3_four_channel_phase_distribution_0/v3_four_channel_output_collection_0/v3_four_channel_placement_0/v3_channel_selector_late_promotion_1/v3_selector_route_pilot_0/G1_MUX_AXIS/a_535_374# VDPWR sky130_fd_pr__pfet_01v8_hvt ad=0 pd=0 as=0.0882 ps=1.26 w=0.42 l=0.15
X600 v3_four_channel_output_load_integration_0/v3_four_channel_shared_support_integration_0/v3_four_channel_bias_reference_distribution_0/v3_four_channel_phase_distribution_0/v3_four_channel_output_collection_0/v3_four_channel_placement_0/v3_channel_selector_late_promotion_1/v3_selector_route_pilot_0/G1_MUX_AXIS/a_505_21# v3_four_channel_output_load_integration_0/v3_four_channel_shared_support_integration_0/v3_four_channel_bias_reference_distribution_0/v3_four_channel_phase_distribution_0/v3_four_channel_output_collection_0/v3_four_channel_placement_0/v3_channel_selector_late_promotion_1/group1_bit1 VDPWR VDPWR sky130_fd_pr__pfet_01v8_hvt ad=0.1176 pd=1.4 as=0 ps=0 w=0.42 l=0.15
X601 v3_four_channel_output_load_integration_0/v3_four_channel_shared_support_integration_0/v3_four_channel_bias_reference_distribution_0/v3_four_channel_phase_distribution_0/v3_four_channel_output_collection_0/v3_four_channel_placement_0/v3_channel_selector_late_promotion_1/v3_selector_route_pilot_0/G1_MUX_AXIS/a_218_374# v3_four_channel_output_load_integration_0/v3_four_channel_shared_support_integration_0/v3_four_channel_bias_reference_distribution_0/v3_four_channel_phase_distribution_0/v3_four_channel_output_collection_0/v3_four_channel_placement_0/v3_channel_selector_late_promotion_1/group1_bit1 VDPWR VDPWR sky130_fd_pr__pfet_01v8_hvt ad=0.1533 pd=1.57 as=0 ps=0 w=0.42 l=0.15
X602 VGND v3_four_channel_output_load_integration_0/v3_four_channel_shared_support_integration_0/v3_four_channel_bias_reference_distribution_0/v3_four_channel_phase_distribution_0/v3_four_channel_output_collection_0/v3_four_channel_placement_0/v3_channel_selector_late_promotion_1/v3_selector_route_pilot_0/G1_MUX_AXIS/a_505_21# v3_four_channel_output_load_integration_0/v3_four_channel_shared_support_integration_0/v3_four_channel_bias_reference_distribution_0/v3_four_channel_phase_distribution_0/v3_four_channel_output_collection_0/v3_four_channel_placement_0/v3_channel_selector_late_promotion_1/v3_selector_route_pilot_0/G1_MUX_AXIS/a_439_47# VGND sky130_fd_pr__nfet_01v8 ad=0 pd=0 as=0.1386 ps=1.5 w=0.42 l=0.15
X603 v3_four_channel_output_load_integration_0/v3_four_channel_shared_support_integration_0/v3_four_channel_bias_reference_distribution_0/v3_four_channel_phase_distribution_0/v3_four_channel_output_collection_0/v3_four_channel_placement_0/v3_channel_selector_late_promotion_1/v3_selector_route_pilot_0/G1_MUX_AXIS/a_76_199# v3_four_channel_output_load_integration_0/v3_four_channel_shared_support_integration_0/v3_four_channel_bias_reference_distribution_0/v3_four_channel_phase_distribution_0/v3_four_channel_output_collection_0/v3_four_channel_placement_0/v3_channel_selector_late_promotion_1/v3_selector_route_pilot_0/G1_MUX_POS/X v3_four_channel_output_load_integration_0/v3_four_channel_shared_support_integration_0/v3_four_channel_bias_reference_distribution_0/v3_four_channel_phase_distribution_0/v3_four_channel_output_collection_0/v3_four_channel_placement_0/v3_channel_selector_late_promotion_1/v3_selector_route_pilot_0/G1_MUX_AXIS/a_218_374# VDPWR sky130_fd_pr__pfet_01v8_hvt ad=0.3864 pd=2.68 as=0 ps=0 w=0.42 l=0.15
X604 v3_four_channel_output_load_integration_0/v3_four_channel_shared_support_integration_0/v3_four_channel_bias_reference_distribution_0/v3_four_channel_phase_distribution_0/v3_four_channel_output_collection_0/v3_four_channel_placement_0/v3_channel_selector_late_promotion_1/v3_selector_route_pilot_0/G1_MUX_AXIS/a_505_21# v3_four_channel_output_load_integration_0/v3_four_channel_shared_support_integration_0/v3_four_channel_bias_reference_distribution_0/v3_four_channel_phase_distribution_0/v3_four_channel_output_collection_0/v3_four_channel_placement_0/v3_channel_selector_late_promotion_1/group1_bit1 VGND VGND sky130_fd_pr__nfet_01v8 ad=0.1092 pd=1.36 as=0 ps=0 w=0.42 l=0.15
X605 v3_four_channel_output_load_integration_0/v3_four_channel_shared_support_integration_0/v3_four_channel_bias_reference_distribution_0/v3_four_channel_phase_distribution_0/v3_four_channel_output_collection_0/v3_four_channel_placement_0/v3_channel_selector_late_promotion_1/v3_selector_route_pilot_0/G1_MUX_AXIS/a_439_47# v3_four_channel_output_load_integration_0/v3_four_channel_shared_support_integration_0/v3_four_channel_bias_reference_distribution_0/v3_four_channel_phase_distribution_0/v3_four_channel_output_collection_0/v3_four_channel_placement_0/v3_channel_selector_late_promotion_1/v3_selector_route_pilot_0/G1_MUX_POS/X v3_four_channel_output_load_integration_0/v3_four_channel_shared_support_integration_0/v3_four_channel_bias_reference_distribution_0/v3_four_channel_phase_distribution_0/v3_four_channel_output_collection_0/v3_four_channel_placement_0/v3_channel_selector_late_promotion_1/v3_selector_route_pilot_0/G1_MUX_AXIS/a_76_199# VGND sky130_fd_pr__nfet_01v8 ad=0 pd=0 as=0.1995 ps=1.79 w=0.42 l=0.15
X606 v3_four_channel_output_load_integration_0/v3_four_channel_shared_support_integration_0/v3_four_channel_bias_reference_distribution_0/v3_four_channel_phase_distribution_0/v3_four_channel_output_collection_0/v3_four_channel_placement_0/v3_channel_selector_late_promotion_1/v3_selector_route_pilot_0/G1_MUX_AXIS/a_535_374# v3_four_channel_output_load_integration_0/v3_four_channel_shared_support_integration_0/v3_four_channel_bias_reference_distribution_0/v3_four_channel_phase_distribution_0/v3_four_channel_output_collection_0/v3_four_channel_placement_0/v3_channel_selector_late_promotion_1/v3_selector_route_pilot_0/G1_MUX_NEG/X v3_four_channel_output_load_integration_0/v3_four_channel_shared_support_integration_0/v3_four_channel_bias_reference_distribution_0/v3_four_channel_phase_distribution_0/v3_four_channel_output_collection_0/v3_four_channel_placement_0/v3_channel_selector_late_promotion_1/v3_selector_route_pilot_0/G1_MUX_AXIS/a_76_199# VDPWR sky130_fd_pr__pfet_01v8_hvt ad=0 pd=0 as=0 ps=0 w=0.42 l=0.15
X607 v3_four_channel_output_load_integration_0/v3_four_channel_shared_support_integration_0/v3_four_channel_bias_reference_distribution_0/v3_four_channel_phase_distribution_0/v3_four_channel_output_collection_0/v3_four_channel_placement_0/v3_channel_selector_late_promotion_1/v3_selector_route_pilot_0/G1_MUX_AXIS/a_76_199# v3_four_channel_output_load_integration_0/v3_four_channel_shared_support_integration_0/v3_four_channel_bias_reference_distribution_0/v3_four_channel_phase_distribution_0/v3_four_channel_output_collection_0/v3_four_channel_placement_0/v3_channel_selector_late_promotion_1/v3_selector_route_pilot_0/G1_MUX_NEG/X v3_four_channel_output_load_integration_0/v3_four_channel_shared_support_integration_0/v3_four_channel_bias_reference_distribution_0/v3_four_channel_phase_distribution_0/v3_four_channel_output_collection_0/v3_four_channel_placement_0/v3_channel_selector_late_promotion_1/v3_selector_route_pilot_0/G1_MUX_AXIS/a_218_47# VGND sky130_fd_pr__nfet_01v8 ad=0 pd=0 as=0.1386 ps=1.5 w=0.42 l=0.15
X608 v3_four_channel_output_load_integration_0/v3_four_channel_shared_support_integration_0/v3_four_channel_bias_reference_distribution_0/v3_four_channel_phase_distribution_0/v3_four_channel_output_collection_0/v3_four_channel_placement_0/v3_channel_selector_late_promotion_1/v3_selector_route_pilot_0/G1_MUX_AXIS/a_218_47# v3_four_channel_output_load_integration_0/v3_four_channel_shared_support_integration_0/v3_four_channel_bias_reference_distribution_0/v3_four_channel_phase_distribution_0/v3_four_channel_output_collection_0/v3_four_channel_placement_0/v3_channel_selector_late_promotion_1/group1_bit1 VGND VGND sky130_fd_pr__nfet_01v8 ad=0 pd=0 as=0 ps=0 w=0.42 l=0.15
X609 VDPWR v3_four_channel_output_load_integration_0/v3_four_channel_shared_support_integration_0/v3_four_channel_bias_reference_distribution_0/v3_four_channel_phase_distribution_0/v3_four_channel_output_collection_0/v3_four_channel_placement_0/v3_channel_selector_late_promotion_1/v3_selector_route_pilot_0/G1_MUX_AXIS/a_76_199# v3_four_channel_output_load_integration_0/v3_four_channel_shared_support_integration_0/v3_four_channel_bias_reference_distribution_0/v3_four_channel_phase_distribution_0/v3_four_channel_output_collection_0/v3_four_channel_placement_0/v3_channel_selector_late_promotion_1/v3_selector_route_pilot_0/G1_MUX_AXIS/X VDPWR sky130_fd_pr__pfet_01v8_hvt ad=0 pd=0 as=0.26 ps=2.52 w=1 l=0.15
X610 VGND v3_four_channel_output_load_integration_0/v3_four_channel_shared_support_integration_0/v3_four_channel_bias_reference_distribution_0/v3_four_channel_phase_distribution_0/v3_four_channel_output_collection_0/v3_four_channel_placement_0/v3_channel_selector_late_promotion_1/v3_selector_route_pilot_0/G1_MUX_AXIS/a_76_199# v3_four_channel_output_load_integration_0/v3_four_channel_shared_support_integration_0/v3_four_channel_bias_reference_distribution_0/v3_four_channel_phase_distribution_0/v3_four_channel_output_collection_0/v3_four_channel_placement_0/v3_channel_selector_late_promotion_1/v3_selector_route_pilot_0/G1_MUX_AXIS/X VGND sky130_fd_pr__nfet_01v8 ad=0 pd=0 as=0.169 ps=1.82 w=0.65 l=0.15
X611 VDPWR v3_four_channel_output_load_integration_0/v3_four_channel_shared_support_integration_0/v3_four_channel_bias_reference_distribution_0/v3_four_channel_phase_distribution_0/v3_four_channel_output_collection_0/v3_four_channel_placement_0/v3_channel_selector_late_promotion_1/v3_selector_route_pilot_0/G3_LO_P_AND/B v3_four_channel_output_load_integration_0/v3_four_channel_shared_support_integration_0/v3_four_channel_bias_reference_distribution_0/v3_four_channel_phase_distribution_0/v3_four_channel_output_collection_0/v3_four_channel_placement_0/v3_channel_selector_late_promotion_1/v3_selector_route_pilot_0/G1_LO_N_ANDNOT/a_207_413# VDPWR sky130_fd_pr__pfet_01v8_hvt ad=0 pd=0 as=0.1218 ps=1.42 w=0.42 l=0.15
X612 v3_four_channel_output_load_integration_0/v3_four_channel_shared_support_integration_0/v3_four_channel_bias_reference_distribution_0/v3_four_channel_phase_distribution_0/v3_four_channel_output_collection_0/v3_four_channel_placement_0/v3_channel_selector_late_promotion_1/v3_selector_route_pilot_0/group1_lo_n v3_four_channel_output_load_integration_0/v3_four_channel_shared_support_integration_0/v3_four_channel_bias_reference_distribution_0/v3_four_channel_phase_distribution_0/v3_four_channel_output_collection_0/v3_four_channel_placement_0/v3_channel_selector_late_promotion_1/v3_selector_route_pilot_0/G1_LO_N_ANDNOT/a_207_413# VDPWR VDPWR sky130_fd_pr__pfet_01v8_hvt ad=0.26 pd=2.52 as=0 ps=0 w=1 l=0.15
X613 v3_four_channel_output_load_integration_0/v3_four_channel_shared_support_integration_0/v3_four_channel_bias_reference_distribution_0/v3_four_channel_phase_distribution_0/v3_four_channel_output_collection_0/v3_four_channel_placement_0/v3_channel_selector_late_promotion_1/v3_selector_route_pilot_0/G1_LO_N_ANDNOT/a_297_47# v3_four_channel_output_load_integration_0/v3_four_channel_shared_support_integration_0/v3_four_channel_bias_reference_distribution_0/v3_four_channel_phase_distribution_0/v3_four_channel_output_collection_0/v3_four_channel_placement_0/v3_channel_selector_late_promotion_1/v3_selector_route_pilot_0/G1_LO_N_ANDNOT/a_27_413# v3_four_channel_output_load_integration_0/v3_four_channel_shared_support_integration_0/v3_four_channel_bias_reference_distribution_0/v3_four_channel_phase_distribution_0/v3_four_channel_output_collection_0/v3_four_channel_placement_0/v3_channel_selector_late_promotion_1/v3_selector_route_pilot_0/G1_LO_N_ANDNOT/a_207_413# VGND sky130_fd_pr__nfet_01v8 ad=0.1008 pd=1.32 as=0.1092 ps=1.36 w=0.42 l=0.15
X614 v3_four_channel_output_load_integration_0/v3_four_channel_shared_support_integration_0/v3_four_channel_bias_reference_distribution_0/v3_four_channel_phase_distribution_0/v3_four_channel_output_collection_0/v3_four_channel_placement_0/v3_channel_selector_late_promotion_1/v3_selector_route_pilot_0/group1_lo_n v3_four_channel_output_load_integration_0/v3_four_channel_shared_support_integration_0/v3_four_channel_bias_reference_distribution_0/v3_four_channel_phase_distribution_0/v3_four_channel_output_collection_0/v3_four_channel_placement_0/v3_channel_selector_late_promotion_1/v3_selector_route_pilot_0/G1_LO_N_ANDNOT/a_207_413# VGND VGND sky130_fd_pr__nfet_01v8 ad=0.169 pd=1.82 as=0 ps=0 w=0.65 l=0.15
X615 v3_four_channel_output_load_integration_0/v3_four_channel_shared_support_integration_0/v3_four_channel_bias_reference_distribution_0/v3_four_channel_phase_distribution_0/v3_four_channel_output_collection_0/v3_four_channel_placement_0/v3_channel_selector_late_promotion_1/v3_selector_route_pilot_0/G1_LO_N_ANDNOT/a_207_413# v3_four_channel_output_load_integration_0/v3_four_channel_shared_support_integration_0/v3_four_channel_bias_reference_distribution_0/v3_four_channel_phase_distribution_0/v3_four_channel_output_collection_0/v3_four_channel_placement_0/v3_channel_selector_late_promotion_1/v3_selector_route_pilot_0/G1_LO_N_ANDNOT/a_27_413# VDPWR VDPWR sky130_fd_pr__pfet_01v8_hvt ad=0 pd=0 as=0 ps=0 w=0.42 l=0.15
X616 VDPWR v3_four_channel_output_load_integration_0/v3_four_channel_shared_support_integration_0/v3_four_channel_bias_reference_distribution_0/v3_four_channel_phase_distribution_0/v3_four_channel_output_collection_0/v3_four_channel_placement_0/v3_channel_selector_late_promotion_1/v3_selector_route_pilot_0/G1_MUX_AXIS/X v3_four_channel_output_load_integration_0/v3_four_channel_shared_support_integration_0/v3_four_channel_bias_reference_distribution_0/v3_four_channel_phase_distribution_0/v3_four_channel_output_collection_0/v3_four_channel_placement_0/v3_channel_selector_late_promotion_1/v3_selector_route_pilot_0/G1_LO_N_ANDNOT/a_27_413# VDPWR sky130_fd_pr__pfet_01v8_hvt ad=0 pd=0 as=0.1092 ps=1.36 w=0.42 l=0.15
X617 VGND v3_four_channel_output_load_integration_0/v3_four_channel_shared_support_integration_0/v3_four_channel_bias_reference_distribution_0/v3_four_channel_phase_distribution_0/v3_four_channel_output_collection_0/v3_four_channel_placement_0/v3_channel_selector_late_promotion_1/v3_selector_route_pilot_0/G3_LO_P_AND/B v3_four_channel_output_load_integration_0/v3_four_channel_shared_support_integration_0/v3_four_channel_bias_reference_distribution_0/v3_four_channel_phase_distribution_0/v3_four_channel_output_collection_0/v3_four_channel_placement_0/v3_channel_selector_late_promotion_1/v3_selector_route_pilot_0/G1_LO_N_ANDNOT/a_297_47# VGND sky130_fd_pr__nfet_01v8 ad=0 pd=0 as=0 ps=0 w=0.42 l=0.15
X618 v3_four_channel_output_load_integration_0/v3_four_channel_shared_support_integration_0/v3_four_channel_bias_reference_distribution_0/v3_four_channel_phase_distribution_0/v3_four_channel_output_collection_0/v3_four_channel_placement_0/v3_channel_selector_late_promotion_1/v3_selector_route_pilot_0/G1_LO_N_ANDNOT/a_27_413# v3_four_channel_output_load_integration_0/v3_four_channel_shared_support_integration_0/v3_four_channel_bias_reference_distribution_0/v3_four_channel_phase_distribution_0/v3_four_channel_output_collection_0/v3_four_channel_placement_0/v3_channel_selector_late_promotion_1/v3_selector_route_pilot_0/G1_MUX_AXIS/X VGND VGND sky130_fd_pr__nfet_01v8 ad=0.1092 pd=1.36 as=0 ps=0 w=0.42 l=0.15
X619 VDPWR v3_four_channel_output_load_integration_0/v3_four_channel_shared_support_integration_0/v3_four_channel_bias_reference_distribution_0/v3_four_channel_phase_distribution_0/v3_four_channel_output_collection_0/v3_four_channel_placement_0/v3_channel_selector_late_promotion_1/v3_selector_route_pilot_0/G3_LO_P_AND/B v3_four_channel_output_load_integration_0/v3_four_channel_shared_support_integration_0/v3_four_channel_bias_reference_distribution_0/v3_four_channel_phase_distribution_0/v3_four_channel_output_collection_0/v3_four_channel_placement_0/v3_channel_selector_late_promotion_1/v3_selector_route_pilot_0/G3_LO_P_AND/a_59_75# VDPWR sky130_fd_pr__pfet_01v8_hvt ad=0 pd=0 as=0.1134 ps=1.38 w=0.42 l=0.15
X620 v3_four_channel_output_load_integration_0/v3_four_channel_shared_support_integration_0/v3_four_channel_bias_reference_distribution_0/v3_four_channel_phase_distribution_0/v3_four_channel_output_collection_0/v3_four_channel_placement_0/v3_channel_selector_late_promotion_1/v3_selector_route_pilot_0/group3_lo_p v3_four_channel_output_load_integration_0/v3_four_channel_shared_support_integration_0/v3_four_channel_bias_reference_distribution_0/v3_four_channel_phase_distribution_0/v3_four_channel_output_collection_0/v3_four_channel_placement_0/v3_channel_selector_late_promotion_1/v3_selector_route_pilot_0/G3_LO_P_AND/a_59_75# VDPWR VDPWR sky130_fd_pr__pfet_01v8_hvt ad=0.475 pd=2.95 as=0 ps=0 w=1 l=0.15
X621 VGND v3_four_channel_output_load_integration_0/v3_four_channel_shared_support_integration_0/v3_four_channel_bias_reference_distribution_0/v3_four_channel_phase_distribution_0/v3_four_channel_output_collection_0/v3_four_channel_placement_0/v3_channel_selector_late_promotion_1/v3_selector_route_pilot_0/G3_LO_P_AND/B v3_four_channel_output_load_integration_0/v3_four_channel_shared_support_integration_0/v3_four_channel_bias_reference_distribution_0/v3_four_channel_phase_distribution_0/v3_four_channel_output_collection_0/v3_four_channel_placement_0/v3_channel_selector_late_promotion_1/v3_selector_route_pilot_0/G3_LO_P_AND/a_145_75# VGND sky130_fd_pr__nfet_01v8 ad=0 pd=0 as=0.1134 ps=1.38 w=0.42 l=0.15
X622 v3_four_channel_output_load_integration_0/v3_four_channel_shared_support_integration_0/v3_four_channel_bias_reference_distribution_0/v3_four_channel_phase_distribution_0/v3_four_channel_output_collection_0/v3_four_channel_placement_0/v3_channel_selector_late_promotion_1/v3_selector_route_pilot_0/G3_LO_P_AND/a_59_75# v3_four_channel_output_load_integration_0/v3_four_channel_shared_support_integration_0/v3_four_channel_bias_reference_distribution_0/v3_four_channel_phase_distribution_0/v3_four_channel_output_collection_0/v3_four_channel_placement_0/v3_channel_selector_late_promotion_1/v3_selector_route_pilot_0/G3_MUX_AXIS/X VDPWR VDPWR sky130_fd_pr__pfet_01v8_hvt ad=0 pd=0 as=0 ps=0 w=0.42 l=0.15
X623 v3_four_channel_output_load_integration_0/v3_four_channel_shared_support_integration_0/v3_four_channel_bias_reference_distribution_0/v3_four_channel_phase_distribution_0/v3_four_channel_output_collection_0/v3_four_channel_placement_0/v3_channel_selector_late_promotion_1/v3_selector_route_pilot_0/group3_lo_p v3_four_channel_output_load_integration_0/v3_four_channel_shared_support_integration_0/v3_four_channel_bias_reference_distribution_0/v3_four_channel_phase_distribution_0/v3_four_channel_output_collection_0/v3_four_channel_placement_0/v3_channel_selector_late_promotion_1/v3_selector_route_pilot_0/G3_LO_P_AND/a_59_75# VGND VGND sky130_fd_pr__nfet_01v8 ad=0.182 pd=1.86 as=0 ps=0 w=0.65 l=0.15
X624 v3_four_channel_output_load_integration_0/v3_four_channel_shared_support_integration_0/v3_four_channel_bias_reference_distribution_0/v3_four_channel_phase_distribution_0/v3_four_channel_output_collection_0/v3_four_channel_placement_0/v3_channel_selector_late_promotion_1/v3_selector_route_pilot_0/G3_LO_P_AND/a_145_75# v3_four_channel_output_load_integration_0/v3_four_channel_shared_support_integration_0/v3_four_channel_bias_reference_distribution_0/v3_four_channel_phase_distribution_0/v3_four_channel_output_collection_0/v3_four_channel_placement_0/v3_channel_selector_late_promotion_1/v3_selector_route_pilot_0/G3_MUX_AXIS/X v3_four_channel_output_load_integration_0/v3_four_channel_shared_support_integration_0/v3_four_channel_bias_reference_distribution_0/v3_four_channel_phase_distribution_0/v3_four_channel_output_collection_0/v3_four_channel_placement_0/v3_channel_selector_late_promotion_1/v3_selector_route_pilot_0/G3_LO_P_AND/a_59_75# VGND sky130_fd_pr__nfet_01v8 ad=0 pd=0 as=0.1176 ps=1.4 w=0.42 l=0.15
X625 VDPWR v3_four_channel_output_load_integration_0/v3_four_channel_shared_support_integration_0/v3_four_channel_bias_reference_distribution_0/v3_four_channel_phase_distribution_0/v3_four_channel_output_collection_0/v3_four_channel_placement_0/v3_channel_selector_late_promotion_1/v3_selector_route_pilot_0/G2_MUX_POS/a_505_21# v3_four_channel_output_load_integration_0/v3_four_channel_shared_support_integration_0/v3_four_channel_bias_reference_distribution_0/v3_four_channel_phase_distribution_0/v3_four_channel_output_collection_0/v3_four_channel_placement_0/v3_channel_selector_late_promotion_1/v3_selector_route_pilot_0/G2_MUX_POS/a_535_374# VDPWR sky130_fd_pr__pfet_01v8_hvt ad=0 pd=0 as=0.0882 ps=1.26 w=0.42 l=0.15
X626 v3_four_channel_output_load_integration_0/v3_four_channel_shared_support_integration_0/v3_four_channel_bias_reference_distribution_0/v3_four_channel_phase_distribution_0/v3_four_channel_output_collection_0/v3_four_channel_placement_0/v3_channel_selector_late_promotion_1/v3_selector_route_pilot_0/G2_MUX_POS/a_505_21# v3_four_channel_output_load_integration_0/v3_four_channel_shared_support_integration_0/v3_four_channel_bias_reference_distribution_0/v3_four_channel_phase_distribution_0/v3_four_channel_output_collection_0/v3_four_channel_placement_0/v3_channel_selector_late_promotion_1/group2_bit0 VDPWR VDPWR sky130_fd_pr__pfet_01v8_hvt ad=0.1176 pd=1.4 as=0 ps=0 w=0.42 l=0.15
X627 v3_four_channel_output_load_integration_0/v3_four_channel_shared_support_integration_0/v3_four_channel_bias_reference_distribution_0/v3_four_channel_phase_distribution_0/v3_four_channel_output_collection_0/v3_four_channel_placement_0/v3_channel_selector_late_promotion_1/v3_selector_route_pilot_0/G2_MUX_POS/a_218_374# v3_four_channel_output_load_integration_0/v3_four_channel_shared_support_integration_0/v3_four_channel_bias_reference_distribution_0/v3_four_channel_phase_distribution_0/v3_four_channel_output_collection_0/v3_four_channel_placement_0/v3_channel_selector_late_promotion_1/group2_bit0 VDPWR VDPWR sky130_fd_pr__pfet_01v8_hvt ad=0.1533 pd=1.57 as=0 ps=0 w=0.42 l=0.15
X628 VGND v3_four_channel_output_load_integration_0/v3_four_channel_shared_support_integration_0/v3_four_channel_bias_reference_distribution_0/v3_four_channel_phase_distribution_0/v3_four_channel_output_collection_0/v3_four_channel_placement_0/v3_channel_selector_late_promotion_1/v3_selector_route_pilot_0/G2_MUX_POS/a_505_21# v3_four_channel_output_load_integration_0/v3_four_channel_shared_support_integration_0/v3_four_channel_bias_reference_distribution_0/v3_four_channel_phase_distribution_0/v3_four_channel_output_collection_0/v3_four_channel_placement_0/v3_channel_selector_late_promotion_1/v3_selector_route_pilot_0/G2_MUX_POS/a_439_47# VGND sky130_fd_pr__nfet_01v8 ad=0 pd=0 as=0.1386 ps=1.5 w=0.42 l=0.15
X629 v3_four_channel_output_load_integration_0/v3_four_channel_shared_support_integration_0/v3_four_channel_bias_reference_distribution_0/v3_four_channel_phase_distribution_0/v3_four_channel_output_collection_0/v3_four_channel_placement_0/v3_channel_selector_late_promotion_1/v3_selector_route_pilot_0/G2_MUX_POS/a_76_199# v3_four_channel_output_load_integration_0/v3_four_channel_shared_support_integration_0/v3_four_channel_bias_reference_distribution_0/v3_four_channel_phase_distribution_0/phase_0 v3_four_channel_output_load_integration_0/v3_four_channel_shared_support_integration_0/v3_four_channel_bias_reference_distribution_0/v3_four_channel_phase_distribution_0/v3_four_channel_output_collection_0/v3_four_channel_placement_0/v3_channel_selector_late_promotion_1/v3_selector_route_pilot_0/G2_MUX_POS/a_218_374# VDPWR sky130_fd_pr__pfet_01v8_hvt ad=0.3864 pd=2.68 as=0 ps=0 w=0.42 l=0.15
X630 v3_four_channel_output_load_integration_0/v3_four_channel_shared_support_integration_0/v3_four_channel_bias_reference_distribution_0/v3_four_channel_phase_distribution_0/v3_four_channel_output_collection_0/v3_four_channel_placement_0/v3_channel_selector_late_promotion_1/v3_selector_route_pilot_0/G2_MUX_POS/a_505_21# v3_four_channel_output_load_integration_0/v3_four_channel_shared_support_integration_0/v3_four_channel_bias_reference_distribution_0/v3_four_channel_phase_distribution_0/v3_four_channel_output_collection_0/v3_four_channel_placement_0/v3_channel_selector_late_promotion_1/group2_bit0 VGND VGND sky130_fd_pr__nfet_01v8 ad=0.1092 pd=1.36 as=0 ps=0 w=0.42 l=0.15
X631 v3_four_channel_output_load_integration_0/v3_four_channel_shared_support_integration_0/v3_four_channel_bias_reference_distribution_0/v3_four_channel_phase_distribution_0/v3_four_channel_output_collection_0/v3_four_channel_placement_0/v3_channel_selector_late_promotion_1/v3_selector_route_pilot_0/G2_MUX_POS/a_439_47# v3_four_channel_output_load_integration_0/v3_four_channel_shared_support_integration_0/v3_four_channel_bias_reference_distribution_0/v3_four_channel_phase_distribution_0/phase_0 v3_four_channel_output_load_integration_0/v3_four_channel_shared_support_integration_0/v3_four_channel_bias_reference_distribution_0/v3_four_channel_phase_distribution_0/v3_four_channel_output_collection_0/v3_four_channel_placement_0/v3_channel_selector_late_promotion_1/v3_selector_route_pilot_0/G2_MUX_POS/a_76_199# VGND sky130_fd_pr__nfet_01v8 ad=0 pd=0 as=0.1995 ps=1.79 w=0.42 l=0.15
X632 v3_four_channel_output_load_integration_0/v3_four_channel_shared_support_integration_0/v3_four_channel_bias_reference_distribution_0/v3_four_channel_phase_distribution_0/v3_four_channel_output_collection_0/v3_four_channel_placement_0/v3_channel_selector_late_promotion_1/v3_selector_route_pilot_0/G2_MUX_POS/a_535_374# v3_four_channel_output_load_integration_0/v3_four_channel_shared_support_integration_0/v3_four_channel_bias_reference_distribution_0/v3_four_channel_phase_distribution_0/phase_90 v3_four_channel_output_load_integration_0/v3_four_channel_shared_support_integration_0/v3_four_channel_bias_reference_distribution_0/v3_four_channel_phase_distribution_0/v3_four_channel_output_collection_0/v3_four_channel_placement_0/v3_channel_selector_late_promotion_1/v3_selector_route_pilot_0/G2_MUX_POS/a_76_199# VDPWR sky130_fd_pr__pfet_01v8_hvt ad=0 pd=0 as=0 ps=0 w=0.42 l=0.15
X633 v3_four_channel_output_load_integration_0/v3_four_channel_shared_support_integration_0/v3_four_channel_bias_reference_distribution_0/v3_four_channel_phase_distribution_0/v3_four_channel_output_collection_0/v3_four_channel_placement_0/v3_channel_selector_late_promotion_1/v3_selector_route_pilot_0/G2_MUX_POS/a_76_199# v3_four_channel_output_load_integration_0/v3_four_channel_shared_support_integration_0/v3_four_channel_bias_reference_distribution_0/v3_four_channel_phase_distribution_0/phase_90 v3_four_channel_output_load_integration_0/v3_four_channel_shared_support_integration_0/v3_four_channel_bias_reference_distribution_0/v3_four_channel_phase_distribution_0/v3_four_channel_output_collection_0/v3_four_channel_placement_0/v3_channel_selector_late_promotion_1/v3_selector_route_pilot_0/G2_MUX_POS/a_218_47# VGND sky130_fd_pr__nfet_01v8 ad=0 pd=0 as=0.1386 ps=1.5 w=0.42 l=0.15
X634 v3_four_channel_output_load_integration_0/v3_four_channel_shared_support_integration_0/v3_four_channel_bias_reference_distribution_0/v3_four_channel_phase_distribution_0/v3_four_channel_output_collection_0/v3_four_channel_placement_0/v3_channel_selector_late_promotion_1/v3_selector_route_pilot_0/G2_MUX_POS/a_218_47# v3_four_channel_output_load_integration_0/v3_four_channel_shared_support_integration_0/v3_four_channel_bias_reference_distribution_0/v3_four_channel_phase_distribution_0/v3_four_channel_output_collection_0/v3_four_channel_placement_0/v3_channel_selector_late_promotion_1/group2_bit0 VGND VGND sky130_fd_pr__nfet_01v8 ad=0 pd=0 as=0 ps=0 w=0.42 l=0.15
X635 VDPWR v3_four_channel_output_load_integration_0/v3_four_channel_shared_support_integration_0/v3_four_channel_bias_reference_distribution_0/v3_four_channel_phase_distribution_0/v3_four_channel_output_collection_0/v3_four_channel_placement_0/v3_channel_selector_late_promotion_1/v3_selector_route_pilot_0/G2_MUX_POS/a_76_199# v3_four_channel_output_load_integration_0/v3_four_channel_shared_support_integration_0/v3_four_channel_bias_reference_distribution_0/v3_four_channel_phase_distribution_0/v3_four_channel_output_collection_0/v3_four_channel_placement_0/v3_channel_selector_late_promotion_1/v3_selector_route_pilot_0/G2_MUX_POS/X VDPWR sky130_fd_pr__pfet_01v8_hvt ad=0 pd=0 as=0.26 ps=2.52 w=1 l=0.15
X636 VGND v3_four_channel_output_load_integration_0/v3_four_channel_shared_support_integration_0/v3_four_channel_bias_reference_distribution_0/v3_four_channel_phase_distribution_0/v3_four_channel_output_collection_0/v3_four_channel_placement_0/v3_channel_selector_late_promotion_1/v3_selector_route_pilot_0/G2_MUX_POS/a_76_199# v3_four_channel_output_load_integration_0/v3_four_channel_shared_support_integration_0/v3_four_channel_bias_reference_distribution_0/v3_four_channel_phase_distribution_0/v3_four_channel_output_collection_0/v3_four_channel_placement_0/v3_channel_selector_late_promotion_1/v3_selector_route_pilot_0/G2_MUX_POS/X VGND sky130_fd_pr__nfet_01v8 ad=0 pd=0 as=0.169 ps=1.82 w=0.65 l=0.15
X637 VDPWR v3_four_channel_output_load_integration_0/v3_four_channel_shared_support_integration_0/v3_four_channel_bias_reference_distribution_0/v3_four_channel_phase_distribution_0/v3_four_channel_output_collection_0/v3_four_channel_placement_0/v3_channel_selector_late_promotion_1/v3_selector_route_pilot_0/G2_MUX_NEG/a_505_21# v3_four_channel_output_load_integration_0/v3_four_channel_shared_support_integration_0/v3_four_channel_bias_reference_distribution_0/v3_four_channel_phase_distribution_0/v3_four_channel_output_collection_0/v3_four_channel_placement_0/v3_channel_selector_late_promotion_1/v3_selector_route_pilot_0/G2_MUX_NEG/a_535_374# VDPWR sky130_fd_pr__pfet_01v8_hvt ad=0 pd=0 as=0.0882 ps=1.26 w=0.42 l=0.15
X638 v3_four_channel_output_load_integration_0/v3_four_channel_shared_support_integration_0/v3_four_channel_bias_reference_distribution_0/v3_four_channel_phase_distribution_0/v3_four_channel_output_collection_0/v3_four_channel_placement_0/v3_channel_selector_late_promotion_1/v3_selector_route_pilot_0/G2_MUX_NEG/a_505_21# v3_four_channel_output_load_integration_0/v3_four_channel_shared_support_integration_0/v3_four_channel_bias_reference_distribution_0/v3_four_channel_phase_distribution_0/v3_four_channel_output_collection_0/v3_four_channel_placement_0/v3_channel_selector_late_promotion_1/group2_bit0 VDPWR VDPWR sky130_fd_pr__pfet_01v8_hvt ad=0.1176 pd=1.4 as=0 ps=0 w=0.42 l=0.15
X639 v3_four_channel_output_load_integration_0/v3_four_channel_shared_support_integration_0/v3_four_channel_bias_reference_distribution_0/v3_four_channel_phase_distribution_0/v3_four_channel_output_collection_0/v3_four_channel_placement_0/v3_channel_selector_late_promotion_1/v3_selector_route_pilot_0/G2_MUX_NEG/a_218_374# v3_four_channel_output_load_integration_0/v3_four_channel_shared_support_integration_0/v3_four_channel_bias_reference_distribution_0/v3_four_channel_phase_distribution_0/v3_four_channel_output_collection_0/v3_four_channel_placement_0/v3_channel_selector_late_promotion_1/group2_bit0 VDPWR VDPWR sky130_fd_pr__pfet_01v8_hvt ad=0.1533 pd=1.57 as=0 ps=0 w=0.42 l=0.15
X640 VGND v3_four_channel_output_load_integration_0/v3_four_channel_shared_support_integration_0/v3_four_channel_bias_reference_distribution_0/v3_four_channel_phase_distribution_0/v3_four_channel_output_collection_0/v3_four_channel_placement_0/v3_channel_selector_late_promotion_1/v3_selector_route_pilot_0/G2_MUX_NEG/a_505_21# v3_four_channel_output_load_integration_0/v3_four_channel_shared_support_integration_0/v3_four_channel_bias_reference_distribution_0/v3_four_channel_phase_distribution_0/v3_four_channel_output_collection_0/v3_four_channel_placement_0/v3_channel_selector_late_promotion_1/v3_selector_route_pilot_0/G2_MUX_NEG/a_439_47# VGND sky130_fd_pr__nfet_01v8 ad=0 pd=0 as=0.1386 ps=1.5 w=0.42 l=0.15
X641 v3_four_channel_output_load_integration_0/v3_four_channel_shared_support_integration_0/v3_four_channel_bias_reference_distribution_0/v3_four_channel_phase_distribution_0/v3_four_channel_output_collection_0/v3_four_channel_placement_0/v3_channel_selector_late_promotion_1/v3_selector_route_pilot_0/G2_MUX_NEG/a_76_199# v3_four_channel_output_load_integration_0/v3_four_channel_shared_support_integration_0/v3_four_channel_bias_reference_distribution_0/v3_four_channel_phase_distribution_0/phase_180 v3_four_channel_output_load_integration_0/v3_four_channel_shared_support_integration_0/v3_four_channel_bias_reference_distribution_0/v3_four_channel_phase_distribution_0/v3_four_channel_output_collection_0/v3_four_channel_placement_0/v3_channel_selector_late_promotion_1/v3_selector_route_pilot_0/G2_MUX_NEG/a_218_374# VDPWR sky130_fd_pr__pfet_01v8_hvt ad=0.3864 pd=2.68 as=0 ps=0 w=0.42 l=0.15
X642 v3_four_channel_output_load_integration_0/v3_four_channel_shared_support_integration_0/v3_four_channel_bias_reference_distribution_0/v3_four_channel_phase_distribution_0/v3_four_channel_output_collection_0/v3_four_channel_placement_0/v3_channel_selector_late_promotion_1/v3_selector_route_pilot_0/G2_MUX_NEG/a_505_21# v3_four_channel_output_load_integration_0/v3_four_channel_shared_support_integration_0/v3_four_channel_bias_reference_distribution_0/v3_four_channel_phase_distribution_0/v3_four_channel_output_collection_0/v3_four_channel_placement_0/v3_channel_selector_late_promotion_1/group2_bit0 VGND VGND sky130_fd_pr__nfet_01v8 ad=0.1092 pd=1.36 as=0 ps=0 w=0.42 l=0.15
X643 v3_four_channel_output_load_integration_0/v3_four_channel_shared_support_integration_0/v3_four_channel_bias_reference_distribution_0/v3_four_channel_phase_distribution_0/v3_four_channel_output_collection_0/v3_four_channel_placement_0/v3_channel_selector_late_promotion_1/v3_selector_route_pilot_0/G2_MUX_NEG/a_439_47# v3_four_channel_output_load_integration_0/v3_four_channel_shared_support_integration_0/v3_four_channel_bias_reference_distribution_0/v3_four_channel_phase_distribution_0/phase_180 v3_four_channel_output_load_integration_0/v3_four_channel_shared_support_integration_0/v3_four_channel_bias_reference_distribution_0/v3_four_channel_phase_distribution_0/v3_four_channel_output_collection_0/v3_four_channel_placement_0/v3_channel_selector_late_promotion_1/v3_selector_route_pilot_0/G2_MUX_NEG/a_76_199# VGND sky130_fd_pr__nfet_01v8 ad=0 pd=0 as=0.1995 ps=1.79 w=0.42 l=0.15
X644 v3_four_channel_output_load_integration_0/v3_four_channel_shared_support_integration_0/v3_four_channel_bias_reference_distribution_0/v3_four_channel_phase_distribution_0/v3_four_channel_output_collection_0/v3_four_channel_placement_0/v3_channel_selector_late_promotion_1/v3_selector_route_pilot_0/G2_MUX_NEG/a_535_374# v3_four_channel_output_load_integration_0/v3_four_channel_shared_support_integration_0/v3_four_channel_bias_reference_distribution_0/v3_four_channel_phase_distribution_0/phase_270 v3_four_channel_output_load_integration_0/v3_four_channel_shared_support_integration_0/v3_four_channel_bias_reference_distribution_0/v3_four_channel_phase_distribution_0/v3_four_channel_output_collection_0/v3_four_channel_placement_0/v3_channel_selector_late_promotion_1/v3_selector_route_pilot_0/G2_MUX_NEG/a_76_199# VDPWR sky130_fd_pr__pfet_01v8_hvt ad=0 pd=0 as=0 ps=0 w=0.42 l=0.15
X645 v3_four_channel_output_load_integration_0/v3_four_channel_shared_support_integration_0/v3_four_channel_bias_reference_distribution_0/v3_four_channel_phase_distribution_0/v3_four_channel_output_collection_0/v3_four_channel_placement_0/v3_channel_selector_late_promotion_1/v3_selector_route_pilot_0/G2_MUX_NEG/a_76_199# v3_four_channel_output_load_integration_0/v3_four_channel_shared_support_integration_0/v3_four_channel_bias_reference_distribution_0/v3_four_channel_phase_distribution_0/phase_270 v3_four_channel_output_load_integration_0/v3_four_channel_shared_support_integration_0/v3_four_channel_bias_reference_distribution_0/v3_four_channel_phase_distribution_0/v3_four_channel_output_collection_0/v3_four_channel_placement_0/v3_channel_selector_late_promotion_1/v3_selector_route_pilot_0/G2_MUX_NEG/a_218_47# VGND sky130_fd_pr__nfet_01v8 ad=0 pd=0 as=0.1386 ps=1.5 w=0.42 l=0.15
X646 v3_four_channel_output_load_integration_0/v3_four_channel_shared_support_integration_0/v3_four_channel_bias_reference_distribution_0/v3_four_channel_phase_distribution_0/v3_four_channel_output_collection_0/v3_four_channel_placement_0/v3_channel_selector_late_promotion_1/v3_selector_route_pilot_0/G2_MUX_NEG/a_218_47# v3_four_channel_output_load_integration_0/v3_four_channel_shared_support_integration_0/v3_four_channel_bias_reference_distribution_0/v3_four_channel_phase_distribution_0/v3_four_channel_output_collection_0/v3_four_channel_placement_0/v3_channel_selector_late_promotion_1/group2_bit0 VGND VGND sky130_fd_pr__nfet_01v8 ad=0 pd=0 as=0 ps=0 w=0.42 l=0.15
X647 VDPWR v3_four_channel_output_load_integration_0/v3_four_channel_shared_support_integration_0/v3_four_channel_bias_reference_distribution_0/v3_four_channel_phase_distribution_0/v3_four_channel_output_collection_0/v3_four_channel_placement_0/v3_channel_selector_late_promotion_1/v3_selector_route_pilot_0/G2_MUX_NEG/a_76_199# v3_four_channel_output_load_integration_0/v3_four_channel_shared_support_integration_0/v3_four_channel_bias_reference_distribution_0/v3_four_channel_phase_distribution_0/v3_four_channel_output_collection_0/v3_four_channel_placement_0/v3_channel_selector_late_promotion_1/v3_selector_route_pilot_0/G2_MUX_NEG/X VDPWR sky130_fd_pr__pfet_01v8_hvt ad=0 pd=0 as=0.26 ps=2.52 w=1 l=0.15
X648 VGND v3_four_channel_output_load_integration_0/v3_four_channel_shared_support_integration_0/v3_four_channel_bias_reference_distribution_0/v3_four_channel_phase_distribution_0/v3_four_channel_output_collection_0/v3_four_channel_placement_0/v3_channel_selector_late_promotion_1/v3_selector_route_pilot_0/G2_MUX_NEG/a_76_199# v3_four_channel_output_load_integration_0/v3_four_channel_shared_support_integration_0/v3_four_channel_bias_reference_distribution_0/v3_four_channel_phase_distribution_0/v3_four_channel_output_collection_0/v3_four_channel_placement_0/v3_channel_selector_late_promotion_1/v3_selector_route_pilot_0/G2_MUX_NEG/X VGND sky130_fd_pr__nfet_01v8 ad=0 pd=0 as=0.169 ps=1.82 w=0.65 l=0.15
X649 VDPWR v3_four_channel_output_load_integration_0/v3_four_channel_shared_support_integration_0/v3_four_channel_bias_reference_distribution_0/v3_four_channel_phase_distribution_0/v3_four_channel_output_collection_0/v3_four_channel_placement_0/v3_channel_selector_late_promotion_1/v3_selector_route_pilot_0/G0_MUX_AXIS/a_505_21# v3_four_channel_output_load_integration_0/v3_four_channel_shared_support_integration_0/v3_four_channel_bias_reference_distribution_0/v3_four_channel_phase_distribution_0/v3_four_channel_output_collection_0/v3_four_channel_placement_0/v3_channel_selector_late_promotion_1/v3_selector_route_pilot_0/G0_MUX_AXIS/a_535_374# VDPWR sky130_fd_pr__pfet_01v8_hvt ad=0 pd=0 as=0.0882 ps=1.26 w=0.42 l=0.15
X650 v3_four_channel_output_load_integration_0/v3_four_channel_shared_support_integration_0/v3_four_channel_bias_reference_distribution_0/v3_four_channel_phase_distribution_0/v3_four_channel_output_collection_0/v3_four_channel_placement_0/v3_channel_selector_late_promotion_1/v3_selector_route_pilot_0/G0_MUX_AXIS/a_505_21# v3_four_channel_output_load_integration_0/v3_four_channel_shared_support_integration_0/v3_four_channel_bias_reference_distribution_0/v3_four_channel_phase_distribution_0/v3_four_channel_output_collection_0/v3_four_channel_placement_0/v3_channel_selector_late_promotion_1/group0_bit1 VDPWR VDPWR sky130_fd_pr__pfet_01v8_hvt ad=0.1176 pd=1.4 as=0 ps=0 w=0.42 l=0.15
X651 v3_four_channel_output_load_integration_0/v3_four_channel_shared_support_integration_0/v3_four_channel_bias_reference_distribution_0/v3_four_channel_phase_distribution_0/v3_four_channel_output_collection_0/v3_four_channel_placement_0/v3_channel_selector_late_promotion_1/v3_selector_route_pilot_0/G0_MUX_AXIS/a_218_374# v3_four_channel_output_load_integration_0/v3_four_channel_shared_support_integration_0/v3_four_channel_bias_reference_distribution_0/v3_four_channel_phase_distribution_0/v3_four_channel_output_collection_0/v3_four_channel_placement_0/v3_channel_selector_late_promotion_1/group0_bit1 VDPWR VDPWR sky130_fd_pr__pfet_01v8_hvt ad=0.1533 pd=1.57 as=0 ps=0 w=0.42 l=0.15
X652 VGND v3_four_channel_output_load_integration_0/v3_four_channel_shared_support_integration_0/v3_four_channel_bias_reference_distribution_0/v3_four_channel_phase_distribution_0/v3_four_channel_output_collection_0/v3_four_channel_placement_0/v3_channel_selector_late_promotion_1/v3_selector_route_pilot_0/G0_MUX_AXIS/a_505_21# v3_four_channel_output_load_integration_0/v3_four_channel_shared_support_integration_0/v3_four_channel_bias_reference_distribution_0/v3_four_channel_phase_distribution_0/v3_four_channel_output_collection_0/v3_four_channel_placement_0/v3_channel_selector_late_promotion_1/v3_selector_route_pilot_0/G0_MUX_AXIS/a_439_47# VGND sky130_fd_pr__nfet_01v8 ad=0 pd=0 as=0.1386 ps=1.5 w=0.42 l=0.15
X653 v3_four_channel_output_load_integration_0/v3_four_channel_shared_support_integration_0/v3_four_channel_bias_reference_distribution_0/v3_four_channel_phase_distribution_0/v3_four_channel_output_collection_0/v3_four_channel_placement_0/v3_channel_selector_late_promotion_1/v3_selector_route_pilot_0/G0_MUX_AXIS/a_76_199# v3_four_channel_output_load_integration_0/v3_four_channel_shared_support_integration_0/v3_four_channel_bias_reference_distribution_0/v3_four_channel_phase_distribution_0/v3_four_channel_output_collection_0/v3_four_channel_placement_0/v3_channel_selector_late_promotion_1/v3_selector_route_pilot_0/G0_MUX_POS/X v3_four_channel_output_load_integration_0/v3_four_channel_shared_support_integration_0/v3_four_channel_bias_reference_distribution_0/v3_four_channel_phase_distribution_0/v3_four_channel_output_collection_0/v3_four_channel_placement_0/v3_channel_selector_late_promotion_1/v3_selector_route_pilot_0/G0_MUX_AXIS/a_218_374# VDPWR sky130_fd_pr__pfet_01v8_hvt ad=0.3864 pd=2.68 as=0 ps=0 w=0.42 l=0.15
X654 v3_four_channel_output_load_integration_0/v3_four_channel_shared_support_integration_0/v3_four_channel_bias_reference_distribution_0/v3_four_channel_phase_distribution_0/v3_four_channel_output_collection_0/v3_four_channel_placement_0/v3_channel_selector_late_promotion_1/v3_selector_route_pilot_0/G0_MUX_AXIS/a_505_21# v3_four_channel_output_load_integration_0/v3_four_channel_shared_support_integration_0/v3_four_channel_bias_reference_distribution_0/v3_four_channel_phase_distribution_0/v3_four_channel_output_collection_0/v3_four_channel_placement_0/v3_channel_selector_late_promotion_1/group0_bit1 VGND VGND sky130_fd_pr__nfet_01v8 ad=0.1092 pd=1.36 as=0 ps=0 w=0.42 l=0.15
X655 v3_four_channel_output_load_integration_0/v3_four_channel_shared_support_integration_0/v3_four_channel_bias_reference_distribution_0/v3_four_channel_phase_distribution_0/v3_four_channel_output_collection_0/v3_four_channel_placement_0/v3_channel_selector_late_promotion_1/v3_selector_route_pilot_0/G0_MUX_AXIS/a_439_47# v3_four_channel_output_load_integration_0/v3_four_channel_shared_support_integration_0/v3_four_channel_bias_reference_distribution_0/v3_four_channel_phase_distribution_0/v3_four_channel_output_collection_0/v3_four_channel_placement_0/v3_channel_selector_late_promotion_1/v3_selector_route_pilot_0/G0_MUX_POS/X v3_four_channel_output_load_integration_0/v3_four_channel_shared_support_integration_0/v3_four_channel_bias_reference_distribution_0/v3_four_channel_phase_distribution_0/v3_four_channel_output_collection_0/v3_four_channel_placement_0/v3_channel_selector_late_promotion_1/v3_selector_route_pilot_0/G0_MUX_AXIS/a_76_199# VGND sky130_fd_pr__nfet_01v8 ad=0 pd=0 as=0.1995 ps=1.79 w=0.42 l=0.15
X656 v3_four_channel_output_load_integration_0/v3_four_channel_shared_support_integration_0/v3_four_channel_bias_reference_distribution_0/v3_four_channel_phase_distribution_0/v3_four_channel_output_collection_0/v3_four_channel_placement_0/v3_channel_selector_late_promotion_1/v3_selector_route_pilot_0/G0_MUX_AXIS/a_535_374# v3_four_channel_output_load_integration_0/v3_four_channel_shared_support_integration_0/v3_four_channel_bias_reference_distribution_0/v3_four_channel_phase_distribution_0/v3_four_channel_output_collection_0/v3_four_channel_placement_0/v3_channel_selector_late_promotion_1/v3_selector_route_pilot_0/G0_MUX_NEG/X v3_four_channel_output_load_integration_0/v3_four_channel_shared_support_integration_0/v3_four_channel_bias_reference_distribution_0/v3_four_channel_phase_distribution_0/v3_four_channel_output_collection_0/v3_four_channel_placement_0/v3_channel_selector_late_promotion_1/v3_selector_route_pilot_0/G0_MUX_AXIS/a_76_199# VDPWR sky130_fd_pr__pfet_01v8_hvt ad=0 pd=0 as=0 ps=0 w=0.42 l=0.15
X657 v3_four_channel_output_load_integration_0/v3_four_channel_shared_support_integration_0/v3_four_channel_bias_reference_distribution_0/v3_four_channel_phase_distribution_0/v3_four_channel_output_collection_0/v3_four_channel_placement_0/v3_channel_selector_late_promotion_1/v3_selector_route_pilot_0/G0_MUX_AXIS/a_76_199# v3_four_channel_output_load_integration_0/v3_four_channel_shared_support_integration_0/v3_four_channel_bias_reference_distribution_0/v3_four_channel_phase_distribution_0/v3_four_channel_output_collection_0/v3_four_channel_placement_0/v3_channel_selector_late_promotion_1/v3_selector_route_pilot_0/G0_MUX_NEG/X v3_four_channel_output_load_integration_0/v3_four_channel_shared_support_integration_0/v3_four_channel_bias_reference_distribution_0/v3_four_channel_phase_distribution_0/v3_four_channel_output_collection_0/v3_four_channel_placement_0/v3_channel_selector_late_promotion_1/v3_selector_route_pilot_0/G0_MUX_AXIS/a_218_47# VGND sky130_fd_pr__nfet_01v8 ad=0 pd=0 as=0.1386 ps=1.5 w=0.42 l=0.15
X658 v3_four_channel_output_load_integration_0/v3_four_channel_shared_support_integration_0/v3_four_channel_bias_reference_distribution_0/v3_four_channel_phase_distribution_0/v3_four_channel_output_collection_0/v3_four_channel_placement_0/v3_channel_selector_late_promotion_1/v3_selector_route_pilot_0/G0_MUX_AXIS/a_218_47# v3_four_channel_output_load_integration_0/v3_four_channel_shared_support_integration_0/v3_four_channel_bias_reference_distribution_0/v3_four_channel_phase_distribution_0/v3_four_channel_output_collection_0/v3_four_channel_placement_0/v3_channel_selector_late_promotion_1/group0_bit1 VGND VGND sky130_fd_pr__nfet_01v8 ad=0 pd=0 as=0 ps=0 w=0.42 l=0.15
X659 VDPWR v3_four_channel_output_load_integration_0/v3_four_channel_shared_support_integration_0/v3_four_channel_bias_reference_distribution_0/v3_four_channel_phase_distribution_0/v3_four_channel_output_collection_0/v3_four_channel_placement_0/v3_channel_selector_late_promotion_1/v3_selector_route_pilot_0/G0_MUX_AXIS/a_76_199# v3_four_channel_output_load_integration_0/v3_four_channel_shared_support_integration_0/v3_four_channel_bias_reference_distribution_0/v3_four_channel_phase_distribution_0/v3_four_channel_output_collection_0/v3_four_channel_placement_0/v3_channel_selector_late_promotion_1/v3_selector_route_pilot_0/G0_MUX_AXIS/X VDPWR sky130_fd_pr__pfet_01v8_hvt ad=0 pd=0 as=0.26 ps=2.52 w=1 l=0.15
X660 VGND v3_four_channel_output_load_integration_0/v3_four_channel_shared_support_integration_0/v3_four_channel_bias_reference_distribution_0/v3_four_channel_phase_distribution_0/v3_four_channel_output_collection_0/v3_four_channel_placement_0/v3_channel_selector_late_promotion_1/v3_selector_route_pilot_0/G0_MUX_AXIS/a_76_199# v3_four_channel_output_load_integration_0/v3_four_channel_shared_support_integration_0/v3_four_channel_bias_reference_distribution_0/v3_four_channel_phase_distribution_0/v3_four_channel_output_collection_0/v3_four_channel_placement_0/v3_channel_selector_late_promotion_1/v3_selector_route_pilot_0/G0_MUX_AXIS/X VGND sky130_fd_pr__nfet_01v8 ad=0 pd=0 as=0.169 ps=1.82 w=0.65 l=0.15
X661 VDPWR v3_four_channel_output_load_integration_0/v3_four_channel_shared_support_integration_0/v3_four_channel_bias_reference_distribution_0/v3_four_channel_phase_distribution_0/v3_four_channel_output_collection_0/v3_four_channel_placement_0/v3_channel_selector_late_promotion_1/v3_selector_route_pilot_0/G3_LO_P_AND/B v3_four_channel_output_load_integration_0/v3_four_channel_shared_support_integration_0/v3_four_channel_bias_reference_distribution_0/v3_four_channel_phase_distribution_0/v3_four_channel_output_collection_0/v3_four_channel_placement_0/v3_channel_selector_late_promotion_1/v3_selector_route_pilot_0/G2_LO_P_AND/a_59_75# VDPWR sky130_fd_pr__pfet_01v8_hvt ad=0 pd=0 as=0.1134 ps=1.38 w=0.42 l=0.15
X662 v3_four_channel_output_load_integration_0/v3_four_channel_shared_support_integration_0/v3_four_channel_bias_reference_distribution_0/v3_four_channel_phase_distribution_0/v3_four_channel_output_collection_0/v3_four_channel_placement_0/v3_channel_selector_late_promotion_1/v3_selector_route_pilot_0/group2_lo_p v3_four_channel_output_load_integration_0/v3_four_channel_shared_support_integration_0/v3_four_channel_bias_reference_distribution_0/v3_four_channel_phase_distribution_0/v3_four_channel_output_collection_0/v3_four_channel_placement_0/v3_channel_selector_late_promotion_1/v3_selector_route_pilot_0/G2_LO_P_AND/a_59_75# VDPWR VDPWR sky130_fd_pr__pfet_01v8_hvt ad=0.475 pd=2.95 as=0 ps=0 w=1 l=0.15
X663 VGND v3_four_channel_output_load_integration_0/v3_four_channel_shared_support_integration_0/v3_four_channel_bias_reference_distribution_0/v3_four_channel_phase_distribution_0/v3_four_channel_output_collection_0/v3_four_channel_placement_0/v3_channel_selector_late_promotion_1/v3_selector_route_pilot_0/G3_LO_P_AND/B v3_four_channel_output_load_integration_0/v3_four_channel_shared_support_integration_0/v3_four_channel_bias_reference_distribution_0/v3_four_channel_phase_distribution_0/v3_four_channel_output_collection_0/v3_four_channel_placement_0/v3_channel_selector_late_promotion_1/v3_selector_route_pilot_0/G2_LO_P_AND/a_145_75# VGND sky130_fd_pr__nfet_01v8 ad=0 pd=0 as=0.1134 ps=1.38 w=0.42 l=0.15
X664 v3_four_channel_output_load_integration_0/v3_four_channel_shared_support_integration_0/v3_four_channel_bias_reference_distribution_0/v3_four_channel_phase_distribution_0/v3_four_channel_output_collection_0/v3_four_channel_placement_0/v3_channel_selector_late_promotion_1/v3_selector_route_pilot_0/G2_LO_P_AND/a_59_75# v3_four_channel_output_load_integration_0/v3_four_channel_shared_support_integration_0/v3_four_channel_bias_reference_distribution_0/v3_four_channel_phase_distribution_0/v3_four_channel_output_collection_0/v3_four_channel_placement_0/v3_channel_selector_late_promotion_1/v3_selector_route_pilot_0/G2_MUX_AXIS/X VDPWR VDPWR sky130_fd_pr__pfet_01v8_hvt ad=0 pd=0 as=0 ps=0 w=0.42 l=0.15
X665 v3_four_channel_output_load_integration_0/v3_four_channel_shared_support_integration_0/v3_four_channel_bias_reference_distribution_0/v3_four_channel_phase_distribution_0/v3_four_channel_output_collection_0/v3_four_channel_placement_0/v3_channel_selector_late_promotion_1/v3_selector_route_pilot_0/group2_lo_p v3_four_channel_output_load_integration_0/v3_four_channel_shared_support_integration_0/v3_four_channel_bias_reference_distribution_0/v3_four_channel_phase_distribution_0/v3_four_channel_output_collection_0/v3_four_channel_placement_0/v3_channel_selector_late_promotion_1/v3_selector_route_pilot_0/G2_LO_P_AND/a_59_75# VGND VGND sky130_fd_pr__nfet_01v8 ad=0.182 pd=1.86 as=0 ps=0 w=0.65 l=0.15
X666 v3_four_channel_output_load_integration_0/v3_four_channel_shared_support_integration_0/v3_four_channel_bias_reference_distribution_0/v3_four_channel_phase_distribution_0/v3_four_channel_output_collection_0/v3_four_channel_placement_0/v3_channel_selector_late_promotion_1/v3_selector_route_pilot_0/G2_LO_P_AND/a_145_75# v3_four_channel_output_load_integration_0/v3_four_channel_shared_support_integration_0/v3_four_channel_bias_reference_distribution_0/v3_four_channel_phase_distribution_0/v3_four_channel_output_collection_0/v3_four_channel_placement_0/v3_channel_selector_late_promotion_1/v3_selector_route_pilot_0/G2_MUX_AXIS/X v3_four_channel_output_load_integration_0/v3_four_channel_shared_support_integration_0/v3_four_channel_bias_reference_distribution_0/v3_four_channel_phase_distribution_0/v3_four_channel_output_collection_0/v3_four_channel_placement_0/v3_channel_selector_late_promotion_1/v3_selector_route_pilot_0/G2_LO_P_AND/a_59_75# VGND sky130_fd_pr__nfet_01v8 ad=0 pd=0 as=0.1176 ps=1.4 w=0.42 l=0.15
X667 v3_four_channel_output_load_integration_0/v3_four_channel_shared_support_integration_0/v3_four_channel_bias_reference_distribution_0/v3_four_channel_phase_distribution_0/v3_four_channel_output_collection_0/v3_four_channel_placement_0/v3_channel_selector_late_promotion_2/v3_channel_input_bias_late_promotion_0/a_4678_23422# v3_four_channel_output_load_integration_0/v3_four_channel_shared_support_integration_0/v3_four_channel_bias_reference_distribution_0/v3_four_channel_phase_distribution_0/v3_four_channel_output_collection_0/v3_four_channel_placement_0/v3_channel_selector_late_promotion_2/v3_selector_route_pilot_0/group3_lo_p v3_four_channel_output_load_integration_0/combined_n VGND sky130_fd_pr__nfet_01v8 ad=0.6206 pd=6.02 as=0 ps=0 w=0.65 l=0.15
X668 v3_four_channel_output_load_integration_0/combined_n v3_four_channel_output_load_integration_0/v3_four_channel_shared_support_integration_0/v3_four_channel_bias_reference_distribution_0/v3_four_channel_phase_distribution_0/v3_four_channel_output_collection_0/v3_four_channel_placement_0/v3_channel_selector_late_promotion_2/v3_selector_route_pilot_0/group3_lo_p v3_four_channel_output_load_integration_0/v3_four_channel_shared_support_integration_0/v3_four_channel_bias_reference_distribution_0/v3_four_channel_phase_distribution_0/v3_four_channel_output_collection_0/v3_four_channel_placement_0/v3_channel_selector_late_promotion_2/v3_channel_input_bias_late_promotion_0/a_4254_6978# VGND sky130_fd_pr__nfet_01v8 ad=0 pd=0 as=0.6206 ps=6.02 w=0.65 l=0.15
X669 v3_four_channel_output_load_integration_0/v3_four_channel_shared_support_integration_0/v3_four_channel_bias_reference_distribution_0/v3_four_channel_phase_distribution_0/v3_four_channel_output_collection_0/v3_four_channel_placement_0/v3_channel_selector_late_promotion_2/v3_channel_input_bias_late_promotion_0/a_4678_23422# v3_four_channel_output_load_integration_0/v3_four_channel_shared_support_integration_0/v3_vcm_support_block_0/ref v3_four_channel_output_load_integration_0/v3_four_channel_shared_support_integration_0/v3_four_channel_bias_reference_distribution_0/v3_four_channel_phase_distribution_0/v3_four_channel_output_collection_0/v3_four_channel_placement_0/v3_channel_selector_late_promotion_2/v3_channel_input_bias_late_promotion_0/a_4382_21688# VGND sky130_fd_pr__nfet_01v8 ad=0 pd=0 as=1.9575 ps=15.24 w=0.84 l=0.6
X670 v3_four_channel_output_load_integration_0/combined_n v3_four_channel_output_load_integration_0/v3_four_channel_shared_support_integration_0/v3_four_channel_bias_reference_distribution_0/v3_four_channel_phase_distribution_0/v3_four_channel_output_collection_0/v3_four_channel_placement_0/v3_channel_selector_late_promotion_2/v3_selector_route_pilot_0/group3_lo_n v3_four_channel_output_load_integration_0/v3_four_channel_shared_support_integration_0/v3_four_channel_bias_reference_distribution_0/v3_four_channel_phase_distribution_0/v3_four_channel_output_collection_0/v3_four_channel_placement_0/v3_channel_selector_late_promotion_2/v3_channel_input_bias_late_promotion_0/a_7038_22978# VGND sky130_fd_pr__nfet_01v8 ad=0 pd=0 as=0.6206 ps=6.02 w=0.65 l=0.15
X671 v3_four_channel_output_load_integration_0/combined_n v3_four_channel_output_load_integration_0/v3_four_channel_shared_support_integration_0/v3_four_channel_bias_reference_distribution_0/v3_four_channel_phase_distribution_0/v3_four_channel_output_collection_0/v3_four_channel_placement_0/v3_channel_selector_late_promotion_2/v3_selector_route_pilot_0/group3_lo_p v3_four_channel_output_load_integration_0/v3_four_channel_shared_support_integration_0/v3_four_channel_bias_reference_distribution_0/v3_four_channel_phase_distribution_0/v3_four_channel_output_collection_0/v3_four_channel_placement_0/v3_channel_selector_late_promotion_2/v3_channel_input_bias_late_promotion_0/a_7038_6978# VGND sky130_fd_pr__nfet_01v8 ad=0 pd=0 as=0.6206 ps=6.02 w=0.65 l=0.15
X672 v3_four_channel_output_load_integration_0/v3_four_channel_shared_support_integration_0/v3_four_channel_bias_reference_distribution_0/v3_four_channel_phase_distribution_0/v3_four_channel_output_collection_0/v3_four_channel_placement_0/v3_channel_selector_late_promotion_2/v3_channel_input_bias_late_promotion_0/a_7462_11422# v3_four_channel_output_load_integration_0/v3_four_channel_shared_support_integration_0/v3_four_channel_bias_reference_distribution_0/v3_four_channel_phase_distribution_0/v3_four_channel_output_collection_0/v3_four_channel_placement_0/v3_channel_selector_late_promotion_2/element_input v3_four_channel_output_load_integration_0/v3_four_channel_shared_support_integration_0/v3_four_channel_bias_reference_distribution_0/v3_four_channel_phase_distribution_0/v3_four_channel_output_collection_0/v3_four_channel_placement_0/v3_channel_selector_late_promotion_2/v3_channel_input_bias_late_promotion_0/a_7216_10978# VGND sky130_fd_pr__nfet_01v8 ad=0.6206 pd=6.02 as=1.9575 ps=15.24 w=0.84 l=0.6
X673 v3_four_channel_output_load_integration_0/v3_four_channel_shared_support_integration_0/v3_four_channel_bias_reference_distribution_0/v3_four_channel_phase_distribution_0/v3_four_channel_output_collection_0/v3_four_channel_placement_0/v3_channel_selector_late_promotion_2/v3_channel_input_bias_late_promotion_0/a_7462_11422# v3_four_channel_output_load_integration_0/v3_four_channel_shared_support_integration_0/v3_four_channel_bias_reference_distribution_0/v3_four_channel_phase_distribution_0/v3_four_channel_output_collection_0/v3_four_channel_placement_0/v3_channel_selector_late_promotion_2/v3_selector_route_pilot_0/group2_lo_n v3_four_channel_output_load_integration_0/combined_n VGND sky130_fd_pr__nfet_01v8 ad=0 pd=0 as=0 ps=0 w=0.65 l=0.15
X674 v3_four_channel_output_load_integration_0/v3_four_channel_shared_support_integration_0/v3_four_channel_bias_reference_distribution_0/v3_four_channel_phase_distribution_0/v3_four_channel_output_collection_0/v3_four_channel_placement_0/v3_channel_selector_late_promotion_2/v3_channel_input_bias_late_promotion_0/a_5774_21688# v3_four_channel_output_load_integration_0/v3_four_channel_shared_support_integration_0/v3_four_channel_bias_reference_distribution_0/v3_four_channel_phase_distribution_0/v3_four_channel_output_collection_0/v3_four_channel_placement_0/v3_channel_selector_late_promotion_2/element_input v3_four_channel_output_load_integration_0/v3_four_channel_shared_support_integration_0/v3_four_channel_bias_reference_distribution_0/v3_four_channel_phase_distribution_0/v3_four_channel_output_collection_0/v3_four_channel_placement_0/v3_channel_selector_late_promotion_2/v3_channel_input_bias_late_promotion_0/a_5646_22978# VGND sky130_fd_pr__nfet_01v8 ad=1.9575 pd=15.24 as=0.6206 ps=6.02 w=0.84 l=0.6
X675 VGND v3_four_channel_output_load_integration_0/v3_four_channel_shared_support_integration_0/v3_tail_bias_support_block_0/vbias v3_four_channel_output_load_integration_0/v3_four_channel_shared_support_integration_0/v3_four_channel_bias_reference_distribution_0/v3_four_channel_phase_distribution_0/v3_four_channel_output_collection_0/v3_four_channel_placement_0/v3_channel_selector_late_promotion_2/v3_channel_input_bias_late_promotion_0/a_5774_17688# VGND sky130_fd_pr__nfet_01v8 ad=0 pd=0 as=1.9575 ps=15.24 w=5.07 l=1
X676 v3_four_channel_output_load_integration_0/v3_four_channel_shared_support_integration_0/v3_four_channel_bias_reference_distribution_0/v3_four_channel_phase_distribution_0/v3_four_channel_output_collection_0/v3_four_channel_placement_0/v3_channel_selector_late_promotion_2/v3_channel_input_bias_late_promotion_0/a_6070_7422# v3_four_channel_output_load_integration_0/v3_four_channel_shared_support_integration_0/v3_four_channel_bias_reference_distribution_0/v3_four_channel_phase_distribution_0/v3_four_channel_output_collection_0/v3_four_channel_placement_0/v3_channel_selector_late_promotion_2/element_input v3_four_channel_output_load_integration_0/v3_four_channel_shared_support_integration_0/v3_four_channel_bias_reference_distribution_0/v3_four_channel_phase_distribution_0/v3_four_channel_output_collection_0/v3_four_channel_placement_0/v3_channel_selector_late_promotion_2/v3_channel_input_bias_late_promotion_0/a_5824_6978# VGND sky130_fd_pr__nfet_01v8 ad=0.6206 pd=6.02 as=1.9575 ps=15.24 w=0.84 l=0.6
X677 v3_four_channel_output_load_integration_0/v3_four_channel_shared_support_integration_0/v3_four_channel_bias_reference_distribution_0/v3_four_channel_phase_distribution_0/v3_four_channel_output_collection_0/v3_four_channel_placement_0/v3_channel_selector_late_promotion_2/v3_channel_input_bias_late_promotion_0/a_6070_7422# v3_four_channel_output_load_integration_0/v3_four_channel_shared_support_integration_0/v3_four_channel_bias_reference_distribution_0/v3_four_channel_phase_distribution_0/v3_four_channel_output_collection_0/v3_four_channel_placement_0/v3_channel_selector_late_promotion_2/v3_selector_route_pilot_0/group3_lo_n v3_four_channel_output_load_integration_0/combined_n VGND sky130_fd_pr__nfet_01v8 ad=0 pd=0 as=0 ps=0 w=0.65 l=0.15
X678 v3_four_channel_output_load_integration_0/v3_four_channel_shared_support_integration_0/v3_vcm_support_block_0/ref v3_four_channel_output_load_integration_0/v3_four_channel_shared_support_integration_0/v3_four_channel_bias_reference_distribution_0/v3_four_channel_phase_distribution_0/v3_four_channel_output_collection_0/v3_four_channel_placement_0/v3_channel_selector_late_promotion_2/element_input VGND sky130_fd_pr__res_xhigh_po_0p35 l=17.36
X679 v3_four_channel_output_load_integration_0/v3_four_channel_shared_support_integration_0/v3_four_channel_bias_reference_distribution_0/v3_four_channel_phase_distribution_0/v3_four_channel_output_collection_0/v3_four_channel_placement_0/v3_channel_selector_late_promotion_2/v3_channel_input_bias_late_promotion_0/a_7462_23422# v3_four_channel_output_load_integration_0/v3_four_channel_shared_support_integration_0/v3_vcm_support_block_0/ref v3_four_channel_output_load_integration_0/v3_four_channel_shared_support_integration_0/v3_four_channel_bias_reference_distribution_0/v3_four_channel_phase_distribution_0/v3_four_channel_output_collection_0/v3_four_channel_placement_0/v3_channel_selector_late_promotion_2/v3_channel_input_bias_late_promotion_0/a_7166_21688# VGND sky130_fd_pr__nfet_01v8 ad=0.6206 pd=6.02 as=1.9575 ps=15.24 w=0.84 l=0.6
X680 v3_four_channel_output_load_integration_0/v3_four_channel_shared_support_integration_0/v3_four_channel_bias_reference_distribution_0/v3_four_channel_phase_distribution_0/v3_four_channel_output_collection_0/v3_four_channel_placement_0/v3_channel_selector_late_promotion_2/v3_channel_input_bias_late_promotion_0/a_7462_23422# v3_four_channel_output_load_integration_0/v3_four_channel_shared_support_integration_0/v3_four_channel_bias_reference_distribution_0/v3_four_channel_phase_distribution_0/v3_four_channel_output_collection_0/v3_four_channel_placement_0/v3_channel_selector_late_promotion_2/v3_selector_route_pilot_0/group3_lo_p v3_four_channel_output_load_integration_0/combined_n VGND sky130_fd_pr__nfet_01v8 ad=0 pd=0 as=0 ps=0 w=0.65 l=0.15
X681 VGND v3_four_channel_output_load_integration_0/v3_four_channel_shared_support_integration_0/v3_tail_bias_support_block_0/vbias v3_four_channel_output_load_integration_0/v3_four_channel_shared_support_integration_0/v3_four_channel_bias_reference_distribution_0/v3_four_channel_phase_distribution_0/v3_four_channel_output_collection_0/v3_four_channel_placement_0/v3_channel_selector_late_promotion_2/v3_channel_input_bias_late_promotion_0/a_4382_21688# VGND sky130_fd_pr__nfet_01v8 ad=0 pd=0 as=0 ps=0 w=5.07 l=1
X682 VGND v3_four_channel_output_load_integration_0/v3_four_channel_shared_support_integration_0/v3_tail_bias_support_block_0/vbias v3_four_channel_output_load_integration_0/v3_four_channel_shared_support_integration_0/v3_four_channel_bias_reference_distribution_0/v3_four_channel_phase_distribution_0/v3_four_channel_output_collection_0/v3_four_channel_placement_0/v3_channel_selector_late_promotion_2/v3_channel_input_bias_late_promotion_0/a_5774_13688# VGND sky130_fd_pr__nfet_01v8 ad=0 pd=0 as=1.9575 ps=15.24 w=5.07 l=1
X683 VGND v3_four_channel_output_load_integration_0/v3_four_channel_shared_support_integration_0/v3_tail_bias_support_block_0/vbias v3_four_channel_output_load_integration_0/v3_four_channel_shared_support_integration_0/v3_four_channel_bias_reference_distribution_0/v3_four_channel_phase_distribution_0/v3_four_channel_output_collection_0/v3_four_channel_placement_0/v3_channel_selector_late_promotion_2/v3_channel_input_bias_late_promotion_0/a_7166_17688# VGND sky130_fd_pr__nfet_01v8 ad=0 pd=0 as=1.9575 ps=15.24 w=5.07 l=1
X684 VGND VGND VGND VGND sky130_fd_pr__nfet_01v8 ad=0 pd=0 as=0 ps=0 w=0.65 l=0.15
X685 v3_four_channel_output_load_integration_0/combined_p v3_four_channel_output_load_integration_0/v3_four_channel_shared_support_integration_0/v3_four_channel_bias_reference_distribution_0/v3_four_channel_phase_distribution_0/v3_four_channel_output_collection_0/v3_four_channel_placement_0/v3_channel_selector_late_promotion_2/v3_selector_route_pilot_0/group3_lo_p v3_four_channel_output_load_integration_0/v3_four_channel_shared_support_integration_0/v3_four_channel_bias_reference_distribution_0/v3_four_channel_phase_distribution_0/v3_four_channel_output_collection_0/v3_four_channel_placement_0/v3_channel_selector_late_promotion_2/v3_channel_input_bias_late_promotion_0/a_5646_18978# VGND sky130_fd_pr__nfet_01v8 ad=0 pd=0 as=0.6206 ps=6.02 w=0.65 l=0.15
X686 VGND VGND VGND VGND sky130_fd_pr__nfet_01v8 ad=0 pd=0 as=0 ps=0 w=0.65 l=0.15
X687 v3_four_channel_output_load_integration_0/v3_four_channel_shared_support_integration_0/v3_four_channel_bias_reference_distribution_0/v3_four_channel_phase_distribution_0/v3_four_channel_output_collection_0/v3_four_channel_placement_0/v3_channel_selector_late_promotion_2/v3_channel_input_bias_late_promotion_0/a_6070_19422# v3_four_channel_output_load_integration_0/v3_four_channel_shared_support_integration_0/v3_four_channel_bias_reference_distribution_0/v3_four_channel_phase_distribution_0/v3_four_channel_output_collection_0/v3_four_channel_placement_0/v3_channel_selector_late_promotion_2/v3_selector_route_pilot_0/group3_lo_n v3_four_channel_output_load_integration_0/combined_p VGND sky130_fd_pr__nfet_01v8 ad=0.6206 pd=6.02 as=0 ps=0 w=0.65 l=0.15
X688 VGND VGND VGND VGND sky130_fd_pr__nfet_01v8 ad=0 pd=0 as=0 ps=0 w=0.65 l=0.15
X689 v3_four_channel_output_load_integration_0/combined_p v3_four_channel_output_load_integration_0/v3_four_channel_shared_support_integration_0/v3_four_channel_bias_reference_distribution_0/v3_four_channel_phase_distribution_0/v3_four_channel_output_collection_0/v3_four_channel_placement_0/v3_channel_selector_late_promotion_2/v3_selector_route_pilot_0/group2_lo_p v3_four_channel_output_load_integration_0/v3_four_channel_shared_support_integration_0/v3_four_channel_bias_reference_distribution_0/v3_four_channel_phase_distribution_0/v3_four_channel_output_collection_0/v3_four_channel_placement_0/v3_channel_selector_late_promotion_2/v3_channel_input_bias_late_promotion_0/a_4254_18978# VGND sky130_fd_pr__nfet_01v8 ad=0 pd=0 as=0.6206 ps=6.02 w=0.65 l=0.15
X690 v3_four_channel_output_load_integration_0/v3_four_channel_shared_support_integration_0/v3_four_channel_bias_reference_distribution_0/v3_four_channel_phase_distribution_0/v3_four_channel_output_collection_0/v3_four_channel_placement_0/v3_channel_selector_late_promotion_2/v3_channel_input_bias_late_promotion_0/a_7216_14978# v3_four_channel_output_load_integration_0/v3_four_channel_shared_support_integration_0/v3_tail_bias_support_block_0/vbias VGND VGND sky130_fd_pr__nfet_01v8 ad=1.9575 pd=15.24 as=0 ps=0 w=5.07 l=1
X691 VGND VGND VGND VGND sky130_fd_pr__nfet_01v8 ad=0 pd=0 as=0 ps=0 w=0.65 l=0.15
X692 VGND VGND VGND VGND sky130_fd_pr__nfet_01v8 ad=0 pd=0 as=0 ps=0 w=0.65 l=0.15
X693 v3_four_channel_output_load_integration_0/v3_four_channel_shared_support_integration_0/v3_four_channel_bias_reference_distribution_0/v3_four_channel_phase_distribution_0/v3_four_channel_output_collection_0/v3_four_channel_placement_0/v3_channel_selector_late_promotion_2/v3_channel_input_bias_late_promotion_0/a_4382_17688# v3_four_channel_output_load_integration_0/v3_four_channel_shared_support_integration_0/v3_four_channel_bias_reference_distribution_0/v3_four_channel_phase_distribution_0/v3_four_channel_output_collection_0/v3_four_channel_placement_0/v3_channel_selector_late_promotion_2/element_input v3_four_channel_output_load_integration_0/v3_four_channel_shared_support_integration_0/v3_four_channel_bias_reference_distribution_0/v3_four_channel_phase_distribution_0/v3_four_channel_output_collection_0/v3_four_channel_placement_0/v3_channel_selector_late_promotion_2/v3_channel_input_bias_late_promotion_0/a_4254_18978# VGND sky130_fd_pr__nfet_01v8 ad=1.9575 pd=15.24 as=0 ps=0 w=0.84 l=0.6
X694 v3_four_channel_output_load_integration_0/v3_four_channel_shared_support_integration_0/v3_four_channel_bias_reference_distribution_0/v3_four_channel_phase_distribution_0/v3_four_channel_output_collection_0/v3_four_channel_placement_0/v3_channel_selector_late_promotion_2/v3_channel_input_bias_late_promotion_0/a_4678_19422# v3_four_channel_output_load_integration_0/v3_four_channel_shared_support_integration_0/v3_four_channel_bias_reference_distribution_0/v3_four_channel_phase_distribution_0/v3_four_channel_output_collection_0/v3_four_channel_placement_0/v3_channel_selector_late_promotion_2/v3_selector_route_pilot_0/group2_lo_n v3_four_channel_output_load_integration_0/combined_p VGND sky130_fd_pr__nfet_01v8 ad=0.6206 pd=6.02 as=0 ps=0 w=0.65 l=0.15
X695 v3_four_channel_output_load_integration_0/combined_p v3_four_channel_output_load_integration_0/v3_four_channel_shared_support_integration_0/v3_four_channel_bias_reference_distribution_0/v3_four_channel_phase_distribution_0/v3_four_channel_output_collection_0/v3_four_channel_placement_0/v3_channel_selector_late_promotion_2/v3_selector_route_pilot_0/group0_lo_p v3_four_channel_output_load_integration_0/v3_four_channel_shared_support_integration_0/v3_four_channel_bias_reference_distribution_0/v3_four_channel_phase_distribution_0/v3_four_channel_output_collection_0/v3_four_channel_placement_0/v3_channel_selector_late_promotion_2/v3_channel_input_bias_late_promotion_0/a_5646_14978# VGND sky130_fd_pr__nfet_01v8 ad=0 pd=0 as=0.6206 ps=6.02 w=0.65 l=0.15
X696 v3_four_channel_output_load_integration_0/combined_p v3_four_channel_output_load_integration_0/v3_four_channel_shared_support_integration_0/v3_four_channel_bias_reference_distribution_0/v3_four_channel_phase_distribution_0/v3_four_channel_output_collection_0/v3_four_channel_placement_0/v3_channel_selector_late_promotion_2/v3_selector_route_pilot_0/group2_lo_p v3_four_channel_output_load_integration_0/v3_four_channel_shared_support_integration_0/v3_four_channel_bias_reference_distribution_0/v3_four_channel_phase_distribution_0/v3_four_channel_output_collection_0/v3_four_channel_placement_0/v3_channel_selector_late_promotion_2/v3_channel_input_bias_late_promotion_0/a_7038_18978# VGND sky130_fd_pr__nfet_01v8 ad=0 pd=0 as=0.6206 ps=6.02 w=0.65 l=0.15
X697 VGND VGND VGND VGND sky130_fd_pr__nfet_01v8 ad=0 pd=0 as=0 ps=0 w=5.07 l=1
X698 v3_four_channel_output_load_integration_0/v3_four_channel_shared_support_integration_0/v3_four_channel_bias_reference_distribution_0/v3_four_channel_phase_distribution_0/v3_four_channel_output_collection_0/v3_four_channel_placement_0/v3_channel_selector_late_promotion_2/v3_channel_input_bias_late_promotion_0/a_6070_15422# v3_four_channel_output_load_integration_0/v3_four_channel_shared_support_integration_0/v3_four_channel_bias_reference_distribution_0/v3_four_channel_phase_distribution_0/v3_four_channel_output_collection_0/v3_four_channel_placement_0/v3_channel_selector_late_promotion_2/v3_selector_route_pilot_0/group0_lo_n v3_four_channel_output_load_integration_0/combined_p VGND sky130_fd_pr__nfet_01v8 ad=0.6206 pd=6.02 as=0 ps=0 w=0.65 l=0.15
X699 v3_four_channel_output_load_integration_0/v3_four_channel_shared_support_integration_0/v3_four_channel_bias_reference_distribution_0/v3_four_channel_phase_distribution_0/v3_four_channel_output_collection_0/v3_four_channel_placement_0/v3_channel_selector_late_promotion_2/v3_channel_input_bias_late_promotion_0/a_7166_17688# v3_four_channel_output_load_integration_0/v3_four_channel_shared_support_integration_0/v3_four_channel_bias_reference_distribution_0/v3_four_channel_phase_distribution_0/v3_four_channel_output_collection_0/v3_four_channel_placement_0/v3_channel_selector_late_promotion_2/element_input v3_four_channel_output_load_integration_0/v3_four_channel_shared_support_integration_0/v3_four_channel_bias_reference_distribution_0/v3_four_channel_phase_distribution_0/v3_four_channel_output_collection_0/v3_four_channel_placement_0/v3_channel_selector_late_promotion_2/v3_channel_input_bias_late_promotion_0/a_7038_18978# VGND sky130_fd_pr__nfet_01v8 ad=0 pd=0 as=0 ps=0 w=0.84 l=0.6
X700 v3_four_channel_output_load_integration_0/combined_n v3_four_channel_output_load_integration_0/v3_four_channel_shared_support_integration_0/v3_four_channel_bias_reference_distribution_0/v3_four_channel_phase_distribution_0/v3_four_channel_output_collection_0/v3_four_channel_placement_0/v3_channel_selector_late_promotion_2/v3_selector_route_pilot_0/group3_lo_n v3_four_channel_output_load_integration_0/v3_four_channel_shared_support_integration_0/v3_four_channel_bias_reference_distribution_0/v3_four_channel_phase_distribution_0/v3_four_channel_output_collection_0/v3_four_channel_placement_0/v3_channel_selector_late_promotion_2/v3_channel_input_bias_late_promotion_0/a_5646_18978# VGND sky130_fd_pr__nfet_01v8 ad=0 pd=0 as=0 ps=0 w=0.65 l=0.15
X701 VGND v3_four_channel_output_load_integration_0/v3_four_channel_shared_support_integration_0/v3_tail_bias_support_block_0/vbias v3_four_channel_output_load_integration_0/v3_four_channel_shared_support_integration_0/v3_four_channel_bias_reference_distribution_0/v3_four_channel_phase_distribution_0/v3_four_channel_output_collection_0/v3_four_channel_placement_0/v3_channel_selector_late_promotion_2/v3_channel_input_bias_late_promotion_0/a_5774_21688# VGND sky130_fd_pr__nfet_01v8 ad=0 pd=0 as=0 ps=0 w=5.07 l=1
X702 v3_four_channel_output_load_integration_0/v3_four_channel_shared_support_integration_0/v3_four_channel_bias_reference_distribution_0/v3_four_channel_phase_distribution_0/v3_four_channel_output_collection_0/v3_four_channel_placement_0/v3_channel_selector_late_promotion_2/v3_channel_input_bias_late_promotion_0/a_6070_19422# v3_four_channel_output_load_integration_0/v3_four_channel_shared_support_integration_0/v3_vcm_support_block_0/ref v3_four_channel_output_load_integration_0/v3_four_channel_shared_support_integration_0/v3_four_channel_bias_reference_distribution_0/v3_four_channel_phase_distribution_0/v3_four_channel_output_collection_0/v3_four_channel_placement_0/v3_channel_selector_late_promotion_2/v3_channel_input_bias_late_promotion_0/a_5774_17688# VGND sky130_fd_pr__nfet_01v8 ad=0 pd=0 as=0 ps=0 w=0.84 l=0.6
X703 VGND VGND VGND VGND sky130_fd_pr__nfet_01v8 ad=0 pd=0 as=0 ps=0 w=5.07 l=1
X704 v3_four_channel_output_load_integration_0/combined_p v3_four_channel_output_load_integration_0/v3_four_channel_shared_support_integration_0/v3_four_channel_bias_reference_distribution_0/v3_four_channel_phase_distribution_0/v3_four_channel_output_collection_0/v3_four_channel_placement_0/v3_channel_selector_late_promotion_2/v3_selector_route_pilot_0/group1_lo_p v3_four_channel_output_load_integration_0/v3_four_channel_shared_support_integration_0/v3_four_channel_bias_reference_distribution_0/v3_four_channel_phase_distribution_0/v3_four_channel_output_collection_0/v3_four_channel_placement_0/v3_channel_selector_late_promotion_2/v3_channel_input_bias_late_promotion_0/a_4254_14978# VGND sky130_fd_pr__nfet_01v8 ad=0 pd=0 as=0.6206 ps=6.02 w=0.65 l=0.15
X705 v3_four_channel_output_load_integration_0/v3_four_channel_shared_support_integration_0/v3_four_channel_bias_reference_distribution_0/v3_four_channel_phase_distribution_0/v3_four_channel_output_collection_0/v3_four_channel_placement_0/v3_channel_selector_late_promotion_2/v3_channel_input_bias_late_promotion_0/a_6070_19422# v3_four_channel_output_load_integration_0/v3_four_channel_shared_support_integration_0/v3_four_channel_bias_reference_distribution_0/v3_four_channel_phase_distribution_0/v3_four_channel_output_collection_0/v3_four_channel_placement_0/v3_channel_selector_late_promotion_2/v3_selector_route_pilot_0/group3_lo_p v3_four_channel_output_load_integration_0/combined_n VGND sky130_fd_pr__nfet_01v8 ad=0 pd=0 as=0 ps=0 w=0.65 l=0.15
X706 VGND VGND VGND VGND sky130_fd_pr__nfet_01v8 ad=0 pd=0 as=0 ps=0 w=0.65 l=0.15
X707 v3_four_channel_output_load_integration_0/v3_four_channel_shared_support_integration_0/v3_four_channel_bias_reference_distribution_0/v3_four_channel_phase_distribution_0/v3_four_channel_output_collection_0/v3_four_channel_placement_0/v3_channel_selector_late_promotion_2/v3_channel_input_bias_late_promotion_0/a_5824_10978# v3_four_channel_output_load_integration_0/v3_four_channel_shared_support_integration_0/v3_tail_bias_support_block_0/vbias VGND VGND sky130_fd_pr__nfet_01v8 ad=1.9575 pd=15.24 as=0 ps=0 w=5.07 l=1
X708 v3_four_channel_output_load_integration_0/v3_four_channel_shared_support_integration_0/v3_four_channel_bias_reference_distribution_0/v3_four_channel_phase_distribution_0/v3_four_channel_output_collection_0/v3_four_channel_placement_0/v3_channel_selector_late_promotion_2/v3_channel_input_bias_late_promotion_0/a_4382_13688# v3_four_channel_output_load_integration_0/v3_four_channel_shared_support_integration_0/v3_four_channel_bias_reference_distribution_0/v3_four_channel_phase_distribution_0/v3_four_channel_output_collection_0/v3_four_channel_placement_0/v3_channel_selector_late_promotion_2/element_input v3_four_channel_output_load_integration_0/v3_four_channel_shared_support_integration_0/v3_four_channel_bias_reference_distribution_0/v3_four_channel_phase_distribution_0/v3_four_channel_output_collection_0/v3_four_channel_placement_0/v3_channel_selector_late_promotion_2/v3_channel_input_bias_late_promotion_0/a_4254_14978# VGND sky130_fd_pr__nfet_01v8 ad=1.9575 pd=15.24 as=0 ps=0 w=0.84 l=0.6
X709 v3_four_channel_output_load_integration_0/v3_four_channel_shared_support_integration_0/v3_four_channel_bias_reference_distribution_0/v3_four_channel_phase_distribution_0/v3_four_channel_output_collection_0/v3_four_channel_placement_0/v3_channel_selector_late_promotion_2/v3_channel_input_bias_late_promotion_0/a_4678_15422# v3_four_channel_output_load_integration_0/v3_four_channel_shared_support_integration_0/v3_four_channel_bias_reference_distribution_0/v3_four_channel_phase_distribution_0/v3_four_channel_output_collection_0/v3_four_channel_placement_0/v3_channel_selector_late_promotion_2/v3_selector_route_pilot_0/group1_lo_n v3_four_channel_output_load_integration_0/combined_p VGND sky130_fd_pr__nfet_01v8 ad=0.6206 pd=6.02 as=0 ps=0 w=0.65 l=0.15
X710 v3_four_channel_output_load_integration_0/combined_n v3_four_channel_output_load_integration_0/v3_four_channel_shared_support_integration_0/v3_four_channel_bias_reference_distribution_0/v3_four_channel_phase_distribution_0/v3_four_channel_output_collection_0/v3_four_channel_placement_0/v3_channel_selector_late_promotion_2/v3_selector_route_pilot_0/group2_lo_n v3_four_channel_output_load_integration_0/v3_four_channel_shared_support_integration_0/v3_four_channel_bias_reference_distribution_0/v3_four_channel_phase_distribution_0/v3_four_channel_output_collection_0/v3_four_channel_placement_0/v3_channel_selector_late_promotion_2/v3_channel_input_bias_late_promotion_0/a_4254_18978# VGND sky130_fd_pr__nfet_01v8 ad=0 pd=0 as=0 ps=0 w=0.65 l=0.15
X711 v3_four_channel_output_load_integration_0/combined_p v3_four_channel_output_load_integration_0/v3_four_channel_shared_support_integration_0/v3_four_channel_bias_reference_distribution_0/v3_four_channel_phase_distribution_0/v3_four_channel_output_collection_0/v3_four_channel_placement_0/v3_channel_selector_late_promotion_2/v3_selector_route_pilot_0/group3_lo_n v3_four_channel_output_load_integration_0/v3_four_channel_shared_support_integration_0/v3_four_channel_bias_reference_distribution_0/v3_four_channel_phase_distribution_0/v3_four_channel_output_collection_0/v3_four_channel_placement_0/v3_channel_selector_late_promotion_2/v3_channel_input_bias_late_promotion_0/a_5646_10978# VGND sky130_fd_pr__nfet_01v8 ad=0 pd=0 as=0.6206 ps=6.02 w=0.65 l=0.15
X712 v3_four_channel_output_load_integration_0/combined_p v3_four_channel_output_load_integration_0/v3_four_channel_shared_support_integration_0/v3_four_channel_bias_reference_distribution_0/v3_four_channel_phase_distribution_0/v3_four_channel_output_collection_0/v3_four_channel_placement_0/v3_channel_selector_late_promotion_2/v3_selector_route_pilot_0/group1_lo_n v3_four_channel_output_load_integration_0/v3_four_channel_shared_support_integration_0/v3_four_channel_bias_reference_distribution_0/v3_four_channel_phase_distribution_0/v3_four_channel_output_collection_0/v3_four_channel_placement_0/v3_channel_selector_late_promotion_2/v3_channel_input_bias_late_promotion_0/a_7038_14978# VGND sky130_fd_pr__nfet_01v8 ad=0 pd=0 as=0.6206 ps=6.02 w=0.65 l=0.15
X713 v3_four_channel_output_load_integration_0/v3_four_channel_shared_support_integration_0/v3_four_channel_bias_reference_distribution_0/v3_four_channel_phase_distribution_0/v3_four_channel_output_collection_0/v3_four_channel_placement_0/v3_channel_selector_late_promotion_2/v3_channel_input_bias_late_promotion_0/a_7462_19422# v3_four_channel_output_load_integration_0/v3_four_channel_shared_support_integration_0/v3_four_channel_bias_reference_distribution_0/v3_four_channel_phase_distribution_0/v3_four_channel_output_collection_0/v3_four_channel_placement_0/v3_channel_selector_late_promotion_2/v3_selector_route_pilot_0/group2_lo_n v3_four_channel_output_load_integration_0/combined_p VGND sky130_fd_pr__nfet_01v8 ad=0.6206 pd=6.02 as=0 ps=0 w=0.65 l=0.15
X714 v3_four_channel_output_load_integration_0/v3_four_channel_shared_support_integration_0/v3_four_channel_bias_reference_distribution_0/v3_four_channel_phase_distribution_0/v3_four_channel_output_collection_0/v3_four_channel_placement_0/v3_channel_selector_late_promotion_2/v3_channel_input_bias_late_promotion_0/a_4678_7422# v3_four_channel_output_load_integration_0/v3_four_channel_shared_support_integration_0/v3_four_channel_bias_reference_distribution_0/v3_four_channel_phase_distribution_0/v3_four_channel_output_collection_0/v3_four_channel_placement_0/v3_channel_selector_late_promotion_2/v3_selector_route_pilot_0/group3_lo_p v3_four_channel_output_load_integration_0/combined_p VGND sky130_fd_pr__nfet_01v8 ad=0.6206 pd=6.02 as=0 ps=0 w=0.65 l=0.15
X715 v3_four_channel_output_load_integration_0/v3_four_channel_shared_support_integration_0/v3_four_channel_bias_reference_distribution_0/v3_four_channel_phase_distribution_0/v3_four_channel_output_collection_0/v3_four_channel_placement_0/v3_channel_selector_late_promotion_2/v3_channel_input_bias_late_promotion_0/a_6070_11422# v3_four_channel_output_load_integration_0/v3_four_channel_shared_support_integration_0/v3_four_channel_bias_reference_distribution_0/v3_four_channel_phase_distribution_0/v3_four_channel_output_collection_0/v3_four_channel_placement_0/v3_channel_selector_late_promotion_2/v3_selector_route_pilot_0/group3_lo_p v3_four_channel_output_load_integration_0/combined_p VGND sky130_fd_pr__nfet_01v8 ad=0.6206 pd=6.02 as=0 ps=0 w=0.65 l=0.15
X716 v3_four_channel_output_load_integration_0/v3_four_channel_shared_support_integration_0/v3_four_channel_bias_reference_distribution_0/v3_four_channel_phase_distribution_0/v3_four_channel_output_collection_0/v3_four_channel_placement_0/v3_channel_selector_late_promotion_2/v3_channel_input_bias_late_promotion_0/a_7216_10978# v3_four_channel_output_load_integration_0/v3_four_channel_shared_support_integration_0/v3_tail_bias_support_block_0/vbias VGND VGND sky130_fd_pr__nfet_01v8 ad=0 pd=0 as=0 ps=0 w=5.07 l=1
X717 v3_four_channel_output_load_integration_0/v3_four_channel_shared_support_integration_0/v3_four_channel_bias_reference_distribution_0/v3_four_channel_phase_distribution_0/v3_four_channel_output_collection_0/v3_four_channel_placement_0/v3_channel_selector_late_promotion_2/v3_channel_input_bias_late_promotion_0/a_7216_14978# v3_four_channel_output_load_integration_0/v3_four_channel_shared_support_integration_0/v3_vcm_support_block_0/ref v3_four_channel_output_load_integration_0/v3_four_channel_shared_support_integration_0/v3_four_channel_bias_reference_distribution_0/v3_four_channel_phase_distribution_0/v3_four_channel_output_collection_0/v3_four_channel_placement_0/v3_channel_selector_late_promotion_2/v3_channel_input_bias_late_promotion_0/a_7038_14978# VGND sky130_fd_pr__nfet_01v8 ad=0 pd=0 as=0 ps=0 w=0.84 l=0.6
X718 v3_four_channel_output_load_integration_0/v3_four_channel_shared_support_integration_0/v3_four_channel_bias_reference_distribution_0/v3_four_channel_phase_distribution_0/v3_four_channel_output_collection_0/v3_four_channel_placement_0/v3_channel_selector_late_promotion_2/v3_channel_input_bias_late_promotion_0/a_4678_19422# v3_four_channel_output_load_integration_0/v3_four_channel_shared_support_integration_0/v3_vcm_support_block_0/ref v3_four_channel_output_load_integration_0/v3_four_channel_shared_support_integration_0/v3_four_channel_bias_reference_distribution_0/v3_four_channel_phase_distribution_0/v3_four_channel_output_collection_0/v3_four_channel_placement_0/v3_channel_selector_late_promotion_2/v3_channel_input_bias_late_promotion_0/a_4382_17688# VGND sky130_fd_pr__nfet_01v8 ad=0 pd=0 as=0 ps=0 w=0.84 l=0.6
X719 v3_four_channel_output_load_integration_0/v3_four_channel_shared_support_integration_0/v3_four_channel_bias_reference_distribution_0/v3_four_channel_phase_distribution_0/v3_four_channel_output_collection_0/v3_four_channel_placement_0/v3_channel_selector_late_promotion_2/v3_channel_input_bias_late_promotion_0/a_4678_19422# v3_four_channel_output_load_integration_0/v3_four_channel_shared_support_integration_0/v3_four_channel_bias_reference_distribution_0/v3_four_channel_phase_distribution_0/v3_four_channel_output_collection_0/v3_four_channel_placement_0/v3_channel_selector_late_promotion_2/v3_selector_route_pilot_0/group2_lo_p v3_four_channel_output_load_integration_0/combined_n VGND sky130_fd_pr__nfet_01v8 ad=0 pd=0 as=0 ps=0 w=0.65 l=0.15
X720 v3_four_channel_output_load_integration_0/combined_n v3_four_channel_output_load_integration_0/v3_four_channel_shared_support_integration_0/v3_four_channel_bias_reference_distribution_0/v3_four_channel_phase_distribution_0/v3_four_channel_output_collection_0/v3_four_channel_placement_0/v3_channel_selector_late_promotion_2/v3_selector_route_pilot_0/group0_lo_n v3_four_channel_output_load_integration_0/v3_four_channel_shared_support_integration_0/v3_four_channel_bias_reference_distribution_0/v3_four_channel_phase_distribution_0/v3_four_channel_output_collection_0/v3_four_channel_placement_0/v3_channel_selector_late_promotion_2/v3_channel_input_bias_late_promotion_0/a_5646_14978# VGND sky130_fd_pr__nfet_01v8 ad=0 pd=0 as=0 ps=0 w=0.65 l=0.15
X721 v3_four_channel_output_load_integration_0/combined_n v3_four_channel_output_load_integration_0/v3_four_channel_shared_support_integration_0/v3_four_channel_bias_reference_distribution_0/v3_four_channel_phase_distribution_0/v3_four_channel_output_collection_0/v3_four_channel_placement_0/v3_channel_selector_late_promotion_2/v3_selector_route_pilot_0/group2_lo_n v3_four_channel_output_load_integration_0/v3_four_channel_shared_support_integration_0/v3_four_channel_bias_reference_distribution_0/v3_four_channel_phase_distribution_0/v3_four_channel_output_collection_0/v3_four_channel_placement_0/v3_channel_selector_late_promotion_2/v3_channel_input_bias_late_promotion_0/a_7038_18978# VGND sky130_fd_pr__nfet_01v8 ad=0 pd=0 as=0 ps=0 w=0.65 l=0.15
X722 v3_four_channel_output_load_integration_0/v3_four_channel_shared_support_integration_0/v3_four_channel_bias_reference_distribution_0/v3_four_channel_phase_distribution_0/v3_four_channel_output_collection_0/v3_four_channel_placement_0/v3_channel_selector_late_promotion_2/v3_channel_input_bias_late_promotion_0/a_7462_7422# v3_four_channel_output_load_integration_0/v3_four_channel_shared_support_integration_0/v3_four_channel_bias_reference_distribution_0/v3_four_channel_phase_distribution_0/v3_four_channel_output_collection_0/v3_four_channel_placement_0/v3_channel_selector_late_promotion_2/v3_selector_route_pilot_0/group3_lo_p v3_four_channel_output_load_integration_0/combined_p VGND sky130_fd_pr__nfet_01v8 ad=0.6206 pd=6.02 as=0 ps=0 w=0.65 l=0.15
X723 VGND v3_four_channel_output_load_integration_0/v3_four_channel_shared_support_integration_0/v3_tail_bias_support_block_0/vbias v3_four_channel_output_load_integration_0/v3_four_channel_shared_support_integration_0/v3_four_channel_bias_reference_distribution_0/v3_four_channel_phase_distribution_0/v3_four_channel_output_collection_0/v3_four_channel_placement_0/v3_channel_selector_late_promotion_2/v3_channel_input_bias_late_promotion_0/a_7166_21688# VGND sky130_fd_pr__nfet_01v8 ad=0 pd=0 as=0 ps=0 w=5.07 l=1
X724 v3_four_channel_output_load_integration_0/v3_four_channel_shared_support_integration_0/v3_four_channel_bias_reference_distribution_0/v3_four_channel_phase_distribution_0/v3_four_channel_output_collection_0/v3_four_channel_placement_0/v3_channel_selector_late_promotion_2/v3_channel_input_bias_late_promotion_0/a_6070_15422# v3_four_channel_output_load_integration_0/v3_four_channel_shared_support_integration_0/v3_vcm_support_block_0/ref v3_four_channel_output_load_integration_0/v3_four_channel_shared_support_integration_0/v3_four_channel_bias_reference_distribution_0/v3_four_channel_phase_distribution_0/v3_four_channel_output_collection_0/v3_four_channel_placement_0/v3_channel_selector_late_promotion_2/v3_channel_input_bias_late_promotion_0/a_5774_13688# VGND sky130_fd_pr__nfet_01v8 ad=0 pd=0 as=0 ps=0 w=0.84 l=0.6
X725 v3_four_channel_output_load_integration_0/combined_p v3_four_channel_output_load_integration_0/v3_four_channel_shared_support_integration_0/v3_four_channel_bias_reference_distribution_0/v3_four_channel_phase_distribution_0/v3_four_channel_output_collection_0/v3_four_channel_placement_0/v3_channel_selector_late_promotion_2/v3_selector_route_pilot_0/group2_lo_n v3_four_channel_output_load_integration_0/v3_four_channel_shared_support_integration_0/v3_four_channel_bias_reference_distribution_0/v3_four_channel_phase_distribution_0/v3_four_channel_output_collection_0/v3_four_channel_placement_0/v3_channel_selector_late_promotion_2/v3_channel_input_bias_late_promotion_0/a_4254_10978# VGND sky130_fd_pr__nfet_01v8 ad=0 pd=0 as=0.6206 ps=6.02 w=0.65 l=0.15
X726 v3_four_channel_output_load_integration_0/v3_four_channel_shared_support_integration_0/v3_four_channel_bias_reference_distribution_0/v3_four_channel_phase_distribution_0/v3_four_channel_output_collection_0/v3_four_channel_placement_0/v3_channel_selector_late_promotion_2/v3_channel_input_bias_late_promotion_0/a_6070_15422# v3_four_channel_output_load_integration_0/v3_four_channel_shared_support_integration_0/v3_four_channel_bias_reference_distribution_0/v3_four_channel_phase_distribution_0/v3_four_channel_output_collection_0/v3_four_channel_placement_0/v3_channel_selector_late_promotion_2/v3_selector_route_pilot_0/group0_lo_p v3_four_channel_output_load_integration_0/combined_n VGND sky130_fd_pr__nfet_01v8 ad=0 pd=0 as=0 ps=0 w=0.65 l=0.15
X727 v3_four_channel_output_load_integration_0/v3_four_channel_shared_support_integration_0/v3_four_channel_bias_reference_distribution_0/v3_four_channel_phase_distribution_0/v3_four_channel_output_collection_0/v3_four_channel_placement_0/v3_channel_selector_late_promotion_2/v3_channel_input_bias_late_promotion_0/a_5824_6978# v3_four_channel_output_load_integration_0/v3_four_channel_shared_support_integration_0/v3_vcm_support_block_0/ref v3_four_channel_output_load_integration_0/v3_four_channel_shared_support_integration_0/v3_four_channel_bias_reference_distribution_0/v3_four_channel_phase_distribution_0/v3_four_channel_output_collection_0/v3_four_channel_placement_0/v3_channel_selector_late_promotion_2/v3_channel_input_bias_late_promotion_0/a_5646_6978# VGND sky130_fd_pr__nfet_01v8 ad=0 pd=0 as=0.6206 ps=6.02 w=0.84 l=0.6
X728 v3_four_channel_output_load_integration_0/v3_four_channel_shared_support_integration_0/v3_four_channel_bias_reference_distribution_0/v3_four_channel_phase_distribution_0/v3_four_channel_output_collection_0/v3_four_channel_placement_0/v3_channel_selector_late_promotion_2/v3_channel_input_bias_late_promotion_0/a_5774_17688# v3_four_channel_output_load_integration_0/v3_four_channel_shared_support_integration_0/v3_four_channel_bias_reference_distribution_0/v3_four_channel_phase_distribution_0/v3_four_channel_output_collection_0/v3_four_channel_placement_0/v3_channel_selector_late_promotion_2/element_input v3_four_channel_output_load_integration_0/v3_four_channel_shared_support_integration_0/v3_four_channel_bias_reference_distribution_0/v3_four_channel_phase_distribution_0/v3_four_channel_output_collection_0/v3_four_channel_placement_0/v3_channel_selector_late_promotion_2/v3_channel_input_bias_late_promotion_0/a_5646_18978# VGND sky130_fd_pr__nfet_01v8 ad=0 pd=0 as=0 ps=0 w=0.84 l=0.6
X729 v3_four_channel_output_load_integration_0/combined_p v3_four_channel_output_load_integration_0/v3_four_channel_shared_support_integration_0/v3_four_channel_bias_reference_distribution_0/v3_four_channel_phase_distribution_0/v3_four_channel_output_collection_0/v3_four_channel_placement_0/v3_channel_selector_late_promotion_2/v3_selector_route_pilot_0/group3_lo_p v3_four_channel_output_load_integration_0/v3_four_channel_shared_support_integration_0/v3_four_channel_bias_reference_distribution_0/v3_four_channel_phase_distribution_0/v3_four_channel_output_collection_0/v3_four_channel_placement_0/v3_channel_selector_late_promotion_2/v3_channel_input_bias_late_promotion_0/a_5646_22978# VGND sky130_fd_pr__nfet_01v8 ad=0 pd=0 as=0 ps=0 w=0.65 l=0.15
X730 v3_four_channel_output_load_integration_0/v3_four_channel_shared_support_integration_0/v3_four_channel_bias_reference_distribution_0/v3_four_channel_phase_distribution_0/v3_four_channel_output_collection_0/v3_four_channel_placement_0/v3_channel_selector_late_promotion_2/v3_channel_input_bias_late_promotion_0/a_5824_6978# v3_four_channel_output_load_integration_0/v3_four_channel_shared_support_integration_0/v3_tail_bias_support_block_0/vbias VGND VGND sky130_fd_pr__nfet_01v8 ad=0 pd=0 as=0 ps=0 w=5.07 l=1
X731 v3_four_channel_output_load_integration_0/v3_four_channel_shared_support_integration_0/v3_four_channel_bias_reference_distribution_0/v3_four_channel_phase_distribution_0/v3_four_channel_output_collection_0/v3_four_channel_placement_0/v3_channel_selector_late_promotion_2/v3_channel_input_bias_late_promotion_0/a_4432_10978# v3_four_channel_output_load_integration_0/v3_four_channel_shared_support_integration_0/v3_vcm_support_block_0/ref v3_four_channel_output_load_integration_0/v3_four_channel_shared_support_integration_0/v3_four_channel_bias_reference_distribution_0/v3_four_channel_phase_distribution_0/v3_four_channel_output_collection_0/v3_four_channel_placement_0/v3_channel_selector_late_promotion_2/v3_channel_input_bias_late_promotion_0/a_4254_10978# VGND sky130_fd_pr__nfet_01v8 ad=1.9575 pd=15.24 as=0 ps=0 w=0.84 l=0.6
X732 v3_four_channel_output_load_integration_0/v3_four_channel_shared_support_integration_0/v3_four_channel_bias_reference_distribution_0/v3_four_channel_phase_distribution_0/v3_four_channel_output_collection_0/v3_four_channel_placement_0/v3_channel_selector_late_promotion_2/v3_channel_input_bias_late_promotion_0/a_4678_11422# v3_four_channel_output_load_integration_0/v3_four_channel_shared_support_integration_0/v3_four_channel_bias_reference_distribution_0/v3_four_channel_phase_distribution_0/v3_four_channel_output_collection_0/v3_four_channel_placement_0/v3_channel_selector_late_promotion_2/v3_selector_route_pilot_0/group2_lo_p v3_four_channel_output_load_integration_0/combined_p VGND sky130_fd_pr__nfet_01v8 ad=0.6206 pd=6.02 as=0 ps=0 w=0.65 l=0.15
X733 v3_four_channel_output_load_integration_0/v3_four_channel_shared_support_integration_0/v3_four_channel_bias_reference_distribution_0/v3_four_channel_phase_distribution_0/v3_four_channel_output_collection_0/v3_four_channel_placement_0/v3_channel_selector_late_promotion_2/v3_channel_input_bias_late_promotion_0/a_6070_23422# v3_four_channel_output_load_integration_0/v3_four_channel_shared_support_integration_0/v3_four_channel_bias_reference_distribution_0/v3_four_channel_phase_distribution_0/v3_four_channel_output_collection_0/v3_four_channel_placement_0/v3_channel_selector_late_promotion_2/v3_selector_route_pilot_0/group3_lo_n v3_four_channel_output_load_integration_0/combined_p VGND sky130_fd_pr__nfet_01v8 ad=0.6206 pd=6.02 as=0 ps=0 w=0.65 l=0.15
X734 v3_four_channel_output_load_integration_0/combined_n v3_four_channel_output_load_integration_0/v3_four_channel_shared_support_integration_0/v3_four_channel_bias_reference_distribution_0/v3_four_channel_phase_distribution_0/v3_four_channel_output_collection_0/v3_four_channel_placement_0/v3_channel_selector_late_promotion_2/v3_selector_route_pilot_0/group1_lo_n v3_four_channel_output_load_integration_0/v3_four_channel_shared_support_integration_0/v3_four_channel_bias_reference_distribution_0/v3_four_channel_phase_distribution_0/v3_four_channel_output_collection_0/v3_four_channel_placement_0/v3_channel_selector_late_promotion_2/v3_channel_input_bias_late_promotion_0/a_4254_14978# VGND sky130_fd_pr__nfet_01v8 ad=0 pd=0 as=0 ps=0 w=0.65 l=0.15
X735 v3_four_channel_output_load_integration_0/combined_p v3_four_channel_output_load_integration_0/v3_four_channel_shared_support_integration_0/v3_four_channel_bias_reference_distribution_0/v3_four_channel_phase_distribution_0/v3_four_channel_output_collection_0/v3_four_channel_placement_0/v3_channel_selector_late_promotion_2/v3_selector_route_pilot_0/group2_lo_n v3_four_channel_output_load_integration_0/v3_four_channel_shared_support_integration_0/v3_four_channel_bias_reference_distribution_0/v3_four_channel_phase_distribution_0/v3_four_channel_output_collection_0/v3_four_channel_placement_0/v3_channel_selector_late_promotion_2/v3_channel_input_bias_late_promotion_0/a_7038_10978# VGND sky130_fd_pr__nfet_01v8 ad=0 pd=0 as=0.6206 ps=6.02 w=0.65 l=0.15
X736 v3_four_channel_output_load_integration_0/v3_four_channel_shared_support_integration_0/v3_four_channel_bias_reference_distribution_0/v3_four_channel_phase_distribution_0/v3_four_channel_output_collection_0/v3_four_channel_placement_0/v3_channel_selector_late_promotion_2/v3_channel_input_bias_late_promotion_0/a_7462_15422# v3_four_channel_output_load_integration_0/v3_four_channel_shared_support_integration_0/v3_four_channel_bias_reference_distribution_0/v3_four_channel_phase_distribution_0/v3_four_channel_output_collection_0/v3_four_channel_placement_0/v3_channel_selector_late_promotion_2/v3_selector_route_pilot_0/group1_lo_p v3_four_channel_output_load_integration_0/combined_p VGND sky130_fd_pr__nfet_01v8 ad=0.6206 pd=6.02 as=0 ps=0 w=0.65 l=0.15
X737 VGND VGND VGND VGND sky130_fd_pr__nfet_01v8 ad=0 pd=0 as=0 ps=0 w=5.07 l=1
X738 v3_four_channel_output_load_integration_0/v3_four_channel_shared_support_integration_0/v3_four_channel_bias_reference_distribution_0/v3_four_channel_phase_distribution_0/v3_four_channel_output_collection_0/v3_four_channel_placement_0/v3_channel_selector_late_promotion_2/v3_channel_input_bias_late_promotion_0/a_7216_6978# v3_four_channel_output_load_integration_0/v3_four_channel_shared_support_integration_0/v3_tail_bias_support_block_0/vbias VGND VGND sky130_fd_pr__nfet_01v8 ad=1.9575 pd=15.24 as=0 ps=0 w=5.07 l=1
X739 v3_four_channel_output_load_integration_0/v3_four_channel_shared_support_integration_0/v3_four_channel_bias_reference_distribution_0/v3_four_channel_phase_distribution_0/v3_four_channel_output_collection_0/v3_four_channel_placement_0/v3_channel_selector_late_promotion_2/v3_channel_input_bias_late_promotion_0/a_7216_10978# v3_four_channel_output_load_integration_0/v3_four_channel_shared_support_integration_0/v3_vcm_support_block_0/ref v3_four_channel_output_load_integration_0/v3_four_channel_shared_support_integration_0/v3_four_channel_bias_reference_distribution_0/v3_four_channel_phase_distribution_0/v3_four_channel_output_collection_0/v3_four_channel_placement_0/v3_channel_selector_late_promotion_2/v3_channel_input_bias_late_promotion_0/a_7038_10978# VGND sky130_fd_pr__nfet_01v8 ad=0 pd=0 as=0 ps=0 w=0.84 l=0.6
X740 v3_four_channel_output_load_integration_0/v3_four_channel_shared_support_integration_0/v3_four_channel_bias_reference_distribution_0/v3_four_channel_phase_distribution_0/v3_four_channel_output_collection_0/v3_four_channel_placement_0/v3_channel_selector_late_promotion_2/v3_channel_input_bias_late_promotion_0/a_4678_15422# v3_four_channel_output_load_integration_0/v3_four_channel_shared_support_integration_0/v3_vcm_support_block_0/ref v3_four_channel_output_load_integration_0/v3_four_channel_shared_support_integration_0/v3_four_channel_bias_reference_distribution_0/v3_four_channel_phase_distribution_0/v3_four_channel_output_collection_0/v3_four_channel_placement_0/v3_channel_selector_late_promotion_2/v3_channel_input_bias_late_promotion_0/a_4382_13688# VGND sky130_fd_pr__nfet_01v8 ad=0 pd=0 as=0 ps=0 w=0.84 l=0.6
X741 v3_four_channel_output_load_integration_0/v3_four_channel_shared_support_integration_0/v3_four_channel_bias_reference_distribution_0/v3_four_channel_phase_distribution_0/v3_four_channel_output_collection_0/v3_four_channel_placement_0/v3_channel_selector_late_promotion_2/v3_channel_input_bias_late_promotion_0/a_4678_15422# v3_four_channel_output_load_integration_0/v3_four_channel_shared_support_integration_0/v3_four_channel_bias_reference_distribution_0/v3_four_channel_phase_distribution_0/v3_four_channel_output_collection_0/v3_four_channel_placement_0/v3_channel_selector_late_promotion_2/v3_selector_route_pilot_0/group1_lo_p v3_four_channel_output_load_integration_0/combined_n VGND sky130_fd_pr__nfet_01v8 ad=0 pd=0 as=0 ps=0 w=0.65 l=0.15
X742 v3_four_channel_output_load_integration_0/combined_p v3_four_channel_output_load_integration_0/v3_four_channel_shared_support_integration_0/v3_four_channel_bias_reference_distribution_0/v3_four_channel_phase_distribution_0/v3_four_channel_output_collection_0/v3_four_channel_placement_0/v3_channel_selector_late_promotion_2/v3_selector_route_pilot_0/group3_lo_p v3_four_channel_output_load_integration_0/v3_four_channel_shared_support_integration_0/v3_four_channel_bias_reference_distribution_0/v3_four_channel_phase_distribution_0/v3_four_channel_output_collection_0/v3_four_channel_placement_0/v3_channel_selector_late_promotion_2/v3_channel_input_bias_late_promotion_0/a_4254_22978# VGND sky130_fd_pr__nfet_01v8 ad=0 pd=0 as=0.6206 ps=6.02 w=0.65 l=0.15
X743 v3_four_channel_output_load_integration_0/v3_four_channel_shared_support_integration_0/v3_four_channel_bias_reference_distribution_0/v3_four_channel_phase_distribution_0/v3_four_channel_output_collection_0/v3_four_channel_placement_0/v3_channel_selector_late_promotion_2/v3_channel_input_bias_late_promotion_0/a_7462_19422# v3_four_channel_output_load_integration_0/v3_four_channel_shared_support_integration_0/v3_vcm_support_block_0/ref v3_four_channel_output_load_integration_0/v3_four_channel_shared_support_integration_0/v3_four_channel_bias_reference_distribution_0/v3_four_channel_phase_distribution_0/v3_four_channel_output_collection_0/v3_four_channel_placement_0/v3_channel_selector_late_promotion_2/v3_channel_input_bias_late_promotion_0/a_7166_17688# VGND sky130_fd_pr__nfet_01v8 ad=0 pd=0 as=0 ps=0 w=0.84 l=0.6
X744 v3_four_channel_output_load_integration_0/combined_n v3_four_channel_output_load_integration_0/v3_four_channel_shared_support_integration_0/v3_four_channel_bias_reference_distribution_0/v3_four_channel_phase_distribution_0/v3_four_channel_output_collection_0/v3_four_channel_placement_0/v3_channel_selector_late_promotion_2/v3_selector_route_pilot_0/group3_lo_p v3_four_channel_output_load_integration_0/v3_four_channel_shared_support_integration_0/v3_four_channel_bias_reference_distribution_0/v3_four_channel_phase_distribution_0/v3_four_channel_output_collection_0/v3_four_channel_placement_0/v3_channel_selector_late_promotion_2/v3_channel_input_bias_late_promotion_0/a_5646_10978# VGND sky130_fd_pr__nfet_01v8 ad=0 pd=0 as=0 ps=0 w=0.65 l=0.15
X745 v3_four_channel_output_load_integration_0/combined_n v3_four_channel_output_load_integration_0/v3_four_channel_shared_support_integration_0/v3_four_channel_bias_reference_distribution_0/v3_four_channel_phase_distribution_0/v3_four_channel_output_collection_0/v3_four_channel_placement_0/v3_channel_selector_late_promotion_2/v3_selector_route_pilot_0/group1_lo_p v3_four_channel_output_load_integration_0/v3_four_channel_shared_support_integration_0/v3_four_channel_bias_reference_distribution_0/v3_four_channel_phase_distribution_0/v3_four_channel_output_collection_0/v3_four_channel_placement_0/v3_channel_selector_late_promotion_2/v3_channel_input_bias_late_promotion_0/a_7038_14978# VGND sky130_fd_pr__nfet_01v8 ad=0 pd=0 as=0 ps=0 w=0.65 l=0.15
X746 v3_four_channel_output_load_integration_0/v3_four_channel_shared_support_integration_0/v3_four_channel_bias_reference_distribution_0/v3_four_channel_phase_distribution_0/v3_four_channel_output_collection_0/v3_four_channel_placement_0/v3_channel_selector_late_promotion_2/v3_channel_input_bias_late_promotion_0/a_7462_19422# v3_four_channel_output_load_integration_0/v3_four_channel_shared_support_integration_0/v3_four_channel_bias_reference_distribution_0/v3_four_channel_phase_distribution_0/v3_four_channel_output_collection_0/v3_four_channel_placement_0/v3_channel_selector_late_promotion_2/v3_selector_route_pilot_0/group2_lo_p v3_four_channel_output_load_integration_0/combined_n VGND sky130_fd_pr__nfet_01v8 ad=0 pd=0 as=0 ps=0 w=0.65 l=0.15
X747 v3_four_channel_output_load_integration_0/v3_four_channel_shared_support_integration_0/v3_four_channel_bias_reference_distribution_0/v3_four_channel_phase_distribution_0/v3_four_channel_output_collection_0/v3_four_channel_placement_0/v3_channel_selector_late_promotion_2/v3_channel_input_bias_late_promotion_0/a_4678_7422# v3_four_channel_output_load_integration_0/v3_four_channel_shared_support_integration_0/v3_four_channel_bias_reference_distribution_0/v3_four_channel_phase_distribution_0/v3_four_channel_output_collection_0/v3_four_channel_placement_0/v3_channel_selector_late_promotion_2/element_input v3_four_channel_output_load_integration_0/v3_four_channel_shared_support_integration_0/v3_four_channel_bias_reference_distribution_0/v3_four_channel_phase_distribution_0/v3_four_channel_output_collection_0/v3_four_channel_placement_0/v3_channel_selector_late_promotion_2/v3_channel_input_bias_late_promotion_0/a_4432_6978# VGND sky130_fd_pr__nfet_01v8 ad=0 pd=0 as=1.9575 ps=15.24 w=0.84 l=0.6
X748 v3_four_channel_output_load_integration_0/combined_p v3_four_channel_output_load_integration_0/v3_four_channel_shared_support_integration_0/v3_four_channel_bias_reference_distribution_0/v3_four_channel_phase_distribution_0/v3_four_channel_output_collection_0/v3_four_channel_placement_0/v3_channel_selector_late_promotion_2/v3_selector_route_pilot_0/group3_lo_n v3_four_channel_output_load_integration_0/v3_four_channel_shared_support_integration_0/v3_four_channel_bias_reference_distribution_0/v3_four_channel_phase_distribution_0/v3_four_channel_output_collection_0/v3_four_channel_placement_0/v3_channel_selector_late_promotion_2/v3_channel_input_bias_late_promotion_0/a_5646_6978# VGND sky130_fd_pr__nfet_01v8 ad=0 pd=0 as=0 ps=0 w=0.65 l=0.15
X749 v3_four_channel_output_load_integration_0/v3_four_channel_shared_support_integration_0/v3_four_channel_bias_reference_distribution_0/v3_four_channel_phase_distribution_0/v3_four_channel_output_collection_0/v3_four_channel_placement_0/v3_channel_selector_late_promotion_2/v3_channel_input_bias_late_promotion_0/a_4678_7422# v3_four_channel_output_load_integration_0/v3_four_channel_shared_support_integration_0/v3_four_channel_bias_reference_distribution_0/v3_four_channel_phase_distribution_0/v3_four_channel_output_collection_0/v3_four_channel_placement_0/v3_channel_selector_late_promotion_2/v3_selector_route_pilot_0/group3_lo_n v3_four_channel_output_load_integration_0/combined_n VGND sky130_fd_pr__nfet_01v8 ad=0 pd=0 as=0 ps=0 w=0.65 l=0.15
X750 v3_four_channel_output_load_integration_0/v3_four_channel_shared_support_integration_0/v3_four_channel_bias_reference_distribution_0/v3_four_channel_phase_distribution_0/v3_four_channel_output_collection_0/v3_four_channel_placement_0/v3_channel_selector_late_promotion_2/v3_channel_input_bias_late_promotion_0/a_6070_11422# v3_four_channel_output_load_integration_0/v3_four_channel_shared_support_integration_0/v3_four_channel_bias_reference_distribution_0/v3_four_channel_phase_distribution_0/v3_four_channel_output_collection_0/v3_four_channel_placement_0/v3_channel_selector_late_promotion_2/element_input v3_four_channel_output_load_integration_0/v3_four_channel_shared_support_integration_0/v3_four_channel_bias_reference_distribution_0/v3_four_channel_phase_distribution_0/v3_four_channel_output_collection_0/v3_four_channel_placement_0/v3_channel_selector_late_promotion_2/v3_channel_input_bias_late_promotion_0/a_5824_10978# VGND sky130_fd_pr__nfet_01v8 ad=0 pd=0 as=0 ps=0 w=0.84 l=0.6
X751 v3_four_channel_output_load_integration_0/v3_four_channel_shared_support_integration_0/v3_four_channel_bias_reference_distribution_0/v3_four_channel_phase_distribution_0/v3_four_channel_output_collection_0/v3_four_channel_placement_0/v3_channel_selector_late_promotion_2/v3_channel_input_bias_late_promotion_0/a_6070_11422# v3_four_channel_output_load_integration_0/v3_four_channel_shared_support_integration_0/v3_four_channel_bias_reference_distribution_0/v3_four_channel_phase_distribution_0/v3_four_channel_output_collection_0/v3_four_channel_placement_0/v3_channel_selector_late_promotion_2/v3_selector_route_pilot_0/group3_lo_n v3_four_channel_output_load_integration_0/combined_n VGND sky130_fd_pr__nfet_01v8 ad=0 pd=0 as=0 ps=0 w=0.65 l=0.15
X752 v3_four_channel_output_load_integration_0/v3_four_channel_shared_support_integration_0/v3_four_channel_bias_reference_distribution_0/v3_four_channel_phase_distribution_0/v3_four_channel_output_collection_0/v3_four_channel_placement_0/v3_channel_selector_late_promotion_2/v3_channel_input_bias_late_promotion_0/a_4382_21688# v3_four_channel_output_load_integration_0/v3_four_channel_shared_support_integration_0/v3_four_channel_bias_reference_distribution_0/v3_four_channel_phase_distribution_0/v3_four_channel_output_collection_0/v3_four_channel_placement_0/v3_channel_selector_late_promotion_2/element_input v3_four_channel_output_load_integration_0/v3_four_channel_shared_support_integration_0/v3_four_channel_bias_reference_distribution_0/v3_four_channel_phase_distribution_0/v3_four_channel_output_collection_0/v3_four_channel_placement_0/v3_channel_selector_late_promotion_2/v3_channel_input_bias_late_promotion_0/a_4254_22978# VGND sky130_fd_pr__nfet_01v8 ad=0 pd=0 as=0 ps=0 w=0.84 l=0.6
X753 v3_four_channel_output_load_integration_0/v3_four_channel_shared_support_integration_0/v3_four_channel_bias_reference_distribution_0/v3_four_channel_phase_distribution_0/v3_four_channel_output_collection_0/v3_four_channel_placement_0/v3_channel_selector_late_promotion_2/v3_channel_input_bias_late_promotion_0/a_4678_23422# v3_four_channel_output_load_integration_0/v3_four_channel_shared_support_integration_0/v3_four_channel_bias_reference_distribution_0/v3_four_channel_phase_distribution_0/v3_four_channel_output_collection_0/v3_four_channel_placement_0/v3_channel_selector_late_promotion_2/v3_selector_route_pilot_0/group3_lo_n v3_four_channel_output_load_integration_0/combined_p VGND sky130_fd_pr__nfet_01v8 ad=0 pd=0 as=0 ps=0 w=0.65 l=0.15
X754 v3_four_channel_output_load_integration_0/combined_p v3_four_channel_output_load_integration_0/v3_four_channel_shared_support_integration_0/v3_four_channel_bias_reference_distribution_0/v3_four_channel_phase_distribution_0/v3_four_channel_output_collection_0/v3_four_channel_placement_0/v3_channel_selector_late_promotion_2/v3_selector_route_pilot_0/group3_lo_n v3_four_channel_output_load_integration_0/v3_four_channel_shared_support_integration_0/v3_four_channel_bias_reference_distribution_0/v3_four_channel_phase_distribution_0/v3_four_channel_output_collection_0/v3_four_channel_placement_0/v3_channel_selector_late_promotion_2/v3_channel_input_bias_late_promotion_0/a_4254_6978# VGND sky130_fd_pr__nfet_01v8 ad=0 pd=0 as=0 ps=0 w=0.65 l=0.15
X755 v3_four_channel_output_load_integration_0/v3_four_channel_shared_support_integration_0/v3_four_channel_bias_reference_distribution_0/v3_four_channel_phase_distribution_0/v3_four_channel_output_collection_0/v3_four_channel_placement_0/v3_channel_selector_late_promotion_2/v3_channel_input_bias_late_promotion_0/a_5774_13688# v3_four_channel_output_load_integration_0/v3_four_channel_shared_support_integration_0/v3_four_channel_bias_reference_distribution_0/v3_four_channel_phase_distribution_0/v3_four_channel_output_collection_0/v3_four_channel_placement_0/v3_channel_selector_late_promotion_2/element_input v3_four_channel_output_load_integration_0/v3_four_channel_shared_support_integration_0/v3_four_channel_bias_reference_distribution_0/v3_four_channel_phase_distribution_0/v3_four_channel_output_collection_0/v3_four_channel_placement_0/v3_channel_selector_late_promotion_2/v3_channel_input_bias_late_promotion_0/a_5646_14978# VGND sky130_fd_pr__nfet_01v8 ad=0 pd=0 as=0 ps=0 w=0.84 l=0.6
X756 v3_four_channel_output_load_integration_0/combined_p v3_four_channel_output_load_integration_0/v3_four_channel_shared_support_integration_0/v3_four_channel_bias_reference_distribution_0/v3_four_channel_phase_distribution_0/v3_four_channel_output_collection_0/v3_four_channel_placement_0/v3_channel_selector_late_promotion_2/v3_selector_route_pilot_0/group3_lo_p v3_four_channel_output_load_integration_0/v3_four_channel_shared_support_integration_0/v3_four_channel_bias_reference_distribution_0/v3_four_channel_phase_distribution_0/v3_four_channel_output_collection_0/v3_four_channel_placement_0/v3_channel_selector_late_promotion_2/v3_channel_input_bias_late_promotion_0/a_7038_22978# VGND sky130_fd_pr__nfet_01v8 ad=0 pd=0 as=0 ps=0 w=0.65 l=0.15
X757 v3_four_channel_output_load_integration_0/v3_four_channel_shared_support_integration_0/v3_four_channel_bias_reference_distribution_0/v3_four_channel_phase_distribution_0/v3_four_channel_output_collection_0/v3_four_channel_placement_0/v3_channel_selector_late_promotion_2/v3_channel_input_bias_late_promotion_0/a_7462_7422# v3_four_channel_output_load_integration_0/v3_four_channel_shared_support_integration_0/v3_four_channel_bias_reference_distribution_0/v3_four_channel_phase_distribution_0/v3_four_channel_output_collection_0/v3_four_channel_placement_0/v3_channel_selector_late_promotion_2/element_input v3_four_channel_output_load_integration_0/v3_four_channel_shared_support_integration_0/v3_four_channel_bias_reference_distribution_0/v3_four_channel_phase_distribution_0/v3_four_channel_output_collection_0/v3_four_channel_placement_0/v3_channel_selector_late_promotion_2/v3_channel_input_bias_late_promotion_0/a_7216_6978# VGND sky130_fd_pr__nfet_01v8 ad=0 pd=0 as=0 ps=0 w=0.84 l=0.6
X758 v3_four_channel_output_load_integration_0/v3_four_channel_shared_support_integration_0/v3_four_channel_bias_reference_distribution_0/v3_four_channel_phase_distribution_0/v3_four_channel_output_collection_0/v3_four_channel_placement_0/v3_channel_selector_late_promotion_2/v3_channel_input_bias_late_promotion_0/a_4432_10978# v3_four_channel_output_load_integration_0/v3_four_channel_shared_support_integration_0/v3_tail_bias_support_block_0/vbias VGND VGND sky130_fd_pr__nfet_01v8 ad=0 pd=0 as=0 ps=0 w=5.07 l=1
X759 v3_four_channel_output_load_integration_0/v3_four_channel_shared_support_integration_0/v3_four_channel_bias_reference_distribution_0/v3_four_channel_phase_distribution_0/v3_four_channel_output_collection_0/v3_four_channel_placement_0/v3_channel_selector_late_promotion_2/v3_channel_input_bias_late_promotion_0/a_7462_7422# v3_four_channel_output_load_integration_0/v3_four_channel_shared_support_integration_0/v3_four_channel_bias_reference_distribution_0/v3_four_channel_phase_distribution_0/v3_four_channel_output_collection_0/v3_four_channel_placement_0/v3_channel_selector_late_promotion_2/v3_selector_route_pilot_0/group3_lo_n v3_four_channel_output_load_integration_0/combined_n VGND sky130_fd_pr__nfet_01v8 ad=0 pd=0 as=0 ps=0 w=0.65 l=0.15
X760 VGND v3_four_channel_output_load_integration_0/v3_four_channel_shared_support_integration_0/v3_tail_bias_support_block_0/vbias v3_four_channel_output_load_integration_0/v3_four_channel_shared_support_integration_0/v3_four_channel_bias_reference_distribution_0/v3_four_channel_phase_distribution_0/v3_four_channel_output_collection_0/v3_four_channel_placement_0/v3_channel_selector_late_promotion_2/v3_channel_input_bias_late_promotion_0/a_4382_17688# VGND sky130_fd_pr__nfet_01v8 ad=0 pd=0 as=0 ps=0 w=5.07 l=1
X761 v3_four_channel_output_load_integration_0/combined_p v3_four_channel_output_load_integration_0/v3_four_channel_shared_support_integration_0/v3_four_channel_bias_reference_distribution_0/v3_four_channel_phase_distribution_0/v3_four_channel_output_collection_0/v3_four_channel_placement_0/v3_channel_selector_late_promotion_2/v3_selector_route_pilot_0/group3_lo_n v3_four_channel_output_load_integration_0/v3_four_channel_shared_support_integration_0/v3_four_channel_bias_reference_distribution_0/v3_four_channel_phase_distribution_0/v3_four_channel_output_collection_0/v3_four_channel_placement_0/v3_channel_selector_late_promotion_2/v3_channel_input_bias_late_promotion_0/a_7038_6978# VGND sky130_fd_pr__nfet_01v8 ad=0 pd=0 as=0 ps=0 w=0.65 l=0.15
X762 v3_four_channel_output_load_integration_0/combined_n v3_four_channel_output_load_integration_0/v3_four_channel_shared_support_integration_0/v3_four_channel_bias_reference_distribution_0/v3_four_channel_phase_distribution_0/v3_four_channel_output_collection_0/v3_four_channel_placement_0/v3_channel_selector_late_promotion_2/v3_selector_route_pilot_0/group2_lo_p v3_four_channel_output_load_integration_0/v3_four_channel_shared_support_integration_0/v3_four_channel_bias_reference_distribution_0/v3_four_channel_phase_distribution_0/v3_four_channel_output_collection_0/v3_four_channel_placement_0/v3_channel_selector_late_promotion_2/v3_channel_input_bias_late_promotion_0/a_4254_10978# VGND sky130_fd_pr__nfet_01v8 ad=0 pd=0 as=0 ps=0 w=0.65 l=0.15
X763 v3_four_channel_output_load_integration_0/v3_four_channel_shared_support_integration_0/v3_four_channel_bias_reference_distribution_0/v3_four_channel_phase_distribution_0/v3_four_channel_output_collection_0/v3_four_channel_placement_0/v3_channel_selector_late_promotion_2/v3_channel_input_bias_late_promotion_0/a_7462_11422# v3_four_channel_output_load_integration_0/v3_four_channel_shared_support_integration_0/v3_four_channel_bias_reference_distribution_0/v3_four_channel_phase_distribution_0/v3_four_channel_output_collection_0/v3_four_channel_placement_0/v3_channel_selector_late_promotion_2/v3_selector_route_pilot_0/group2_lo_p v3_four_channel_output_load_integration_0/combined_p VGND sky130_fd_pr__nfet_01v8 ad=0 pd=0 as=0 ps=0 w=0.65 l=0.15
X764 v3_four_channel_output_load_integration_0/v3_four_channel_shared_support_integration_0/v3_four_channel_bias_reference_distribution_0/v3_four_channel_phase_distribution_0/v3_four_channel_output_collection_0/v3_four_channel_placement_0/v3_channel_selector_late_promotion_2/v3_channel_input_bias_late_promotion_0/a_7166_21688# v3_four_channel_output_load_integration_0/v3_four_channel_shared_support_integration_0/v3_four_channel_bias_reference_distribution_0/v3_four_channel_phase_distribution_0/v3_four_channel_output_collection_0/v3_four_channel_placement_0/v3_channel_selector_late_promotion_2/element_input v3_four_channel_output_load_integration_0/v3_four_channel_shared_support_integration_0/v3_four_channel_bias_reference_distribution_0/v3_four_channel_phase_distribution_0/v3_four_channel_output_collection_0/v3_four_channel_placement_0/v3_channel_selector_late_promotion_2/v3_channel_input_bias_late_promotion_0/a_7038_22978# VGND sky130_fd_pr__nfet_01v8 ad=0 pd=0 as=0 ps=0 w=0.84 l=0.6
X765 v3_four_channel_output_load_integration_0/combined_n v3_four_channel_output_load_integration_0/v3_four_channel_shared_support_integration_0/v3_four_channel_bias_reference_distribution_0/v3_four_channel_phase_distribution_0/v3_four_channel_output_collection_0/v3_four_channel_placement_0/v3_channel_selector_late_promotion_2/v3_selector_route_pilot_0/group3_lo_n v3_four_channel_output_load_integration_0/v3_four_channel_shared_support_integration_0/v3_four_channel_bias_reference_distribution_0/v3_four_channel_phase_distribution_0/v3_four_channel_output_collection_0/v3_four_channel_placement_0/v3_channel_selector_late_promotion_2/v3_channel_input_bias_late_promotion_0/a_5646_22978# VGND sky130_fd_pr__nfet_01v8 ad=0 pd=0 as=0 ps=0 w=0.65 l=0.15
X766 v3_four_channel_output_load_integration_0/v3_four_channel_shared_support_integration_0/v3_four_channel_bias_reference_distribution_0/v3_four_channel_phase_distribution_0/v3_four_channel_output_collection_0/v3_four_channel_placement_0/v3_channel_selector_late_promotion_2/v3_channel_input_bias_late_promotion_0/a_4678_11422# v3_four_channel_output_load_integration_0/v3_four_channel_shared_support_integration_0/v3_four_channel_bias_reference_distribution_0/v3_four_channel_phase_distribution_0/v3_four_channel_output_collection_0/v3_four_channel_placement_0/v3_channel_selector_late_promotion_2/element_input v3_four_channel_output_load_integration_0/v3_four_channel_shared_support_integration_0/v3_four_channel_bias_reference_distribution_0/v3_four_channel_phase_distribution_0/v3_four_channel_output_collection_0/v3_four_channel_placement_0/v3_channel_selector_late_promotion_2/v3_channel_input_bias_late_promotion_0/a_4432_10978# VGND sky130_fd_pr__nfet_01v8 ad=0 pd=0 as=0 ps=0 w=0.84 l=0.6
X767 v3_four_channel_output_load_integration_0/v3_four_channel_shared_support_integration_0/v3_four_channel_bias_reference_distribution_0/v3_four_channel_phase_distribution_0/v3_four_channel_output_collection_0/v3_four_channel_placement_0/v3_channel_selector_late_promotion_2/v3_channel_input_bias_late_promotion_0/a_6070_23422# v3_four_channel_output_load_integration_0/v3_four_channel_shared_support_integration_0/v3_vcm_support_block_0/ref v3_four_channel_output_load_integration_0/v3_four_channel_shared_support_integration_0/v3_four_channel_bias_reference_distribution_0/v3_four_channel_phase_distribution_0/v3_four_channel_output_collection_0/v3_four_channel_placement_0/v3_channel_selector_late_promotion_2/v3_channel_input_bias_late_promotion_0/a_5774_21688# VGND sky130_fd_pr__nfet_01v8 ad=0 pd=0 as=0 ps=0 w=0.84 l=0.6
X768 v3_four_channel_output_load_integration_0/v3_four_channel_shared_support_integration_0/v3_four_channel_bias_reference_distribution_0/v3_four_channel_phase_distribution_0/v3_four_channel_output_collection_0/v3_four_channel_placement_0/v3_channel_selector_late_promotion_2/v3_channel_input_bias_late_promotion_0/a_6070_23422# v3_four_channel_output_load_integration_0/v3_four_channel_shared_support_integration_0/v3_four_channel_bias_reference_distribution_0/v3_four_channel_phase_distribution_0/v3_four_channel_output_collection_0/v3_four_channel_placement_0/v3_channel_selector_late_promotion_2/v3_selector_route_pilot_0/group3_lo_p v3_four_channel_output_load_integration_0/combined_n VGND sky130_fd_pr__nfet_01v8 ad=0 pd=0 as=0 ps=0 w=0.65 l=0.15
X769 v3_four_channel_output_load_integration_0/v3_four_channel_shared_support_integration_0/v3_four_channel_bias_reference_distribution_0/v3_four_channel_phase_distribution_0/v3_four_channel_output_collection_0/v3_four_channel_placement_0/v3_channel_selector_late_promotion_2/v3_channel_input_bias_late_promotion_0/a_4678_11422# v3_four_channel_output_load_integration_0/v3_four_channel_shared_support_integration_0/v3_four_channel_bias_reference_distribution_0/v3_four_channel_phase_distribution_0/v3_four_channel_output_collection_0/v3_four_channel_placement_0/v3_channel_selector_late_promotion_2/v3_selector_route_pilot_0/group2_lo_n v3_four_channel_output_load_integration_0/combined_n VGND sky130_fd_pr__nfet_01v8 ad=0 pd=0 as=0 ps=0 w=0.65 l=0.15
X770 v3_four_channel_output_load_integration_0/v3_four_channel_shared_support_integration_0/v3_four_channel_bias_reference_distribution_0/v3_four_channel_phase_distribution_0/v3_four_channel_output_collection_0/v3_four_channel_placement_0/v3_channel_selector_late_promotion_2/v3_channel_input_bias_late_promotion_0/a_7462_15422# v3_four_channel_output_load_integration_0/v3_four_channel_shared_support_integration_0/v3_four_channel_bias_reference_distribution_0/v3_four_channel_phase_distribution_0/v3_four_channel_output_collection_0/v3_four_channel_placement_0/v3_channel_selector_late_promotion_2/element_input v3_four_channel_output_load_integration_0/v3_four_channel_shared_support_integration_0/v3_four_channel_bias_reference_distribution_0/v3_four_channel_phase_distribution_0/v3_four_channel_output_collection_0/v3_four_channel_placement_0/v3_channel_selector_late_promotion_2/v3_channel_input_bias_late_promotion_0/a_7216_14978# VGND sky130_fd_pr__nfet_01v8 ad=0 pd=0 as=0 ps=0 w=0.84 l=0.6
X771 v3_four_channel_output_load_integration_0/v3_four_channel_shared_support_integration_0/v3_four_channel_bias_reference_distribution_0/v3_four_channel_phase_distribution_0/v3_four_channel_output_collection_0/v3_four_channel_placement_0/v3_channel_selector_late_promotion_2/v3_channel_input_bias_late_promotion_0/a_6070_7422# v3_four_channel_output_load_integration_0/v3_four_channel_shared_support_integration_0/v3_four_channel_bias_reference_distribution_0/v3_four_channel_phase_distribution_0/v3_four_channel_output_collection_0/v3_four_channel_placement_0/v3_channel_selector_late_promotion_2/v3_selector_route_pilot_0/group3_lo_p v3_four_channel_output_load_integration_0/combined_p VGND sky130_fd_pr__nfet_01v8 ad=0 pd=0 as=0 ps=0 w=0.65 l=0.15
X772 v3_four_channel_output_load_integration_0/combined_n v3_four_channel_output_load_integration_0/v3_four_channel_shared_support_integration_0/v3_four_channel_bias_reference_distribution_0/v3_four_channel_phase_distribution_0/v3_four_channel_output_collection_0/v3_four_channel_placement_0/v3_channel_selector_late_promotion_2/v3_selector_route_pilot_0/group2_lo_p v3_four_channel_output_load_integration_0/v3_four_channel_shared_support_integration_0/v3_four_channel_bias_reference_distribution_0/v3_four_channel_phase_distribution_0/v3_four_channel_output_collection_0/v3_four_channel_placement_0/v3_channel_selector_late_promotion_2/v3_channel_input_bias_late_promotion_0/a_7038_10978# VGND sky130_fd_pr__nfet_01v8 ad=0 pd=0 as=0 ps=0 w=0.65 l=0.15
X773 v3_four_channel_output_load_integration_0/v3_four_channel_shared_support_integration_0/v3_four_channel_bias_reference_distribution_0/v3_four_channel_phase_distribution_0/v3_four_channel_output_collection_0/v3_four_channel_placement_0/v3_channel_selector_late_promotion_2/v3_channel_input_bias_late_promotion_0/a_7462_15422# v3_four_channel_output_load_integration_0/v3_four_channel_shared_support_integration_0/v3_four_channel_bias_reference_distribution_0/v3_four_channel_phase_distribution_0/v3_four_channel_output_collection_0/v3_four_channel_placement_0/v3_channel_selector_late_promotion_2/v3_selector_route_pilot_0/group1_lo_n v3_four_channel_output_load_integration_0/combined_n VGND sky130_fd_pr__nfet_01v8 ad=0 pd=0 as=0 ps=0 w=0.65 l=0.15
X774 v3_four_channel_output_load_integration_0/v3_four_channel_shared_support_integration_0/v3_four_channel_bias_reference_distribution_0/v3_four_channel_phase_distribution_0/v3_four_channel_output_collection_0/v3_four_channel_placement_0/v3_channel_selector_late_promotion_2/v3_channel_input_bias_late_promotion_0/a_4432_6978# v3_four_channel_output_load_integration_0/v3_four_channel_shared_support_integration_0/v3_vcm_support_block_0/ref v3_four_channel_output_load_integration_0/v3_four_channel_shared_support_integration_0/v3_four_channel_bias_reference_distribution_0/v3_four_channel_phase_distribution_0/v3_four_channel_output_collection_0/v3_four_channel_placement_0/v3_channel_selector_late_promotion_2/v3_channel_input_bias_late_promotion_0/a_4254_6978# VGND sky130_fd_pr__nfet_01v8 ad=0 pd=0 as=0 ps=0 w=0.84 l=0.6
X775 v3_four_channel_output_load_integration_0/v3_four_channel_shared_support_integration_0/v3_four_channel_bias_reference_distribution_0/v3_four_channel_phase_distribution_0/v3_four_channel_output_collection_0/v3_four_channel_placement_0/v3_channel_selector_late_promotion_2/v3_channel_input_bias_late_promotion_0/a_5824_10978# v3_four_channel_output_load_integration_0/v3_four_channel_shared_support_integration_0/v3_vcm_support_block_0/ref v3_four_channel_output_load_integration_0/v3_four_channel_shared_support_integration_0/v3_four_channel_bias_reference_distribution_0/v3_four_channel_phase_distribution_0/v3_four_channel_output_collection_0/v3_four_channel_placement_0/v3_channel_selector_late_promotion_2/v3_channel_input_bias_late_promotion_0/a_5646_10978# VGND sky130_fd_pr__nfet_01v8 ad=0 pd=0 as=0 ps=0 w=0.84 l=0.6
X776 v3_four_channel_output_load_integration_0/combined_n v3_four_channel_output_load_integration_0/v3_four_channel_shared_support_integration_0/v3_four_channel_bias_reference_distribution_0/v3_four_channel_phase_distribution_0/v3_four_channel_output_collection_0/v3_four_channel_placement_0/v3_channel_selector_late_promotion_2/v3_selector_route_pilot_0/group3_lo_n v3_four_channel_output_load_integration_0/v3_four_channel_shared_support_integration_0/v3_four_channel_bias_reference_distribution_0/v3_four_channel_phase_distribution_0/v3_four_channel_output_collection_0/v3_four_channel_placement_0/v3_channel_selector_late_promotion_2/v3_channel_input_bias_late_promotion_0/a_4254_22978# VGND sky130_fd_pr__nfet_01v8 ad=0 pd=0 as=0 ps=0 w=0.65 l=0.15
X777 v3_four_channel_output_load_integration_0/v3_four_channel_shared_support_integration_0/v3_four_channel_bias_reference_distribution_0/v3_four_channel_phase_distribution_0/v3_four_channel_output_collection_0/v3_four_channel_placement_0/v3_channel_selector_late_promotion_2/v3_channel_input_bias_late_promotion_0/a_7462_23422# v3_four_channel_output_load_integration_0/v3_four_channel_shared_support_integration_0/v3_four_channel_bias_reference_distribution_0/v3_four_channel_phase_distribution_0/v3_four_channel_output_collection_0/v3_four_channel_placement_0/v3_channel_selector_late_promotion_2/v3_selector_route_pilot_0/group3_lo_n v3_four_channel_output_load_integration_0/combined_p VGND sky130_fd_pr__nfet_01v8 ad=0 pd=0 as=0 ps=0 w=0.65 l=0.15
X778 v3_four_channel_output_load_integration_0/v3_four_channel_shared_support_integration_0/v3_four_channel_bias_reference_distribution_0/v3_four_channel_phase_distribution_0/v3_four_channel_output_collection_0/v3_four_channel_placement_0/v3_channel_selector_late_promotion_2/v3_channel_input_bias_late_promotion_0/a_4432_6978# v3_four_channel_output_load_integration_0/v3_four_channel_shared_support_integration_0/v3_tail_bias_support_block_0/vbias VGND VGND sky130_fd_pr__nfet_01v8 ad=0 pd=0 as=0 ps=0 w=5.07 l=1
X779 v3_four_channel_output_load_integration_0/v3_four_channel_shared_support_integration_0/v3_four_channel_bias_reference_distribution_0/v3_four_channel_phase_distribution_0/v3_four_channel_output_collection_0/v3_four_channel_placement_0/v3_channel_selector_late_promotion_2/v3_channel_input_bias_late_promotion_0/a_7216_6978# v3_four_channel_output_load_integration_0/v3_four_channel_shared_support_integration_0/v3_vcm_support_block_0/ref v3_four_channel_output_load_integration_0/v3_four_channel_shared_support_integration_0/v3_four_channel_bias_reference_distribution_0/v3_four_channel_phase_distribution_0/v3_four_channel_output_collection_0/v3_four_channel_placement_0/v3_channel_selector_late_promotion_2/v3_channel_input_bias_late_promotion_0/a_7038_6978# VGND sky130_fd_pr__nfet_01v8 ad=0 pd=0 as=0 ps=0 w=0.84 l=0.6
X780 v3_four_channel_output_load_integration_0/combined_n v3_four_channel_output_load_integration_0/v3_four_channel_shared_support_integration_0/v3_four_channel_bias_reference_distribution_0/v3_four_channel_phase_distribution_0/v3_four_channel_output_collection_0/v3_four_channel_placement_0/v3_channel_selector_late_promotion_2/v3_selector_route_pilot_0/group3_lo_p v3_four_channel_output_load_integration_0/v3_four_channel_shared_support_integration_0/v3_four_channel_bias_reference_distribution_0/v3_four_channel_phase_distribution_0/v3_four_channel_output_collection_0/v3_four_channel_placement_0/v3_channel_selector_late_promotion_2/v3_channel_input_bias_late_promotion_0/a_5646_6978# VGND sky130_fd_pr__nfet_01v8 ad=0 pd=0 as=0 ps=0 w=0.65 l=0.15
X781 VGND v3_four_channel_output_load_integration_0/v3_four_channel_shared_support_integration_0/v3_tail_bias_support_block_0/vbias v3_four_channel_output_load_integration_0/v3_four_channel_shared_support_integration_0/v3_four_channel_bias_reference_distribution_0/v3_four_channel_phase_distribution_0/v3_four_channel_output_collection_0/v3_four_channel_placement_0/v3_channel_selector_late_promotion_2/v3_channel_input_bias_late_promotion_0/a_4382_13688# VGND sky130_fd_pr__nfet_01v8 ad=0 pd=0 as=0 ps=0 w=5.07 l=1
X782 VDPWR v3_four_channel_output_load_integration_0/v3_four_channel_shared_support_integration_0/v3_four_channel_bias_reference_distribution_0/v3_four_channel_phase_distribution_0/v3_four_channel_output_collection_0/v3_four_channel_placement_0/v3_channel_selector_late_promotion_2/v3_selector_route_pilot_0/G1_MUX_POS/a_505_21# v3_four_channel_output_load_integration_0/v3_four_channel_shared_support_integration_0/v3_four_channel_bias_reference_distribution_0/v3_four_channel_phase_distribution_0/v3_four_channel_output_collection_0/v3_four_channel_placement_0/v3_channel_selector_late_promotion_2/v3_selector_route_pilot_0/G1_MUX_POS/a_535_374# VDPWR sky130_fd_pr__pfet_01v8_hvt ad=0 pd=0 as=0.0882 ps=1.26 w=0.42 l=0.15
X783 v3_four_channel_output_load_integration_0/v3_four_channel_shared_support_integration_0/v3_four_channel_bias_reference_distribution_0/v3_four_channel_phase_distribution_0/v3_four_channel_output_collection_0/v3_four_channel_placement_0/v3_channel_selector_late_promotion_2/v3_selector_route_pilot_0/G1_MUX_POS/a_505_21# v3_four_channel_output_load_integration_0/v3_four_channel_shared_support_integration_0/v3_four_channel_bias_reference_distribution_0/v3_four_channel_phase_distribution_0/v3_four_channel_output_collection_0/v3_four_channel_placement_0/v3_channel_selector_late_promotion_2/group1_bit0 VDPWR VDPWR sky130_fd_pr__pfet_01v8_hvt ad=0.1176 pd=1.4 as=0 ps=0 w=0.42 l=0.15
X784 v3_four_channel_output_load_integration_0/v3_four_channel_shared_support_integration_0/v3_four_channel_bias_reference_distribution_0/v3_four_channel_phase_distribution_0/v3_four_channel_output_collection_0/v3_four_channel_placement_0/v3_channel_selector_late_promotion_2/v3_selector_route_pilot_0/G1_MUX_POS/a_218_374# v3_four_channel_output_load_integration_0/v3_four_channel_shared_support_integration_0/v3_four_channel_bias_reference_distribution_0/v3_four_channel_phase_distribution_0/v3_four_channel_output_collection_0/v3_four_channel_placement_0/v3_channel_selector_late_promotion_2/group1_bit0 VDPWR VDPWR sky130_fd_pr__pfet_01v8_hvt ad=0.1533 pd=1.57 as=0 ps=0 w=0.42 l=0.15
X785 VGND v3_four_channel_output_load_integration_0/v3_four_channel_shared_support_integration_0/v3_four_channel_bias_reference_distribution_0/v3_four_channel_phase_distribution_0/v3_four_channel_output_collection_0/v3_four_channel_placement_0/v3_channel_selector_late_promotion_2/v3_selector_route_pilot_0/G1_MUX_POS/a_505_21# v3_four_channel_output_load_integration_0/v3_four_channel_shared_support_integration_0/v3_four_channel_bias_reference_distribution_0/v3_four_channel_phase_distribution_0/v3_four_channel_output_collection_0/v3_four_channel_placement_0/v3_channel_selector_late_promotion_2/v3_selector_route_pilot_0/G1_MUX_POS/a_439_47# VGND sky130_fd_pr__nfet_01v8 ad=0 pd=0 as=0.1386 ps=1.5 w=0.42 l=0.15
X786 v3_four_channel_output_load_integration_0/v3_four_channel_shared_support_integration_0/v3_four_channel_bias_reference_distribution_0/v3_four_channel_phase_distribution_0/v3_four_channel_output_collection_0/v3_four_channel_placement_0/v3_channel_selector_late_promotion_2/v3_selector_route_pilot_0/G1_MUX_POS/a_76_199# v3_four_channel_output_load_integration_0/v3_four_channel_shared_support_integration_0/v3_four_channel_bias_reference_distribution_0/v3_four_channel_phase_distribution_0/phase_0 v3_four_channel_output_load_integration_0/v3_four_channel_shared_support_integration_0/v3_four_channel_bias_reference_distribution_0/v3_four_channel_phase_distribution_0/v3_four_channel_output_collection_0/v3_four_channel_placement_0/v3_channel_selector_late_promotion_2/v3_selector_route_pilot_0/G1_MUX_POS/a_218_374# VDPWR sky130_fd_pr__pfet_01v8_hvt ad=0.3864 pd=2.68 as=0 ps=0 w=0.42 l=0.15
X787 v3_four_channel_output_load_integration_0/v3_four_channel_shared_support_integration_0/v3_four_channel_bias_reference_distribution_0/v3_four_channel_phase_distribution_0/v3_four_channel_output_collection_0/v3_four_channel_placement_0/v3_channel_selector_late_promotion_2/v3_selector_route_pilot_0/G1_MUX_POS/a_505_21# v3_four_channel_output_load_integration_0/v3_four_channel_shared_support_integration_0/v3_four_channel_bias_reference_distribution_0/v3_four_channel_phase_distribution_0/v3_four_channel_output_collection_0/v3_four_channel_placement_0/v3_channel_selector_late_promotion_2/group1_bit0 VGND VGND sky130_fd_pr__nfet_01v8 ad=0.1092 pd=1.36 as=0 ps=0 w=0.42 l=0.15
X788 v3_four_channel_output_load_integration_0/v3_four_channel_shared_support_integration_0/v3_four_channel_bias_reference_distribution_0/v3_four_channel_phase_distribution_0/v3_four_channel_output_collection_0/v3_four_channel_placement_0/v3_channel_selector_late_promotion_2/v3_selector_route_pilot_0/G1_MUX_POS/a_439_47# v3_four_channel_output_load_integration_0/v3_four_channel_shared_support_integration_0/v3_four_channel_bias_reference_distribution_0/v3_four_channel_phase_distribution_0/phase_0 v3_four_channel_output_load_integration_0/v3_four_channel_shared_support_integration_0/v3_four_channel_bias_reference_distribution_0/v3_four_channel_phase_distribution_0/v3_four_channel_output_collection_0/v3_four_channel_placement_0/v3_channel_selector_late_promotion_2/v3_selector_route_pilot_0/G1_MUX_POS/a_76_199# VGND sky130_fd_pr__nfet_01v8 ad=0 pd=0 as=0.1995 ps=1.79 w=0.42 l=0.15
X789 v3_four_channel_output_load_integration_0/v3_four_channel_shared_support_integration_0/v3_four_channel_bias_reference_distribution_0/v3_four_channel_phase_distribution_0/v3_four_channel_output_collection_0/v3_four_channel_placement_0/v3_channel_selector_late_promotion_2/v3_selector_route_pilot_0/G1_MUX_POS/a_535_374# v3_four_channel_output_load_integration_0/v3_four_channel_shared_support_integration_0/v3_four_channel_bias_reference_distribution_0/v3_four_channel_phase_distribution_0/phase_90 v3_four_channel_output_load_integration_0/v3_four_channel_shared_support_integration_0/v3_four_channel_bias_reference_distribution_0/v3_four_channel_phase_distribution_0/v3_four_channel_output_collection_0/v3_four_channel_placement_0/v3_channel_selector_late_promotion_2/v3_selector_route_pilot_0/G1_MUX_POS/a_76_199# VDPWR sky130_fd_pr__pfet_01v8_hvt ad=0 pd=0 as=0 ps=0 w=0.42 l=0.15
X790 v3_four_channel_output_load_integration_0/v3_four_channel_shared_support_integration_0/v3_four_channel_bias_reference_distribution_0/v3_four_channel_phase_distribution_0/v3_four_channel_output_collection_0/v3_four_channel_placement_0/v3_channel_selector_late_promotion_2/v3_selector_route_pilot_0/G1_MUX_POS/a_76_199# v3_four_channel_output_load_integration_0/v3_four_channel_shared_support_integration_0/v3_four_channel_bias_reference_distribution_0/v3_four_channel_phase_distribution_0/phase_90 v3_four_channel_output_load_integration_0/v3_four_channel_shared_support_integration_0/v3_four_channel_bias_reference_distribution_0/v3_four_channel_phase_distribution_0/v3_four_channel_output_collection_0/v3_four_channel_placement_0/v3_channel_selector_late_promotion_2/v3_selector_route_pilot_0/G1_MUX_POS/a_218_47# VGND sky130_fd_pr__nfet_01v8 ad=0 pd=0 as=0.1386 ps=1.5 w=0.42 l=0.15
X791 v3_four_channel_output_load_integration_0/v3_four_channel_shared_support_integration_0/v3_four_channel_bias_reference_distribution_0/v3_four_channel_phase_distribution_0/v3_four_channel_output_collection_0/v3_four_channel_placement_0/v3_channel_selector_late_promotion_2/v3_selector_route_pilot_0/G1_MUX_POS/a_218_47# v3_four_channel_output_load_integration_0/v3_four_channel_shared_support_integration_0/v3_four_channel_bias_reference_distribution_0/v3_four_channel_phase_distribution_0/v3_four_channel_output_collection_0/v3_four_channel_placement_0/v3_channel_selector_late_promotion_2/group1_bit0 VGND VGND sky130_fd_pr__nfet_01v8 ad=0 pd=0 as=0 ps=0 w=0.42 l=0.15
X792 VDPWR v3_four_channel_output_load_integration_0/v3_four_channel_shared_support_integration_0/v3_four_channel_bias_reference_distribution_0/v3_four_channel_phase_distribution_0/v3_four_channel_output_collection_0/v3_four_channel_placement_0/v3_channel_selector_late_promotion_2/v3_selector_route_pilot_0/G1_MUX_POS/a_76_199# v3_four_channel_output_load_integration_0/v3_four_channel_shared_support_integration_0/v3_four_channel_bias_reference_distribution_0/v3_four_channel_phase_distribution_0/v3_four_channel_output_collection_0/v3_four_channel_placement_0/v3_channel_selector_late_promotion_2/v3_selector_route_pilot_0/G1_MUX_POS/X VDPWR sky130_fd_pr__pfet_01v8_hvt ad=0 pd=0 as=0.26 ps=2.52 w=1 l=0.15
X793 VGND v3_four_channel_output_load_integration_0/v3_four_channel_shared_support_integration_0/v3_four_channel_bias_reference_distribution_0/v3_four_channel_phase_distribution_0/v3_four_channel_output_collection_0/v3_four_channel_placement_0/v3_channel_selector_late_promotion_2/v3_selector_route_pilot_0/G1_MUX_POS/a_76_199# v3_four_channel_output_load_integration_0/v3_four_channel_shared_support_integration_0/v3_four_channel_bias_reference_distribution_0/v3_four_channel_phase_distribution_0/v3_four_channel_output_collection_0/v3_four_channel_placement_0/v3_channel_selector_late_promotion_2/v3_selector_route_pilot_0/G1_MUX_POS/X VGND sky130_fd_pr__nfet_01v8 ad=0 pd=0 as=0.169 ps=1.82 w=0.65 l=0.15
X794 VDPWR v3_four_channel_output_load_integration_0/v3_four_channel_shared_support_integration_0/v3_four_channel_bias_reference_distribution_0/v3_four_channel_phase_distribution_0/v3_four_channel_output_collection_0/v3_four_channel_placement_0/v3_channel_selector_late_promotion_2/v3_selector_route_pilot_0/G3_MUX_AXIS/a_505_21# v3_four_channel_output_load_integration_0/v3_four_channel_shared_support_integration_0/v3_four_channel_bias_reference_distribution_0/v3_four_channel_phase_distribution_0/v3_four_channel_output_collection_0/v3_four_channel_placement_0/v3_channel_selector_late_promotion_2/v3_selector_route_pilot_0/G3_MUX_AXIS/a_535_374# VDPWR sky130_fd_pr__pfet_01v8_hvt ad=0 pd=0 as=0.0882 ps=1.26 w=0.42 l=0.15
X795 v3_four_channel_output_load_integration_0/v3_four_channel_shared_support_integration_0/v3_four_channel_bias_reference_distribution_0/v3_four_channel_phase_distribution_0/v3_four_channel_output_collection_0/v3_four_channel_placement_0/v3_channel_selector_late_promotion_2/v3_selector_route_pilot_0/G3_MUX_AXIS/a_505_21# v3_four_channel_output_load_integration_0/v3_four_channel_shared_support_integration_0/v3_four_channel_bias_reference_distribution_0/v3_four_channel_phase_distribution_0/v3_four_channel_output_collection_0/v3_four_channel_placement_0/v3_channel_selector_late_promotion_2/group3_bit1 VDPWR VDPWR sky130_fd_pr__pfet_01v8_hvt ad=0.1176 pd=1.4 as=0 ps=0 w=0.42 l=0.15
X796 v3_four_channel_output_load_integration_0/v3_four_channel_shared_support_integration_0/v3_four_channel_bias_reference_distribution_0/v3_four_channel_phase_distribution_0/v3_four_channel_output_collection_0/v3_four_channel_placement_0/v3_channel_selector_late_promotion_2/v3_selector_route_pilot_0/G3_MUX_AXIS/a_218_374# v3_four_channel_output_load_integration_0/v3_four_channel_shared_support_integration_0/v3_four_channel_bias_reference_distribution_0/v3_four_channel_phase_distribution_0/v3_four_channel_output_collection_0/v3_four_channel_placement_0/v3_channel_selector_late_promotion_2/group3_bit1 VDPWR VDPWR sky130_fd_pr__pfet_01v8_hvt ad=0.1533 pd=1.57 as=0 ps=0 w=0.42 l=0.15
X797 VGND v3_four_channel_output_load_integration_0/v3_four_channel_shared_support_integration_0/v3_four_channel_bias_reference_distribution_0/v3_four_channel_phase_distribution_0/v3_four_channel_output_collection_0/v3_four_channel_placement_0/v3_channel_selector_late_promotion_2/v3_selector_route_pilot_0/G3_MUX_AXIS/a_505_21# v3_four_channel_output_load_integration_0/v3_four_channel_shared_support_integration_0/v3_four_channel_bias_reference_distribution_0/v3_four_channel_phase_distribution_0/v3_four_channel_output_collection_0/v3_four_channel_placement_0/v3_channel_selector_late_promotion_2/v3_selector_route_pilot_0/G3_MUX_AXIS/a_439_47# VGND sky130_fd_pr__nfet_01v8 ad=0 pd=0 as=0.1386 ps=1.5 w=0.42 l=0.15
X798 v3_four_channel_output_load_integration_0/v3_four_channel_shared_support_integration_0/v3_four_channel_bias_reference_distribution_0/v3_four_channel_phase_distribution_0/v3_four_channel_output_collection_0/v3_four_channel_placement_0/v3_channel_selector_late_promotion_2/v3_selector_route_pilot_0/G3_MUX_AXIS/a_76_199# v3_four_channel_output_load_integration_0/v3_four_channel_shared_support_integration_0/v3_four_channel_bias_reference_distribution_0/v3_four_channel_phase_distribution_0/v3_four_channel_output_collection_0/v3_four_channel_placement_0/v3_channel_selector_late_promotion_2/v3_selector_route_pilot_0/G3_MUX_POS/X v3_four_channel_output_load_integration_0/v3_four_channel_shared_support_integration_0/v3_four_channel_bias_reference_distribution_0/v3_four_channel_phase_distribution_0/v3_four_channel_output_collection_0/v3_four_channel_placement_0/v3_channel_selector_late_promotion_2/v3_selector_route_pilot_0/G3_MUX_AXIS/a_218_374# VDPWR sky130_fd_pr__pfet_01v8_hvt ad=0.3864 pd=2.68 as=0 ps=0 w=0.42 l=0.15
X799 v3_four_channel_output_load_integration_0/v3_four_channel_shared_support_integration_0/v3_four_channel_bias_reference_distribution_0/v3_four_channel_phase_distribution_0/v3_four_channel_output_collection_0/v3_four_channel_placement_0/v3_channel_selector_late_promotion_2/v3_selector_route_pilot_0/G3_MUX_AXIS/a_505_21# v3_four_channel_output_load_integration_0/v3_four_channel_shared_support_integration_0/v3_four_channel_bias_reference_distribution_0/v3_four_channel_phase_distribution_0/v3_four_channel_output_collection_0/v3_four_channel_placement_0/v3_channel_selector_late_promotion_2/group3_bit1 VGND VGND sky130_fd_pr__nfet_01v8 ad=0.1092 pd=1.36 as=0 ps=0 w=0.42 l=0.15
X800 v3_four_channel_output_load_integration_0/v3_four_channel_shared_support_integration_0/v3_four_channel_bias_reference_distribution_0/v3_four_channel_phase_distribution_0/v3_four_channel_output_collection_0/v3_four_channel_placement_0/v3_channel_selector_late_promotion_2/v3_selector_route_pilot_0/G3_MUX_AXIS/a_439_47# v3_four_channel_output_load_integration_0/v3_four_channel_shared_support_integration_0/v3_four_channel_bias_reference_distribution_0/v3_four_channel_phase_distribution_0/v3_four_channel_output_collection_0/v3_four_channel_placement_0/v3_channel_selector_late_promotion_2/v3_selector_route_pilot_0/G3_MUX_POS/X v3_four_channel_output_load_integration_0/v3_four_channel_shared_support_integration_0/v3_four_channel_bias_reference_distribution_0/v3_four_channel_phase_distribution_0/v3_four_channel_output_collection_0/v3_four_channel_placement_0/v3_channel_selector_late_promotion_2/v3_selector_route_pilot_0/G3_MUX_AXIS/a_76_199# VGND sky130_fd_pr__nfet_01v8 ad=0 pd=0 as=0.1995 ps=1.79 w=0.42 l=0.15
X801 v3_four_channel_output_load_integration_0/v3_four_channel_shared_support_integration_0/v3_four_channel_bias_reference_distribution_0/v3_four_channel_phase_distribution_0/v3_four_channel_output_collection_0/v3_four_channel_placement_0/v3_channel_selector_late_promotion_2/v3_selector_route_pilot_0/G3_MUX_AXIS/a_535_374# v3_four_channel_output_load_integration_0/v3_four_channel_shared_support_integration_0/v3_four_channel_bias_reference_distribution_0/v3_four_channel_phase_distribution_0/v3_four_channel_output_collection_0/v3_four_channel_placement_0/v3_channel_selector_late_promotion_2/v3_selector_route_pilot_0/G3_MUX_NEG/X v3_four_channel_output_load_integration_0/v3_four_channel_shared_support_integration_0/v3_four_channel_bias_reference_distribution_0/v3_four_channel_phase_distribution_0/v3_four_channel_output_collection_0/v3_four_channel_placement_0/v3_channel_selector_late_promotion_2/v3_selector_route_pilot_0/G3_MUX_AXIS/a_76_199# VDPWR sky130_fd_pr__pfet_01v8_hvt ad=0 pd=0 as=0 ps=0 w=0.42 l=0.15
X802 v3_four_channel_output_load_integration_0/v3_four_channel_shared_support_integration_0/v3_four_channel_bias_reference_distribution_0/v3_four_channel_phase_distribution_0/v3_four_channel_output_collection_0/v3_four_channel_placement_0/v3_channel_selector_late_promotion_2/v3_selector_route_pilot_0/G3_MUX_AXIS/a_76_199# v3_four_channel_output_load_integration_0/v3_four_channel_shared_support_integration_0/v3_four_channel_bias_reference_distribution_0/v3_four_channel_phase_distribution_0/v3_four_channel_output_collection_0/v3_four_channel_placement_0/v3_channel_selector_late_promotion_2/v3_selector_route_pilot_0/G3_MUX_NEG/X v3_four_channel_output_load_integration_0/v3_four_channel_shared_support_integration_0/v3_four_channel_bias_reference_distribution_0/v3_four_channel_phase_distribution_0/v3_four_channel_output_collection_0/v3_four_channel_placement_0/v3_channel_selector_late_promotion_2/v3_selector_route_pilot_0/G3_MUX_AXIS/a_218_47# VGND sky130_fd_pr__nfet_01v8 ad=0 pd=0 as=0.1386 ps=1.5 w=0.42 l=0.15
X803 v3_four_channel_output_load_integration_0/v3_four_channel_shared_support_integration_0/v3_four_channel_bias_reference_distribution_0/v3_four_channel_phase_distribution_0/v3_four_channel_output_collection_0/v3_four_channel_placement_0/v3_channel_selector_late_promotion_2/v3_selector_route_pilot_0/G3_MUX_AXIS/a_218_47# v3_four_channel_output_load_integration_0/v3_four_channel_shared_support_integration_0/v3_four_channel_bias_reference_distribution_0/v3_four_channel_phase_distribution_0/v3_four_channel_output_collection_0/v3_four_channel_placement_0/v3_channel_selector_late_promotion_2/group3_bit1 VGND VGND sky130_fd_pr__nfet_01v8 ad=0 pd=0 as=0 ps=0 w=0.42 l=0.15
X804 VDPWR v3_four_channel_output_load_integration_0/v3_four_channel_shared_support_integration_0/v3_four_channel_bias_reference_distribution_0/v3_four_channel_phase_distribution_0/v3_four_channel_output_collection_0/v3_four_channel_placement_0/v3_channel_selector_late_promotion_2/v3_selector_route_pilot_0/G3_MUX_AXIS/a_76_199# v3_four_channel_output_load_integration_0/v3_four_channel_shared_support_integration_0/v3_four_channel_bias_reference_distribution_0/v3_four_channel_phase_distribution_0/v3_four_channel_output_collection_0/v3_four_channel_placement_0/v3_channel_selector_late_promotion_2/v3_selector_route_pilot_0/G3_MUX_AXIS/X VDPWR sky130_fd_pr__pfet_01v8_hvt ad=0 pd=0 as=0.26 ps=2.52 w=1 l=0.15
X805 VGND v3_four_channel_output_load_integration_0/v3_four_channel_shared_support_integration_0/v3_four_channel_bias_reference_distribution_0/v3_four_channel_phase_distribution_0/v3_four_channel_output_collection_0/v3_four_channel_placement_0/v3_channel_selector_late_promotion_2/v3_selector_route_pilot_0/G3_MUX_AXIS/a_76_199# v3_four_channel_output_load_integration_0/v3_four_channel_shared_support_integration_0/v3_four_channel_bias_reference_distribution_0/v3_four_channel_phase_distribution_0/v3_four_channel_output_collection_0/v3_four_channel_placement_0/v3_channel_selector_late_promotion_2/v3_selector_route_pilot_0/G3_MUX_AXIS/X VGND sky130_fd_pr__nfet_01v8 ad=0 pd=0 as=0.169 ps=1.82 w=0.65 l=0.15
X806 VDPWR v3_four_channel_output_load_integration_0/v3_four_channel_shared_support_integration_0/v3_four_channel_bias_reference_distribution_0/v3_four_channel_phase_distribution_0/v3_four_channel_output_collection_0/v3_four_channel_placement_0/v3_channel_selector_late_promotion_2/channel_enable v3_four_channel_output_load_integration_0/v3_four_channel_shared_support_integration_0/v3_four_channel_bias_reference_distribution_0/v3_four_channel_phase_distribution_0/v3_four_channel_output_collection_0/v3_four_channel_placement_0/v3_channel_selector_late_promotion_2/v3_selector_route_pilot_0/ENABLE_ANDNOT/a_207_413# VDPWR sky130_fd_pr__pfet_01v8_hvt ad=0 pd=0 as=0.1218 ps=1.42 w=0.42 l=0.15
X807 v3_four_channel_output_load_integration_0/v3_four_channel_shared_support_integration_0/v3_four_channel_bias_reference_distribution_0/v3_four_channel_phase_distribution_0/v3_four_channel_output_collection_0/v3_four_channel_placement_0/v3_channel_selector_late_promotion_2/v3_selector_route_pilot_0/G3_LO_P_AND/B v3_four_channel_output_load_integration_0/v3_four_channel_shared_support_integration_0/v3_four_channel_bias_reference_distribution_0/v3_four_channel_phase_distribution_0/v3_four_channel_output_collection_0/v3_four_channel_placement_0/v3_channel_selector_late_promotion_2/v3_selector_route_pilot_0/ENABLE_ANDNOT/a_207_413# VDPWR VDPWR sky130_fd_pr__pfet_01v8_hvt ad=0.26 pd=2.52 as=0 ps=0 w=1 l=0.15
X808 v3_four_channel_output_load_integration_0/v3_four_channel_shared_support_integration_0/v3_four_channel_bias_reference_distribution_0/v3_four_channel_phase_distribution_0/v3_four_channel_output_collection_0/v3_four_channel_placement_0/v3_channel_selector_late_promotion_2/v3_selector_route_pilot_0/ENABLE_ANDNOT/a_297_47# v3_four_channel_output_load_integration_0/v3_four_channel_shared_support_integration_0/v3_four_channel_bias_reference_distribution_0/v3_four_channel_phase_distribution_0/v3_four_channel_output_collection_0/v3_four_channel_placement_0/v3_channel_selector_late_promotion_2/v3_selector_route_pilot_0/ENABLE_ANDNOT/a_27_413# v3_four_channel_output_load_integration_0/v3_four_channel_shared_support_integration_0/v3_four_channel_bias_reference_distribution_0/v3_four_channel_phase_distribution_0/v3_four_channel_output_collection_0/v3_four_channel_placement_0/v3_channel_selector_late_promotion_2/v3_selector_route_pilot_0/ENABLE_ANDNOT/a_207_413# VGND sky130_fd_pr__nfet_01v8 ad=0.1008 pd=1.32 as=0.1092 ps=1.36 w=0.42 l=0.15
X809 v3_four_channel_output_load_integration_0/v3_four_channel_shared_support_integration_0/v3_four_channel_bias_reference_distribution_0/v3_four_channel_phase_distribution_0/v3_four_channel_output_collection_0/v3_four_channel_placement_0/v3_channel_selector_late_promotion_2/v3_selector_route_pilot_0/G3_LO_P_AND/B v3_four_channel_output_load_integration_0/v3_four_channel_shared_support_integration_0/v3_four_channel_bias_reference_distribution_0/v3_four_channel_phase_distribution_0/v3_four_channel_output_collection_0/v3_four_channel_placement_0/v3_channel_selector_late_promotion_2/v3_selector_route_pilot_0/ENABLE_ANDNOT/a_207_413# VGND VGND sky130_fd_pr__nfet_01v8 ad=0.169 pd=1.82 as=0 ps=0 w=0.65 l=0.15
X810 v3_four_channel_output_load_integration_0/v3_four_channel_shared_support_integration_0/v3_four_channel_bias_reference_distribution_0/v3_four_channel_phase_distribution_0/v3_four_channel_output_collection_0/v3_four_channel_placement_0/v3_channel_selector_late_promotion_2/v3_selector_route_pilot_0/ENABLE_ANDNOT/a_207_413# v3_four_channel_output_load_integration_0/v3_four_channel_shared_support_integration_0/v3_four_channel_bias_reference_distribution_0/v3_four_channel_phase_distribution_0/v3_four_channel_output_collection_0/v3_four_channel_placement_0/v3_channel_selector_late_promotion_2/v3_selector_route_pilot_0/ENABLE_ANDNOT/a_27_413# VDPWR VDPWR sky130_fd_pr__pfet_01v8_hvt ad=0 pd=0 as=0 ps=0 w=0.42 l=0.15
X811 VDPWR v3_four_channel_output_load_integration_0/v3_four_channel_shared_support_integration_0/v3_four_channel_bias_reference_distribution_0/v3_four_channel_phase_distribution_0/v3_four_channel_output_collection_0/v3_four_channel_placement_0/v3_channel_selector_late_promotion_2/mixers_blank v3_four_channel_output_load_integration_0/v3_four_channel_shared_support_integration_0/v3_four_channel_bias_reference_distribution_0/v3_four_channel_phase_distribution_0/v3_four_channel_output_collection_0/v3_four_channel_placement_0/v3_channel_selector_late_promotion_2/v3_selector_route_pilot_0/ENABLE_ANDNOT/a_27_413# VDPWR sky130_fd_pr__pfet_01v8_hvt ad=0 pd=0 as=0.1092 ps=1.36 w=0.42 l=0.15
X812 VGND v3_four_channel_output_load_integration_0/v3_four_channel_shared_support_integration_0/v3_four_channel_bias_reference_distribution_0/v3_four_channel_phase_distribution_0/v3_four_channel_output_collection_0/v3_four_channel_placement_0/v3_channel_selector_late_promotion_2/channel_enable v3_four_channel_output_load_integration_0/v3_four_channel_shared_support_integration_0/v3_four_channel_bias_reference_distribution_0/v3_four_channel_phase_distribution_0/v3_four_channel_output_collection_0/v3_four_channel_placement_0/v3_channel_selector_late_promotion_2/v3_selector_route_pilot_0/ENABLE_ANDNOT/a_297_47# VGND sky130_fd_pr__nfet_01v8 ad=0 pd=0 as=0 ps=0 w=0.42 l=0.15
X813 v3_four_channel_output_load_integration_0/v3_four_channel_shared_support_integration_0/v3_four_channel_bias_reference_distribution_0/v3_four_channel_phase_distribution_0/v3_four_channel_output_collection_0/v3_four_channel_placement_0/v3_channel_selector_late_promotion_2/v3_selector_route_pilot_0/ENABLE_ANDNOT/a_27_413# v3_four_channel_output_load_integration_0/v3_four_channel_shared_support_integration_0/v3_four_channel_bias_reference_distribution_0/v3_four_channel_phase_distribution_0/v3_four_channel_output_collection_0/v3_four_channel_placement_0/v3_channel_selector_late_promotion_2/mixers_blank VGND VGND sky130_fd_pr__nfet_01v8 ad=0.1092 pd=1.36 as=0 ps=0 w=0.42 l=0.15
X814 VDPWR v3_four_channel_output_load_integration_0/v3_four_channel_shared_support_integration_0/v3_four_channel_bias_reference_distribution_0/v3_four_channel_phase_distribution_0/v3_four_channel_output_collection_0/v3_four_channel_placement_0/v3_channel_selector_late_promotion_2/v3_selector_route_pilot_0/G1_MUX_NEG/a_505_21# v3_four_channel_output_load_integration_0/v3_four_channel_shared_support_integration_0/v3_four_channel_bias_reference_distribution_0/v3_four_channel_phase_distribution_0/v3_four_channel_output_collection_0/v3_four_channel_placement_0/v3_channel_selector_late_promotion_2/v3_selector_route_pilot_0/G1_MUX_NEG/a_535_374# VDPWR sky130_fd_pr__pfet_01v8_hvt ad=0 pd=0 as=0.0882 ps=1.26 w=0.42 l=0.15
X815 v3_four_channel_output_load_integration_0/v3_four_channel_shared_support_integration_0/v3_four_channel_bias_reference_distribution_0/v3_four_channel_phase_distribution_0/v3_four_channel_output_collection_0/v3_four_channel_placement_0/v3_channel_selector_late_promotion_2/v3_selector_route_pilot_0/G1_MUX_NEG/a_505_21# v3_four_channel_output_load_integration_0/v3_four_channel_shared_support_integration_0/v3_four_channel_bias_reference_distribution_0/v3_four_channel_phase_distribution_0/v3_four_channel_output_collection_0/v3_four_channel_placement_0/v3_channel_selector_late_promotion_2/group1_bit0 VDPWR VDPWR sky130_fd_pr__pfet_01v8_hvt ad=0.1176 pd=1.4 as=0 ps=0 w=0.42 l=0.15
X816 v3_four_channel_output_load_integration_0/v3_four_channel_shared_support_integration_0/v3_four_channel_bias_reference_distribution_0/v3_four_channel_phase_distribution_0/v3_four_channel_output_collection_0/v3_four_channel_placement_0/v3_channel_selector_late_promotion_2/v3_selector_route_pilot_0/G1_MUX_NEG/a_218_374# v3_four_channel_output_load_integration_0/v3_four_channel_shared_support_integration_0/v3_four_channel_bias_reference_distribution_0/v3_four_channel_phase_distribution_0/v3_four_channel_output_collection_0/v3_four_channel_placement_0/v3_channel_selector_late_promotion_2/group1_bit0 VDPWR VDPWR sky130_fd_pr__pfet_01v8_hvt ad=0.1533 pd=1.57 as=0 ps=0 w=0.42 l=0.15
X817 VGND v3_four_channel_output_load_integration_0/v3_four_channel_shared_support_integration_0/v3_four_channel_bias_reference_distribution_0/v3_four_channel_phase_distribution_0/v3_four_channel_output_collection_0/v3_four_channel_placement_0/v3_channel_selector_late_promotion_2/v3_selector_route_pilot_0/G1_MUX_NEG/a_505_21# v3_four_channel_output_load_integration_0/v3_four_channel_shared_support_integration_0/v3_four_channel_bias_reference_distribution_0/v3_four_channel_phase_distribution_0/v3_four_channel_output_collection_0/v3_four_channel_placement_0/v3_channel_selector_late_promotion_2/v3_selector_route_pilot_0/G1_MUX_NEG/a_439_47# VGND sky130_fd_pr__nfet_01v8 ad=0 pd=0 as=0.1386 ps=1.5 w=0.42 l=0.15
X818 v3_four_channel_output_load_integration_0/v3_four_channel_shared_support_integration_0/v3_four_channel_bias_reference_distribution_0/v3_four_channel_phase_distribution_0/v3_four_channel_output_collection_0/v3_four_channel_placement_0/v3_channel_selector_late_promotion_2/v3_selector_route_pilot_0/G1_MUX_NEG/a_76_199# v3_four_channel_output_load_integration_0/v3_four_channel_shared_support_integration_0/v3_four_channel_bias_reference_distribution_0/v3_four_channel_phase_distribution_0/phase_180 v3_four_channel_output_load_integration_0/v3_four_channel_shared_support_integration_0/v3_four_channel_bias_reference_distribution_0/v3_four_channel_phase_distribution_0/v3_four_channel_output_collection_0/v3_four_channel_placement_0/v3_channel_selector_late_promotion_2/v3_selector_route_pilot_0/G1_MUX_NEG/a_218_374# VDPWR sky130_fd_pr__pfet_01v8_hvt ad=0.3864 pd=2.68 as=0 ps=0 w=0.42 l=0.15
X819 v3_four_channel_output_load_integration_0/v3_four_channel_shared_support_integration_0/v3_four_channel_bias_reference_distribution_0/v3_four_channel_phase_distribution_0/v3_four_channel_output_collection_0/v3_four_channel_placement_0/v3_channel_selector_late_promotion_2/v3_selector_route_pilot_0/G1_MUX_NEG/a_505_21# v3_four_channel_output_load_integration_0/v3_four_channel_shared_support_integration_0/v3_four_channel_bias_reference_distribution_0/v3_four_channel_phase_distribution_0/v3_four_channel_output_collection_0/v3_four_channel_placement_0/v3_channel_selector_late_promotion_2/group1_bit0 VGND VGND sky130_fd_pr__nfet_01v8 ad=0.1092 pd=1.36 as=0 ps=0 w=0.42 l=0.15
X820 v3_four_channel_output_load_integration_0/v3_four_channel_shared_support_integration_0/v3_four_channel_bias_reference_distribution_0/v3_four_channel_phase_distribution_0/v3_four_channel_output_collection_0/v3_four_channel_placement_0/v3_channel_selector_late_promotion_2/v3_selector_route_pilot_0/G1_MUX_NEG/a_439_47# v3_four_channel_output_load_integration_0/v3_four_channel_shared_support_integration_0/v3_four_channel_bias_reference_distribution_0/v3_four_channel_phase_distribution_0/phase_180 v3_four_channel_output_load_integration_0/v3_four_channel_shared_support_integration_0/v3_four_channel_bias_reference_distribution_0/v3_four_channel_phase_distribution_0/v3_four_channel_output_collection_0/v3_four_channel_placement_0/v3_channel_selector_late_promotion_2/v3_selector_route_pilot_0/G1_MUX_NEG/a_76_199# VGND sky130_fd_pr__nfet_01v8 ad=0 pd=0 as=0.1995 ps=1.79 w=0.42 l=0.15
X821 v3_four_channel_output_load_integration_0/v3_four_channel_shared_support_integration_0/v3_four_channel_bias_reference_distribution_0/v3_four_channel_phase_distribution_0/v3_four_channel_output_collection_0/v3_four_channel_placement_0/v3_channel_selector_late_promotion_2/v3_selector_route_pilot_0/G1_MUX_NEG/a_535_374# v3_four_channel_output_load_integration_0/v3_four_channel_shared_support_integration_0/v3_four_channel_bias_reference_distribution_0/v3_four_channel_phase_distribution_0/phase_270 v3_four_channel_output_load_integration_0/v3_four_channel_shared_support_integration_0/v3_four_channel_bias_reference_distribution_0/v3_four_channel_phase_distribution_0/v3_four_channel_output_collection_0/v3_four_channel_placement_0/v3_channel_selector_late_promotion_2/v3_selector_route_pilot_0/G1_MUX_NEG/a_76_199# VDPWR sky130_fd_pr__pfet_01v8_hvt ad=0 pd=0 as=0 ps=0 w=0.42 l=0.15
X822 v3_four_channel_output_load_integration_0/v3_four_channel_shared_support_integration_0/v3_four_channel_bias_reference_distribution_0/v3_four_channel_phase_distribution_0/v3_four_channel_output_collection_0/v3_four_channel_placement_0/v3_channel_selector_late_promotion_2/v3_selector_route_pilot_0/G1_MUX_NEG/a_76_199# v3_four_channel_output_load_integration_0/v3_four_channel_shared_support_integration_0/v3_four_channel_bias_reference_distribution_0/v3_four_channel_phase_distribution_0/phase_270 v3_four_channel_output_load_integration_0/v3_four_channel_shared_support_integration_0/v3_four_channel_bias_reference_distribution_0/v3_four_channel_phase_distribution_0/v3_four_channel_output_collection_0/v3_four_channel_placement_0/v3_channel_selector_late_promotion_2/v3_selector_route_pilot_0/G1_MUX_NEG/a_218_47# VGND sky130_fd_pr__nfet_01v8 ad=0 pd=0 as=0.1386 ps=1.5 w=0.42 l=0.15
X823 v3_four_channel_output_load_integration_0/v3_four_channel_shared_support_integration_0/v3_four_channel_bias_reference_distribution_0/v3_four_channel_phase_distribution_0/v3_four_channel_output_collection_0/v3_four_channel_placement_0/v3_channel_selector_late_promotion_2/v3_selector_route_pilot_0/G1_MUX_NEG/a_218_47# v3_four_channel_output_load_integration_0/v3_four_channel_shared_support_integration_0/v3_four_channel_bias_reference_distribution_0/v3_four_channel_phase_distribution_0/v3_four_channel_output_collection_0/v3_four_channel_placement_0/v3_channel_selector_late_promotion_2/group1_bit0 VGND VGND sky130_fd_pr__nfet_01v8 ad=0 pd=0 as=0 ps=0 w=0.42 l=0.15
X824 VDPWR v3_four_channel_output_load_integration_0/v3_four_channel_shared_support_integration_0/v3_four_channel_bias_reference_distribution_0/v3_four_channel_phase_distribution_0/v3_four_channel_output_collection_0/v3_four_channel_placement_0/v3_channel_selector_late_promotion_2/v3_selector_route_pilot_0/G1_MUX_NEG/a_76_199# v3_four_channel_output_load_integration_0/v3_four_channel_shared_support_integration_0/v3_four_channel_bias_reference_distribution_0/v3_four_channel_phase_distribution_0/v3_four_channel_output_collection_0/v3_four_channel_placement_0/v3_channel_selector_late_promotion_2/v3_selector_route_pilot_0/G1_MUX_NEG/X VDPWR sky130_fd_pr__pfet_01v8_hvt ad=0 pd=0 as=0.26 ps=2.52 w=1 l=0.15
X825 VGND v3_four_channel_output_load_integration_0/v3_four_channel_shared_support_integration_0/v3_four_channel_bias_reference_distribution_0/v3_four_channel_phase_distribution_0/v3_four_channel_output_collection_0/v3_four_channel_placement_0/v3_channel_selector_late_promotion_2/v3_selector_route_pilot_0/G1_MUX_NEG/a_76_199# v3_four_channel_output_load_integration_0/v3_four_channel_shared_support_integration_0/v3_four_channel_bias_reference_distribution_0/v3_four_channel_phase_distribution_0/v3_four_channel_output_collection_0/v3_four_channel_placement_0/v3_channel_selector_late_promotion_2/v3_selector_route_pilot_0/G1_MUX_NEG/X VGND sky130_fd_pr__nfet_01v8 ad=0 pd=0 as=0.169 ps=1.82 w=0.65 l=0.15
X826 VDPWR v3_four_channel_output_load_integration_0/v3_four_channel_shared_support_integration_0/v3_four_channel_bias_reference_distribution_0/v3_four_channel_phase_distribution_0/v3_four_channel_output_collection_0/v3_four_channel_placement_0/v3_channel_selector_late_promotion_2/v3_selector_route_pilot_0/G3_LO_P_AND/B v3_four_channel_output_load_integration_0/v3_four_channel_shared_support_integration_0/v3_four_channel_bias_reference_distribution_0/v3_four_channel_phase_distribution_0/v3_four_channel_output_collection_0/v3_four_channel_placement_0/v3_channel_selector_late_promotion_2/v3_selector_route_pilot_0/G1_LO_P_AND/a_59_75# VDPWR sky130_fd_pr__pfet_01v8_hvt ad=0 pd=0 as=0.1134 ps=1.38 w=0.42 l=0.15
X827 v3_four_channel_output_load_integration_0/v3_four_channel_shared_support_integration_0/v3_four_channel_bias_reference_distribution_0/v3_four_channel_phase_distribution_0/v3_four_channel_output_collection_0/v3_four_channel_placement_0/v3_channel_selector_late_promotion_2/v3_selector_route_pilot_0/group1_lo_p v3_four_channel_output_load_integration_0/v3_four_channel_shared_support_integration_0/v3_four_channel_bias_reference_distribution_0/v3_four_channel_phase_distribution_0/v3_four_channel_output_collection_0/v3_four_channel_placement_0/v3_channel_selector_late_promotion_2/v3_selector_route_pilot_0/G1_LO_P_AND/a_59_75# VDPWR VDPWR sky130_fd_pr__pfet_01v8_hvt ad=0.475 pd=2.95 as=0 ps=0 w=1 l=0.15
X828 VGND v3_four_channel_output_load_integration_0/v3_four_channel_shared_support_integration_0/v3_four_channel_bias_reference_distribution_0/v3_four_channel_phase_distribution_0/v3_four_channel_output_collection_0/v3_four_channel_placement_0/v3_channel_selector_late_promotion_2/v3_selector_route_pilot_0/G3_LO_P_AND/B v3_four_channel_output_load_integration_0/v3_four_channel_shared_support_integration_0/v3_four_channel_bias_reference_distribution_0/v3_four_channel_phase_distribution_0/v3_four_channel_output_collection_0/v3_four_channel_placement_0/v3_channel_selector_late_promotion_2/v3_selector_route_pilot_0/G1_LO_P_AND/a_145_75# VGND sky130_fd_pr__nfet_01v8 ad=0 pd=0 as=0.1134 ps=1.38 w=0.42 l=0.15
X829 v3_four_channel_output_load_integration_0/v3_four_channel_shared_support_integration_0/v3_four_channel_bias_reference_distribution_0/v3_four_channel_phase_distribution_0/v3_four_channel_output_collection_0/v3_four_channel_placement_0/v3_channel_selector_late_promotion_2/v3_selector_route_pilot_0/G1_LO_P_AND/a_59_75# v3_four_channel_output_load_integration_0/v3_four_channel_shared_support_integration_0/v3_four_channel_bias_reference_distribution_0/v3_four_channel_phase_distribution_0/v3_four_channel_output_collection_0/v3_four_channel_placement_0/v3_channel_selector_late_promotion_2/v3_selector_route_pilot_0/G1_MUX_AXIS/X VDPWR VDPWR sky130_fd_pr__pfet_01v8_hvt ad=0 pd=0 as=0 ps=0 w=0.42 l=0.15
X830 v3_four_channel_output_load_integration_0/v3_four_channel_shared_support_integration_0/v3_four_channel_bias_reference_distribution_0/v3_four_channel_phase_distribution_0/v3_four_channel_output_collection_0/v3_four_channel_placement_0/v3_channel_selector_late_promotion_2/v3_selector_route_pilot_0/group1_lo_p v3_four_channel_output_load_integration_0/v3_four_channel_shared_support_integration_0/v3_four_channel_bias_reference_distribution_0/v3_four_channel_phase_distribution_0/v3_four_channel_output_collection_0/v3_four_channel_placement_0/v3_channel_selector_late_promotion_2/v3_selector_route_pilot_0/G1_LO_P_AND/a_59_75# VGND VGND sky130_fd_pr__nfet_01v8 ad=0.182 pd=1.86 as=0 ps=0 w=0.65 l=0.15
X831 v3_four_channel_output_load_integration_0/v3_four_channel_shared_support_integration_0/v3_four_channel_bias_reference_distribution_0/v3_four_channel_phase_distribution_0/v3_four_channel_output_collection_0/v3_four_channel_placement_0/v3_channel_selector_late_promotion_2/v3_selector_route_pilot_0/G1_LO_P_AND/a_145_75# v3_four_channel_output_load_integration_0/v3_four_channel_shared_support_integration_0/v3_four_channel_bias_reference_distribution_0/v3_four_channel_phase_distribution_0/v3_four_channel_output_collection_0/v3_four_channel_placement_0/v3_channel_selector_late_promotion_2/v3_selector_route_pilot_0/G1_MUX_AXIS/X v3_four_channel_output_load_integration_0/v3_four_channel_shared_support_integration_0/v3_four_channel_bias_reference_distribution_0/v3_four_channel_phase_distribution_0/v3_four_channel_output_collection_0/v3_four_channel_placement_0/v3_channel_selector_late_promotion_2/v3_selector_route_pilot_0/G1_LO_P_AND/a_59_75# VGND sky130_fd_pr__nfet_01v8 ad=0 pd=0 as=0.1176 ps=1.4 w=0.42 l=0.15
X832 VDPWR v3_four_channel_output_load_integration_0/v3_four_channel_shared_support_integration_0/v3_four_channel_bias_reference_distribution_0/v3_four_channel_phase_distribution_0/v3_four_channel_output_collection_0/v3_four_channel_placement_0/v3_channel_selector_late_promotion_2/v3_selector_route_pilot_0/G0_MUX_POS/a_505_21# v3_four_channel_output_load_integration_0/v3_four_channel_shared_support_integration_0/v3_four_channel_bias_reference_distribution_0/v3_four_channel_phase_distribution_0/v3_four_channel_output_collection_0/v3_four_channel_placement_0/v3_channel_selector_late_promotion_2/v3_selector_route_pilot_0/G0_MUX_POS/a_535_374# VDPWR sky130_fd_pr__pfet_01v8_hvt ad=0 pd=0 as=0.0882 ps=1.26 w=0.42 l=0.15
X833 v3_four_channel_output_load_integration_0/v3_four_channel_shared_support_integration_0/v3_four_channel_bias_reference_distribution_0/v3_four_channel_phase_distribution_0/v3_four_channel_output_collection_0/v3_four_channel_placement_0/v3_channel_selector_late_promotion_2/v3_selector_route_pilot_0/G0_MUX_POS/a_505_21# v3_four_channel_output_load_integration_0/v3_four_channel_shared_support_integration_0/v3_four_channel_bias_reference_distribution_0/v3_four_channel_phase_distribution_0/v3_four_channel_output_collection_0/v3_four_channel_placement_0/v3_channel_selector_late_promotion_2/group0_bit0 VDPWR VDPWR sky130_fd_pr__pfet_01v8_hvt ad=0.1176 pd=1.4 as=0 ps=0 w=0.42 l=0.15
X834 v3_four_channel_output_load_integration_0/v3_four_channel_shared_support_integration_0/v3_four_channel_bias_reference_distribution_0/v3_four_channel_phase_distribution_0/v3_four_channel_output_collection_0/v3_four_channel_placement_0/v3_channel_selector_late_promotion_2/v3_selector_route_pilot_0/G0_MUX_POS/a_218_374# v3_four_channel_output_load_integration_0/v3_four_channel_shared_support_integration_0/v3_four_channel_bias_reference_distribution_0/v3_four_channel_phase_distribution_0/v3_four_channel_output_collection_0/v3_four_channel_placement_0/v3_channel_selector_late_promotion_2/group0_bit0 VDPWR VDPWR sky130_fd_pr__pfet_01v8_hvt ad=0.1533 pd=1.57 as=0 ps=0 w=0.42 l=0.15
X835 VGND v3_four_channel_output_load_integration_0/v3_four_channel_shared_support_integration_0/v3_four_channel_bias_reference_distribution_0/v3_four_channel_phase_distribution_0/v3_four_channel_output_collection_0/v3_four_channel_placement_0/v3_channel_selector_late_promotion_2/v3_selector_route_pilot_0/G0_MUX_POS/a_505_21# v3_four_channel_output_load_integration_0/v3_four_channel_shared_support_integration_0/v3_four_channel_bias_reference_distribution_0/v3_four_channel_phase_distribution_0/v3_four_channel_output_collection_0/v3_four_channel_placement_0/v3_channel_selector_late_promotion_2/v3_selector_route_pilot_0/G0_MUX_POS/a_439_47# VGND sky130_fd_pr__nfet_01v8 ad=0 pd=0 as=0.1386 ps=1.5 w=0.42 l=0.15
X836 v3_four_channel_output_load_integration_0/v3_four_channel_shared_support_integration_0/v3_four_channel_bias_reference_distribution_0/v3_four_channel_phase_distribution_0/v3_four_channel_output_collection_0/v3_four_channel_placement_0/v3_channel_selector_late_promotion_2/v3_selector_route_pilot_0/G0_MUX_POS/a_76_199# v3_four_channel_output_load_integration_0/v3_four_channel_shared_support_integration_0/v3_four_channel_bias_reference_distribution_0/v3_four_channel_phase_distribution_0/phase_0 v3_four_channel_output_load_integration_0/v3_four_channel_shared_support_integration_0/v3_four_channel_bias_reference_distribution_0/v3_four_channel_phase_distribution_0/v3_four_channel_output_collection_0/v3_four_channel_placement_0/v3_channel_selector_late_promotion_2/v3_selector_route_pilot_0/G0_MUX_POS/a_218_374# VDPWR sky130_fd_pr__pfet_01v8_hvt ad=0.3864 pd=2.68 as=0 ps=0 w=0.42 l=0.15
X837 v3_four_channel_output_load_integration_0/v3_four_channel_shared_support_integration_0/v3_four_channel_bias_reference_distribution_0/v3_four_channel_phase_distribution_0/v3_four_channel_output_collection_0/v3_four_channel_placement_0/v3_channel_selector_late_promotion_2/v3_selector_route_pilot_0/G0_MUX_POS/a_505_21# v3_four_channel_output_load_integration_0/v3_four_channel_shared_support_integration_0/v3_four_channel_bias_reference_distribution_0/v3_four_channel_phase_distribution_0/v3_four_channel_output_collection_0/v3_four_channel_placement_0/v3_channel_selector_late_promotion_2/group0_bit0 VGND VGND sky130_fd_pr__nfet_01v8 ad=0.1092 pd=1.36 as=0 ps=0 w=0.42 l=0.15
X838 v3_four_channel_output_load_integration_0/v3_four_channel_shared_support_integration_0/v3_four_channel_bias_reference_distribution_0/v3_four_channel_phase_distribution_0/v3_four_channel_output_collection_0/v3_four_channel_placement_0/v3_channel_selector_late_promotion_2/v3_selector_route_pilot_0/G0_MUX_POS/a_439_47# v3_four_channel_output_load_integration_0/v3_four_channel_shared_support_integration_0/v3_four_channel_bias_reference_distribution_0/v3_four_channel_phase_distribution_0/phase_0 v3_four_channel_output_load_integration_0/v3_four_channel_shared_support_integration_0/v3_four_channel_bias_reference_distribution_0/v3_four_channel_phase_distribution_0/v3_four_channel_output_collection_0/v3_four_channel_placement_0/v3_channel_selector_late_promotion_2/v3_selector_route_pilot_0/G0_MUX_POS/a_76_199# VGND sky130_fd_pr__nfet_01v8 ad=0 pd=0 as=0.1995 ps=1.79 w=0.42 l=0.15
X839 v3_four_channel_output_load_integration_0/v3_four_channel_shared_support_integration_0/v3_four_channel_bias_reference_distribution_0/v3_four_channel_phase_distribution_0/v3_four_channel_output_collection_0/v3_four_channel_placement_0/v3_channel_selector_late_promotion_2/v3_selector_route_pilot_0/G0_MUX_POS/a_535_374# v3_four_channel_output_load_integration_0/v3_four_channel_shared_support_integration_0/v3_four_channel_bias_reference_distribution_0/v3_four_channel_phase_distribution_0/phase_90 v3_four_channel_output_load_integration_0/v3_four_channel_shared_support_integration_0/v3_four_channel_bias_reference_distribution_0/v3_four_channel_phase_distribution_0/v3_four_channel_output_collection_0/v3_four_channel_placement_0/v3_channel_selector_late_promotion_2/v3_selector_route_pilot_0/G0_MUX_POS/a_76_199# VDPWR sky130_fd_pr__pfet_01v8_hvt ad=0 pd=0 as=0 ps=0 w=0.42 l=0.15
X840 v3_four_channel_output_load_integration_0/v3_four_channel_shared_support_integration_0/v3_four_channel_bias_reference_distribution_0/v3_four_channel_phase_distribution_0/v3_four_channel_output_collection_0/v3_four_channel_placement_0/v3_channel_selector_late_promotion_2/v3_selector_route_pilot_0/G0_MUX_POS/a_76_199# v3_four_channel_output_load_integration_0/v3_four_channel_shared_support_integration_0/v3_four_channel_bias_reference_distribution_0/v3_four_channel_phase_distribution_0/phase_90 v3_four_channel_output_load_integration_0/v3_four_channel_shared_support_integration_0/v3_four_channel_bias_reference_distribution_0/v3_four_channel_phase_distribution_0/v3_four_channel_output_collection_0/v3_four_channel_placement_0/v3_channel_selector_late_promotion_2/v3_selector_route_pilot_0/G0_MUX_POS/a_218_47# VGND sky130_fd_pr__nfet_01v8 ad=0 pd=0 as=0.1386 ps=1.5 w=0.42 l=0.15
X841 v3_four_channel_output_load_integration_0/v3_four_channel_shared_support_integration_0/v3_four_channel_bias_reference_distribution_0/v3_four_channel_phase_distribution_0/v3_four_channel_output_collection_0/v3_four_channel_placement_0/v3_channel_selector_late_promotion_2/v3_selector_route_pilot_0/G0_MUX_POS/a_218_47# v3_four_channel_output_load_integration_0/v3_four_channel_shared_support_integration_0/v3_four_channel_bias_reference_distribution_0/v3_four_channel_phase_distribution_0/v3_four_channel_output_collection_0/v3_four_channel_placement_0/v3_channel_selector_late_promotion_2/group0_bit0 VGND VGND sky130_fd_pr__nfet_01v8 ad=0 pd=0 as=0 ps=0 w=0.42 l=0.15
X842 VDPWR v3_four_channel_output_load_integration_0/v3_four_channel_shared_support_integration_0/v3_four_channel_bias_reference_distribution_0/v3_four_channel_phase_distribution_0/v3_four_channel_output_collection_0/v3_four_channel_placement_0/v3_channel_selector_late_promotion_2/v3_selector_route_pilot_0/G0_MUX_POS/a_76_199# v3_four_channel_output_load_integration_0/v3_four_channel_shared_support_integration_0/v3_four_channel_bias_reference_distribution_0/v3_four_channel_phase_distribution_0/v3_four_channel_output_collection_0/v3_four_channel_placement_0/v3_channel_selector_late_promotion_2/v3_selector_route_pilot_0/G0_MUX_POS/X VDPWR sky130_fd_pr__pfet_01v8_hvt ad=0 pd=0 as=0.26 ps=2.52 w=1 l=0.15
X843 VGND v3_four_channel_output_load_integration_0/v3_four_channel_shared_support_integration_0/v3_four_channel_bias_reference_distribution_0/v3_four_channel_phase_distribution_0/v3_four_channel_output_collection_0/v3_four_channel_placement_0/v3_channel_selector_late_promotion_2/v3_selector_route_pilot_0/G0_MUX_POS/a_76_199# v3_four_channel_output_load_integration_0/v3_four_channel_shared_support_integration_0/v3_four_channel_bias_reference_distribution_0/v3_four_channel_phase_distribution_0/v3_four_channel_output_collection_0/v3_four_channel_placement_0/v3_channel_selector_late_promotion_2/v3_selector_route_pilot_0/G0_MUX_POS/X VGND sky130_fd_pr__nfet_01v8 ad=0 pd=0 as=0.169 ps=1.82 w=0.65 l=0.15
X844 VDPWR v3_four_channel_output_load_integration_0/v3_four_channel_shared_support_integration_0/v3_four_channel_bias_reference_distribution_0/v3_four_channel_phase_distribution_0/v3_four_channel_output_collection_0/v3_four_channel_placement_0/v3_channel_selector_late_promotion_2/v3_selector_route_pilot_0/G0_MUX_NEG/a_505_21# v3_four_channel_output_load_integration_0/v3_four_channel_shared_support_integration_0/v3_four_channel_bias_reference_distribution_0/v3_four_channel_phase_distribution_0/v3_four_channel_output_collection_0/v3_four_channel_placement_0/v3_channel_selector_late_promotion_2/v3_selector_route_pilot_0/G0_MUX_NEG/a_535_374# VDPWR sky130_fd_pr__pfet_01v8_hvt ad=0 pd=0 as=0.0882 ps=1.26 w=0.42 l=0.15
X845 v3_four_channel_output_load_integration_0/v3_four_channel_shared_support_integration_0/v3_four_channel_bias_reference_distribution_0/v3_four_channel_phase_distribution_0/v3_four_channel_output_collection_0/v3_four_channel_placement_0/v3_channel_selector_late_promotion_2/v3_selector_route_pilot_0/G0_MUX_NEG/a_505_21# v3_four_channel_output_load_integration_0/v3_four_channel_shared_support_integration_0/v3_four_channel_bias_reference_distribution_0/v3_four_channel_phase_distribution_0/v3_four_channel_output_collection_0/v3_four_channel_placement_0/v3_channel_selector_late_promotion_2/group0_bit0 VDPWR VDPWR sky130_fd_pr__pfet_01v8_hvt ad=0.1176 pd=1.4 as=0 ps=0 w=0.42 l=0.15
X846 v3_four_channel_output_load_integration_0/v3_four_channel_shared_support_integration_0/v3_four_channel_bias_reference_distribution_0/v3_four_channel_phase_distribution_0/v3_four_channel_output_collection_0/v3_four_channel_placement_0/v3_channel_selector_late_promotion_2/v3_selector_route_pilot_0/G0_MUX_NEG/a_218_374# v3_four_channel_output_load_integration_0/v3_four_channel_shared_support_integration_0/v3_four_channel_bias_reference_distribution_0/v3_four_channel_phase_distribution_0/v3_four_channel_output_collection_0/v3_four_channel_placement_0/v3_channel_selector_late_promotion_2/group0_bit0 VDPWR VDPWR sky130_fd_pr__pfet_01v8_hvt ad=0.1533 pd=1.57 as=0 ps=0 w=0.42 l=0.15
X847 VGND v3_four_channel_output_load_integration_0/v3_four_channel_shared_support_integration_0/v3_four_channel_bias_reference_distribution_0/v3_four_channel_phase_distribution_0/v3_four_channel_output_collection_0/v3_four_channel_placement_0/v3_channel_selector_late_promotion_2/v3_selector_route_pilot_0/G0_MUX_NEG/a_505_21# v3_four_channel_output_load_integration_0/v3_four_channel_shared_support_integration_0/v3_four_channel_bias_reference_distribution_0/v3_four_channel_phase_distribution_0/v3_four_channel_output_collection_0/v3_four_channel_placement_0/v3_channel_selector_late_promotion_2/v3_selector_route_pilot_0/G0_MUX_NEG/a_439_47# VGND sky130_fd_pr__nfet_01v8 ad=0 pd=0 as=0.1386 ps=1.5 w=0.42 l=0.15
X848 v3_four_channel_output_load_integration_0/v3_four_channel_shared_support_integration_0/v3_four_channel_bias_reference_distribution_0/v3_four_channel_phase_distribution_0/v3_four_channel_output_collection_0/v3_four_channel_placement_0/v3_channel_selector_late_promotion_2/v3_selector_route_pilot_0/G0_MUX_NEG/a_76_199# v3_four_channel_output_load_integration_0/v3_four_channel_shared_support_integration_0/v3_four_channel_bias_reference_distribution_0/v3_four_channel_phase_distribution_0/phase_180 v3_four_channel_output_load_integration_0/v3_four_channel_shared_support_integration_0/v3_four_channel_bias_reference_distribution_0/v3_four_channel_phase_distribution_0/v3_four_channel_output_collection_0/v3_four_channel_placement_0/v3_channel_selector_late_promotion_2/v3_selector_route_pilot_0/G0_MUX_NEG/a_218_374# VDPWR sky130_fd_pr__pfet_01v8_hvt ad=0.3864 pd=2.68 as=0 ps=0 w=0.42 l=0.15
X849 v3_four_channel_output_load_integration_0/v3_four_channel_shared_support_integration_0/v3_four_channel_bias_reference_distribution_0/v3_four_channel_phase_distribution_0/v3_four_channel_output_collection_0/v3_four_channel_placement_0/v3_channel_selector_late_promotion_2/v3_selector_route_pilot_0/G0_MUX_NEG/a_505_21# v3_four_channel_output_load_integration_0/v3_four_channel_shared_support_integration_0/v3_four_channel_bias_reference_distribution_0/v3_four_channel_phase_distribution_0/v3_four_channel_output_collection_0/v3_four_channel_placement_0/v3_channel_selector_late_promotion_2/group0_bit0 VGND VGND sky130_fd_pr__nfet_01v8 ad=0.1092 pd=1.36 as=0 ps=0 w=0.42 l=0.15
X850 v3_four_channel_output_load_integration_0/v3_four_channel_shared_support_integration_0/v3_four_channel_bias_reference_distribution_0/v3_four_channel_phase_distribution_0/v3_four_channel_output_collection_0/v3_four_channel_placement_0/v3_channel_selector_late_promotion_2/v3_selector_route_pilot_0/G0_MUX_NEG/a_439_47# v3_four_channel_output_load_integration_0/v3_four_channel_shared_support_integration_0/v3_four_channel_bias_reference_distribution_0/v3_four_channel_phase_distribution_0/phase_180 v3_four_channel_output_load_integration_0/v3_four_channel_shared_support_integration_0/v3_four_channel_bias_reference_distribution_0/v3_four_channel_phase_distribution_0/v3_four_channel_output_collection_0/v3_four_channel_placement_0/v3_channel_selector_late_promotion_2/v3_selector_route_pilot_0/G0_MUX_NEG/a_76_199# VGND sky130_fd_pr__nfet_01v8 ad=0 pd=0 as=0.1995 ps=1.79 w=0.42 l=0.15
X851 v3_four_channel_output_load_integration_0/v3_four_channel_shared_support_integration_0/v3_four_channel_bias_reference_distribution_0/v3_four_channel_phase_distribution_0/v3_four_channel_output_collection_0/v3_four_channel_placement_0/v3_channel_selector_late_promotion_2/v3_selector_route_pilot_0/G0_MUX_NEG/a_535_374# v3_four_channel_output_load_integration_0/v3_four_channel_shared_support_integration_0/v3_four_channel_bias_reference_distribution_0/v3_four_channel_phase_distribution_0/phase_270 v3_four_channel_output_load_integration_0/v3_four_channel_shared_support_integration_0/v3_four_channel_bias_reference_distribution_0/v3_four_channel_phase_distribution_0/v3_four_channel_output_collection_0/v3_four_channel_placement_0/v3_channel_selector_late_promotion_2/v3_selector_route_pilot_0/G0_MUX_NEG/a_76_199# VDPWR sky130_fd_pr__pfet_01v8_hvt ad=0 pd=0 as=0 ps=0 w=0.42 l=0.15
X852 v3_four_channel_output_load_integration_0/v3_four_channel_shared_support_integration_0/v3_four_channel_bias_reference_distribution_0/v3_four_channel_phase_distribution_0/v3_four_channel_output_collection_0/v3_four_channel_placement_0/v3_channel_selector_late_promotion_2/v3_selector_route_pilot_0/G0_MUX_NEG/a_76_199# v3_four_channel_output_load_integration_0/v3_four_channel_shared_support_integration_0/v3_four_channel_bias_reference_distribution_0/v3_four_channel_phase_distribution_0/phase_270 v3_four_channel_output_load_integration_0/v3_four_channel_shared_support_integration_0/v3_four_channel_bias_reference_distribution_0/v3_four_channel_phase_distribution_0/v3_four_channel_output_collection_0/v3_four_channel_placement_0/v3_channel_selector_late_promotion_2/v3_selector_route_pilot_0/G0_MUX_NEG/a_218_47# VGND sky130_fd_pr__nfet_01v8 ad=0 pd=0 as=0.1386 ps=1.5 w=0.42 l=0.15
X853 v3_four_channel_output_load_integration_0/v3_four_channel_shared_support_integration_0/v3_four_channel_bias_reference_distribution_0/v3_four_channel_phase_distribution_0/v3_four_channel_output_collection_0/v3_four_channel_placement_0/v3_channel_selector_late_promotion_2/v3_selector_route_pilot_0/G0_MUX_NEG/a_218_47# v3_four_channel_output_load_integration_0/v3_four_channel_shared_support_integration_0/v3_four_channel_bias_reference_distribution_0/v3_four_channel_phase_distribution_0/v3_four_channel_output_collection_0/v3_four_channel_placement_0/v3_channel_selector_late_promotion_2/group0_bit0 VGND VGND sky130_fd_pr__nfet_01v8 ad=0 pd=0 as=0 ps=0 w=0.42 l=0.15
X854 VDPWR v3_four_channel_output_load_integration_0/v3_four_channel_shared_support_integration_0/v3_four_channel_bias_reference_distribution_0/v3_four_channel_phase_distribution_0/v3_four_channel_output_collection_0/v3_four_channel_placement_0/v3_channel_selector_late_promotion_2/v3_selector_route_pilot_0/G0_MUX_NEG/a_76_199# v3_four_channel_output_load_integration_0/v3_four_channel_shared_support_integration_0/v3_four_channel_bias_reference_distribution_0/v3_four_channel_phase_distribution_0/v3_four_channel_output_collection_0/v3_four_channel_placement_0/v3_channel_selector_late_promotion_2/v3_selector_route_pilot_0/G0_MUX_NEG/X VDPWR sky130_fd_pr__pfet_01v8_hvt ad=0 pd=0 as=0.26 ps=2.52 w=1 l=0.15
X855 VGND v3_four_channel_output_load_integration_0/v3_four_channel_shared_support_integration_0/v3_four_channel_bias_reference_distribution_0/v3_four_channel_phase_distribution_0/v3_four_channel_output_collection_0/v3_four_channel_placement_0/v3_channel_selector_late_promotion_2/v3_selector_route_pilot_0/G0_MUX_NEG/a_76_199# v3_four_channel_output_load_integration_0/v3_four_channel_shared_support_integration_0/v3_four_channel_bias_reference_distribution_0/v3_four_channel_phase_distribution_0/v3_four_channel_output_collection_0/v3_four_channel_placement_0/v3_channel_selector_late_promotion_2/v3_selector_route_pilot_0/G0_MUX_NEG/X VGND sky130_fd_pr__nfet_01v8 ad=0 pd=0 as=0.169 ps=1.82 w=0.65 l=0.15
X856 VDPWR v3_four_channel_output_load_integration_0/v3_four_channel_shared_support_integration_0/v3_four_channel_bias_reference_distribution_0/v3_four_channel_phase_distribution_0/v3_four_channel_output_collection_0/v3_four_channel_placement_0/v3_channel_selector_late_promotion_2/v3_selector_route_pilot_0/G2_MUX_AXIS/a_505_21# v3_four_channel_output_load_integration_0/v3_four_channel_shared_support_integration_0/v3_four_channel_bias_reference_distribution_0/v3_four_channel_phase_distribution_0/v3_four_channel_output_collection_0/v3_four_channel_placement_0/v3_channel_selector_late_promotion_2/v3_selector_route_pilot_0/G2_MUX_AXIS/a_535_374# VDPWR sky130_fd_pr__pfet_01v8_hvt ad=0 pd=0 as=0.0882 ps=1.26 w=0.42 l=0.15
X857 v3_four_channel_output_load_integration_0/v3_four_channel_shared_support_integration_0/v3_four_channel_bias_reference_distribution_0/v3_four_channel_phase_distribution_0/v3_four_channel_output_collection_0/v3_four_channel_placement_0/v3_channel_selector_late_promotion_2/v3_selector_route_pilot_0/G2_MUX_AXIS/a_505_21# v3_four_channel_output_load_integration_0/v3_four_channel_shared_support_integration_0/v3_four_channel_bias_reference_distribution_0/v3_four_channel_phase_distribution_0/v3_four_channel_output_collection_0/v3_four_channel_placement_0/v3_channel_selector_late_promotion_2/group2_bit1 VDPWR VDPWR sky130_fd_pr__pfet_01v8_hvt ad=0.1176 pd=1.4 as=0 ps=0 w=0.42 l=0.15
X858 v3_four_channel_output_load_integration_0/v3_four_channel_shared_support_integration_0/v3_four_channel_bias_reference_distribution_0/v3_four_channel_phase_distribution_0/v3_four_channel_output_collection_0/v3_four_channel_placement_0/v3_channel_selector_late_promotion_2/v3_selector_route_pilot_0/G2_MUX_AXIS/a_218_374# v3_four_channel_output_load_integration_0/v3_four_channel_shared_support_integration_0/v3_four_channel_bias_reference_distribution_0/v3_four_channel_phase_distribution_0/v3_four_channel_output_collection_0/v3_four_channel_placement_0/v3_channel_selector_late_promotion_2/group2_bit1 VDPWR VDPWR sky130_fd_pr__pfet_01v8_hvt ad=0.1533 pd=1.57 as=0 ps=0 w=0.42 l=0.15
X859 VGND v3_four_channel_output_load_integration_0/v3_four_channel_shared_support_integration_0/v3_four_channel_bias_reference_distribution_0/v3_four_channel_phase_distribution_0/v3_four_channel_output_collection_0/v3_four_channel_placement_0/v3_channel_selector_late_promotion_2/v3_selector_route_pilot_0/G2_MUX_AXIS/a_505_21# v3_four_channel_output_load_integration_0/v3_four_channel_shared_support_integration_0/v3_four_channel_bias_reference_distribution_0/v3_four_channel_phase_distribution_0/v3_four_channel_output_collection_0/v3_four_channel_placement_0/v3_channel_selector_late_promotion_2/v3_selector_route_pilot_0/G2_MUX_AXIS/a_439_47# VGND sky130_fd_pr__nfet_01v8 ad=0 pd=0 as=0.1386 ps=1.5 w=0.42 l=0.15
X860 v3_four_channel_output_load_integration_0/v3_four_channel_shared_support_integration_0/v3_four_channel_bias_reference_distribution_0/v3_four_channel_phase_distribution_0/v3_four_channel_output_collection_0/v3_four_channel_placement_0/v3_channel_selector_late_promotion_2/v3_selector_route_pilot_0/G2_MUX_AXIS/a_76_199# v3_four_channel_output_load_integration_0/v3_four_channel_shared_support_integration_0/v3_four_channel_bias_reference_distribution_0/v3_four_channel_phase_distribution_0/v3_four_channel_output_collection_0/v3_four_channel_placement_0/v3_channel_selector_late_promotion_2/v3_selector_route_pilot_0/G2_MUX_POS/X v3_four_channel_output_load_integration_0/v3_four_channel_shared_support_integration_0/v3_four_channel_bias_reference_distribution_0/v3_four_channel_phase_distribution_0/v3_four_channel_output_collection_0/v3_four_channel_placement_0/v3_channel_selector_late_promotion_2/v3_selector_route_pilot_0/G2_MUX_AXIS/a_218_374# VDPWR sky130_fd_pr__pfet_01v8_hvt ad=0.3864 pd=2.68 as=0 ps=0 w=0.42 l=0.15
X861 v3_four_channel_output_load_integration_0/v3_four_channel_shared_support_integration_0/v3_four_channel_bias_reference_distribution_0/v3_four_channel_phase_distribution_0/v3_four_channel_output_collection_0/v3_four_channel_placement_0/v3_channel_selector_late_promotion_2/v3_selector_route_pilot_0/G2_MUX_AXIS/a_505_21# v3_four_channel_output_load_integration_0/v3_four_channel_shared_support_integration_0/v3_four_channel_bias_reference_distribution_0/v3_four_channel_phase_distribution_0/v3_four_channel_output_collection_0/v3_four_channel_placement_0/v3_channel_selector_late_promotion_2/group2_bit1 VGND VGND sky130_fd_pr__nfet_01v8 ad=0.1092 pd=1.36 as=0 ps=0 w=0.42 l=0.15
X862 v3_four_channel_output_load_integration_0/v3_four_channel_shared_support_integration_0/v3_four_channel_bias_reference_distribution_0/v3_four_channel_phase_distribution_0/v3_four_channel_output_collection_0/v3_four_channel_placement_0/v3_channel_selector_late_promotion_2/v3_selector_route_pilot_0/G2_MUX_AXIS/a_439_47# v3_four_channel_output_load_integration_0/v3_four_channel_shared_support_integration_0/v3_four_channel_bias_reference_distribution_0/v3_four_channel_phase_distribution_0/v3_four_channel_output_collection_0/v3_four_channel_placement_0/v3_channel_selector_late_promotion_2/v3_selector_route_pilot_0/G2_MUX_POS/X v3_four_channel_output_load_integration_0/v3_four_channel_shared_support_integration_0/v3_four_channel_bias_reference_distribution_0/v3_four_channel_phase_distribution_0/v3_four_channel_output_collection_0/v3_four_channel_placement_0/v3_channel_selector_late_promotion_2/v3_selector_route_pilot_0/G2_MUX_AXIS/a_76_199# VGND sky130_fd_pr__nfet_01v8 ad=0 pd=0 as=0.1995 ps=1.79 w=0.42 l=0.15
X863 v3_four_channel_output_load_integration_0/v3_four_channel_shared_support_integration_0/v3_four_channel_bias_reference_distribution_0/v3_four_channel_phase_distribution_0/v3_four_channel_output_collection_0/v3_four_channel_placement_0/v3_channel_selector_late_promotion_2/v3_selector_route_pilot_0/G2_MUX_AXIS/a_535_374# v3_four_channel_output_load_integration_0/v3_four_channel_shared_support_integration_0/v3_four_channel_bias_reference_distribution_0/v3_four_channel_phase_distribution_0/v3_four_channel_output_collection_0/v3_four_channel_placement_0/v3_channel_selector_late_promotion_2/v3_selector_route_pilot_0/G2_MUX_NEG/X v3_four_channel_output_load_integration_0/v3_four_channel_shared_support_integration_0/v3_four_channel_bias_reference_distribution_0/v3_four_channel_phase_distribution_0/v3_four_channel_output_collection_0/v3_four_channel_placement_0/v3_channel_selector_late_promotion_2/v3_selector_route_pilot_0/G2_MUX_AXIS/a_76_199# VDPWR sky130_fd_pr__pfet_01v8_hvt ad=0 pd=0 as=0 ps=0 w=0.42 l=0.15
X864 v3_four_channel_output_load_integration_0/v3_four_channel_shared_support_integration_0/v3_four_channel_bias_reference_distribution_0/v3_four_channel_phase_distribution_0/v3_four_channel_output_collection_0/v3_four_channel_placement_0/v3_channel_selector_late_promotion_2/v3_selector_route_pilot_0/G2_MUX_AXIS/a_76_199# v3_four_channel_output_load_integration_0/v3_four_channel_shared_support_integration_0/v3_four_channel_bias_reference_distribution_0/v3_four_channel_phase_distribution_0/v3_four_channel_output_collection_0/v3_four_channel_placement_0/v3_channel_selector_late_promotion_2/v3_selector_route_pilot_0/G2_MUX_NEG/X v3_four_channel_output_load_integration_0/v3_four_channel_shared_support_integration_0/v3_four_channel_bias_reference_distribution_0/v3_four_channel_phase_distribution_0/v3_four_channel_output_collection_0/v3_four_channel_placement_0/v3_channel_selector_late_promotion_2/v3_selector_route_pilot_0/G2_MUX_AXIS/a_218_47# VGND sky130_fd_pr__nfet_01v8 ad=0 pd=0 as=0.1386 ps=1.5 w=0.42 l=0.15
X865 v3_four_channel_output_load_integration_0/v3_four_channel_shared_support_integration_0/v3_four_channel_bias_reference_distribution_0/v3_four_channel_phase_distribution_0/v3_four_channel_output_collection_0/v3_four_channel_placement_0/v3_channel_selector_late_promotion_2/v3_selector_route_pilot_0/G2_MUX_AXIS/a_218_47# v3_four_channel_output_load_integration_0/v3_four_channel_shared_support_integration_0/v3_four_channel_bias_reference_distribution_0/v3_four_channel_phase_distribution_0/v3_four_channel_output_collection_0/v3_four_channel_placement_0/v3_channel_selector_late_promotion_2/group2_bit1 VGND VGND sky130_fd_pr__nfet_01v8 ad=0 pd=0 as=0 ps=0 w=0.42 l=0.15
X866 VDPWR v3_four_channel_output_load_integration_0/v3_four_channel_shared_support_integration_0/v3_four_channel_bias_reference_distribution_0/v3_four_channel_phase_distribution_0/v3_four_channel_output_collection_0/v3_four_channel_placement_0/v3_channel_selector_late_promotion_2/v3_selector_route_pilot_0/G2_MUX_AXIS/a_76_199# v3_four_channel_output_load_integration_0/v3_four_channel_shared_support_integration_0/v3_four_channel_bias_reference_distribution_0/v3_four_channel_phase_distribution_0/v3_four_channel_output_collection_0/v3_four_channel_placement_0/v3_channel_selector_late_promotion_2/v3_selector_route_pilot_0/G2_MUX_AXIS/X VDPWR sky130_fd_pr__pfet_01v8_hvt ad=0 pd=0 as=0.26 ps=2.52 w=1 l=0.15
X867 VGND v3_four_channel_output_load_integration_0/v3_four_channel_shared_support_integration_0/v3_four_channel_bias_reference_distribution_0/v3_four_channel_phase_distribution_0/v3_four_channel_output_collection_0/v3_four_channel_placement_0/v3_channel_selector_late_promotion_2/v3_selector_route_pilot_0/G2_MUX_AXIS/a_76_199# v3_four_channel_output_load_integration_0/v3_four_channel_shared_support_integration_0/v3_four_channel_bias_reference_distribution_0/v3_four_channel_phase_distribution_0/v3_four_channel_output_collection_0/v3_four_channel_placement_0/v3_channel_selector_late_promotion_2/v3_selector_route_pilot_0/G2_MUX_AXIS/X VGND sky130_fd_pr__nfet_01v8 ad=0 pd=0 as=0.169 ps=1.82 w=0.65 l=0.15
X868 VDPWR v3_four_channel_output_load_integration_0/v3_four_channel_shared_support_integration_0/v3_four_channel_bias_reference_distribution_0/v3_four_channel_phase_distribution_0/v3_four_channel_output_collection_0/v3_four_channel_placement_0/v3_channel_selector_late_promotion_2/v3_selector_route_pilot_0/G3_MUX_POS/a_505_21# v3_four_channel_output_load_integration_0/v3_four_channel_shared_support_integration_0/v3_four_channel_bias_reference_distribution_0/v3_four_channel_phase_distribution_0/v3_four_channel_output_collection_0/v3_four_channel_placement_0/v3_channel_selector_late_promotion_2/v3_selector_route_pilot_0/G3_MUX_POS/a_535_374# VDPWR sky130_fd_pr__pfet_01v8_hvt ad=0 pd=0 as=0.0882 ps=1.26 w=0.42 l=0.15
X869 v3_four_channel_output_load_integration_0/v3_four_channel_shared_support_integration_0/v3_four_channel_bias_reference_distribution_0/v3_four_channel_phase_distribution_0/v3_four_channel_output_collection_0/v3_four_channel_placement_0/v3_channel_selector_late_promotion_2/v3_selector_route_pilot_0/G3_MUX_POS/a_505_21# v3_four_channel_output_load_integration_0/v3_four_channel_shared_support_integration_0/v3_four_channel_bias_reference_distribution_0/v3_four_channel_phase_distribution_0/v3_four_channel_output_collection_0/v3_four_channel_placement_0/v3_channel_selector_late_promotion_2/group3_bit0 VDPWR VDPWR sky130_fd_pr__pfet_01v8_hvt ad=0.1176 pd=1.4 as=0 ps=0 w=0.42 l=0.15
X870 v3_four_channel_output_load_integration_0/v3_four_channel_shared_support_integration_0/v3_four_channel_bias_reference_distribution_0/v3_four_channel_phase_distribution_0/v3_four_channel_output_collection_0/v3_four_channel_placement_0/v3_channel_selector_late_promotion_2/v3_selector_route_pilot_0/G3_MUX_POS/a_218_374# v3_four_channel_output_load_integration_0/v3_four_channel_shared_support_integration_0/v3_four_channel_bias_reference_distribution_0/v3_four_channel_phase_distribution_0/v3_four_channel_output_collection_0/v3_four_channel_placement_0/v3_channel_selector_late_promotion_2/group3_bit0 VDPWR VDPWR sky130_fd_pr__pfet_01v8_hvt ad=0.1533 pd=1.57 as=0 ps=0 w=0.42 l=0.15
X871 VGND v3_four_channel_output_load_integration_0/v3_four_channel_shared_support_integration_0/v3_four_channel_bias_reference_distribution_0/v3_four_channel_phase_distribution_0/v3_four_channel_output_collection_0/v3_four_channel_placement_0/v3_channel_selector_late_promotion_2/v3_selector_route_pilot_0/G3_MUX_POS/a_505_21# v3_four_channel_output_load_integration_0/v3_four_channel_shared_support_integration_0/v3_four_channel_bias_reference_distribution_0/v3_four_channel_phase_distribution_0/v3_four_channel_output_collection_0/v3_four_channel_placement_0/v3_channel_selector_late_promotion_2/v3_selector_route_pilot_0/G3_MUX_POS/a_439_47# VGND sky130_fd_pr__nfet_01v8 ad=0 pd=0 as=0.1386 ps=1.5 w=0.42 l=0.15
X872 v3_four_channel_output_load_integration_0/v3_four_channel_shared_support_integration_0/v3_four_channel_bias_reference_distribution_0/v3_four_channel_phase_distribution_0/v3_four_channel_output_collection_0/v3_four_channel_placement_0/v3_channel_selector_late_promotion_2/v3_selector_route_pilot_0/G3_MUX_POS/a_76_199# v3_four_channel_output_load_integration_0/v3_four_channel_shared_support_integration_0/v3_four_channel_bias_reference_distribution_0/v3_four_channel_phase_distribution_0/phase_0 v3_four_channel_output_load_integration_0/v3_four_channel_shared_support_integration_0/v3_four_channel_bias_reference_distribution_0/v3_four_channel_phase_distribution_0/v3_four_channel_output_collection_0/v3_four_channel_placement_0/v3_channel_selector_late_promotion_2/v3_selector_route_pilot_0/G3_MUX_POS/a_218_374# VDPWR sky130_fd_pr__pfet_01v8_hvt ad=0.3864 pd=2.68 as=0 ps=0 w=0.42 l=0.15
X873 v3_four_channel_output_load_integration_0/v3_four_channel_shared_support_integration_0/v3_four_channel_bias_reference_distribution_0/v3_four_channel_phase_distribution_0/v3_four_channel_output_collection_0/v3_four_channel_placement_0/v3_channel_selector_late_promotion_2/v3_selector_route_pilot_0/G3_MUX_POS/a_505_21# v3_four_channel_output_load_integration_0/v3_four_channel_shared_support_integration_0/v3_four_channel_bias_reference_distribution_0/v3_four_channel_phase_distribution_0/v3_four_channel_output_collection_0/v3_four_channel_placement_0/v3_channel_selector_late_promotion_2/group3_bit0 VGND VGND sky130_fd_pr__nfet_01v8 ad=0.1092 pd=1.36 as=0 ps=0 w=0.42 l=0.15
X874 v3_four_channel_output_load_integration_0/v3_four_channel_shared_support_integration_0/v3_four_channel_bias_reference_distribution_0/v3_four_channel_phase_distribution_0/v3_four_channel_output_collection_0/v3_four_channel_placement_0/v3_channel_selector_late_promotion_2/v3_selector_route_pilot_0/G3_MUX_POS/a_439_47# v3_four_channel_output_load_integration_0/v3_four_channel_shared_support_integration_0/v3_four_channel_bias_reference_distribution_0/v3_four_channel_phase_distribution_0/phase_0 v3_four_channel_output_load_integration_0/v3_four_channel_shared_support_integration_0/v3_four_channel_bias_reference_distribution_0/v3_four_channel_phase_distribution_0/v3_four_channel_output_collection_0/v3_four_channel_placement_0/v3_channel_selector_late_promotion_2/v3_selector_route_pilot_0/G3_MUX_POS/a_76_199# VGND sky130_fd_pr__nfet_01v8 ad=0 pd=0 as=0.1995 ps=1.79 w=0.42 l=0.15
X875 v3_four_channel_output_load_integration_0/v3_four_channel_shared_support_integration_0/v3_four_channel_bias_reference_distribution_0/v3_four_channel_phase_distribution_0/v3_four_channel_output_collection_0/v3_four_channel_placement_0/v3_channel_selector_late_promotion_2/v3_selector_route_pilot_0/G3_MUX_POS/a_535_374# v3_four_channel_output_load_integration_0/v3_four_channel_shared_support_integration_0/v3_four_channel_bias_reference_distribution_0/v3_four_channel_phase_distribution_0/phase_90 v3_four_channel_output_load_integration_0/v3_four_channel_shared_support_integration_0/v3_four_channel_bias_reference_distribution_0/v3_four_channel_phase_distribution_0/v3_four_channel_output_collection_0/v3_four_channel_placement_0/v3_channel_selector_late_promotion_2/v3_selector_route_pilot_0/G3_MUX_POS/a_76_199# VDPWR sky130_fd_pr__pfet_01v8_hvt ad=0 pd=0 as=0 ps=0 w=0.42 l=0.15
X876 v3_four_channel_output_load_integration_0/v3_four_channel_shared_support_integration_0/v3_four_channel_bias_reference_distribution_0/v3_four_channel_phase_distribution_0/v3_four_channel_output_collection_0/v3_four_channel_placement_0/v3_channel_selector_late_promotion_2/v3_selector_route_pilot_0/G3_MUX_POS/a_76_199# v3_four_channel_output_load_integration_0/v3_four_channel_shared_support_integration_0/v3_four_channel_bias_reference_distribution_0/v3_four_channel_phase_distribution_0/phase_90 v3_four_channel_output_load_integration_0/v3_four_channel_shared_support_integration_0/v3_four_channel_bias_reference_distribution_0/v3_four_channel_phase_distribution_0/v3_four_channel_output_collection_0/v3_four_channel_placement_0/v3_channel_selector_late_promotion_2/v3_selector_route_pilot_0/G3_MUX_POS/a_218_47# VGND sky130_fd_pr__nfet_01v8 ad=0 pd=0 as=0.1386 ps=1.5 w=0.42 l=0.15
X877 v3_four_channel_output_load_integration_0/v3_four_channel_shared_support_integration_0/v3_four_channel_bias_reference_distribution_0/v3_four_channel_phase_distribution_0/v3_four_channel_output_collection_0/v3_four_channel_placement_0/v3_channel_selector_late_promotion_2/v3_selector_route_pilot_0/G3_MUX_POS/a_218_47# v3_four_channel_output_load_integration_0/v3_four_channel_shared_support_integration_0/v3_four_channel_bias_reference_distribution_0/v3_four_channel_phase_distribution_0/v3_four_channel_output_collection_0/v3_four_channel_placement_0/v3_channel_selector_late_promotion_2/group3_bit0 VGND VGND sky130_fd_pr__nfet_01v8 ad=0 pd=0 as=0 ps=0 w=0.42 l=0.15
X878 VDPWR v3_four_channel_output_load_integration_0/v3_four_channel_shared_support_integration_0/v3_four_channel_bias_reference_distribution_0/v3_four_channel_phase_distribution_0/v3_four_channel_output_collection_0/v3_four_channel_placement_0/v3_channel_selector_late_promotion_2/v3_selector_route_pilot_0/G3_MUX_POS/a_76_199# v3_four_channel_output_load_integration_0/v3_four_channel_shared_support_integration_0/v3_four_channel_bias_reference_distribution_0/v3_four_channel_phase_distribution_0/v3_four_channel_output_collection_0/v3_four_channel_placement_0/v3_channel_selector_late_promotion_2/v3_selector_route_pilot_0/G3_MUX_POS/X VDPWR sky130_fd_pr__pfet_01v8_hvt ad=0 pd=0 as=0.26 ps=2.52 w=1 l=0.15
X879 VGND v3_four_channel_output_load_integration_0/v3_four_channel_shared_support_integration_0/v3_four_channel_bias_reference_distribution_0/v3_four_channel_phase_distribution_0/v3_four_channel_output_collection_0/v3_four_channel_placement_0/v3_channel_selector_late_promotion_2/v3_selector_route_pilot_0/G3_MUX_POS/a_76_199# v3_four_channel_output_load_integration_0/v3_four_channel_shared_support_integration_0/v3_four_channel_bias_reference_distribution_0/v3_four_channel_phase_distribution_0/v3_four_channel_output_collection_0/v3_four_channel_placement_0/v3_channel_selector_late_promotion_2/v3_selector_route_pilot_0/G3_MUX_POS/X VGND sky130_fd_pr__nfet_01v8 ad=0 pd=0 as=0.169 ps=1.82 w=0.65 l=0.15
X880 VDPWR v3_four_channel_output_load_integration_0/v3_four_channel_shared_support_integration_0/v3_four_channel_bias_reference_distribution_0/v3_four_channel_phase_distribution_0/v3_four_channel_output_collection_0/v3_four_channel_placement_0/v3_channel_selector_late_promotion_2/v3_selector_route_pilot_0/G3_MUX_NEG/a_505_21# v3_four_channel_output_load_integration_0/v3_four_channel_shared_support_integration_0/v3_four_channel_bias_reference_distribution_0/v3_four_channel_phase_distribution_0/v3_four_channel_output_collection_0/v3_four_channel_placement_0/v3_channel_selector_late_promotion_2/v3_selector_route_pilot_0/G3_MUX_NEG/a_535_374# VDPWR sky130_fd_pr__pfet_01v8_hvt ad=0 pd=0 as=0.0882 ps=1.26 w=0.42 l=0.15
X881 v3_four_channel_output_load_integration_0/v3_four_channel_shared_support_integration_0/v3_four_channel_bias_reference_distribution_0/v3_four_channel_phase_distribution_0/v3_four_channel_output_collection_0/v3_four_channel_placement_0/v3_channel_selector_late_promotion_2/v3_selector_route_pilot_0/G3_MUX_NEG/a_505_21# v3_four_channel_output_load_integration_0/v3_four_channel_shared_support_integration_0/v3_four_channel_bias_reference_distribution_0/v3_four_channel_phase_distribution_0/v3_four_channel_output_collection_0/v3_four_channel_placement_0/v3_channel_selector_late_promotion_2/group3_bit0 VDPWR VDPWR sky130_fd_pr__pfet_01v8_hvt ad=0.1176 pd=1.4 as=0 ps=0 w=0.42 l=0.15
X882 v3_four_channel_output_load_integration_0/v3_four_channel_shared_support_integration_0/v3_four_channel_bias_reference_distribution_0/v3_four_channel_phase_distribution_0/v3_four_channel_output_collection_0/v3_four_channel_placement_0/v3_channel_selector_late_promotion_2/v3_selector_route_pilot_0/G3_MUX_NEG/a_218_374# v3_four_channel_output_load_integration_0/v3_four_channel_shared_support_integration_0/v3_four_channel_bias_reference_distribution_0/v3_four_channel_phase_distribution_0/v3_four_channel_output_collection_0/v3_four_channel_placement_0/v3_channel_selector_late_promotion_2/group3_bit0 VDPWR VDPWR sky130_fd_pr__pfet_01v8_hvt ad=0.1533 pd=1.57 as=0 ps=0 w=0.42 l=0.15
X883 VGND v3_four_channel_output_load_integration_0/v3_four_channel_shared_support_integration_0/v3_four_channel_bias_reference_distribution_0/v3_four_channel_phase_distribution_0/v3_four_channel_output_collection_0/v3_four_channel_placement_0/v3_channel_selector_late_promotion_2/v3_selector_route_pilot_0/G3_MUX_NEG/a_505_21# v3_four_channel_output_load_integration_0/v3_four_channel_shared_support_integration_0/v3_four_channel_bias_reference_distribution_0/v3_four_channel_phase_distribution_0/v3_four_channel_output_collection_0/v3_four_channel_placement_0/v3_channel_selector_late_promotion_2/v3_selector_route_pilot_0/G3_MUX_NEG/a_439_47# VGND sky130_fd_pr__nfet_01v8 ad=0 pd=0 as=0.1386 ps=1.5 w=0.42 l=0.15
X884 v3_four_channel_output_load_integration_0/v3_four_channel_shared_support_integration_0/v3_four_channel_bias_reference_distribution_0/v3_four_channel_phase_distribution_0/v3_four_channel_output_collection_0/v3_four_channel_placement_0/v3_channel_selector_late_promotion_2/v3_selector_route_pilot_0/G3_MUX_NEG/a_76_199# v3_four_channel_output_load_integration_0/v3_four_channel_shared_support_integration_0/v3_four_channel_bias_reference_distribution_0/v3_four_channel_phase_distribution_0/phase_180 v3_four_channel_output_load_integration_0/v3_four_channel_shared_support_integration_0/v3_four_channel_bias_reference_distribution_0/v3_four_channel_phase_distribution_0/v3_four_channel_output_collection_0/v3_four_channel_placement_0/v3_channel_selector_late_promotion_2/v3_selector_route_pilot_0/G3_MUX_NEG/a_218_374# VDPWR sky130_fd_pr__pfet_01v8_hvt ad=0.3864 pd=2.68 as=0 ps=0 w=0.42 l=0.15
X885 v3_four_channel_output_load_integration_0/v3_four_channel_shared_support_integration_0/v3_four_channel_bias_reference_distribution_0/v3_four_channel_phase_distribution_0/v3_four_channel_output_collection_0/v3_four_channel_placement_0/v3_channel_selector_late_promotion_2/v3_selector_route_pilot_0/G3_MUX_NEG/a_505_21# v3_four_channel_output_load_integration_0/v3_four_channel_shared_support_integration_0/v3_four_channel_bias_reference_distribution_0/v3_four_channel_phase_distribution_0/v3_four_channel_output_collection_0/v3_four_channel_placement_0/v3_channel_selector_late_promotion_2/group3_bit0 VGND VGND sky130_fd_pr__nfet_01v8 ad=0.1092 pd=1.36 as=0 ps=0 w=0.42 l=0.15
X886 v3_four_channel_output_load_integration_0/v3_four_channel_shared_support_integration_0/v3_four_channel_bias_reference_distribution_0/v3_four_channel_phase_distribution_0/v3_four_channel_output_collection_0/v3_four_channel_placement_0/v3_channel_selector_late_promotion_2/v3_selector_route_pilot_0/G3_MUX_NEG/a_439_47# v3_four_channel_output_load_integration_0/v3_four_channel_shared_support_integration_0/v3_four_channel_bias_reference_distribution_0/v3_four_channel_phase_distribution_0/phase_180 v3_four_channel_output_load_integration_0/v3_four_channel_shared_support_integration_0/v3_four_channel_bias_reference_distribution_0/v3_four_channel_phase_distribution_0/v3_four_channel_output_collection_0/v3_four_channel_placement_0/v3_channel_selector_late_promotion_2/v3_selector_route_pilot_0/G3_MUX_NEG/a_76_199# VGND sky130_fd_pr__nfet_01v8 ad=0 pd=0 as=0.1995 ps=1.79 w=0.42 l=0.15
X887 v3_four_channel_output_load_integration_0/v3_four_channel_shared_support_integration_0/v3_four_channel_bias_reference_distribution_0/v3_four_channel_phase_distribution_0/v3_four_channel_output_collection_0/v3_four_channel_placement_0/v3_channel_selector_late_promotion_2/v3_selector_route_pilot_0/G3_MUX_NEG/a_535_374# v3_four_channel_output_load_integration_0/v3_four_channel_shared_support_integration_0/v3_four_channel_bias_reference_distribution_0/v3_four_channel_phase_distribution_0/phase_270 v3_four_channel_output_load_integration_0/v3_four_channel_shared_support_integration_0/v3_four_channel_bias_reference_distribution_0/v3_four_channel_phase_distribution_0/v3_four_channel_output_collection_0/v3_four_channel_placement_0/v3_channel_selector_late_promotion_2/v3_selector_route_pilot_0/G3_MUX_NEG/a_76_199# VDPWR sky130_fd_pr__pfet_01v8_hvt ad=0 pd=0 as=0 ps=0 w=0.42 l=0.15
X888 v3_four_channel_output_load_integration_0/v3_four_channel_shared_support_integration_0/v3_four_channel_bias_reference_distribution_0/v3_four_channel_phase_distribution_0/v3_four_channel_output_collection_0/v3_four_channel_placement_0/v3_channel_selector_late_promotion_2/v3_selector_route_pilot_0/G3_MUX_NEG/a_76_199# v3_four_channel_output_load_integration_0/v3_four_channel_shared_support_integration_0/v3_four_channel_bias_reference_distribution_0/v3_four_channel_phase_distribution_0/phase_270 v3_four_channel_output_load_integration_0/v3_four_channel_shared_support_integration_0/v3_four_channel_bias_reference_distribution_0/v3_four_channel_phase_distribution_0/v3_four_channel_output_collection_0/v3_four_channel_placement_0/v3_channel_selector_late_promotion_2/v3_selector_route_pilot_0/G3_MUX_NEG/a_218_47# VGND sky130_fd_pr__nfet_01v8 ad=0 pd=0 as=0.1386 ps=1.5 w=0.42 l=0.15
X889 v3_four_channel_output_load_integration_0/v3_four_channel_shared_support_integration_0/v3_four_channel_bias_reference_distribution_0/v3_four_channel_phase_distribution_0/v3_four_channel_output_collection_0/v3_four_channel_placement_0/v3_channel_selector_late_promotion_2/v3_selector_route_pilot_0/G3_MUX_NEG/a_218_47# v3_four_channel_output_load_integration_0/v3_four_channel_shared_support_integration_0/v3_four_channel_bias_reference_distribution_0/v3_four_channel_phase_distribution_0/v3_four_channel_output_collection_0/v3_four_channel_placement_0/v3_channel_selector_late_promotion_2/group3_bit0 VGND VGND sky130_fd_pr__nfet_01v8 ad=0 pd=0 as=0 ps=0 w=0.42 l=0.15
X890 VDPWR v3_four_channel_output_load_integration_0/v3_four_channel_shared_support_integration_0/v3_four_channel_bias_reference_distribution_0/v3_four_channel_phase_distribution_0/v3_four_channel_output_collection_0/v3_four_channel_placement_0/v3_channel_selector_late_promotion_2/v3_selector_route_pilot_0/G3_MUX_NEG/a_76_199# v3_four_channel_output_load_integration_0/v3_four_channel_shared_support_integration_0/v3_four_channel_bias_reference_distribution_0/v3_four_channel_phase_distribution_0/v3_four_channel_output_collection_0/v3_four_channel_placement_0/v3_channel_selector_late_promotion_2/v3_selector_route_pilot_0/G3_MUX_NEG/X VDPWR sky130_fd_pr__pfet_01v8_hvt ad=0 pd=0 as=0.26 ps=2.52 w=1 l=0.15
X891 VGND v3_four_channel_output_load_integration_0/v3_four_channel_shared_support_integration_0/v3_four_channel_bias_reference_distribution_0/v3_four_channel_phase_distribution_0/v3_four_channel_output_collection_0/v3_four_channel_placement_0/v3_channel_selector_late_promotion_2/v3_selector_route_pilot_0/G3_MUX_NEG/a_76_199# v3_four_channel_output_load_integration_0/v3_four_channel_shared_support_integration_0/v3_four_channel_bias_reference_distribution_0/v3_four_channel_phase_distribution_0/v3_four_channel_output_collection_0/v3_four_channel_placement_0/v3_channel_selector_late_promotion_2/v3_selector_route_pilot_0/G3_MUX_NEG/X VGND sky130_fd_pr__nfet_01v8 ad=0 pd=0 as=0.169 ps=1.82 w=0.65 l=0.15
X892 VDPWR v3_four_channel_output_load_integration_0/v3_four_channel_shared_support_integration_0/v3_four_channel_bias_reference_distribution_0/v3_four_channel_phase_distribution_0/v3_four_channel_output_collection_0/v3_four_channel_placement_0/v3_channel_selector_late_promotion_2/v3_selector_route_pilot_0/G3_LO_P_AND/B v3_four_channel_output_load_integration_0/v3_four_channel_shared_support_integration_0/v3_four_channel_bias_reference_distribution_0/v3_four_channel_phase_distribution_0/v3_four_channel_output_collection_0/v3_four_channel_placement_0/v3_channel_selector_late_promotion_2/v3_selector_route_pilot_0/G0_LO_P_AND/a_59_75# VDPWR sky130_fd_pr__pfet_01v8_hvt ad=0 pd=0 as=0.1134 ps=1.38 w=0.42 l=0.15
X893 v3_four_channel_output_load_integration_0/v3_four_channel_shared_support_integration_0/v3_four_channel_bias_reference_distribution_0/v3_four_channel_phase_distribution_0/v3_four_channel_output_collection_0/v3_four_channel_placement_0/v3_channel_selector_late_promotion_2/v3_selector_route_pilot_0/group0_lo_p v3_four_channel_output_load_integration_0/v3_four_channel_shared_support_integration_0/v3_four_channel_bias_reference_distribution_0/v3_four_channel_phase_distribution_0/v3_four_channel_output_collection_0/v3_four_channel_placement_0/v3_channel_selector_late_promotion_2/v3_selector_route_pilot_0/G0_LO_P_AND/a_59_75# VDPWR VDPWR sky130_fd_pr__pfet_01v8_hvt ad=0.475 pd=2.95 as=0 ps=0 w=1 l=0.15
X894 VGND v3_four_channel_output_load_integration_0/v3_four_channel_shared_support_integration_0/v3_four_channel_bias_reference_distribution_0/v3_four_channel_phase_distribution_0/v3_four_channel_output_collection_0/v3_four_channel_placement_0/v3_channel_selector_late_promotion_2/v3_selector_route_pilot_0/G3_LO_P_AND/B v3_four_channel_output_load_integration_0/v3_four_channel_shared_support_integration_0/v3_four_channel_bias_reference_distribution_0/v3_four_channel_phase_distribution_0/v3_four_channel_output_collection_0/v3_four_channel_placement_0/v3_channel_selector_late_promotion_2/v3_selector_route_pilot_0/G0_LO_P_AND/a_145_75# VGND sky130_fd_pr__nfet_01v8 ad=0 pd=0 as=0.1134 ps=1.38 w=0.42 l=0.15
X895 v3_four_channel_output_load_integration_0/v3_four_channel_shared_support_integration_0/v3_four_channel_bias_reference_distribution_0/v3_four_channel_phase_distribution_0/v3_four_channel_output_collection_0/v3_four_channel_placement_0/v3_channel_selector_late_promotion_2/v3_selector_route_pilot_0/G0_LO_P_AND/a_59_75# v3_four_channel_output_load_integration_0/v3_four_channel_shared_support_integration_0/v3_four_channel_bias_reference_distribution_0/v3_four_channel_phase_distribution_0/v3_four_channel_output_collection_0/v3_four_channel_placement_0/v3_channel_selector_late_promotion_2/v3_selector_route_pilot_0/G0_MUX_AXIS/X VDPWR VDPWR sky130_fd_pr__pfet_01v8_hvt ad=0 pd=0 as=0 ps=0 w=0.42 l=0.15
X896 v3_four_channel_output_load_integration_0/v3_four_channel_shared_support_integration_0/v3_four_channel_bias_reference_distribution_0/v3_four_channel_phase_distribution_0/v3_four_channel_output_collection_0/v3_four_channel_placement_0/v3_channel_selector_late_promotion_2/v3_selector_route_pilot_0/group0_lo_p v3_four_channel_output_load_integration_0/v3_four_channel_shared_support_integration_0/v3_four_channel_bias_reference_distribution_0/v3_four_channel_phase_distribution_0/v3_four_channel_output_collection_0/v3_four_channel_placement_0/v3_channel_selector_late_promotion_2/v3_selector_route_pilot_0/G0_LO_P_AND/a_59_75# VGND VGND sky130_fd_pr__nfet_01v8 ad=0.182 pd=1.86 as=0 ps=0 w=0.65 l=0.15
X897 v3_four_channel_output_load_integration_0/v3_four_channel_shared_support_integration_0/v3_four_channel_bias_reference_distribution_0/v3_four_channel_phase_distribution_0/v3_four_channel_output_collection_0/v3_four_channel_placement_0/v3_channel_selector_late_promotion_2/v3_selector_route_pilot_0/G0_LO_P_AND/a_145_75# v3_four_channel_output_load_integration_0/v3_four_channel_shared_support_integration_0/v3_four_channel_bias_reference_distribution_0/v3_four_channel_phase_distribution_0/v3_four_channel_output_collection_0/v3_four_channel_placement_0/v3_channel_selector_late_promotion_2/v3_selector_route_pilot_0/G0_MUX_AXIS/X v3_four_channel_output_load_integration_0/v3_four_channel_shared_support_integration_0/v3_four_channel_bias_reference_distribution_0/v3_four_channel_phase_distribution_0/v3_four_channel_output_collection_0/v3_four_channel_placement_0/v3_channel_selector_late_promotion_2/v3_selector_route_pilot_0/G0_LO_P_AND/a_59_75# VGND sky130_fd_pr__nfet_01v8 ad=0 pd=0 as=0.1176 ps=1.4 w=0.42 l=0.15
X898 VDPWR v3_four_channel_output_load_integration_0/v3_four_channel_shared_support_integration_0/v3_four_channel_bias_reference_distribution_0/v3_four_channel_phase_distribution_0/v3_four_channel_output_collection_0/v3_four_channel_placement_0/v3_channel_selector_late_promotion_2/v3_selector_route_pilot_0/G3_LO_P_AND/B v3_four_channel_output_load_integration_0/v3_four_channel_shared_support_integration_0/v3_four_channel_bias_reference_distribution_0/v3_four_channel_phase_distribution_0/v3_four_channel_output_collection_0/v3_four_channel_placement_0/v3_channel_selector_late_promotion_2/v3_selector_route_pilot_0/G3_LO_N_ANDNOT/a_207_413# VDPWR sky130_fd_pr__pfet_01v8_hvt ad=0 pd=0 as=0.1218 ps=1.42 w=0.42 l=0.15
X899 v3_four_channel_output_load_integration_0/v3_four_channel_shared_support_integration_0/v3_four_channel_bias_reference_distribution_0/v3_four_channel_phase_distribution_0/v3_four_channel_output_collection_0/v3_four_channel_placement_0/v3_channel_selector_late_promotion_2/v3_selector_route_pilot_0/group3_lo_n v3_four_channel_output_load_integration_0/v3_four_channel_shared_support_integration_0/v3_four_channel_bias_reference_distribution_0/v3_four_channel_phase_distribution_0/v3_four_channel_output_collection_0/v3_four_channel_placement_0/v3_channel_selector_late_promotion_2/v3_selector_route_pilot_0/G3_LO_N_ANDNOT/a_207_413# VDPWR VDPWR sky130_fd_pr__pfet_01v8_hvt ad=0.26 pd=2.52 as=0 ps=0 w=1 l=0.15
X900 v3_four_channel_output_load_integration_0/v3_four_channel_shared_support_integration_0/v3_four_channel_bias_reference_distribution_0/v3_four_channel_phase_distribution_0/v3_four_channel_output_collection_0/v3_four_channel_placement_0/v3_channel_selector_late_promotion_2/v3_selector_route_pilot_0/G3_LO_N_ANDNOT/a_297_47# v3_four_channel_output_load_integration_0/v3_four_channel_shared_support_integration_0/v3_four_channel_bias_reference_distribution_0/v3_four_channel_phase_distribution_0/v3_four_channel_output_collection_0/v3_four_channel_placement_0/v3_channel_selector_late_promotion_2/v3_selector_route_pilot_0/G3_LO_N_ANDNOT/a_27_413# v3_four_channel_output_load_integration_0/v3_four_channel_shared_support_integration_0/v3_four_channel_bias_reference_distribution_0/v3_four_channel_phase_distribution_0/v3_four_channel_output_collection_0/v3_four_channel_placement_0/v3_channel_selector_late_promotion_2/v3_selector_route_pilot_0/G3_LO_N_ANDNOT/a_207_413# VGND sky130_fd_pr__nfet_01v8 ad=0.1008 pd=1.32 as=0.1092 ps=1.36 w=0.42 l=0.15
X901 v3_four_channel_output_load_integration_0/v3_four_channel_shared_support_integration_0/v3_four_channel_bias_reference_distribution_0/v3_four_channel_phase_distribution_0/v3_four_channel_output_collection_0/v3_four_channel_placement_0/v3_channel_selector_late_promotion_2/v3_selector_route_pilot_0/group3_lo_n v3_four_channel_output_load_integration_0/v3_four_channel_shared_support_integration_0/v3_four_channel_bias_reference_distribution_0/v3_four_channel_phase_distribution_0/v3_four_channel_output_collection_0/v3_four_channel_placement_0/v3_channel_selector_late_promotion_2/v3_selector_route_pilot_0/G3_LO_N_ANDNOT/a_207_413# VGND VGND sky130_fd_pr__nfet_01v8 ad=0.169 pd=1.82 as=0 ps=0 w=0.65 l=0.15
X902 v3_four_channel_output_load_integration_0/v3_four_channel_shared_support_integration_0/v3_four_channel_bias_reference_distribution_0/v3_four_channel_phase_distribution_0/v3_four_channel_output_collection_0/v3_four_channel_placement_0/v3_channel_selector_late_promotion_2/v3_selector_route_pilot_0/G3_LO_N_ANDNOT/a_207_413# v3_four_channel_output_load_integration_0/v3_four_channel_shared_support_integration_0/v3_four_channel_bias_reference_distribution_0/v3_four_channel_phase_distribution_0/v3_four_channel_output_collection_0/v3_four_channel_placement_0/v3_channel_selector_late_promotion_2/v3_selector_route_pilot_0/G3_LO_N_ANDNOT/a_27_413# VDPWR VDPWR sky130_fd_pr__pfet_01v8_hvt ad=0 pd=0 as=0 ps=0 w=0.42 l=0.15
X903 VDPWR v3_four_channel_output_load_integration_0/v3_four_channel_shared_support_integration_0/v3_four_channel_bias_reference_distribution_0/v3_four_channel_phase_distribution_0/v3_four_channel_output_collection_0/v3_four_channel_placement_0/v3_channel_selector_late_promotion_2/v3_selector_route_pilot_0/G3_MUX_AXIS/X v3_four_channel_output_load_integration_0/v3_four_channel_shared_support_integration_0/v3_four_channel_bias_reference_distribution_0/v3_four_channel_phase_distribution_0/v3_four_channel_output_collection_0/v3_four_channel_placement_0/v3_channel_selector_late_promotion_2/v3_selector_route_pilot_0/G3_LO_N_ANDNOT/a_27_413# VDPWR sky130_fd_pr__pfet_01v8_hvt ad=0 pd=0 as=0.1092 ps=1.36 w=0.42 l=0.15
X904 VGND v3_four_channel_output_load_integration_0/v3_four_channel_shared_support_integration_0/v3_four_channel_bias_reference_distribution_0/v3_four_channel_phase_distribution_0/v3_four_channel_output_collection_0/v3_four_channel_placement_0/v3_channel_selector_late_promotion_2/v3_selector_route_pilot_0/G3_LO_P_AND/B v3_four_channel_output_load_integration_0/v3_four_channel_shared_support_integration_0/v3_four_channel_bias_reference_distribution_0/v3_four_channel_phase_distribution_0/v3_four_channel_output_collection_0/v3_four_channel_placement_0/v3_channel_selector_late_promotion_2/v3_selector_route_pilot_0/G3_LO_N_ANDNOT/a_297_47# VGND sky130_fd_pr__nfet_01v8 ad=0 pd=0 as=0 ps=0 w=0.42 l=0.15
X905 v3_four_channel_output_load_integration_0/v3_four_channel_shared_support_integration_0/v3_four_channel_bias_reference_distribution_0/v3_four_channel_phase_distribution_0/v3_four_channel_output_collection_0/v3_four_channel_placement_0/v3_channel_selector_late_promotion_2/v3_selector_route_pilot_0/G3_LO_N_ANDNOT/a_27_413# v3_four_channel_output_load_integration_0/v3_four_channel_shared_support_integration_0/v3_four_channel_bias_reference_distribution_0/v3_four_channel_phase_distribution_0/v3_four_channel_output_collection_0/v3_four_channel_placement_0/v3_channel_selector_late_promotion_2/v3_selector_route_pilot_0/G3_MUX_AXIS/X VGND VGND sky130_fd_pr__nfet_01v8 ad=0.1092 pd=1.36 as=0 ps=0 w=0.42 l=0.15
X906 VDPWR v3_four_channel_output_load_integration_0/v3_four_channel_shared_support_integration_0/v3_four_channel_bias_reference_distribution_0/v3_four_channel_phase_distribution_0/v3_four_channel_output_collection_0/v3_four_channel_placement_0/v3_channel_selector_late_promotion_2/v3_selector_route_pilot_0/G3_LO_P_AND/B v3_four_channel_output_load_integration_0/v3_four_channel_shared_support_integration_0/v3_four_channel_bias_reference_distribution_0/v3_four_channel_phase_distribution_0/v3_four_channel_output_collection_0/v3_four_channel_placement_0/v3_channel_selector_late_promotion_2/v3_selector_route_pilot_0/G2_LO_N_ANDNOT/a_207_413# VDPWR sky130_fd_pr__pfet_01v8_hvt ad=0 pd=0 as=0.1218 ps=1.42 w=0.42 l=0.15
X907 v3_four_channel_output_load_integration_0/v3_four_channel_shared_support_integration_0/v3_four_channel_bias_reference_distribution_0/v3_four_channel_phase_distribution_0/v3_four_channel_output_collection_0/v3_four_channel_placement_0/v3_channel_selector_late_promotion_2/v3_selector_route_pilot_0/group2_lo_n v3_four_channel_output_load_integration_0/v3_four_channel_shared_support_integration_0/v3_four_channel_bias_reference_distribution_0/v3_four_channel_phase_distribution_0/v3_four_channel_output_collection_0/v3_four_channel_placement_0/v3_channel_selector_late_promotion_2/v3_selector_route_pilot_0/G2_LO_N_ANDNOT/a_207_413# VDPWR VDPWR sky130_fd_pr__pfet_01v8_hvt ad=0.26 pd=2.52 as=0 ps=0 w=1 l=0.15
X908 v3_four_channel_output_load_integration_0/v3_four_channel_shared_support_integration_0/v3_four_channel_bias_reference_distribution_0/v3_four_channel_phase_distribution_0/v3_four_channel_output_collection_0/v3_four_channel_placement_0/v3_channel_selector_late_promotion_2/v3_selector_route_pilot_0/G2_LO_N_ANDNOT/a_297_47# v3_four_channel_output_load_integration_0/v3_four_channel_shared_support_integration_0/v3_four_channel_bias_reference_distribution_0/v3_four_channel_phase_distribution_0/v3_four_channel_output_collection_0/v3_four_channel_placement_0/v3_channel_selector_late_promotion_2/v3_selector_route_pilot_0/G2_LO_N_ANDNOT/a_27_413# v3_four_channel_output_load_integration_0/v3_four_channel_shared_support_integration_0/v3_four_channel_bias_reference_distribution_0/v3_four_channel_phase_distribution_0/v3_four_channel_output_collection_0/v3_four_channel_placement_0/v3_channel_selector_late_promotion_2/v3_selector_route_pilot_0/G2_LO_N_ANDNOT/a_207_413# VGND sky130_fd_pr__nfet_01v8 ad=0.1008 pd=1.32 as=0.1092 ps=1.36 w=0.42 l=0.15
X909 v3_four_channel_output_load_integration_0/v3_four_channel_shared_support_integration_0/v3_four_channel_bias_reference_distribution_0/v3_four_channel_phase_distribution_0/v3_four_channel_output_collection_0/v3_four_channel_placement_0/v3_channel_selector_late_promotion_2/v3_selector_route_pilot_0/group2_lo_n v3_four_channel_output_load_integration_0/v3_four_channel_shared_support_integration_0/v3_four_channel_bias_reference_distribution_0/v3_four_channel_phase_distribution_0/v3_four_channel_output_collection_0/v3_four_channel_placement_0/v3_channel_selector_late_promotion_2/v3_selector_route_pilot_0/G2_LO_N_ANDNOT/a_207_413# VGND VGND sky130_fd_pr__nfet_01v8 ad=0.169 pd=1.82 as=0 ps=0 w=0.65 l=0.15
X910 v3_four_channel_output_load_integration_0/v3_four_channel_shared_support_integration_0/v3_four_channel_bias_reference_distribution_0/v3_four_channel_phase_distribution_0/v3_four_channel_output_collection_0/v3_four_channel_placement_0/v3_channel_selector_late_promotion_2/v3_selector_route_pilot_0/G2_LO_N_ANDNOT/a_207_413# v3_four_channel_output_load_integration_0/v3_four_channel_shared_support_integration_0/v3_four_channel_bias_reference_distribution_0/v3_four_channel_phase_distribution_0/v3_four_channel_output_collection_0/v3_four_channel_placement_0/v3_channel_selector_late_promotion_2/v3_selector_route_pilot_0/G2_LO_N_ANDNOT/a_27_413# VDPWR VDPWR sky130_fd_pr__pfet_01v8_hvt ad=0 pd=0 as=0 ps=0 w=0.42 l=0.15
X911 VDPWR v3_four_channel_output_load_integration_0/v3_four_channel_shared_support_integration_0/v3_four_channel_bias_reference_distribution_0/v3_four_channel_phase_distribution_0/v3_four_channel_output_collection_0/v3_four_channel_placement_0/v3_channel_selector_late_promotion_2/v3_selector_route_pilot_0/G2_MUX_AXIS/X v3_four_channel_output_load_integration_0/v3_four_channel_shared_support_integration_0/v3_four_channel_bias_reference_distribution_0/v3_four_channel_phase_distribution_0/v3_four_channel_output_collection_0/v3_four_channel_placement_0/v3_channel_selector_late_promotion_2/v3_selector_route_pilot_0/G2_LO_N_ANDNOT/a_27_413# VDPWR sky130_fd_pr__pfet_01v8_hvt ad=0 pd=0 as=0.1092 ps=1.36 w=0.42 l=0.15
X912 VGND v3_four_channel_output_load_integration_0/v3_four_channel_shared_support_integration_0/v3_four_channel_bias_reference_distribution_0/v3_four_channel_phase_distribution_0/v3_four_channel_output_collection_0/v3_four_channel_placement_0/v3_channel_selector_late_promotion_2/v3_selector_route_pilot_0/G3_LO_P_AND/B v3_four_channel_output_load_integration_0/v3_four_channel_shared_support_integration_0/v3_four_channel_bias_reference_distribution_0/v3_four_channel_phase_distribution_0/v3_four_channel_output_collection_0/v3_four_channel_placement_0/v3_channel_selector_late_promotion_2/v3_selector_route_pilot_0/G2_LO_N_ANDNOT/a_297_47# VGND sky130_fd_pr__nfet_01v8 ad=0 pd=0 as=0 ps=0 w=0.42 l=0.15
X913 v3_four_channel_output_load_integration_0/v3_four_channel_shared_support_integration_0/v3_four_channel_bias_reference_distribution_0/v3_four_channel_phase_distribution_0/v3_four_channel_output_collection_0/v3_four_channel_placement_0/v3_channel_selector_late_promotion_2/v3_selector_route_pilot_0/G2_LO_N_ANDNOT/a_27_413# v3_four_channel_output_load_integration_0/v3_four_channel_shared_support_integration_0/v3_four_channel_bias_reference_distribution_0/v3_four_channel_phase_distribution_0/v3_four_channel_output_collection_0/v3_four_channel_placement_0/v3_channel_selector_late_promotion_2/v3_selector_route_pilot_0/G2_MUX_AXIS/X VGND VGND sky130_fd_pr__nfet_01v8 ad=0.1092 pd=1.36 as=0 ps=0 w=0.42 l=0.15
X914 VDPWR v3_four_channel_output_load_integration_0/v3_four_channel_shared_support_integration_0/v3_four_channel_bias_reference_distribution_0/v3_four_channel_phase_distribution_0/v3_four_channel_output_collection_0/v3_four_channel_placement_0/v3_channel_selector_late_promotion_2/v3_selector_route_pilot_0/G3_LO_P_AND/B v3_four_channel_output_load_integration_0/v3_four_channel_shared_support_integration_0/v3_four_channel_bias_reference_distribution_0/v3_four_channel_phase_distribution_0/v3_four_channel_output_collection_0/v3_four_channel_placement_0/v3_channel_selector_late_promotion_2/v3_selector_route_pilot_0/G0_LO_N_ANDNOT/a_207_413# VDPWR sky130_fd_pr__pfet_01v8_hvt ad=0 pd=0 as=0.1218 ps=1.42 w=0.42 l=0.15
X915 v3_four_channel_output_load_integration_0/v3_four_channel_shared_support_integration_0/v3_four_channel_bias_reference_distribution_0/v3_four_channel_phase_distribution_0/v3_four_channel_output_collection_0/v3_four_channel_placement_0/v3_channel_selector_late_promotion_2/v3_selector_route_pilot_0/group0_lo_n v3_four_channel_output_load_integration_0/v3_four_channel_shared_support_integration_0/v3_four_channel_bias_reference_distribution_0/v3_four_channel_phase_distribution_0/v3_four_channel_output_collection_0/v3_four_channel_placement_0/v3_channel_selector_late_promotion_2/v3_selector_route_pilot_0/G0_LO_N_ANDNOT/a_207_413# VDPWR VDPWR sky130_fd_pr__pfet_01v8_hvt ad=0.26 pd=2.52 as=0 ps=0 w=1 l=0.15
X916 v3_four_channel_output_load_integration_0/v3_four_channel_shared_support_integration_0/v3_four_channel_bias_reference_distribution_0/v3_four_channel_phase_distribution_0/v3_four_channel_output_collection_0/v3_four_channel_placement_0/v3_channel_selector_late_promotion_2/v3_selector_route_pilot_0/G0_LO_N_ANDNOT/a_297_47# v3_four_channel_output_load_integration_0/v3_four_channel_shared_support_integration_0/v3_four_channel_bias_reference_distribution_0/v3_four_channel_phase_distribution_0/v3_four_channel_output_collection_0/v3_four_channel_placement_0/v3_channel_selector_late_promotion_2/v3_selector_route_pilot_0/G0_LO_N_ANDNOT/a_27_413# v3_four_channel_output_load_integration_0/v3_four_channel_shared_support_integration_0/v3_four_channel_bias_reference_distribution_0/v3_four_channel_phase_distribution_0/v3_four_channel_output_collection_0/v3_four_channel_placement_0/v3_channel_selector_late_promotion_2/v3_selector_route_pilot_0/G0_LO_N_ANDNOT/a_207_413# VGND sky130_fd_pr__nfet_01v8 ad=0.1008 pd=1.32 as=0.1092 ps=1.36 w=0.42 l=0.15
X917 v3_four_channel_output_load_integration_0/v3_four_channel_shared_support_integration_0/v3_four_channel_bias_reference_distribution_0/v3_four_channel_phase_distribution_0/v3_four_channel_output_collection_0/v3_four_channel_placement_0/v3_channel_selector_late_promotion_2/v3_selector_route_pilot_0/group0_lo_n v3_four_channel_output_load_integration_0/v3_four_channel_shared_support_integration_0/v3_four_channel_bias_reference_distribution_0/v3_four_channel_phase_distribution_0/v3_four_channel_output_collection_0/v3_four_channel_placement_0/v3_channel_selector_late_promotion_2/v3_selector_route_pilot_0/G0_LO_N_ANDNOT/a_207_413# VGND VGND sky130_fd_pr__nfet_01v8 ad=0.169 pd=1.82 as=0 ps=0 w=0.65 l=0.15
X918 v3_four_channel_output_load_integration_0/v3_four_channel_shared_support_integration_0/v3_four_channel_bias_reference_distribution_0/v3_four_channel_phase_distribution_0/v3_four_channel_output_collection_0/v3_four_channel_placement_0/v3_channel_selector_late_promotion_2/v3_selector_route_pilot_0/G0_LO_N_ANDNOT/a_207_413# v3_four_channel_output_load_integration_0/v3_four_channel_shared_support_integration_0/v3_four_channel_bias_reference_distribution_0/v3_four_channel_phase_distribution_0/v3_four_channel_output_collection_0/v3_four_channel_placement_0/v3_channel_selector_late_promotion_2/v3_selector_route_pilot_0/G0_LO_N_ANDNOT/a_27_413# VDPWR VDPWR sky130_fd_pr__pfet_01v8_hvt ad=0 pd=0 as=0 ps=0 w=0.42 l=0.15
X919 VDPWR v3_four_channel_output_load_integration_0/v3_four_channel_shared_support_integration_0/v3_four_channel_bias_reference_distribution_0/v3_four_channel_phase_distribution_0/v3_four_channel_output_collection_0/v3_four_channel_placement_0/v3_channel_selector_late_promotion_2/v3_selector_route_pilot_0/G0_MUX_AXIS/X v3_four_channel_output_load_integration_0/v3_four_channel_shared_support_integration_0/v3_four_channel_bias_reference_distribution_0/v3_four_channel_phase_distribution_0/v3_four_channel_output_collection_0/v3_four_channel_placement_0/v3_channel_selector_late_promotion_2/v3_selector_route_pilot_0/G0_LO_N_ANDNOT/a_27_413# VDPWR sky130_fd_pr__pfet_01v8_hvt ad=0 pd=0 as=0.1092 ps=1.36 w=0.42 l=0.15
X920 VGND v3_four_channel_output_load_integration_0/v3_four_channel_shared_support_integration_0/v3_four_channel_bias_reference_distribution_0/v3_four_channel_phase_distribution_0/v3_four_channel_output_collection_0/v3_four_channel_placement_0/v3_channel_selector_late_promotion_2/v3_selector_route_pilot_0/G3_LO_P_AND/B v3_four_channel_output_load_integration_0/v3_four_channel_shared_support_integration_0/v3_four_channel_bias_reference_distribution_0/v3_four_channel_phase_distribution_0/v3_four_channel_output_collection_0/v3_four_channel_placement_0/v3_channel_selector_late_promotion_2/v3_selector_route_pilot_0/G0_LO_N_ANDNOT/a_297_47# VGND sky130_fd_pr__nfet_01v8 ad=0 pd=0 as=0 ps=0 w=0.42 l=0.15
X921 v3_four_channel_output_load_integration_0/v3_four_channel_shared_support_integration_0/v3_four_channel_bias_reference_distribution_0/v3_four_channel_phase_distribution_0/v3_four_channel_output_collection_0/v3_four_channel_placement_0/v3_channel_selector_late_promotion_2/v3_selector_route_pilot_0/G0_LO_N_ANDNOT/a_27_413# v3_four_channel_output_load_integration_0/v3_four_channel_shared_support_integration_0/v3_four_channel_bias_reference_distribution_0/v3_four_channel_phase_distribution_0/v3_four_channel_output_collection_0/v3_four_channel_placement_0/v3_channel_selector_late_promotion_2/v3_selector_route_pilot_0/G0_MUX_AXIS/X VGND VGND sky130_fd_pr__nfet_01v8 ad=0.1092 pd=1.36 as=0 ps=0 w=0.42 l=0.15
X922 VDPWR v3_four_channel_output_load_integration_0/v3_four_channel_shared_support_integration_0/v3_four_channel_bias_reference_distribution_0/v3_four_channel_phase_distribution_0/v3_four_channel_output_collection_0/v3_four_channel_placement_0/v3_channel_selector_late_promotion_2/v3_selector_route_pilot_0/G1_MUX_AXIS/a_505_21# v3_four_channel_output_load_integration_0/v3_four_channel_shared_support_integration_0/v3_four_channel_bias_reference_distribution_0/v3_four_channel_phase_distribution_0/v3_four_channel_output_collection_0/v3_four_channel_placement_0/v3_channel_selector_late_promotion_2/v3_selector_route_pilot_0/G1_MUX_AXIS/a_535_374# VDPWR sky130_fd_pr__pfet_01v8_hvt ad=0 pd=0 as=0.0882 ps=1.26 w=0.42 l=0.15
X923 v3_four_channel_output_load_integration_0/v3_four_channel_shared_support_integration_0/v3_four_channel_bias_reference_distribution_0/v3_four_channel_phase_distribution_0/v3_four_channel_output_collection_0/v3_four_channel_placement_0/v3_channel_selector_late_promotion_2/v3_selector_route_pilot_0/G1_MUX_AXIS/a_505_21# v3_four_channel_output_load_integration_0/v3_four_channel_shared_support_integration_0/v3_four_channel_bias_reference_distribution_0/v3_four_channel_phase_distribution_0/v3_four_channel_output_collection_0/v3_four_channel_placement_0/v3_channel_selector_late_promotion_2/group1_bit1 VDPWR VDPWR sky130_fd_pr__pfet_01v8_hvt ad=0.1176 pd=1.4 as=0 ps=0 w=0.42 l=0.15
X924 v3_four_channel_output_load_integration_0/v3_four_channel_shared_support_integration_0/v3_four_channel_bias_reference_distribution_0/v3_four_channel_phase_distribution_0/v3_four_channel_output_collection_0/v3_four_channel_placement_0/v3_channel_selector_late_promotion_2/v3_selector_route_pilot_0/G1_MUX_AXIS/a_218_374# v3_four_channel_output_load_integration_0/v3_four_channel_shared_support_integration_0/v3_four_channel_bias_reference_distribution_0/v3_four_channel_phase_distribution_0/v3_four_channel_output_collection_0/v3_four_channel_placement_0/v3_channel_selector_late_promotion_2/group1_bit1 VDPWR VDPWR sky130_fd_pr__pfet_01v8_hvt ad=0.1533 pd=1.57 as=0 ps=0 w=0.42 l=0.15
X925 VGND v3_four_channel_output_load_integration_0/v3_four_channel_shared_support_integration_0/v3_four_channel_bias_reference_distribution_0/v3_four_channel_phase_distribution_0/v3_four_channel_output_collection_0/v3_four_channel_placement_0/v3_channel_selector_late_promotion_2/v3_selector_route_pilot_0/G1_MUX_AXIS/a_505_21# v3_four_channel_output_load_integration_0/v3_four_channel_shared_support_integration_0/v3_four_channel_bias_reference_distribution_0/v3_four_channel_phase_distribution_0/v3_four_channel_output_collection_0/v3_four_channel_placement_0/v3_channel_selector_late_promotion_2/v3_selector_route_pilot_0/G1_MUX_AXIS/a_439_47# VGND sky130_fd_pr__nfet_01v8 ad=0 pd=0 as=0.1386 ps=1.5 w=0.42 l=0.15
X926 v3_four_channel_output_load_integration_0/v3_four_channel_shared_support_integration_0/v3_four_channel_bias_reference_distribution_0/v3_four_channel_phase_distribution_0/v3_four_channel_output_collection_0/v3_four_channel_placement_0/v3_channel_selector_late_promotion_2/v3_selector_route_pilot_0/G1_MUX_AXIS/a_76_199# v3_four_channel_output_load_integration_0/v3_four_channel_shared_support_integration_0/v3_four_channel_bias_reference_distribution_0/v3_four_channel_phase_distribution_0/v3_four_channel_output_collection_0/v3_four_channel_placement_0/v3_channel_selector_late_promotion_2/v3_selector_route_pilot_0/G1_MUX_POS/X v3_four_channel_output_load_integration_0/v3_four_channel_shared_support_integration_0/v3_four_channel_bias_reference_distribution_0/v3_four_channel_phase_distribution_0/v3_four_channel_output_collection_0/v3_four_channel_placement_0/v3_channel_selector_late_promotion_2/v3_selector_route_pilot_0/G1_MUX_AXIS/a_218_374# VDPWR sky130_fd_pr__pfet_01v8_hvt ad=0.3864 pd=2.68 as=0 ps=0 w=0.42 l=0.15
X927 v3_four_channel_output_load_integration_0/v3_four_channel_shared_support_integration_0/v3_four_channel_bias_reference_distribution_0/v3_four_channel_phase_distribution_0/v3_four_channel_output_collection_0/v3_four_channel_placement_0/v3_channel_selector_late_promotion_2/v3_selector_route_pilot_0/G1_MUX_AXIS/a_505_21# v3_four_channel_output_load_integration_0/v3_four_channel_shared_support_integration_0/v3_four_channel_bias_reference_distribution_0/v3_four_channel_phase_distribution_0/v3_four_channel_output_collection_0/v3_four_channel_placement_0/v3_channel_selector_late_promotion_2/group1_bit1 VGND VGND sky130_fd_pr__nfet_01v8 ad=0.1092 pd=1.36 as=0 ps=0 w=0.42 l=0.15
X928 v3_four_channel_output_load_integration_0/v3_four_channel_shared_support_integration_0/v3_four_channel_bias_reference_distribution_0/v3_four_channel_phase_distribution_0/v3_four_channel_output_collection_0/v3_four_channel_placement_0/v3_channel_selector_late_promotion_2/v3_selector_route_pilot_0/G1_MUX_AXIS/a_439_47# v3_four_channel_output_load_integration_0/v3_four_channel_shared_support_integration_0/v3_four_channel_bias_reference_distribution_0/v3_four_channel_phase_distribution_0/v3_four_channel_output_collection_0/v3_four_channel_placement_0/v3_channel_selector_late_promotion_2/v3_selector_route_pilot_0/G1_MUX_POS/X v3_four_channel_output_load_integration_0/v3_four_channel_shared_support_integration_0/v3_four_channel_bias_reference_distribution_0/v3_four_channel_phase_distribution_0/v3_four_channel_output_collection_0/v3_four_channel_placement_0/v3_channel_selector_late_promotion_2/v3_selector_route_pilot_0/G1_MUX_AXIS/a_76_199# VGND sky130_fd_pr__nfet_01v8 ad=0 pd=0 as=0.1995 ps=1.79 w=0.42 l=0.15
X929 v3_four_channel_output_load_integration_0/v3_four_channel_shared_support_integration_0/v3_four_channel_bias_reference_distribution_0/v3_four_channel_phase_distribution_0/v3_four_channel_output_collection_0/v3_four_channel_placement_0/v3_channel_selector_late_promotion_2/v3_selector_route_pilot_0/G1_MUX_AXIS/a_535_374# v3_four_channel_output_load_integration_0/v3_four_channel_shared_support_integration_0/v3_four_channel_bias_reference_distribution_0/v3_four_channel_phase_distribution_0/v3_four_channel_output_collection_0/v3_four_channel_placement_0/v3_channel_selector_late_promotion_2/v3_selector_route_pilot_0/G1_MUX_NEG/X v3_four_channel_output_load_integration_0/v3_four_channel_shared_support_integration_0/v3_four_channel_bias_reference_distribution_0/v3_four_channel_phase_distribution_0/v3_four_channel_output_collection_0/v3_four_channel_placement_0/v3_channel_selector_late_promotion_2/v3_selector_route_pilot_0/G1_MUX_AXIS/a_76_199# VDPWR sky130_fd_pr__pfet_01v8_hvt ad=0 pd=0 as=0 ps=0 w=0.42 l=0.15
X930 v3_four_channel_output_load_integration_0/v3_four_channel_shared_support_integration_0/v3_four_channel_bias_reference_distribution_0/v3_four_channel_phase_distribution_0/v3_four_channel_output_collection_0/v3_four_channel_placement_0/v3_channel_selector_late_promotion_2/v3_selector_route_pilot_0/G1_MUX_AXIS/a_76_199# v3_four_channel_output_load_integration_0/v3_four_channel_shared_support_integration_0/v3_four_channel_bias_reference_distribution_0/v3_four_channel_phase_distribution_0/v3_four_channel_output_collection_0/v3_four_channel_placement_0/v3_channel_selector_late_promotion_2/v3_selector_route_pilot_0/G1_MUX_NEG/X v3_four_channel_output_load_integration_0/v3_four_channel_shared_support_integration_0/v3_four_channel_bias_reference_distribution_0/v3_four_channel_phase_distribution_0/v3_four_channel_output_collection_0/v3_four_channel_placement_0/v3_channel_selector_late_promotion_2/v3_selector_route_pilot_0/G1_MUX_AXIS/a_218_47# VGND sky130_fd_pr__nfet_01v8 ad=0 pd=0 as=0.1386 ps=1.5 w=0.42 l=0.15
X931 v3_four_channel_output_load_integration_0/v3_four_channel_shared_support_integration_0/v3_four_channel_bias_reference_distribution_0/v3_four_channel_phase_distribution_0/v3_four_channel_output_collection_0/v3_four_channel_placement_0/v3_channel_selector_late_promotion_2/v3_selector_route_pilot_0/G1_MUX_AXIS/a_218_47# v3_four_channel_output_load_integration_0/v3_four_channel_shared_support_integration_0/v3_four_channel_bias_reference_distribution_0/v3_four_channel_phase_distribution_0/v3_four_channel_output_collection_0/v3_four_channel_placement_0/v3_channel_selector_late_promotion_2/group1_bit1 VGND VGND sky130_fd_pr__nfet_01v8 ad=0 pd=0 as=0 ps=0 w=0.42 l=0.15
X932 VDPWR v3_four_channel_output_load_integration_0/v3_four_channel_shared_support_integration_0/v3_four_channel_bias_reference_distribution_0/v3_four_channel_phase_distribution_0/v3_four_channel_output_collection_0/v3_four_channel_placement_0/v3_channel_selector_late_promotion_2/v3_selector_route_pilot_0/G1_MUX_AXIS/a_76_199# v3_four_channel_output_load_integration_0/v3_four_channel_shared_support_integration_0/v3_four_channel_bias_reference_distribution_0/v3_four_channel_phase_distribution_0/v3_four_channel_output_collection_0/v3_four_channel_placement_0/v3_channel_selector_late_promotion_2/v3_selector_route_pilot_0/G1_MUX_AXIS/X VDPWR sky130_fd_pr__pfet_01v8_hvt ad=0 pd=0 as=0.26 ps=2.52 w=1 l=0.15
X933 VGND v3_four_channel_output_load_integration_0/v3_four_channel_shared_support_integration_0/v3_four_channel_bias_reference_distribution_0/v3_four_channel_phase_distribution_0/v3_four_channel_output_collection_0/v3_four_channel_placement_0/v3_channel_selector_late_promotion_2/v3_selector_route_pilot_0/G1_MUX_AXIS/a_76_199# v3_four_channel_output_load_integration_0/v3_four_channel_shared_support_integration_0/v3_four_channel_bias_reference_distribution_0/v3_four_channel_phase_distribution_0/v3_four_channel_output_collection_0/v3_four_channel_placement_0/v3_channel_selector_late_promotion_2/v3_selector_route_pilot_0/G1_MUX_AXIS/X VGND sky130_fd_pr__nfet_01v8 ad=0 pd=0 as=0.169 ps=1.82 w=0.65 l=0.15
X934 VDPWR v3_four_channel_output_load_integration_0/v3_four_channel_shared_support_integration_0/v3_four_channel_bias_reference_distribution_0/v3_four_channel_phase_distribution_0/v3_four_channel_output_collection_0/v3_four_channel_placement_0/v3_channel_selector_late_promotion_2/v3_selector_route_pilot_0/G3_LO_P_AND/B v3_four_channel_output_load_integration_0/v3_four_channel_shared_support_integration_0/v3_four_channel_bias_reference_distribution_0/v3_four_channel_phase_distribution_0/v3_four_channel_output_collection_0/v3_four_channel_placement_0/v3_channel_selector_late_promotion_2/v3_selector_route_pilot_0/G1_LO_N_ANDNOT/a_207_413# VDPWR sky130_fd_pr__pfet_01v8_hvt ad=0 pd=0 as=0.1218 ps=1.42 w=0.42 l=0.15
X935 v3_four_channel_output_load_integration_0/v3_four_channel_shared_support_integration_0/v3_four_channel_bias_reference_distribution_0/v3_four_channel_phase_distribution_0/v3_four_channel_output_collection_0/v3_four_channel_placement_0/v3_channel_selector_late_promotion_2/v3_selector_route_pilot_0/group1_lo_n v3_four_channel_output_load_integration_0/v3_four_channel_shared_support_integration_0/v3_four_channel_bias_reference_distribution_0/v3_four_channel_phase_distribution_0/v3_four_channel_output_collection_0/v3_four_channel_placement_0/v3_channel_selector_late_promotion_2/v3_selector_route_pilot_0/G1_LO_N_ANDNOT/a_207_413# VDPWR VDPWR sky130_fd_pr__pfet_01v8_hvt ad=0.26 pd=2.52 as=0 ps=0 w=1 l=0.15
X936 v3_four_channel_output_load_integration_0/v3_four_channel_shared_support_integration_0/v3_four_channel_bias_reference_distribution_0/v3_four_channel_phase_distribution_0/v3_four_channel_output_collection_0/v3_four_channel_placement_0/v3_channel_selector_late_promotion_2/v3_selector_route_pilot_0/G1_LO_N_ANDNOT/a_297_47# v3_four_channel_output_load_integration_0/v3_four_channel_shared_support_integration_0/v3_four_channel_bias_reference_distribution_0/v3_four_channel_phase_distribution_0/v3_four_channel_output_collection_0/v3_four_channel_placement_0/v3_channel_selector_late_promotion_2/v3_selector_route_pilot_0/G1_LO_N_ANDNOT/a_27_413# v3_four_channel_output_load_integration_0/v3_four_channel_shared_support_integration_0/v3_four_channel_bias_reference_distribution_0/v3_four_channel_phase_distribution_0/v3_four_channel_output_collection_0/v3_four_channel_placement_0/v3_channel_selector_late_promotion_2/v3_selector_route_pilot_0/G1_LO_N_ANDNOT/a_207_413# VGND sky130_fd_pr__nfet_01v8 ad=0.1008 pd=1.32 as=0.1092 ps=1.36 w=0.42 l=0.15
X937 v3_four_channel_output_load_integration_0/v3_four_channel_shared_support_integration_0/v3_four_channel_bias_reference_distribution_0/v3_four_channel_phase_distribution_0/v3_four_channel_output_collection_0/v3_four_channel_placement_0/v3_channel_selector_late_promotion_2/v3_selector_route_pilot_0/group1_lo_n v3_four_channel_output_load_integration_0/v3_four_channel_shared_support_integration_0/v3_four_channel_bias_reference_distribution_0/v3_four_channel_phase_distribution_0/v3_four_channel_output_collection_0/v3_four_channel_placement_0/v3_channel_selector_late_promotion_2/v3_selector_route_pilot_0/G1_LO_N_ANDNOT/a_207_413# VGND VGND sky130_fd_pr__nfet_01v8 ad=0.169 pd=1.82 as=0 ps=0 w=0.65 l=0.15
X938 v3_four_channel_output_load_integration_0/v3_four_channel_shared_support_integration_0/v3_four_channel_bias_reference_distribution_0/v3_four_channel_phase_distribution_0/v3_four_channel_output_collection_0/v3_four_channel_placement_0/v3_channel_selector_late_promotion_2/v3_selector_route_pilot_0/G1_LO_N_ANDNOT/a_207_413# v3_four_channel_output_load_integration_0/v3_four_channel_shared_support_integration_0/v3_four_channel_bias_reference_distribution_0/v3_four_channel_phase_distribution_0/v3_four_channel_output_collection_0/v3_four_channel_placement_0/v3_channel_selector_late_promotion_2/v3_selector_route_pilot_0/G1_LO_N_ANDNOT/a_27_413# VDPWR VDPWR sky130_fd_pr__pfet_01v8_hvt ad=0 pd=0 as=0 ps=0 w=0.42 l=0.15
X939 VDPWR v3_four_channel_output_load_integration_0/v3_four_channel_shared_support_integration_0/v3_four_channel_bias_reference_distribution_0/v3_four_channel_phase_distribution_0/v3_four_channel_output_collection_0/v3_four_channel_placement_0/v3_channel_selector_late_promotion_2/v3_selector_route_pilot_0/G1_MUX_AXIS/X v3_four_channel_output_load_integration_0/v3_four_channel_shared_support_integration_0/v3_four_channel_bias_reference_distribution_0/v3_four_channel_phase_distribution_0/v3_four_channel_output_collection_0/v3_four_channel_placement_0/v3_channel_selector_late_promotion_2/v3_selector_route_pilot_0/G1_LO_N_ANDNOT/a_27_413# VDPWR sky130_fd_pr__pfet_01v8_hvt ad=0 pd=0 as=0.1092 ps=1.36 w=0.42 l=0.15
X940 VGND v3_four_channel_output_load_integration_0/v3_four_channel_shared_support_integration_0/v3_four_channel_bias_reference_distribution_0/v3_four_channel_phase_distribution_0/v3_four_channel_output_collection_0/v3_four_channel_placement_0/v3_channel_selector_late_promotion_2/v3_selector_route_pilot_0/G3_LO_P_AND/B v3_four_channel_output_load_integration_0/v3_four_channel_shared_support_integration_0/v3_four_channel_bias_reference_distribution_0/v3_four_channel_phase_distribution_0/v3_four_channel_output_collection_0/v3_four_channel_placement_0/v3_channel_selector_late_promotion_2/v3_selector_route_pilot_0/G1_LO_N_ANDNOT/a_297_47# VGND sky130_fd_pr__nfet_01v8 ad=0 pd=0 as=0 ps=0 w=0.42 l=0.15
X941 v3_four_channel_output_load_integration_0/v3_four_channel_shared_support_integration_0/v3_four_channel_bias_reference_distribution_0/v3_four_channel_phase_distribution_0/v3_four_channel_output_collection_0/v3_four_channel_placement_0/v3_channel_selector_late_promotion_2/v3_selector_route_pilot_0/G1_LO_N_ANDNOT/a_27_413# v3_four_channel_output_load_integration_0/v3_four_channel_shared_support_integration_0/v3_four_channel_bias_reference_distribution_0/v3_four_channel_phase_distribution_0/v3_four_channel_output_collection_0/v3_four_channel_placement_0/v3_channel_selector_late_promotion_2/v3_selector_route_pilot_0/G1_MUX_AXIS/X VGND VGND sky130_fd_pr__nfet_01v8 ad=0.1092 pd=1.36 as=0 ps=0 w=0.42 l=0.15
X942 VDPWR v3_four_channel_output_load_integration_0/v3_four_channel_shared_support_integration_0/v3_four_channel_bias_reference_distribution_0/v3_four_channel_phase_distribution_0/v3_four_channel_output_collection_0/v3_four_channel_placement_0/v3_channel_selector_late_promotion_2/v3_selector_route_pilot_0/G3_LO_P_AND/B v3_four_channel_output_load_integration_0/v3_four_channel_shared_support_integration_0/v3_four_channel_bias_reference_distribution_0/v3_four_channel_phase_distribution_0/v3_four_channel_output_collection_0/v3_four_channel_placement_0/v3_channel_selector_late_promotion_2/v3_selector_route_pilot_0/G3_LO_P_AND/a_59_75# VDPWR sky130_fd_pr__pfet_01v8_hvt ad=0 pd=0 as=0.1134 ps=1.38 w=0.42 l=0.15
X943 v3_four_channel_output_load_integration_0/v3_four_channel_shared_support_integration_0/v3_four_channel_bias_reference_distribution_0/v3_four_channel_phase_distribution_0/v3_four_channel_output_collection_0/v3_four_channel_placement_0/v3_channel_selector_late_promotion_2/v3_selector_route_pilot_0/group3_lo_p v3_four_channel_output_load_integration_0/v3_four_channel_shared_support_integration_0/v3_four_channel_bias_reference_distribution_0/v3_four_channel_phase_distribution_0/v3_four_channel_output_collection_0/v3_four_channel_placement_0/v3_channel_selector_late_promotion_2/v3_selector_route_pilot_0/G3_LO_P_AND/a_59_75# VDPWR VDPWR sky130_fd_pr__pfet_01v8_hvt ad=0.475 pd=2.95 as=0 ps=0 w=1 l=0.15
X944 VGND v3_four_channel_output_load_integration_0/v3_four_channel_shared_support_integration_0/v3_four_channel_bias_reference_distribution_0/v3_four_channel_phase_distribution_0/v3_four_channel_output_collection_0/v3_four_channel_placement_0/v3_channel_selector_late_promotion_2/v3_selector_route_pilot_0/G3_LO_P_AND/B v3_four_channel_output_load_integration_0/v3_four_channel_shared_support_integration_0/v3_four_channel_bias_reference_distribution_0/v3_four_channel_phase_distribution_0/v3_four_channel_output_collection_0/v3_four_channel_placement_0/v3_channel_selector_late_promotion_2/v3_selector_route_pilot_0/G3_LO_P_AND/a_145_75# VGND sky130_fd_pr__nfet_01v8 ad=0 pd=0 as=0.1134 ps=1.38 w=0.42 l=0.15
X945 v3_four_channel_output_load_integration_0/v3_four_channel_shared_support_integration_0/v3_four_channel_bias_reference_distribution_0/v3_four_channel_phase_distribution_0/v3_four_channel_output_collection_0/v3_four_channel_placement_0/v3_channel_selector_late_promotion_2/v3_selector_route_pilot_0/G3_LO_P_AND/a_59_75# v3_four_channel_output_load_integration_0/v3_four_channel_shared_support_integration_0/v3_four_channel_bias_reference_distribution_0/v3_four_channel_phase_distribution_0/v3_four_channel_output_collection_0/v3_four_channel_placement_0/v3_channel_selector_late_promotion_2/v3_selector_route_pilot_0/G3_MUX_AXIS/X VDPWR VDPWR sky130_fd_pr__pfet_01v8_hvt ad=0 pd=0 as=0 ps=0 w=0.42 l=0.15
X946 v3_four_channel_output_load_integration_0/v3_four_channel_shared_support_integration_0/v3_four_channel_bias_reference_distribution_0/v3_four_channel_phase_distribution_0/v3_four_channel_output_collection_0/v3_four_channel_placement_0/v3_channel_selector_late_promotion_2/v3_selector_route_pilot_0/group3_lo_p v3_four_channel_output_load_integration_0/v3_four_channel_shared_support_integration_0/v3_four_channel_bias_reference_distribution_0/v3_four_channel_phase_distribution_0/v3_four_channel_output_collection_0/v3_four_channel_placement_0/v3_channel_selector_late_promotion_2/v3_selector_route_pilot_0/G3_LO_P_AND/a_59_75# VGND VGND sky130_fd_pr__nfet_01v8 ad=0.182 pd=1.86 as=0 ps=0 w=0.65 l=0.15
X947 v3_four_channel_output_load_integration_0/v3_four_channel_shared_support_integration_0/v3_four_channel_bias_reference_distribution_0/v3_four_channel_phase_distribution_0/v3_four_channel_output_collection_0/v3_four_channel_placement_0/v3_channel_selector_late_promotion_2/v3_selector_route_pilot_0/G3_LO_P_AND/a_145_75# v3_four_channel_output_load_integration_0/v3_four_channel_shared_support_integration_0/v3_four_channel_bias_reference_distribution_0/v3_four_channel_phase_distribution_0/v3_four_channel_output_collection_0/v3_four_channel_placement_0/v3_channel_selector_late_promotion_2/v3_selector_route_pilot_0/G3_MUX_AXIS/X v3_four_channel_output_load_integration_0/v3_four_channel_shared_support_integration_0/v3_four_channel_bias_reference_distribution_0/v3_four_channel_phase_distribution_0/v3_four_channel_output_collection_0/v3_four_channel_placement_0/v3_channel_selector_late_promotion_2/v3_selector_route_pilot_0/G3_LO_P_AND/a_59_75# VGND sky130_fd_pr__nfet_01v8 ad=0 pd=0 as=0.1176 ps=1.4 w=0.42 l=0.15
X948 VDPWR v3_four_channel_output_load_integration_0/v3_four_channel_shared_support_integration_0/v3_four_channel_bias_reference_distribution_0/v3_four_channel_phase_distribution_0/v3_four_channel_output_collection_0/v3_four_channel_placement_0/v3_channel_selector_late_promotion_2/v3_selector_route_pilot_0/G2_MUX_POS/a_505_21# v3_four_channel_output_load_integration_0/v3_four_channel_shared_support_integration_0/v3_four_channel_bias_reference_distribution_0/v3_four_channel_phase_distribution_0/v3_four_channel_output_collection_0/v3_four_channel_placement_0/v3_channel_selector_late_promotion_2/v3_selector_route_pilot_0/G2_MUX_POS/a_535_374# VDPWR sky130_fd_pr__pfet_01v8_hvt ad=0 pd=0 as=0.0882 ps=1.26 w=0.42 l=0.15
X949 v3_four_channel_output_load_integration_0/v3_four_channel_shared_support_integration_0/v3_four_channel_bias_reference_distribution_0/v3_four_channel_phase_distribution_0/v3_four_channel_output_collection_0/v3_four_channel_placement_0/v3_channel_selector_late_promotion_2/v3_selector_route_pilot_0/G2_MUX_POS/a_505_21# v3_four_channel_output_load_integration_0/v3_four_channel_shared_support_integration_0/v3_four_channel_bias_reference_distribution_0/v3_four_channel_phase_distribution_0/v3_four_channel_output_collection_0/v3_four_channel_placement_0/v3_channel_selector_late_promotion_2/group2_bit0 VDPWR VDPWR sky130_fd_pr__pfet_01v8_hvt ad=0.1176 pd=1.4 as=0 ps=0 w=0.42 l=0.15
X950 v3_four_channel_output_load_integration_0/v3_four_channel_shared_support_integration_0/v3_four_channel_bias_reference_distribution_0/v3_four_channel_phase_distribution_0/v3_four_channel_output_collection_0/v3_four_channel_placement_0/v3_channel_selector_late_promotion_2/v3_selector_route_pilot_0/G2_MUX_POS/a_218_374# v3_four_channel_output_load_integration_0/v3_four_channel_shared_support_integration_0/v3_four_channel_bias_reference_distribution_0/v3_four_channel_phase_distribution_0/v3_four_channel_output_collection_0/v3_four_channel_placement_0/v3_channel_selector_late_promotion_2/group2_bit0 VDPWR VDPWR sky130_fd_pr__pfet_01v8_hvt ad=0.1533 pd=1.57 as=0 ps=0 w=0.42 l=0.15
X951 VGND v3_four_channel_output_load_integration_0/v3_four_channel_shared_support_integration_0/v3_four_channel_bias_reference_distribution_0/v3_four_channel_phase_distribution_0/v3_four_channel_output_collection_0/v3_four_channel_placement_0/v3_channel_selector_late_promotion_2/v3_selector_route_pilot_0/G2_MUX_POS/a_505_21# v3_four_channel_output_load_integration_0/v3_four_channel_shared_support_integration_0/v3_four_channel_bias_reference_distribution_0/v3_four_channel_phase_distribution_0/v3_four_channel_output_collection_0/v3_four_channel_placement_0/v3_channel_selector_late_promotion_2/v3_selector_route_pilot_0/G2_MUX_POS/a_439_47# VGND sky130_fd_pr__nfet_01v8 ad=0 pd=0 as=0.1386 ps=1.5 w=0.42 l=0.15
X952 v3_four_channel_output_load_integration_0/v3_four_channel_shared_support_integration_0/v3_four_channel_bias_reference_distribution_0/v3_four_channel_phase_distribution_0/v3_four_channel_output_collection_0/v3_four_channel_placement_0/v3_channel_selector_late_promotion_2/v3_selector_route_pilot_0/G2_MUX_POS/a_76_199# v3_four_channel_output_load_integration_0/v3_four_channel_shared_support_integration_0/v3_four_channel_bias_reference_distribution_0/v3_four_channel_phase_distribution_0/phase_0 v3_four_channel_output_load_integration_0/v3_four_channel_shared_support_integration_0/v3_four_channel_bias_reference_distribution_0/v3_four_channel_phase_distribution_0/v3_four_channel_output_collection_0/v3_four_channel_placement_0/v3_channel_selector_late_promotion_2/v3_selector_route_pilot_0/G2_MUX_POS/a_218_374# VDPWR sky130_fd_pr__pfet_01v8_hvt ad=0.3864 pd=2.68 as=0 ps=0 w=0.42 l=0.15
X953 v3_four_channel_output_load_integration_0/v3_four_channel_shared_support_integration_0/v3_four_channel_bias_reference_distribution_0/v3_four_channel_phase_distribution_0/v3_four_channel_output_collection_0/v3_four_channel_placement_0/v3_channel_selector_late_promotion_2/v3_selector_route_pilot_0/G2_MUX_POS/a_505_21# v3_four_channel_output_load_integration_0/v3_four_channel_shared_support_integration_0/v3_four_channel_bias_reference_distribution_0/v3_four_channel_phase_distribution_0/v3_four_channel_output_collection_0/v3_four_channel_placement_0/v3_channel_selector_late_promotion_2/group2_bit0 VGND VGND sky130_fd_pr__nfet_01v8 ad=0.1092 pd=1.36 as=0 ps=0 w=0.42 l=0.15
X954 v3_four_channel_output_load_integration_0/v3_four_channel_shared_support_integration_0/v3_four_channel_bias_reference_distribution_0/v3_four_channel_phase_distribution_0/v3_four_channel_output_collection_0/v3_four_channel_placement_0/v3_channel_selector_late_promotion_2/v3_selector_route_pilot_0/G2_MUX_POS/a_439_47# v3_four_channel_output_load_integration_0/v3_four_channel_shared_support_integration_0/v3_four_channel_bias_reference_distribution_0/v3_four_channel_phase_distribution_0/phase_0 v3_four_channel_output_load_integration_0/v3_four_channel_shared_support_integration_0/v3_four_channel_bias_reference_distribution_0/v3_four_channel_phase_distribution_0/v3_four_channel_output_collection_0/v3_four_channel_placement_0/v3_channel_selector_late_promotion_2/v3_selector_route_pilot_0/G2_MUX_POS/a_76_199# VGND sky130_fd_pr__nfet_01v8 ad=0 pd=0 as=0.1995 ps=1.79 w=0.42 l=0.15
X955 v3_four_channel_output_load_integration_0/v3_four_channel_shared_support_integration_0/v3_four_channel_bias_reference_distribution_0/v3_four_channel_phase_distribution_0/v3_four_channel_output_collection_0/v3_four_channel_placement_0/v3_channel_selector_late_promotion_2/v3_selector_route_pilot_0/G2_MUX_POS/a_535_374# v3_four_channel_output_load_integration_0/v3_four_channel_shared_support_integration_0/v3_four_channel_bias_reference_distribution_0/v3_four_channel_phase_distribution_0/phase_90 v3_four_channel_output_load_integration_0/v3_four_channel_shared_support_integration_0/v3_four_channel_bias_reference_distribution_0/v3_four_channel_phase_distribution_0/v3_four_channel_output_collection_0/v3_four_channel_placement_0/v3_channel_selector_late_promotion_2/v3_selector_route_pilot_0/G2_MUX_POS/a_76_199# VDPWR sky130_fd_pr__pfet_01v8_hvt ad=0 pd=0 as=0 ps=0 w=0.42 l=0.15
X956 v3_four_channel_output_load_integration_0/v3_four_channel_shared_support_integration_0/v3_four_channel_bias_reference_distribution_0/v3_four_channel_phase_distribution_0/v3_four_channel_output_collection_0/v3_four_channel_placement_0/v3_channel_selector_late_promotion_2/v3_selector_route_pilot_0/G2_MUX_POS/a_76_199# v3_four_channel_output_load_integration_0/v3_four_channel_shared_support_integration_0/v3_four_channel_bias_reference_distribution_0/v3_four_channel_phase_distribution_0/phase_90 v3_four_channel_output_load_integration_0/v3_four_channel_shared_support_integration_0/v3_four_channel_bias_reference_distribution_0/v3_four_channel_phase_distribution_0/v3_four_channel_output_collection_0/v3_four_channel_placement_0/v3_channel_selector_late_promotion_2/v3_selector_route_pilot_0/G2_MUX_POS/a_218_47# VGND sky130_fd_pr__nfet_01v8 ad=0 pd=0 as=0.1386 ps=1.5 w=0.42 l=0.15
X957 v3_four_channel_output_load_integration_0/v3_four_channel_shared_support_integration_0/v3_four_channel_bias_reference_distribution_0/v3_four_channel_phase_distribution_0/v3_four_channel_output_collection_0/v3_four_channel_placement_0/v3_channel_selector_late_promotion_2/v3_selector_route_pilot_0/G2_MUX_POS/a_218_47# v3_four_channel_output_load_integration_0/v3_four_channel_shared_support_integration_0/v3_four_channel_bias_reference_distribution_0/v3_four_channel_phase_distribution_0/v3_four_channel_output_collection_0/v3_four_channel_placement_0/v3_channel_selector_late_promotion_2/group2_bit0 VGND VGND sky130_fd_pr__nfet_01v8 ad=0 pd=0 as=0 ps=0 w=0.42 l=0.15
X958 VDPWR v3_four_channel_output_load_integration_0/v3_four_channel_shared_support_integration_0/v3_four_channel_bias_reference_distribution_0/v3_four_channel_phase_distribution_0/v3_four_channel_output_collection_0/v3_four_channel_placement_0/v3_channel_selector_late_promotion_2/v3_selector_route_pilot_0/G2_MUX_POS/a_76_199# v3_four_channel_output_load_integration_0/v3_four_channel_shared_support_integration_0/v3_four_channel_bias_reference_distribution_0/v3_four_channel_phase_distribution_0/v3_four_channel_output_collection_0/v3_four_channel_placement_0/v3_channel_selector_late_promotion_2/v3_selector_route_pilot_0/G2_MUX_POS/X VDPWR sky130_fd_pr__pfet_01v8_hvt ad=0 pd=0 as=0.26 ps=2.52 w=1 l=0.15
X959 VGND v3_four_channel_output_load_integration_0/v3_four_channel_shared_support_integration_0/v3_four_channel_bias_reference_distribution_0/v3_four_channel_phase_distribution_0/v3_four_channel_output_collection_0/v3_four_channel_placement_0/v3_channel_selector_late_promotion_2/v3_selector_route_pilot_0/G2_MUX_POS/a_76_199# v3_four_channel_output_load_integration_0/v3_four_channel_shared_support_integration_0/v3_four_channel_bias_reference_distribution_0/v3_four_channel_phase_distribution_0/v3_four_channel_output_collection_0/v3_four_channel_placement_0/v3_channel_selector_late_promotion_2/v3_selector_route_pilot_0/G2_MUX_POS/X VGND sky130_fd_pr__nfet_01v8 ad=0 pd=0 as=0.169 ps=1.82 w=0.65 l=0.15
X960 VDPWR v3_four_channel_output_load_integration_0/v3_four_channel_shared_support_integration_0/v3_four_channel_bias_reference_distribution_0/v3_four_channel_phase_distribution_0/v3_four_channel_output_collection_0/v3_four_channel_placement_0/v3_channel_selector_late_promotion_2/v3_selector_route_pilot_0/G2_MUX_NEG/a_505_21# v3_four_channel_output_load_integration_0/v3_four_channel_shared_support_integration_0/v3_four_channel_bias_reference_distribution_0/v3_four_channel_phase_distribution_0/v3_four_channel_output_collection_0/v3_four_channel_placement_0/v3_channel_selector_late_promotion_2/v3_selector_route_pilot_0/G2_MUX_NEG/a_535_374# VDPWR sky130_fd_pr__pfet_01v8_hvt ad=0 pd=0 as=0.0882 ps=1.26 w=0.42 l=0.15
X961 v3_four_channel_output_load_integration_0/v3_four_channel_shared_support_integration_0/v3_four_channel_bias_reference_distribution_0/v3_four_channel_phase_distribution_0/v3_four_channel_output_collection_0/v3_four_channel_placement_0/v3_channel_selector_late_promotion_2/v3_selector_route_pilot_0/G2_MUX_NEG/a_505_21# v3_four_channel_output_load_integration_0/v3_four_channel_shared_support_integration_0/v3_four_channel_bias_reference_distribution_0/v3_four_channel_phase_distribution_0/v3_four_channel_output_collection_0/v3_four_channel_placement_0/v3_channel_selector_late_promotion_2/group2_bit0 VDPWR VDPWR sky130_fd_pr__pfet_01v8_hvt ad=0.1176 pd=1.4 as=0 ps=0 w=0.42 l=0.15
X962 v3_four_channel_output_load_integration_0/v3_four_channel_shared_support_integration_0/v3_four_channel_bias_reference_distribution_0/v3_four_channel_phase_distribution_0/v3_four_channel_output_collection_0/v3_four_channel_placement_0/v3_channel_selector_late_promotion_2/v3_selector_route_pilot_0/G2_MUX_NEG/a_218_374# v3_four_channel_output_load_integration_0/v3_four_channel_shared_support_integration_0/v3_four_channel_bias_reference_distribution_0/v3_four_channel_phase_distribution_0/v3_four_channel_output_collection_0/v3_four_channel_placement_0/v3_channel_selector_late_promotion_2/group2_bit0 VDPWR VDPWR sky130_fd_pr__pfet_01v8_hvt ad=0.1533 pd=1.57 as=0 ps=0 w=0.42 l=0.15
X963 VGND v3_four_channel_output_load_integration_0/v3_four_channel_shared_support_integration_0/v3_four_channel_bias_reference_distribution_0/v3_four_channel_phase_distribution_0/v3_four_channel_output_collection_0/v3_four_channel_placement_0/v3_channel_selector_late_promotion_2/v3_selector_route_pilot_0/G2_MUX_NEG/a_505_21# v3_four_channel_output_load_integration_0/v3_four_channel_shared_support_integration_0/v3_four_channel_bias_reference_distribution_0/v3_four_channel_phase_distribution_0/v3_four_channel_output_collection_0/v3_four_channel_placement_0/v3_channel_selector_late_promotion_2/v3_selector_route_pilot_0/G2_MUX_NEG/a_439_47# VGND sky130_fd_pr__nfet_01v8 ad=0 pd=0 as=0.1386 ps=1.5 w=0.42 l=0.15
X964 v3_four_channel_output_load_integration_0/v3_four_channel_shared_support_integration_0/v3_four_channel_bias_reference_distribution_0/v3_four_channel_phase_distribution_0/v3_four_channel_output_collection_0/v3_four_channel_placement_0/v3_channel_selector_late_promotion_2/v3_selector_route_pilot_0/G2_MUX_NEG/a_76_199# v3_four_channel_output_load_integration_0/v3_four_channel_shared_support_integration_0/v3_four_channel_bias_reference_distribution_0/v3_four_channel_phase_distribution_0/phase_180 v3_four_channel_output_load_integration_0/v3_four_channel_shared_support_integration_0/v3_four_channel_bias_reference_distribution_0/v3_four_channel_phase_distribution_0/v3_four_channel_output_collection_0/v3_four_channel_placement_0/v3_channel_selector_late_promotion_2/v3_selector_route_pilot_0/G2_MUX_NEG/a_218_374# VDPWR sky130_fd_pr__pfet_01v8_hvt ad=0.3864 pd=2.68 as=0 ps=0 w=0.42 l=0.15
X965 v3_four_channel_output_load_integration_0/v3_four_channel_shared_support_integration_0/v3_four_channel_bias_reference_distribution_0/v3_four_channel_phase_distribution_0/v3_four_channel_output_collection_0/v3_four_channel_placement_0/v3_channel_selector_late_promotion_2/v3_selector_route_pilot_0/G2_MUX_NEG/a_505_21# v3_four_channel_output_load_integration_0/v3_four_channel_shared_support_integration_0/v3_four_channel_bias_reference_distribution_0/v3_four_channel_phase_distribution_0/v3_four_channel_output_collection_0/v3_four_channel_placement_0/v3_channel_selector_late_promotion_2/group2_bit0 VGND VGND sky130_fd_pr__nfet_01v8 ad=0.1092 pd=1.36 as=0 ps=0 w=0.42 l=0.15
X966 v3_four_channel_output_load_integration_0/v3_four_channel_shared_support_integration_0/v3_four_channel_bias_reference_distribution_0/v3_four_channel_phase_distribution_0/v3_four_channel_output_collection_0/v3_four_channel_placement_0/v3_channel_selector_late_promotion_2/v3_selector_route_pilot_0/G2_MUX_NEG/a_439_47# v3_four_channel_output_load_integration_0/v3_four_channel_shared_support_integration_0/v3_four_channel_bias_reference_distribution_0/v3_four_channel_phase_distribution_0/phase_180 v3_four_channel_output_load_integration_0/v3_four_channel_shared_support_integration_0/v3_four_channel_bias_reference_distribution_0/v3_four_channel_phase_distribution_0/v3_four_channel_output_collection_0/v3_four_channel_placement_0/v3_channel_selector_late_promotion_2/v3_selector_route_pilot_0/G2_MUX_NEG/a_76_199# VGND sky130_fd_pr__nfet_01v8 ad=0 pd=0 as=0.1995 ps=1.79 w=0.42 l=0.15
X967 v3_four_channel_output_load_integration_0/v3_four_channel_shared_support_integration_0/v3_four_channel_bias_reference_distribution_0/v3_four_channel_phase_distribution_0/v3_four_channel_output_collection_0/v3_four_channel_placement_0/v3_channel_selector_late_promotion_2/v3_selector_route_pilot_0/G2_MUX_NEG/a_535_374# v3_four_channel_output_load_integration_0/v3_four_channel_shared_support_integration_0/v3_four_channel_bias_reference_distribution_0/v3_four_channel_phase_distribution_0/phase_270 v3_four_channel_output_load_integration_0/v3_four_channel_shared_support_integration_0/v3_four_channel_bias_reference_distribution_0/v3_four_channel_phase_distribution_0/v3_four_channel_output_collection_0/v3_four_channel_placement_0/v3_channel_selector_late_promotion_2/v3_selector_route_pilot_0/G2_MUX_NEG/a_76_199# VDPWR sky130_fd_pr__pfet_01v8_hvt ad=0 pd=0 as=0 ps=0 w=0.42 l=0.15
X968 v3_four_channel_output_load_integration_0/v3_four_channel_shared_support_integration_0/v3_four_channel_bias_reference_distribution_0/v3_four_channel_phase_distribution_0/v3_four_channel_output_collection_0/v3_four_channel_placement_0/v3_channel_selector_late_promotion_2/v3_selector_route_pilot_0/G2_MUX_NEG/a_76_199# v3_four_channel_output_load_integration_0/v3_four_channel_shared_support_integration_0/v3_four_channel_bias_reference_distribution_0/v3_four_channel_phase_distribution_0/phase_270 v3_four_channel_output_load_integration_0/v3_four_channel_shared_support_integration_0/v3_four_channel_bias_reference_distribution_0/v3_four_channel_phase_distribution_0/v3_four_channel_output_collection_0/v3_four_channel_placement_0/v3_channel_selector_late_promotion_2/v3_selector_route_pilot_0/G2_MUX_NEG/a_218_47# VGND sky130_fd_pr__nfet_01v8 ad=0 pd=0 as=0.1386 ps=1.5 w=0.42 l=0.15
X969 v3_four_channel_output_load_integration_0/v3_four_channel_shared_support_integration_0/v3_four_channel_bias_reference_distribution_0/v3_four_channel_phase_distribution_0/v3_four_channel_output_collection_0/v3_four_channel_placement_0/v3_channel_selector_late_promotion_2/v3_selector_route_pilot_0/G2_MUX_NEG/a_218_47# v3_four_channel_output_load_integration_0/v3_four_channel_shared_support_integration_0/v3_four_channel_bias_reference_distribution_0/v3_four_channel_phase_distribution_0/v3_four_channel_output_collection_0/v3_four_channel_placement_0/v3_channel_selector_late_promotion_2/group2_bit0 VGND VGND sky130_fd_pr__nfet_01v8 ad=0 pd=0 as=0 ps=0 w=0.42 l=0.15
X970 VDPWR v3_four_channel_output_load_integration_0/v3_four_channel_shared_support_integration_0/v3_four_channel_bias_reference_distribution_0/v3_four_channel_phase_distribution_0/v3_four_channel_output_collection_0/v3_four_channel_placement_0/v3_channel_selector_late_promotion_2/v3_selector_route_pilot_0/G2_MUX_NEG/a_76_199# v3_four_channel_output_load_integration_0/v3_four_channel_shared_support_integration_0/v3_four_channel_bias_reference_distribution_0/v3_four_channel_phase_distribution_0/v3_four_channel_output_collection_0/v3_four_channel_placement_0/v3_channel_selector_late_promotion_2/v3_selector_route_pilot_0/G2_MUX_NEG/X VDPWR sky130_fd_pr__pfet_01v8_hvt ad=0 pd=0 as=0.26 ps=2.52 w=1 l=0.15
X971 VGND v3_four_channel_output_load_integration_0/v3_four_channel_shared_support_integration_0/v3_four_channel_bias_reference_distribution_0/v3_four_channel_phase_distribution_0/v3_four_channel_output_collection_0/v3_four_channel_placement_0/v3_channel_selector_late_promotion_2/v3_selector_route_pilot_0/G2_MUX_NEG/a_76_199# v3_four_channel_output_load_integration_0/v3_four_channel_shared_support_integration_0/v3_four_channel_bias_reference_distribution_0/v3_four_channel_phase_distribution_0/v3_four_channel_output_collection_0/v3_four_channel_placement_0/v3_channel_selector_late_promotion_2/v3_selector_route_pilot_0/G2_MUX_NEG/X VGND sky130_fd_pr__nfet_01v8 ad=0 pd=0 as=0.169 ps=1.82 w=0.65 l=0.15
X972 VDPWR v3_four_channel_output_load_integration_0/v3_four_channel_shared_support_integration_0/v3_four_channel_bias_reference_distribution_0/v3_four_channel_phase_distribution_0/v3_four_channel_output_collection_0/v3_four_channel_placement_0/v3_channel_selector_late_promotion_2/v3_selector_route_pilot_0/G0_MUX_AXIS/a_505_21# v3_four_channel_output_load_integration_0/v3_four_channel_shared_support_integration_0/v3_four_channel_bias_reference_distribution_0/v3_four_channel_phase_distribution_0/v3_four_channel_output_collection_0/v3_four_channel_placement_0/v3_channel_selector_late_promotion_2/v3_selector_route_pilot_0/G0_MUX_AXIS/a_535_374# VDPWR sky130_fd_pr__pfet_01v8_hvt ad=0 pd=0 as=0.0882 ps=1.26 w=0.42 l=0.15
X973 v3_four_channel_output_load_integration_0/v3_four_channel_shared_support_integration_0/v3_four_channel_bias_reference_distribution_0/v3_four_channel_phase_distribution_0/v3_four_channel_output_collection_0/v3_four_channel_placement_0/v3_channel_selector_late_promotion_2/v3_selector_route_pilot_0/G0_MUX_AXIS/a_505_21# v3_four_channel_output_load_integration_0/v3_four_channel_shared_support_integration_0/v3_four_channel_bias_reference_distribution_0/v3_four_channel_phase_distribution_0/v3_four_channel_output_collection_0/v3_four_channel_placement_0/v3_channel_selector_late_promotion_2/group0_bit1 VDPWR VDPWR sky130_fd_pr__pfet_01v8_hvt ad=0.1176 pd=1.4 as=0 ps=0 w=0.42 l=0.15
X974 v3_four_channel_output_load_integration_0/v3_four_channel_shared_support_integration_0/v3_four_channel_bias_reference_distribution_0/v3_four_channel_phase_distribution_0/v3_four_channel_output_collection_0/v3_four_channel_placement_0/v3_channel_selector_late_promotion_2/v3_selector_route_pilot_0/G0_MUX_AXIS/a_218_374# v3_four_channel_output_load_integration_0/v3_four_channel_shared_support_integration_0/v3_four_channel_bias_reference_distribution_0/v3_four_channel_phase_distribution_0/v3_four_channel_output_collection_0/v3_four_channel_placement_0/v3_channel_selector_late_promotion_2/group0_bit1 VDPWR VDPWR sky130_fd_pr__pfet_01v8_hvt ad=0.1533 pd=1.57 as=0 ps=0 w=0.42 l=0.15
X975 VGND v3_four_channel_output_load_integration_0/v3_four_channel_shared_support_integration_0/v3_four_channel_bias_reference_distribution_0/v3_four_channel_phase_distribution_0/v3_four_channel_output_collection_0/v3_four_channel_placement_0/v3_channel_selector_late_promotion_2/v3_selector_route_pilot_0/G0_MUX_AXIS/a_505_21# v3_four_channel_output_load_integration_0/v3_four_channel_shared_support_integration_0/v3_four_channel_bias_reference_distribution_0/v3_four_channel_phase_distribution_0/v3_four_channel_output_collection_0/v3_four_channel_placement_0/v3_channel_selector_late_promotion_2/v3_selector_route_pilot_0/G0_MUX_AXIS/a_439_47# VGND sky130_fd_pr__nfet_01v8 ad=0 pd=0 as=0.1386 ps=1.5 w=0.42 l=0.15
X976 v3_four_channel_output_load_integration_0/v3_four_channel_shared_support_integration_0/v3_four_channel_bias_reference_distribution_0/v3_four_channel_phase_distribution_0/v3_four_channel_output_collection_0/v3_four_channel_placement_0/v3_channel_selector_late_promotion_2/v3_selector_route_pilot_0/G0_MUX_AXIS/a_76_199# v3_four_channel_output_load_integration_0/v3_four_channel_shared_support_integration_0/v3_four_channel_bias_reference_distribution_0/v3_four_channel_phase_distribution_0/v3_four_channel_output_collection_0/v3_four_channel_placement_0/v3_channel_selector_late_promotion_2/v3_selector_route_pilot_0/G0_MUX_POS/X v3_four_channel_output_load_integration_0/v3_four_channel_shared_support_integration_0/v3_four_channel_bias_reference_distribution_0/v3_four_channel_phase_distribution_0/v3_four_channel_output_collection_0/v3_four_channel_placement_0/v3_channel_selector_late_promotion_2/v3_selector_route_pilot_0/G0_MUX_AXIS/a_218_374# VDPWR sky130_fd_pr__pfet_01v8_hvt ad=0.3864 pd=2.68 as=0 ps=0 w=0.42 l=0.15
X977 v3_four_channel_output_load_integration_0/v3_four_channel_shared_support_integration_0/v3_four_channel_bias_reference_distribution_0/v3_four_channel_phase_distribution_0/v3_four_channel_output_collection_0/v3_four_channel_placement_0/v3_channel_selector_late_promotion_2/v3_selector_route_pilot_0/G0_MUX_AXIS/a_505_21# v3_four_channel_output_load_integration_0/v3_four_channel_shared_support_integration_0/v3_four_channel_bias_reference_distribution_0/v3_four_channel_phase_distribution_0/v3_four_channel_output_collection_0/v3_four_channel_placement_0/v3_channel_selector_late_promotion_2/group0_bit1 VGND VGND sky130_fd_pr__nfet_01v8 ad=0.1092 pd=1.36 as=0 ps=0 w=0.42 l=0.15
X978 v3_four_channel_output_load_integration_0/v3_four_channel_shared_support_integration_0/v3_four_channel_bias_reference_distribution_0/v3_four_channel_phase_distribution_0/v3_four_channel_output_collection_0/v3_four_channel_placement_0/v3_channel_selector_late_promotion_2/v3_selector_route_pilot_0/G0_MUX_AXIS/a_439_47# v3_four_channel_output_load_integration_0/v3_four_channel_shared_support_integration_0/v3_four_channel_bias_reference_distribution_0/v3_four_channel_phase_distribution_0/v3_four_channel_output_collection_0/v3_four_channel_placement_0/v3_channel_selector_late_promotion_2/v3_selector_route_pilot_0/G0_MUX_POS/X v3_four_channel_output_load_integration_0/v3_four_channel_shared_support_integration_0/v3_four_channel_bias_reference_distribution_0/v3_four_channel_phase_distribution_0/v3_four_channel_output_collection_0/v3_four_channel_placement_0/v3_channel_selector_late_promotion_2/v3_selector_route_pilot_0/G0_MUX_AXIS/a_76_199# VGND sky130_fd_pr__nfet_01v8 ad=0 pd=0 as=0.1995 ps=1.79 w=0.42 l=0.15
X979 v3_four_channel_output_load_integration_0/v3_four_channel_shared_support_integration_0/v3_four_channel_bias_reference_distribution_0/v3_four_channel_phase_distribution_0/v3_four_channel_output_collection_0/v3_four_channel_placement_0/v3_channel_selector_late_promotion_2/v3_selector_route_pilot_0/G0_MUX_AXIS/a_535_374# v3_four_channel_output_load_integration_0/v3_four_channel_shared_support_integration_0/v3_four_channel_bias_reference_distribution_0/v3_four_channel_phase_distribution_0/v3_four_channel_output_collection_0/v3_four_channel_placement_0/v3_channel_selector_late_promotion_2/v3_selector_route_pilot_0/G0_MUX_NEG/X v3_four_channel_output_load_integration_0/v3_four_channel_shared_support_integration_0/v3_four_channel_bias_reference_distribution_0/v3_four_channel_phase_distribution_0/v3_four_channel_output_collection_0/v3_four_channel_placement_0/v3_channel_selector_late_promotion_2/v3_selector_route_pilot_0/G0_MUX_AXIS/a_76_199# VDPWR sky130_fd_pr__pfet_01v8_hvt ad=0 pd=0 as=0 ps=0 w=0.42 l=0.15
X980 v3_four_channel_output_load_integration_0/v3_four_channel_shared_support_integration_0/v3_four_channel_bias_reference_distribution_0/v3_four_channel_phase_distribution_0/v3_four_channel_output_collection_0/v3_four_channel_placement_0/v3_channel_selector_late_promotion_2/v3_selector_route_pilot_0/G0_MUX_AXIS/a_76_199# v3_four_channel_output_load_integration_0/v3_four_channel_shared_support_integration_0/v3_four_channel_bias_reference_distribution_0/v3_four_channel_phase_distribution_0/v3_four_channel_output_collection_0/v3_four_channel_placement_0/v3_channel_selector_late_promotion_2/v3_selector_route_pilot_0/G0_MUX_NEG/X v3_four_channel_output_load_integration_0/v3_four_channel_shared_support_integration_0/v3_four_channel_bias_reference_distribution_0/v3_four_channel_phase_distribution_0/v3_four_channel_output_collection_0/v3_four_channel_placement_0/v3_channel_selector_late_promotion_2/v3_selector_route_pilot_0/G0_MUX_AXIS/a_218_47# VGND sky130_fd_pr__nfet_01v8 ad=0 pd=0 as=0.1386 ps=1.5 w=0.42 l=0.15
X981 v3_four_channel_output_load_integration_0/v3_four_channel_shared_support_integration_0/v3_four_channel_bias_reference_distribution_0/v3_four_channel_phase_distribution_0/v3_four_channel_output_collection_0/v3_four_channel_placement_0/v3_channel_selector_late_promotion_2/v3_selector_route_pilot_0/G0_MUX_AXIS/a_218_47# v3_four_channel_output_load_integration_0/v3_four_channel_shared_support_integration_0/v3_four_channel_bias_reference_distribution_0/v3_four_channel_phase_distribution_0/v3_four_channel_output_collection_0/v3_four_channel_placement_0/v3_channel_selector_late_promotion_2/group0_bit1 VGND VGND sky130_fd_pr__nfet_01v8 ad=0 pd=0 as=0 ps=0 w=0.42 l=0.15
X982 VDPWR v3_four_channel_output_load_integration_0/v3_four_channel_shared_support_integration_0/v3_four_channel_bias_reference_distribution_0/v3_four_channel_phase_distribution_0/v3_four_channel_output_collection_0/v3_four_channel_placement_0/v3_channel_selector_late_promotion_2/v3_selector_route_pilot_0/G0_MUX_AXIS/a_76_199# v3_four_channel_output_load_integration_0/v3_four_channel_shared_support_integration_0/v3_four_channel_bias_reference_distribution_0/v3_four_channel_phase_distribution_0/v3_four_channel_output_collection_0/v3_four_channel_placement_0/v3_channel_selector_late_promotion_2/v3_selector_route_pilot_0/G0_MUX_AXIS/X VDPWR sky130_fd_pr__pfet_01v8_hvt ad=0 pd=0 as=0.26 ps=2.52 w=1 l=0.15
X983 VGND v3_four_channel_output_load_integration_0/v3_four_channel_shared_support_integration_0/v3_four_channel_bias_reference_distribution_0/v3_four_channel_phase_distribution_0/v3_four_channel_output_collection_0/v3_four_channel_placement_0/v3_channel_selector_late_promotion_2/v3_selector_route_pilot_0/G0_MUX_AXIS/a_76_199# v3_four_channel_output_load_integration_0/v3_four_channel_shared_support_integration_0/v3_four_channel_bias_reference_distribution_0/v3_four_channel_phase_distribution_0/v3_four_channel_output_collection_0/v3_four_channel_placement_0/v3_channel_selector_late_promotion_2/v3_selector_route_pilot_0/G0_MUX_AXIS/X VGND sky130_fd_pr__nfet_01v8 ad=0 pd=0 as=0.169 ps=1.82 w=0.65 l=0.15
X984 VDPWR v3_four_channel_output_load_integration_0/v3_four_channel_shared_support_integration_0/v3_four_channel_bias_reference_distribution_0/v3_four_channel_phase_distribution_0/v3_four_channel_output_collection_0/v3_four_channel_placement_0/v3_channel_selector_late_promotion_2/v3_selector_route_pilot_0/G3_LO_P_AND/B v3_four_channel_output_load_integration_0/v3_four_channel_shared_support_integration_0/v3_four_channel_bias_reference_distribution_0/v3_four_channel_phase_distribution_0/v3_four_channel_output_collection_0/v3_four_channel_placement_0/v3_channel_selector_late_promotion_2/v3_selector_route_pilot_0/G2_LO_P_AND/a_59_75# VDPWR sky130_fd_pr__pfet_01v8_hvt ad=0 pd=0 as=0.1134 ps=1.38 w=0.42 l=0.15
X985 v3_four_channel_output_load_integration_0/v3_four_channel_shared_support_integration_0/v3_four_channel_bias_reference_distribution_0/v3_four_channel_phase_distribution_0/v3_four_channel_output_collection_0/v3_four_channel_placement_0/v3_channel_selector_late_promotion_2/v3_selector_route_pilot_0/group2_lo_p v3_four_channel_output_load_integration_0/v3_four_channel_shared_support_integration_0/v3_four_channel_bias_reference_distribution_0/v3_four_channel_phase_distribution_0/v3_four_channel_output_collection_0/v3_four_channel_placement_0/v3_channel_selector_late_promotion_2/v3_selector_route_pilot_0/G2_LO_P_AND/a_59_75# VDPWR VDPWR sky130_fd_pr__pfet_01v8_hvt ad=0.475 pd=2.95 as=0 ps=0 w=1 l=0.15
X986 VGND v3_four_channel_output_load_integration_0/v3_four_channel_shared_support_integration_0/v3_four_channel_bias_reference_distribution_0/v3_four_channel_phase_distribution_0/v3_four_channel_output_collection_0/v3_four_channel_placement_0/v3_channel_selector_late_promotion_2/v3_selector_route_pilot_0/G3_LO_P_AND/B v3_four_channel_output_load_integration_0/v3_four_channel_shared_support_integration_0/v3_four_channel_bias_reference_distribution_0/v3_four_channel_phase_distribution_0/v3_four_channel_output_collection_0/v3_four_channel_placement_0/v3_channel_selector_late_promotion_2/v3_selector_route_pilot_0/G2_LO_P_AND/a_145_75# VGND sky130_fd_pr__nfet_01v8 ad=0 pd=0 as=0.1134 ps=1.38 w=0.42 l=0.15
X987 v3_four_channel_output_load_integration_0/v3_four_channel_shared_support_integration_0/v3_four_channel_bias_reference_distribution_0/v3_four_channel_phase_distribution_0/v3_four_channel_output_collection_0/v3_four_channel_placement_0/v3_channel_selector_late_promotion_2/v3_selector_route_pilot_0/G2_LO_P_AND/a_59_75# v3_four_channel_output_load_integration_0/v3_four_channel_shared_support_integration_0/v3_four_channel_bias_reference_distribution_0/v3_four_channel_phase_distribution_0/v3_four_channel_output_collection_0/v3_four_channel_placement_0/v3_channel_selector_late_promotion_2/v3_selector_route_pilot_0/G2_MUX_AXIS/X VDPWR VDPWR sky130_fd_pr__pfet_01v8_hvt ad=0 pd=0 as=0 ps=0 w=0.42 l=0.15
X988 v3_four_channel_output_load_integration_0/v3_four_channel_shared_support_integration_0/v3_four_channel_bias_reference_distribution_0/v3_four_channel_phase_distribution_0/v3_four_channel_output_collection_0/v3_four_channel_placement_0/v3_channel_selector_late_promotion_2/v3_selector_route_pilot_0/group2_lo_p v3_four_channel_output_load_integration_0/v3_four_channel_shared_support_integration_0/v3_four_channel_bias_reference_distribution_0/v3_four_channel_phase_distribution_0/v3_four_channel_output_collection_0/v3_four_channel_placement_0/v3_channel_selector_late_promotion_2/v3_selector_route_pilot_0/G2_LO_P_AND/a_59_75# VGND VGND sky130_fd_pr__nfet_01v8 ad=0.182 pd=1.86 as=0 ps=0 w=0.65 l=0.15
X989 v3_four_channel_output_load_integration_0/v3_four_channel_shared_support_integration_0/v3_four_channel_bias_reference_distribution_0/v3_four_channel_phase_distribution_0/v3_four_channel_output_collection_0/v3_four_channel_placement_0/v3_channel_selector_late_promotion_2/v3_selector_route_pilot_0/G2_LO_P_AND/a_145_75# v3_four_channel_output_load_integration_0/v3_four_channel_shared_support_integration_0/v3_four_channel_bias_reference_distribution_0/v3_four_channel_phase_distribution_0/v3_four_channel_output_collection_0/v3_four_channel_placement_0/v3_channel_selector_late_promotion_2/v3_selector_route_pilot_0/G2_MUX_AXIS/X v3_four_channel_output_load_integration_0/v3_four_channel_shared_support_integration_0/v3_four_channel_bias_reference_distribution_0/v3_four_channel_phase_distribution_0/v3_four_channel_output_collection_0/v3_four_channel_placement_0/v3_channel_selector_late_promotion_2/v3_selector_route_pilot_0/G2_LO_P_AND/a_59_75# VGND sky130_fd_pr__nfet_01v8 ad=0 pd=0 as=0.1176 ps=1.4 w=0.42 l=0.15
X990 v3_four_channel_output_load_integration_0/v3_four_channel_shared_support_integration_0/v3_four_channel_bias_reference_distribution_0/v3_four_channel_phase_distribution_0/v3_four_channel_output_collection_0/v3_four_channel_placement_0/v3_channel_selector_late_promotion_3/v3_channel_input_bias_late_promotion_0/a_4678_23422# v3_four_channel_output_load_integration_0/v3_four_channel_shared_support_integration_0/v3_four_channel_bias_reference_distribution_0/v3_four_channel_phase_distribution_0/v3_four_channel_output_collection_0/v3_four_channel_placement_0/v3_channel_selector_late_promotion_3/v3_selector_route_pilot_0/group3_lo_p v3_four_channel_output_load_integration_0/combined_n VGND sky130_fd_pr__nfet_01v8 ad=0.6206 pd=6.02 as=0 ps=0 w=0.65 l=0.15
X991 v3_four_channel_output_load_integration_0/combined_n v3_four_channel_output_load_integration_0/v3_four_channel_shared_support_integration_0/v3_four_channel_bias_reference_distribution_0/v3_four_channel_phase_distribution_0/v3_four_channel_output_collection_0/v3_four_channel_placement_0/v3_channel_selector_late_promotion_3/v3_selector_route_pilot_0/group3_lo_p v3_four_channel_output_load_integration_0/v3_four_channel_shared_support_integration_0/v3_four_channel_bias_reference_distribution_0/v3_four_channel_phase_distribution_0/v3_four_channel_output_collection_0/v3_four_channel_placement_0/v3_channel_selector_late_promotion_3/v3_channel_input_bias_late_promotion_0/a_4254_6978# VGND sky130_fd_pr__nfet_01v8 ad=0 pd=0 as=0.6206 ps=6.02 w=0.65 l=0.15
X992 v3_four_channel_output_load_integration_0/v3_four_channel_shared_support_integration_0/v3_four_channel_bias_reference_distribution_0/v3_four_channel_phase_distribution_0/v3_four_channel_output_collection_0/v3_four_channel_placement_0/v3_channel_selector_late_promotion_3/v3_channel_input_bias_late_promotion_0/a_4678_23422# v3_four_channel_output_load_integration_0/v3_four_channel_shared_support_integration_0/v3_vcm_support_block_0/ref v3_four_channel_output_load_integration_0/v3_four_channel_shared_support_integration_0/v3_four_channel_bias_reference_distribution_0/v3_four_channel_phase_distribution_0/v3_four_channel_output_collection_0/v3_four_channel_placement_0/v3_channel_selector_late_promotion_3/v3_channel_input_bias_late_promotion_0/a_4382_21688# VGND sky130_fd_pr__nfet_01v8 ad=0 pd=0 as=1.9575 ps=15.24 w=0.84 l=0.6
X993 v3_four_channel_output_load_integration_0/combined_n v3_four_channel_output_load_integration_0/v3_four_channel_shared_support_integration_0/v3_four_channel_bias_reference_distribution_0/v3_four_channel_phase_distribution_0/v3_four_channel_output_collection_0/v3_four_channel_placement_0/v3_channel_selector_late_promotion_3/v3_selector_route_pilot_0/group3_lo_n v3_four_channel_output_load_integration_0/v3_four_channel_shared_support_integration_0/v3_four_channel_bias_reference_distribution_0/v3_four_channel_phase_distribution_0/v3_four_channel_output_collection_0/v3_four_channel_placement_0/v3_channel_selector_late_promotion_3/v3_channel_input_bias_late_promotion_0/a_7038_22978# VGND sky130_fd_pr__nfet_01v8 ad=0 pd=0 as=0.6206 ps=6.02 w=0.65 l=0.15
X994 v3_four_channel_output_load_integration_0/combined_n v3_four_channel_output_load_integration_0/v3_four_channel_shared_support_integration_0/v3_four_channel_bias_reference_distribution_0/v3_four_channel_phase_distribution_0/v3_four_channel_output_collection_0/v3_four_channel_placement_0/v3_channel_selector_late_promotion_3/v3_selector_route_pilot_0/group3_lo_p v3_four_channel_output_load_integration_0/v3_four_channel_shared_support_integration_0/v3_four_channel_bias_reference_distribution_0/v3_four_channel_phase_distribution_0/v3_four_channel_output_collection_0/v3_four_channel_placement_0/v3_channel_selector_late_promotion_3/v3_channel_input_bias_late_promotion_0/a_7038_6978# VGND sky130_fd_pr__nfet_01v8 ad=0 pd=0 as=0.6206 ps=6.02 w=0.65 l=0.15
X995 v3_four_channel_output_load_integration_0/v3_four_channel_shared_support_integration_0/v3_four_channel_bias_reference_distribution_0/v3_four_channel_phase_distribution_0/v3_four_channel_output_collection_0/v3_four_channel_placement_0/v3_channel_selector_late_promotion_3/v3_channel_input_bias_late_promotion_0/a_7462_11422# v3_four_channel_output_load_integration_0/v3_four_channel_shared_support_integration_0/v3_four_channel_bias_reference_distribution_0/v3_four_channel_phase_distribution_0/v3_four_channel_output_collection_0/v3_four_channel_placement_0/v3_channel_selector_late_promotion_3/element_input v3_four_channel_output_load_integration_0/v3_four_channel_shared_support_integration_0/v3_four_channel_bias_reference_distribution_0/v3_four_channel_phase_distribution_0/v3_four_channel_output_collection_0/v3_four_channel_placement_0/v3_channel_selector_late_promotion_3/v3_channel_input_bias_late_promotion_0/a_7216_10978# VGND sky130_fd_pr__nfet_01v8 ad=0.6206 pd=6.02 as=1.9575 ps=15.24 w=0.84 l=0.6
X996 v3_four_channel_output_load_integration_0/v3_four_channel_shared_support_integration_0/v3_four_channel_bias_reference_distribution_0/v3_four_channel_phase_distribution_0/v3_four_channel_output_collection_0/v3_four_channel_placement_0/v3_channel_selector_late_promotion_3/v3_channel_input_bias_late_promotion_0/a_7462_11422# v3_four_channel_output_load_integration_0/v3_four_channel_shared_support_integration_0/v3_four_channel_bias_reference_distribution_0/v3_four_channel_phase_distribution_0/v3_four_channel_output_collection_0/v3_four_channel_placement_0/v3_channel_selector_late_promotion_3/v3_selector_route_pilot_0/group2_lo_n v3_four_channel_output_load_integration_0/combined_n VGND sky130_fd_pr__nfet_01v8 ad=0 pd=0 as=0 ps=0 w=0.65 l=0.15
X997 v3_four_channel_output_load_integration_0/v3_four_channel_shared_support_integration_0/v3_four_channel_bias_reference_distribution_0/v3_four_channel_phase_distribution_0/v3_four_channel_output_collection_0/v3_four_channel_placement_0/v3_channel_selector_late_promotion_3/v3_channel_input_bias_late_promotion_0/a_5774_21688# v3_four_channel_output_load_integration_0/v3_four_channel_shared_support_integration_0/v3_four_channel_bias_reference_distribution_0/v3_four_channel_phase_distribution_0/v3_four_channel_output_collection_0/v3_four_channel_placement_0/v3_channel_selector_late_promotion_3/element_input v3_four_channel_output_load_integration_0/v3_four_channel_shared_support_integration_0/v3_four_channel_bias_reference_distribution_0/v3_four_channel_phase_distribution_0/v3_four_channel_output_collection_0/v3_four_channel_placement_0/v3_channel_selector_late_promotion_3/v3_channel_input_bias_late_promotion_0/a_5646_22978# VGND sky130_fd_pr__nfet_01v8 ad=1.9575 pd=15.24 as=0.6206 ps=6.02 w=0.84 l=0.6
X998 VGND v3_four_channel_output_load_integration_0/v3_four_channel_shared_support_integration_0/v3_tail_bias_support_block_0/vbias v3_four_channel_output_load_integration_0/v3_four_channel_shared_support_integration_0/v3_four_channel_bias_reference_distribution_0/v3_four_channel_phase_distribution_0/v3_four_channel_output_collection_0/v3_four_channel_placement_0/v3_channel_selector_late_promotion_3/v3_channel_input_bias_late_promotion_0/a_5774_17688# VGND sky130_fd_pr__nfet_01v8 ad=0 pd=0 as=1.9575 ps=15.24 w=5.07 l=1
X999 v3_four_channel_output_load_integration_0/v3_four_channel_shared_support_integration_0/v3_four_channel_bias_reference_distribution_0/v3_four_channel_phase_distribution_0/v3_four_channel_output_collection_0/v3_four_channel_placement_0/v3_channel_selector_late_promotion_3/v3_channel_input_bias_late_promotion_0/a_6070_7422# v3_four_channel_output_load_integration_0/v3_four_channel_shared_support_integration_0/v3_four_channel_bias_reference_distribution_0/v3_four_channel_phase_distribution_0/v3_four_channel_output_collection_0/v3_four_channel_placement_0/v3_channel_selector_late_promotion_3/element_input v3_four_channel_output_load_integration_0/v3_four_channel_shared_support_integration_0/v3_four_channel_bias_reference_distribution_0/v3_four_channel_phase_distribution_0/v3_four_channel_output_collection_0/v3_four_channel_placement_0/v3_channel_selector_late_promotion_3/v3_channel_input_bias_late_promotion_0/a_5824_6978# VGND sky130_fd_pr__nfet_01v8 ad=0.6206 pd=6.02 as=1.9575 ps=15.24 w=0.84 l=0.6
X1000 v3_four_channel_output_load_integration_0/v3_four_channel_shared_support_integration_0/v3_four_channel_bias_reference_distribution_0/v3_four_channel_phase_distribution_0/v3_four_channel_output_collection_0/v3_four_channel_placement_0/v3_channel_selector_late_promotion_3/v3_channel_input_bias_late_promotion_0/a_6070_7422# v3_four_channel_output_load_integration_0/v3_four_channel_shared_support_integration_0/v3_four_channel_bias_reference_distribution_0/v3_four_channel_phase_distribution_0/v3_four_channel_output_collection_0/v3_four_channel_placement_0/v3_channel_selector_late_promotion_3/v3_selector_route_pilot_0/group3_lo_n v3_four_channel_output_load_integration_0/combined_n VGND sky130_fd_pr__nfet_01v8 ad=0 pd=0 as=0 ps=0 w=0.65 l=0.15
X1001 v3_four_channel_output_load_integration_0/v3_four_channel_shared_support_integration_0/v3_vcm_support_block_0/ref v3_four_channel_output_load_integration_0/v3_four_channel_shared_support_integration_0/v3_four_channel_bias_reference_distribution_0/v3_four_channel_phase_distribution_0/v3_four_channel_output_collection_0/v3_four_channel_placement_0/v3_channel_selector_late_promotion_3/element_input VGND sky130_fd_pr__res_xhigh_po_0p35 l=17.36
X1002 v3_four_channel_output_load_integration_0/v3_four_channel_shared_support_integration_0/v3_four_channel_bias_reference_distribution_0/v3_four_channel_phase_distribution_0/v3_four_channel_output_collection_0/v3_four_channel_placement_0/v3_channel_selector_late_promotion_3/v3_channel_input_bias_late_promotion_0/a_7462_23422# v3_four_channel_output_load_integration_0/v3_four_channel_shared_support_integration_0/v3_vcm_support_block_0/ref v3_four_channel_output_load_integration_0/v3_four_channel_shared_support_integration_0/v3_four_channel_bias_reference_distribution_0/v3_four_channel_phase_distribution_0/v3_four_channel_output_collection_0/v3_four_channel_placement_0/v3_channel_selector_late_promotion_3/v3_channel_input_bias_late_promotion_0/a_7166_21688# VGND sky130_fd_pr__nfet_01v8 ad=0.6206 pd=6.02 as=1.9575 ps=15.24 w=0.84 l=0.6
X1003 v3_four_channel_output_load_integration_0/v3_four_channel_shared_support_integration_0/v3_four_channel_bias_reference_distribution_0/v3_four_channel_phase_distribution_0/v3_four_channel_output_collection_0/v3_four_channel_placement_0/v3_channel_selector_late_promotion_3/v3_channel_input_bias_late_promotion_0/a_7462_23422# v3_four_channel_output_load_integration_0/v3_four_channel_shared_support_integration_0/v3_four_channel_bias_reference_distribution_0/v3_four_channel_phase_distribution_0/v3_four_channel_output_collection_0/v3_four_channel_placement_0/v3_channel_selector_late_promotion_3/v3_selector_route_pilot_0/group3_lo_p v3_four_channel_output_load_integration_0/combined_n VGND sky130_fd_pr__nfet_01v8 ad=0 pd=0 as=0 ps=0 w=0.65 l=0.15
X1004 VGND v3_four_channel_output_load_integration_0/v3_four_channel_shared_support_integration_0/v3_tail_bias_support_block_0/vbias v3_four_channel_output_load_integration_0/v3_four_channel_shared_support_integration_0/v3_four_channel_bias_reference_distribution_0/v3_four_channel_phase_distribution_0/v3_four_channel_output_collection_0/v3_four_channel_placement_0/v3_channel_selector_late_promotion_3/v3_channel_input_bias_late_promotion_0/a_4382_21688# VGND sky130_fd_pr__nfet_01v8 ad=0 pd=0 as=0 ps=0 w=5.07 l=1
X1005 VGND v3_four_channel_output_load_integration_0/v3_four_channel_shared_support_integration_0/v3_tail_bias_support_block_0/vbias v3_four_channel_output_load_integration_0/v3_four_channel_shared_support_integration_0/v3_four_channel_bias_reference_distribution_0/v3_four_channel_phase_distribution_0/v3_four_channel_output_collection_0/v3_four_channel_placement_0/v3_channel_selector_late_promotion_3/v3_channel_input_bias_late_promotion_0/a_5774_13688# VGND sky130_fd_pr__nfet_01v8 ad=0 pd=0 as=1.9575 ps=15.24 w=5.07 l=1
X1006 VGND v3_four_channel_output_load_integration_0/v3_four_channel_shared_support_integration_0/v3_tail_bias_support_block_0/vbias v3_four_channel_output_load_integration_0/v3_four_channel_shared_support_integration_0/v3_four_channel_bias_reference_distribution_0/v3_four_channel_phase_distribution_0/v3_four_channel_output_collection_0/v3_four_channel_placement_0/v3_channel_selector_late_promotion_3/v3_channel_input_bias_late_promotion_0/a_7166_17688# VGND sky130_fd_pr__nfet_01v8 ad=0 pd=0 as=1.9575 ps=15.24 w=5.07 l=1
X1007 VGND VGND VGND VGND sky130_fd_pr__nfet_01v8 ad=0 pd=0 as=0 ps=0 w=0.65 l=0.15
X1008 v3_four_channel_output_load_integration_0/combined_p v3_four_channel_output_load_integration_0/v3_four_channel_shared_support_integration_0/v3_four_channel_bias_reference_distribution_0/v3_four_channel_phase_distribution_0/v3_four_channel_output_collection_0/v3_four_channel_placement_0/v3_channel_selector_late_promotion_3/v3_selector_route_pilot_0/group3_lo_p v3_four_channel_output_load_integration_0/v3_four_channel_shared_support_integration_0/v3_four_channel_bias_reference_distribution_0/v3_four_channel_phase_distribution_0/v3_four_channel_output_collection_0/v3_four_channel_placement_0/v3_channel_selector_late_promotion_3/v3_channel_input_bias_late_promotion_0/a_5646_18978# VGND sky130_fd_pr__nfet_01v8 ad=0 pd=0 as=0.6206 ps=6.02 w=0.65 l=0.15
X1009 VGND VGND VGND VGND sky130_fd_pr__nfet_01v8 ad=0 pd=0 as=0 ps=0 w=0.65 l=0.15
X1010 v3_four_channel_output_load_integration_0/v3_four_channel_shared_support_integration_0/v3_four_channel_bias_reference_distribution_0/v3_four_channel_phase_distribution_0/v3_four_channel_output_collection_0/v3_four_channel_placement_0/v3_channel_selector_late_promotion_3/v3_channel_input_bias_late_promotion_0/a_6070_19422# v3_four_channel_output_load_integration_0/v3_four_channel_shared_support_integration_0/v3_four_channel_bias_reference_distribution_0/v3_four_channel_phase_distribution_0/v3_four_channel_output_collection_0/v3_four_channel_placement_0/v3_channel_selector_late_promotion_3/v3_selector_route_pilot_0/group3_lo_n v3_four_channel_output_load_integration_0/combined_p VGND sky130_fd_pr__nfet_01v8 ad=0.6206 pd=6.02 as=0 ps=0 w=0.65 l=0.15
X1011 VGND VGND VGND VGND sky130_fd_pr__nfet_01v8 ad=0 pd=0 as=0 ps=0 w=0.65 l=0.15
X1012 v3_four_channel_output_load_integration_0/combined_p v3_four_channel_output_load_integration_0/v3_four_channel_shared_support_integration_0/v3_four_channel_bias_reference_distribution_0/v3_four_channel_phase_distribution_0/v3_four_channel_output_collection_0/v3_four_channel_placement_0/v3_channel_selector_late_promotion_3/v3_selector_route_pilot_0/group2_lo_p v3_four_channel_output_load_integration_0/v3_four_channel_shared_support_integration_0/v3_four_channel_bias_reference_distribution_0/v3_four_channel_phase_distribution_0/v3_four_channel_output_collection_0/v3_four_channel_placement_0/v3_channel_selector_late_promotion_3/v3_channel_input_bias_late_promotion_0/a_4254_18978# VGND sky130_fd_pr__nfet_01v8 ad=0 pd=0 as=0.6206 ps=6.02 w=0.65 l=0.15
X1013 v3_four_channel_output_load_integration_0/v3_four_channel_shared_support_integration_0/v3_four_channel_bias_reference_distribution_0/v3_four_channel_phase_distribution_0/v3_four_channel_output_collection_0/v3_four_channel_placement_0/v3_channel_selector_late_promotion_3/v3_channel_input_bias_late_promotion_0/a_7216_14978# v3_four_channel_output_load_integration_0/v3_four_channel_shared_support_integration_0/v3_tail_bias_support_block_0/vbias VGND VGND sky130_fd_pr__nfet_01v8 ad=1.9575 pd=15.24 as=0 ps=0 w=5.07 l=1
X1014 VGND VGND VGND VGND sky130_fd_pr__nfet_01v8 ad=0 pd=0 as=0 ps=0 w=0.65 l=0.15
X1015 VGND VGND VGND VGND sky130_fd_pr__nfet_01v8 ad=0 pd=0 as=0 ps=0 w=0.65 l=0.15
X1016 v3_four_channel_output_load_integration_0/v3_four_channel_shared_support_integration_0/v3_four_channel_bias_reference_distribution_0/v3_four_channel_phase_distribution_0/v3_four_channel_output_collection_0/v3_four_channel_placement_0/v3_channel_selector_late_promotion_3/v3_channel_input_bias_late_promotion_0/a_4382_17688# v3_four_channel_output_load_integration_0/v3_four_channel_shared_support_integration_0/v3_four_channel_bias_reference_distribution_0/v3_four_channel_phase_distribution_0/v3_four_channel_output_collection_0/v3_four_channel_placement_0/v3_channel_selector_late_promotion_3/element_input v3_four_channel_output_load_integration_0/v3_four_channel_shared_support_integration_0/v3_four_channel_bias_reference_distribution_0/v3_four_channel_phase_distribution_0/v3_four_channel_output_collection_0/v3_four_channel_placement_0/v3_channel_selector_late_promotion_3/v3_channel_input_bias_late_promotion_0/a_4254_18978# VGND sky130_fd_pr__nfet_01v8 ad=1.9575 pd=15.24 as=0 ps=0 w=0.84 l=0.6
X1017 v3_four_channel_output_load_integration_0/v3_four_channel_shared_support_integration_0/v3_four_channel_bias_reference_distribution_0/v3_four_channel_phase_distribution_0/v3_four_channel_output_collection_0/v3_four_channel_placement_0/v3_channel_selector_late_promotion_3/v3_channel_input_bias_late_promotion_0/a_4678_19422# v3_four_channel_output_load_integration_0/v3_four_channel_shared_support_integration_0/v3_four_channel_bias_reference_distribution_0/v3_four_channel_phase_distribution_0/v3_four_channel_output_collection_0/v3_four_channel_placement_0/v3_channel_selector_late_promotion_3/v3_selector_route_pilot_0/group2_lo_n v3_four_channel_output_load_integration_0/combined_p VGND sky130_fd_pr__nfet_01v8 ad=0.6206 pd=6.02 as=0 ps=0 w=0.65 l=0.15
X1018 v3_four_channel_output_load_integration_0/combined_p v3_four_channel_output_load_integration_0/v3_four_channel_shared_support_integration_0/v3_four_channel_bias_reference_distribution_0/v3_four_channel_phase_distribution_0/v3_four_channel_output_collection_0/v3_four_channel_placement_0/v3_channel_selector_late_promotion_3/v3_selector_route_pilot_0/group0_lo_p v3_four_channel_output_load_integration_0/v3_four_channel_shared_support_integration_0/v3_four_channel_bias_reference_distribution_0/v3_four_channel_phase_distribution_0/v3_four_channel_output_collection_0/v3_four_channel_placement_0/v3_channel_selector_late_promotion_3/v3_channel_input_bias_late_promotion_0/a_5646_14978# VGND sky130_fd_pr__nfet_01v8 ad=0 pd=0 as=0.6206 ps=6.02 w=0.65 l=0.15
X1019 v3_four_channel_output_load_integration_0/combined_p v3_four_channel_output_load_integration_0/v3_four_channel_shared_support_integration_0/v3_four_channel_bias_reference_distribution_0/v3_four_channel_phase_distribution_0/v3_four_channel_output_collection_0/v3_four_channel_placement_0/v3_channel_selector_late_promotion_3/v3_selector_route_pilot_0/group2_lo_p v3_four_channel_output_load_integration_0/v3_four_channel_shared_support_integration_0/v3_four_channel_bias_reference_distribution_0/v3_four_channel_phase_distribution_0/v3_four_channel_output_collection_0/v3_four_channel_placement_0/v3_channel_selector_late_promotion_3/v3_channel_input_bias_late_promotion_0/a_7038_18978# VGND sky130_fd_pr__nfet_01v8 ad=0 pd=0 as=0.6206 ps=6.02 w=0.65 l=0.15
X1020 VGND VGND VGND VGND sky130_fd_pr__nfet_01v8 ad=0 pd=0 as=0 ps=0 w=5.07 l=1
X1021 v3_four_channel_output_load_integration_0/v3_four_channel_shared_support_integration_0/v3_four_channel_bias_reference_distribution_0/v3_four_channel_phase_distribution_0/v3_four_channel_output_collection_0/v3_four_channel_placement_0/v3_channel_selector_late_promotion_3/v3_channel_input_bias_late_promotion_0/a_6070_15422# v3_four_channel_output_load_integration_0/v3_four_channel_shared_support_integration_0/v3_four_channel_bias_reference_distribution_0/v3_four_channel_phase_distribution_0/v3_four_channel_output_collection_0/v3_four_channel_placement_0/v3_channel_selector_late_promotion_3/v3_selector_route_pilot_0/group0_lo_n v3_four_channel_output_load_integration_0/combined_p VGND sky130_fd_pr__nfet_01v8 ad=0.6206 pd=6.02 as=0 ps=0 w=0.65 l=0.15
X1022 v3_four_channel_output_load_integration_0/v3_four_channel_shared_support_integration_0/v3_four_channel_bias_reference_distribution_0/v3_four_channel_phase_distribution_0/v3_four_channel_output_collection_0/v3_four_channel_placement_0/v3_channel_selector_late_promotion_3/v3_channel_input_bias_late_promotion_0/a_7166_17688# v3_four_channel_output_load_integration_0/v3_four_channel_shared_support_integration_0/v3_four_channel_bias_reference_distribution_0/v3_four_channel_phase_distribution_0/v3_four_channel_output_collection_0/v3_four_channel_placement_0/v3_channel_selector_late_promotion_3/element_input v3_four_channel_output_load_integration_0/v3_four_channel_shared_support_integration_0/v3_four_channel_bias_reference_distribution_0/v3_four_channel_phase_distribution_0/v3_four_channel_output_collection_0/v3_four_channel_placement_0/v3_channel_selector_late_promotion_3/v3_channel_input_bias_late_promotion_0/a_7038_18978# VGND sky130_fd_pr__nfet_01v8 ad=0 pd=0 as=0 ps=0 w=0.84 l=0.6
X1023 v3_four_channel_output_load_integration_0/combined_n v3_four_channel_output_load_integration_0/v3_four_channel_shared_support_integration_0/v3_four_channel_bias_reference_distribution_0/v3_four_channel_phase_distribution_0/v3_four_channel_output_collection_0/v3_four_channel_placement_0/v3_channel_selector_late_promotion_3/v3_selector_route_pilot_0/group3_lo_n v3_four_channel_output_load_integration_0/v3_four_channel_shared_support_integration_0/v3_four_channel_bias_reference_distribution_0/v3_four_channel_phase_distribution_0/v3_four_channel_output_collection_0/v3_four_channel_placement_0/v3_channel_selector_late_promotion_3/v3_channel_input_bias_late_promotion_0/a_5646_18978# VGND sky130_fd_pr__nfet_01v8 ad=0 pd=0 as=0 ps=0 w=0.65 l=0.15
X1024 VGND v3_four_channel_output_load_integration_0/v3_four_channel_shared_support_integration_0/v3_tail_bias_support_block_0/vbias v3_four_channel_output_load_integration_0/v3_four_channel_shared_support_integration_0/v3_four_channel_bias_reference_distribution_0/v3_four_channel_phase_distribution_0/v3_four_channel_output_collection_0/v3_four_channel_placement_0/v3_channel_selector_late_promotion_3/v3_channel_input_bias_late_promotion_0/a_5774_21688# VGND sky130_fd_pr__nfet_01v8 ad=0 pd=0 as=0 ps=0 w=5.07 l=1
X1025 v3_four_channel_output_load_integration_0/v3_four_channel_shared_support_integration_0/v3_four_channel_bias_reference_distribution_0/v3_four_channel_phase_distribution_0/v3_four_channel_output_collection_0/v3_four_channel_placement_0/v3_channel_selector_late_promotion_3/v3_channel_input_bias_late_promotion_0/a_6070_19422# v3_four_channel_output_load_integration_0/v3_four_channel_shared_support_integration_0/v3_vcm_support_block_0/ref v3_four_channel_output_load_integration_0/v3_four_channel_shared_support_integration_0/v3_four_channel_bias_reference_distribution_0/v3_four_channel_phase_distribution_0/v3_four_channel_output_collection_0/v3_four_channel_placement_0/v3_channel_selector_late_promotion_3/v3_channel_input_bias_late_promotion_0/a_5774_17688# VGND sky130_fd_pr__nfet_01v8 ad=0 pd=0 as=0 ps=0 w=0.84 l=0.6
X1026 VGND VGND VGND VGND sky130_fd_pr__nfet_01v8 ad=0 pd=0 as=0 ps=0 w=5.07 l=1
X1027 v3_four_channel_output_load_integration_0/combined_p v3_four_channel_output_load_integration_0/v3_four_channel_shared_support_integration_0/v3_four_channel_bias_reference_distribution_0/v3_four_channel_phase_distribution_0/v3_four_channel_output_collection_0/v3_four_channel_placement_0/v3_channel_selector_late_promotion_3/v3_selector_route_pilot_0/group1_lo_p v3_four_channel_output_load_integration_0/v3_four_channel_shared_support_integration_0/v3_four_channel_bias_reference_distribution_0/v3_four_channel_phase_distribution_0/v3_four_channel_output_collection_0/v3_four_channel_placement_0/v3_channel_selector_late_promotion_3/v3_channel_input_bias_late_promotion_0/a_4254_14978# VGND sky130_fd_pr__nfet_01v8 ad=0 pd=0 as=0.6206 ps=6.02 w=0.65 l=0.15
X1028 v3_four_channel_output_load_integration_0/v3_four_channel_shared_support_integration_0/v3_four_channel_bias_reference_distribution_0/v3_four_channel_phase_distribution_0/v3_four_channel_output_collection_0/v3_four_channel_placement_0/v3_channel_selector_late_promotion_3/v3_channel_input_bias_late_promotion_0/a_6070_19422# v3_four_channel_output_load_integration_0/v3_four_channel_shared_support_integration_0/v3_four_channel_bias_reference_distribution_0/v3_four_channel_phase_distribution_0/v3_four_channel_output_collection_0/v3_four_channel_placement_0/v3_channel_selector_late_promotion_3/v3_selector_route_pilot_0/group3_lo_p v3_four_channel_output_load_integration_0/combined_n VGND sky130_fd_pr__nfet_01v8 ad=0 pd=0 as=0 ps=0 w=0.65 l=0.15
X1029 VGND VGND VGND VGND sky130_fd_pr__nfet_01v8 ad=0 pd=0 as=0 ps=0 w=0.65 l=0.15
X1030 v3_four_channel_output_load_integration_0/v3_four_channel_shared_support_integration_0/v3_four_channel_bias_reference_distribution_0/v3_four_channel_phase_distribution_0/v3_four_channel_output_collection_0/v3_four_channel_placement_0/v3_channel_selector_late_promotion_3/v3_channel_input_bias_late_promotion_0/a_5824_10978# v3_four_channel_output_load_integration_0/v3_four_channel_shared_support_integration_0/v3_tail_bias_support_block_0/vbias VGND VGND sky130_fd_pr__nfet_01v8 ad=1.9575 pd=15.24 as=0 ps=0 w=5.07 l=1
X1031 v3_four_channel_output_load_integration_0/v3_four_channel_shared_support_integration_0/v3_four_channel_bias_reference_distribution_0/v3_four_channel_phase_distribution_0/v3_four_channel_output_collection_0/v3_four_channel_placement_0/v3_channel_selector_late_promotion_3/v3_channel_input_bias_late_promotion_0/a_4382_13688# v3_four_channel_output_load_integration_0/v3_four_channel_shared_support_integration_0/v3_four_channel_bias_reference_distribution_0/v3_four_channel_phase_distribution_0/v3_four_channel_output_collection_0/v3_four_channel_placement_0/v3_channel_selector_late_promotion_3/element_input v3_four_channel_output_load_integration_0/v3_four_channel_shared_support_integration_0/v3_four_channel_bias_reference_distribution_0/v3_four_channel_phase_distribution_0/v3_four_channel_output_collection_0/v3_four_channel_placement_0/v3_channel_selector_late_promotion_3/v3_channel_input_bias_late_promotion_0/a_4254_14978# VGND sky130_fd_pr__nfet_01v8 ad=1.9575 pd=15.24 as=0 ps=0 w=0.84 l=0.6
X1032 v3_four_channel_output_load_integration_0/v3_four_channel_shared_support_integration_0/v3_four_channel_bias_reference_distribution_0/v3_four_channel_phase_distribution_0/v3_four_channel_output_collection_0/v3_four_channel_placement_0/v3_channel_selector_late_promotion_3/v3_channel_input_bias_late_promotion_0/a_4678_15422# v3_four_channel_output_load_integration_0/v3_four_channel_shared_support_integration_0/v3_four_channel_bias_reference_distribution_0/v3_four_channel_phase_distribution_0/v3_four_channel_output_collection_0/v3_four_channel_placement_0/v3_channel_selector_late_promotion_3/v3_selector_route_pilot_0/group1_lo_n v3_four_channel_output_load_integration_0/combined_p VGND sky130_fd_pr__nfet_01v8 ad=0.6206 pd=6.02 as=0 ps=0 w=0.65 l=0.15
X1033 v3_four_channel_output_load_integration_0/combined_n v3_four_channel_output_load_integration_0/v3_four_channel_shared_support_integration_0/v3_four_channel_bias_reference_distribution_0/v3_four_channel_phase_distribution_0/v3_four_channel_output_collection_0/v3_four_channel_placement_0/v3_channel_selector_late_promotion_3/v3_selector_route_pilot_0/group2_lo_n v3_four_channel_output_load_integration_0/v3_four_channel_shared_support_integration_0/v3_four_channel_bias_reference_distribution_0/v3_four_channel_phase_distribution_0/v3_four_channel_output_collection_0/v3_four_channel_placement_0/v3_channel_selector_late_promotion_3/v3_channel_input_bias_late_promotion_0/a_4254_18978# VGND sky130_fd_pr__nfet_01v8 ad=0 pd=0 as=0 ps=0 w=0.65 l=0.15
X1034 v3_four_channel_output_load_integration_0/combined_p v3_four_channel_output_load_integration_0/v3_four_channel_shared_support_integration_0/v3_four_channel_bias_reference_distribution_0/v3_four_channel_phase_distribution_0/v3_four_channel_output_collection_0/v3_four_channel_placement_0/v3_channel_selector_late_promotion_3/v3_selector_route_pilot_0/group3_lo_n v3_four_channel_output_load_integration_0/v3_four_channel_shared_support_integration_0/v3_four_channel_bias_reference_distribution_0/v3_four_channel_phase_distribution_0/v3_four_channel_output_collection_0/v3_four_channel_placement_0/v3_channel_selector_late_promotion_3/v3_channel_input_bias_late_promotion_0/a_5646_10978# VGND sky130_fd_pr__nfet_01v8 ad=0 pd=0 as=0.6206 ps=6.02 w=0.65 l=0.15
X1035 v3_four_channel_output_load_integration_0/combined_p v3_four_channel_output_load_integration_0/v3_four_channel_shared_support_integration_0/v3_four_channel_bias_reference_distribution_0/v3_four_channel_phase_distribution_0/v3_four_channel_output_collection_0/v3_four_channel_placement_0/v3_channel_selector_late_promotion_3/v3_selector_route_pilot_0/group1_lo_n v3_four_channel_output_load_integration_0/v3_four_channel_shared_support_integration_0/v3_four_channel_bias_reference_distribution_0/v3_four_channel_phase_distribution_0/v3_four_channel_output_collection_0/v3_four_channel_placement_0/v3_channel_selector_late_promotion_3/v3_channel_input_bias_late_promotion_0/a_7038_14978# VGND sky130_fd_pr__nfet_01v8 ad=0 pd=0 as=0.6206 ps=6.02 w=0.65 l=0.15
X1036 v3_four_channel_output_load_integration_0/v3_four_channel_shared_support_integration_0/v3_four_channel_bias_reference_distribution_0/v3_four_channel_phase_distribution_0/v3_four_channel_output_collection_0/v3_four_channel_placement_0/v3_channel_selector_late_promotion_3/v3_channel_input_bias_late_promotion_0/a_7462_19422# v3_four_channel_output_load_integration_0/v3_four_channel_shared_support_integration_0/v3_four_channel_bias_reference_distribution_0/v3_four_channel_phase_distribution_0/v3_four_channel_output_collection_0/v3_four_channel_placement_0/v3_channel_selector_late_promotion_3/v3_selector_route_pilot_0/group2_lo_n v3_four_channel_output_load_integration_0/combined_p VGND sky130_fd_pr__nfet_01v8 ad=0.6206 pd=6.02 as=0 ps=0 w=0.65 l=0.15
X1037 v3_four_channel_output_load_integration_0/v3_four_channel_shared_support_integration_0/v3_four_channel_bias_reference_distribution_0/v3_four_channel_phase_distribution_0/v3_four_channel_output_collection_0/v3_four_channel_placement_0/v3_channel_selector_late_promotion_3/v3_channel_input_bias_late_promotion_0/a_4678_7422# v3_four_channel_output_load_integration_0/v3_four_channel_shared_support_integration_0/v3_four_channel_bias_reference_distribution_0/v3_four_channel_phase_distribution_0/v3_four_channel_output_collection_0/v3_four_channel_placement_0/v3_channel_selector_late_promotion_3/v3_selector_route_pilot_0/group3_lo_p v3_four_channel_output_load_integration_0/combined_p VGND sky130_fd_pr__nfet_01v8 ad=0.6206 pd=6.02 as=0 ps=0 w=0.65 l=0.15
X1038 v3_four_channel_output_load_integration_0/v3_four_channel_shared_support_integration_0/v3_four_channel_bias_reference_distribution_0/v3_four_channel_phase_distribution_0/v3_four_channel_output_collection_0/v3_four_channel_placement_0/v3_channel_selector_late_promotion_3/v3_channel_input_bias_late_promotion_0/a_6070_11422# v3_four_channel_output_load_integration_0/v3_four_channel_shared_support_integration_0/v3_four_channel_bias_reference_distribution_0/v3_four_channel_phase_distribution_0/v3_four_channel_output_collection_0/v3_four_channel_placement_0/v3_channel_selector_late_promotion_3/v3_selector_route_pilot_0/group3_lo_p v3_four_channel_output_load_integration_0/combined_p VGND sky130_fd_pr__nfet_01v8 ad=0.6206 pd=6.02 as=0 ps=0 w=0.65 l=0.15
X1039 v3_four_channel_output_load_integration_0/v3_four_channel_shared_support_integration_0/v3_four_channel_bias_reference_distribution_0/v3_four_channel_phase_distribution_0/v3_four_channel_output_collection_0/v3_four_channel_placement_0/v3_channel_selector_late_promotion_3/v3_channel_input_bias_late_promotion_0/a_7216_10978# v3_four_channel_output_load_integration_0/v3_four_channel_shared_support_integration_0/v3_tail_bias_support_block_0/vbias VGND VGND sky130_fd_pr__nfet_01v8 ad=0 pd=0 as=0 ps=0 w=5.07 l=1
X1040 v3_four_channel_output_load_integration_0/v3_four_channel_shared_support_integration_0/v3_four_channel_bias_reference_distribution_0/v3_four_channel_phase_distribution_0/v3_four_channel_output_collection_0/v3_four_channel_placement_0/v3_channel_selector_late_promotion_3/v3_channel_input_bias_late_promotion_0/a_7216_14978# v3_four_channel_output_load_integration_0/v3_four_channel_shared_support_integration_0/v3_vcm_support_block_0/ref v3_four_channel_output_load_integration_0/v3_four_channel_shared_support_integration_0/v3_four_channel_bias_reference_distribution_0/v3_four_channel_phase_distribution_0/v3_four_channel_output_collection_0/v3_four_channel_placement_0/v3_channel_selector_late_promotion_3/v3_channel_input_bias_late_promotion_0/a_7038_14978# VGND sky130_fd_pr__nfet_01v8 ad=0 pd=0 as=0 ps=0 w=0.84 l=0.6
X1041 v3_four_channel_output_load_integration_0/v3_four_channel_shared_support_integration_0/v3_four_channel_bias_reference_distribution_0/v3_four_channel_phase_distribution_0/v3_four_channel_output_collection_0/v3_four_channel_placement_0/v3_channel_selector_late_promotion_3/v3_channel_input_bias_late_promotion_0/a_4678_19422# v3_four_channel_output_load_integration_0/v3_four_channel_shared_support_integration_0/v3_vcm_support_block_0/ref v3_four_channel_output_load_integration_0/v3_four_channel_shared_support_integration_0/v3_four_channel_bias_reference_distribution_0/v3_four_channel_phase_distribution_0/v3_four_channel_output_collection_0/v3_four_channel_placement_0/v3_channel_selector_late_promotion_3/v3_channel_input_bias_late_promotion_0/a_4382_17688# VGND sky130_fd_pr__nfet_01v8 ad=0 pd=0 as=0 ps=0 w=0.84 l=0.6
X1042 v3_four_channel_output_load_integration_0/v3_four_channel_shared_support_integration_0/v3_four_channel_bias_reference_distribution_0/v3_four_channel_phase_distribution_0/v3_four_channel_output_collection_0/v3_four_channel_placement_0/v3_channel_selector_late_promotion_3/v3_channel_input_bias_late_promotion_0/a_4678_19422# v3_four_channel_output_load_integration_0/v3_four_channel_shared_support_integration_0/v3_four_channel_bias_reference_distribution_0/v3_four_channel_phase_distribution_0/v3_four_channel_output_collection_0/v3_four_channel_placement_0/v3_channel_selector_late_promotion_3/v3_selector_route_pilot_0/group2_lo_p v3_four_channel_output_load_integration_0/combined_n VGND sky130_fd_pr__nfet_01v8 ad=0 pd=0 as=0 ps=0 w=0.65 l=0.15
X1043 v3_four_channel_output_load_integration_0/combined_n v3_four_channel_output_load_integration_0/v3_four_channel_shared_support_integration_0/v3_four_channel_bias_reference_distribution_0/v3_four_channel_phase_distribution_0/v3_four_channel_output_collection_0/v3_four_channel_placement_0/v3_channel_selector_late_promotion_3/v3_selector_route_pilot_0/group0_lo_n v3_four_channel_output_load_integration_0/v3_four_channel_shared_support_integration_0/v3_four_channel_bias_reference_distribution_0/v3_four_channel_phase_distribution_0/v3_four_channel_output_collection_0/v3_four_channel_placement_0/v3_channel_selector_late_promotion_3/v3_channel_input_bias_late_promotion_0/a_5646_14978# VGND sky130_fd_pr__nfet_01v8 ad=0 pd=0 as=0 ps=0 w=0.65 l=0.15
X1044 v3_four_channel_output_load_integration_0/combined_n v3_four_channel_output_load_integration_0/v3_four_channel_shared_support_integration_0/v3_four_channel_bias_reference_distribution_0/v3_four_channel_phase_distribution_0/v3_four_channel_output_collection_0/v3_four_channel_placement_0/v3_channel_selector_late_promotion_3/v3_selector_route_pilot_0/group2_lo_n v3_four_channel_output_load_integration_0/v3_four_channel_shared_support_integration_0/v3_four_channel_bias_reference_distribution_0/v3_four_channel_phase_distribution_0/v3_four_channel_output_collection_0/v3_four_channel_placement_0/v3_channel_selector_late_promotion_3/v3_channel_input_bias_late_promotion_0/a_7038_18978# VGND sky130_fd_pr__nfet_01v8 ad=0 pd=0 as=0 ps=0 w=0.65 l=0.15
X1045 v3_four_channel_output_load_integration_0/v3_four_channel_shared_support_integration_0/v3_four_channel_bias_reference_distribution_0/v3_four_channel_phase_distribution_0/v3_four_channel_output_collection_0/v3_four_channel_placement_0/v3_channel_selector_late_promotion_3/v3_channel_input_bias_late_promotion_0/a_7462_7422# v3_four_channel_output_load_integration_0/v3_four_channel_shared_support_integration_0/v3_four_channel_bias_reference_distribution_0/v3_four_channel_phase_distribution_0/v3_four_channel_output_collection_0/v3_four_channel_placement_0/v3_channel_selector_late_promotion_3/v3_selector_route_pilot_0/group3_lo_p v3_four_channel_output_load_integration_0/combined_p VGND sky130_fd_pr__nfet_01v8 ad=0.6206 pd=6.02 as=0 ps=0 w=0.65 l=0.15
X1046 VGND v3_four_channel_output_load_integration_0/v3_four_channel_shared_support_integration_0/v3_tail_bias_support_block_0/vbias v3_four_channel_output_load_integration_0/v3_four_channel_shared_support_integration_0/v3_four_channel_bias_reference_distribution_0/v3_four_channel_phase_distribution_0/v3_four_channel_output_collection_0/v3_four_channel_placement_0/v3_channel_selector_late_promotion_3/v3_channel_input_bias_late_promotion_0/a_7166_21688# VGND sky130_fd_pr__nfet_01v8 ad=0 pd=0 as=0 ps=0 w=5.07 l=1
X1047 v3_four_channel_output_load_integration_0/v3_four_channel_shared_support_integration_0/v3_four_channel_bias_reference_distribution_0/v3_four_channel_phase_distribution_0/v3_four_channel_output_collection_0/v3_four_channel_placement_0/v3_channel_selector_late_promotion_3/v3_channel_input_bias_late_promotion_0/a_6070_15422# v3_four_channel_output_load_integration_0/v3_four_channel_shared_support_integration_0/v3_vcm_support_block_0/ref v3_four_channel_output_load_integration_0/v3_four_channel_shared_support_integration_0/v3_four_channel_bias_reference_distribution_0/v3_four_channel_phase_distribution_0/v3_four_channel_output_collection_0/v3_four_channel_placement_0/v3_channel_selector_late_promotion_3/v3_channel_input_bias_late_promotion_0/a_5774_13688# VGND sky130_fd_pr__nfet_01v8 ad=0 pd=0 as=0 ps=0 w=0.84 l=0.6
X1048 v3_four_channel_output_load_integration_0/combined_p v3_four_channel_output_load_integration_0/v3_four_channel_shared_support_integration_0/v3_four_channel_bias_reference_distribution_0/v3_four_channel_phase_distribution_0/v3_four_channel_output_collection_0/v3_four_channel_placement_0/v3_channel_selector_late_promotion_3/v3_selector_route_pilot_0/group2_lo_n v3_four_channel_output_load_integration_0/v3_four_channel_shared_support_integration_0/v3_four_channel_bias_reference_distribution_0/v3_four_channel_phase_distribution_0/v3_four_channel_output_collection_0/v3_four_channel_placement_0/v3_channel_selector_late_promotion_3/v3_channel_input_bias_late_promotion_0/a_4254_10978# VGND sky130_fd_pr__nfet_01v8 ad=0 pd=0 as=0.6206 ps=6.02 w=0.65 l=0.15
X1049 v3_four_channel_output_load_integration_0/v3_four_channel_shared_support_integration_0/v3_four_channel_bias_reference_distribution_0/v3_four_channel_phase_distribution_0/v3_four_channel_output_collection_0/v3_four_channel_placement_0/v3_channel_selector_late_promotion_3/v3_channel_input_bias_late_promotion_0/a_6070_15422# v3_four_channel_output_load_integration_0/v3_four_channel_shared_support_integration_0/v3_four_channel_bias_reference_distribution_0/v3_four_channel_phase_distribution_0/v3_four_channel_output_collection_0/v3_four_channel_placement_0/v3_channel_selector_late_promotion_3/v3_selector_route_pilot_0/group0_lo_p v3_four_channel_output_load_integration_0/combined_n VGND sky130_fd_pr__nfet_01v8 ad=0 pd=0 as=0 ps=0 w=0.65 l=0.15
X1050 v3_four_channel_output_load_integration_0/v3_four_channel_shared_support_integration_0/v3_four_channel_bias_reference_distribution_0/v3_four_channel_phase_distribution_0/v3_four_channel_output_collection_0/v3_four_channel_placement_0/v3_channel_selector_late_promotion_3/v3_channel_input_bias_late_promotion_0/a_5824_6978# v3_four_channel_output_load_integration_0/v3_four_channel_shared_support_integration_0/v3_vcm_support_block_0/ref v3_four_channel_output_load_integration_0/v3_four_channel_shared_support_integration_0/v3_four_channel_bias_reference_distribution_0/v3_four_channel_phase_distribution_0/v3_four_channel_output_collection_0/v3_four_channel_placement_0/v3_channel_selector_late_promotion_3/v3_channel_input_bias_late_promotion_0/a_5646_6978# VGND sky130_fd_pr__nfet_01v8 ad=0 pd=0 as=0.6206 ps=6.02 w=0.84 l=0.6
X1051 v3_four_channel_output_load_integration_0/v3_four_channel_shared_support_integration_0/v3_four_channel_bias_reference_distribution_0/v3_four_channel_phase_distribution_0/v3_four_channel_output_collection_0/v3_four_channel_placement_0/v3_channel_selector_late_promotion_3/v3_channel_input_bias_late_promotion_0/a_5774_17688# v3_four_channel_output_load_integration_0/v3_four_channel_shared_support_integration_0/v3_four_channel_bias_reference_distribution_0/v3_four_channel_phase_distribution_0/v3_four_channel_output_collection_0/v3_four_channel_placement_0/v3_channel_selector_late_promotion_3/element_input v3_four_channel_output_load_integration_0/v3_four_channel_shared_support_integration_0/v3_four_channel_bias_reference_distribution_0/v3_four_channel_phase_distribution_0/v3_four_channel_output_collection_0/v3_four_channel_placement_0/v3_channel_selector_late_promotion_3/v3_channel_input_bias_late_promotion_0/a_5646_18978# VGND sky130_fd_pr__nfet_01v8 ad=0 pd=0 as=0 ps=0 w=0.84 l=0.6
X1052 v3_four_channel_output_load_integration_0/combined_p v3_four_channel_output_load_integration_0/v3_four_channel_shared_support_integration_0/v3_four_channel_bias_reference_distribution_0/v3_four_channel_phase_distribution_0/v3_four_channel_output_collection_0/v3_four_channel_placement_0/v3_channel_selector_late_promotion_3/v3_selector_route_pilot_0/group3_lo_p v3_four_channel_output_load_integration_0/v3_four_channel_shared_support_integration_0/v3_four_channel_bias_reference_distribution_0/v3_four_channel_phase_distribution_0/v3_four_channel_output_collection_0/v3_four_channel_placement_0/v3_channel_selector_late_promotion_3/v3_channel_input_bias_late_promotion_0/a_5646_22978# VGND sky130_fd_pr__nfet_01v8 ad=0 pd=0 as=0 ps=0 w=0.65 l=0.15
X1053 v3_four_channel_output_load_integration_0/v3_four_channel_shared_support_integration_0/v3_four_channel_bias_reference_distribution_0/v3_four_channel_phase_distribution_0/v3_four_channel_output_collection_0/v3_four_channel_placement_0/v3_channel_selector_late_promotion_3/v3_channel_input_bias_late_promotion_0/a_5824_6978# v3_four_channel_output_load_integration_0/v3_four_channel_shared_support_integration_0/v3_tail_bias_support_block_0/vbias VGND VGND sky130_fd_pr__nfet_01v8 ad=0 pd=0 as=0 ps=0 w=5.07 l=1
X1054 v3_four_channel_output_load_integration_0/v3_four_channel_shared_support_integration_0/v3_four_channel_bias_reference_distribution_0/v3_four_channel_phase_distribution_0/v3_four_channel_output_collection_0/v3_four_channel_placement_0/v3_channel_selector_late_promotion_3/v3_channel_input_bias_late_promotion_0/a_4432_10978# v3_four_channel_output_load_integration_0/v3_four_channel_shared_support_integration_0/v3_vcm_support_block_0/ref v3_four_channel_output_load_integration_0/v3_four_channel_shared_support_integration_0/v3_four_channel_bias_reference_distribution_0/v3_four_channel_phase_distribution_0/v3_four_channel_output_collection_0/v3_four_channel_placement_0/v3_channel_selector_late_promotion_3/v3_channel_input_bias_late_promotion_0/a_4254_10978# VGND sky130_fd_pr__nfet_01v8 ad=1.9575 pd=15.24 as=0 ps=0 w=0.84 l=0.6
X1055 v3_four_channel_output_load_integration_0/v3_four_channel_shared_support_integration_0/v3_four_channel_bias_reference_distribution_0/v3_four_channel_phase_distribution_0/v3_four_channel_output_collection_0/v3_four_channel_placement_0/v3_channel_selector_late_promotion_3/v3_channel_input_bias_late_promotion_0/a_4678_11422# v3_four_channel_output_load_integration_0/v3_four_channel_shared_support_integration_0/v3_four_channel_bias_reference_distribution_0/v3_four_channel_phase_distribution_0/v3_four_channel_output_collection_0/v3_four_channel_placement_0/v3_channel_selector_late_promotion_3/v3_selector_route_pilot_0/group2_lo_p v3_four_channel_output_load_integration_0/combined_p VGND sky130_fd_pr__nfet_01v8 ad=0.6206 pd=6.02 as=0 ps=0 w=0.65 l=0.15
X1056 v3_four_channel_output_load_integration_0/v3_four_channel_shared_support_integration_0/v3_four_channel_bias_reference_distribution_0/v3_four_channel_phase_distribution_0/v3_four_channel_output_collection_0/v3_four_channel_placement_0/v3_channel_selector_late_promotion_3/v3_channel_input_bias_late_promotion_0/a_6070_23422# v3_four_channel_output_load_integration_0/v3_four_channel_shared_support_integration_0/v3_four_channel_bias_reference_distribution_0/v3_four_channel_phase_distribution_0/v3_four_channel_output_collection_0/v3_four_channel_placement_0/v3_channel_selector_late_promotion_3/v3_selector_route_pilot_0/group3_lo_n v3_four_channel_output_load_integration_0/combined_p VGND sky130_fd_pr__nfet_01v8 ad=0.6206 pd=6.02 as=0 ps=0 w=0.65 l=0.15
X1057 v3_four_channel_output_load_integration_0/combined_n v3_four_channel_output_load_integration_0/v3_four_channel_shared_support_integration_0/v3_four_channel_bias_reference_distribution_0/v3_four_channel_phase_distribution_0/v3_four_channel_output_collection_0/v3_four_channel_placement_0/v3_channel_selector_late_promotion_3/v3_selector_route_pilot_0/group1_lo_n v3_four_channel_output_load_integration_0/v3_four_channel_shared_support_integration_0/v3_four_channel_bias_reference_distribution_0/v3_four_channel_phase_distribution_0/v3_four_channel_output_collection_0/v3_four_channel_placement_0/v3_channel_selector_late_promotion_3/v3_channel_input_bias_late_promotion_0/a_4254_14978# VGND sky130_fd_pr__nfet_01v8 ad=0 pd=0 as=0 ps=0 w=0.65 l=0.15
X1058 v3_four_channel_output_load_integration_0/combined_p v3_four_channel_output_load_integration_0/v3_four_channel_shared_support_integration_0/v3_four_channel_bias_reference_distribution_0/v3_four_channel_phase_distribution_0/v3_four_channel_output_collection_0/v3_four_channel_placement_0/v3_channel_selector_late_promotion_3/v3_selector_route_pilot_0/group2_lo_n v3_four_channel_output_load_integration_0/v3_four_channel_shared_support_integration_0/v3_four_channel_bias_reference_distribution_0/v3_four_channel_phase_distribution_0/v3_four_channel_output_collection_0/v3_four_channel_placement_0/v3_channel_selector_late_promotion_3/v3_channel_input_bias_late_promotion_0/a_7038_10978# VGND sky130_fd_pr__nfet_01v8 ad=0 pd=0 as=0.6206 ps=6.02 w=0.65 l=0.15
X1059 v3_four_channel_output_load_integration_0/v3_four_channel_shared_support_integration_0/v3_four_channel_bias_reference_distribution_0/v3_four_channel_phase_distribution_0/v3_four_channel_output_collection_0/v3_four_channel_placement_0/v3_channel_selector_late_promotion_3/v3_channel_input_bias_late_promotion_0/a_7462_15422# v3_four_channel_output_load_integration_0/v3_four_channel_shared_support_integration_0/v3_four_channel_bias_reference_distribution_0/v3_four_channel_phase_distribution_0/v3_four_channel_output_collection_0/v3_four_channel_placement_0/v3_channel_selector_late_promotion_3/v3_selector_route_pilot_0/group1_lo_p v3_four_channel_output_load_integration_0/combined_p VGND sky130_fd_pr__nfet_01v8 ad=0.6206 pd=6.02 as=0 ps=0 w=0.65 l=0.15
X1060 VGND VGND VGND VGND sky130_fd_pr__nfet_01v8 ad=0 pd=0 as=0 ps=0 w=5.07 l=1
X1061 v3_four_channel_output_load_integration_0/v3_four_channel_shared_support_integration_0/v3_four_channel_bias_reference_distribution_0/v3_four_channel_phase_distribution_0/v3_four_channel_output_collection_0/v3_four_channel_placement_0/v3_channel_selector_late_promotion_3/v3_channel_input_bias_late_promotion_0/a_7216_6978# v3_four_channel_output_load_integration_0/v3_four_channel_shared_support_integration_0/v3_tail_bias_support_block_0/vbias VGND VGND sky130_fd_pr__nfet_01v8 ad=1.9575 pd=15.24 as=0 ps=0 w=5.07 l=1
X1062 v3_four_channel_output_load_integration_0/v3_four_channel_shared_support_integration_0/v3_four_channel_bias_reference_distribution_0/v3_four_channel_phase_distribution_0/v3_four_channel_output_collection_0/v3_four_channel_placement_0/v3_channel_selector_late_promotion_3/v3_channel_input_bias_late_promotion_0/a_7216_10978# v3_four_channel_output_load_integration_0/v3_four_channel_shared_support_integration_0/v3_vcm_support_block_0/ref v3_four_channel_output_load_integration_0/v3_four_channel_shared_support_integration_0/v3_four_channel_bias_reference_distribution_0/v3_four_channel_phase_distribution_0/v3_four_channel_output_collection_0/v3_four_channel_placement_0/v3_channel_selector_late_promotion_3/v3_channel_input_bias_late_promotion_0/a_7038_10978# VGND sky130_fd_pr__nfet_01v8 ad=0 pd=0 as=0 ps=0 w=0.84 l=0.6
X1063 v3_four_channel_output_load_integration_0/v3_four_channel_shared_support_integration_0/v3_four_channel_bias_reference_distribution_0/v3_four_channel_phase_distribution_0/v3_four_channel_output_collection_0/v3_four_channel_placement_0/v3_channel_selector_late_promotion_3/v3_channel_input_bias_late_promotion_0/a_4678_15422# v3_four_channel_output_load_integration_0/v3_four_channel_shared_support_integration_0/v3_vcm_support_block_0/ref v3_four_channel_output_load_integration_0/v3_four_channel_shared_support_integration_0/v3_four_channel_bias_reference_distribution_0/v3_four_channel_phase_distribution_0/v3_four_channel_output_collection_0/v3_four_channel_placement_0/v3_channel_selector_late_promotion_3/v3_channel_input_bias_late_promotion_0/a_4382_13688# VGND sky130_fd_pr__nfet_01v8 ad=0 pd=0 as=0 ps=0 w=0.84 l=0.6
X1064 v3_four_channel_output_load_integration_0/v3_four_channel_shared_support_integration_0/v3_four_channel_bias_reference_distribution_0/v3_four_channel_phase_distribution_0/v3_four_channel_output_collection_0/v3_four_channel_placement_0/v3_channel_selector_late_promotion_3/v3_channel_input_bias_late_promotion_0/a_4678_15422# v3_four_channel_output_load_integration_0/v3_four_channel_shared_support_integration_0/v3_four_channel_bias_reference_distribution_0/v3_four_channel_phase_distribution_0/v3_four_channel_output_collection_0/v3_four_channel_placement_0/v3_channel_selector_late_promotion_3/v3_selector_route_pilot_0/group1_lo_p v3_four_channel_output_load_integration_0/combined_n VGND sky130_fd_pr__nfet_01v8 ad=0 pd=0 as=0 ps=0 w=0.65 l=0.15
X1065 v3_four_channel_output_load_integration_0/combined_p v3_four_channel_output_load_integration_0/v3_four_channel_shared_support_integration_0/v3_four_channel_bias_reference_distribution_0/v3_four_channel_phase_distribution_0/v3_four_channel_output_collection_0/v3_four_channel_placement_0/v3_channel_selector_late_promotion_3/v3_selector_route_pilot_0/group3_lo_p v3_four_channel_output_load_integration_0/v3_four_channel_shared_support_integration_0/v3_four_channel_bias_reference_distribution_0/v3_four_channel_phase_distribution_0/v3_four_channel_output_collection_0/v3_four_channel_placement_0/v3_channel_selector_late_promotion_3/v3_channel_input_bias_late_promotion_0/a_4254_22978# VGND sky130_fd_pr__nfet_01v8 ad=0 pd=0 as=0.6206 ps=6.02 w=0.65 l=0.15
X1066 v3_four_channel_output_load_integration_0/v3_four_channel_shared_support_integration_0/v3_four_channel_bias_reference_distribution_0/v3_four_channel_phase_distribution_0/v3_four_channel_output_collection_0/v3_four_channel_placement_0/v3_channel_selector_late_promotion_3/v3_channel_input_bias_late_promotion_0/a_7462_19422# v3_four_channel_output_load_integration_0/v3_four_channel_shared_support_integration_0/v3_vcm_support_block_0/ref v3_four_channel_output_load_integration_0/v3_four_channel_shared_support_integration_0/v3_four_channel_bias_reference_distribution_0/v3_four_channel_phase_distribution_0/v3_four_channel_output_collection_0/v3_four_channel_placement_0/v3_channel_selector_late_promotion_3/v3_channel_input_bias_late_promotion_0/a_7166_17688# VGND sky130_fd_pr__nfet_01v8 ad=0 pd=0 as=0 ps=0 w=0.84 l=0.6
X1067 v3_four_channel_output_load_integration_0/combined_n v3_four_channel_output_load_integration_0/v3_four_channel_shared_support_integration_0/v3_four_channel_bias_reference_distribution_0/v3_four_channel_phase_distribution_0/v3_four_channel_output_collection_0/v3_four_channel_placement_0/v3_channel_selector_late_promotion_3/v3_selector_route_pilot_0/group3_lo_p v3_four_channel_output_load_integration_0/v3_four_channel_shared_support_integration_0/v3_four_channel_bias_reference_distribution_0/v3_four_channel_phase_distribution_0/v3_four_channel_output_collection_0/v3_four_channel_placement_0/v3_channel_selector_late_promotion_3/v3_channel_input_bias_late_promotion_0/a_5646_10978# VGND sky130_fd_pr__nfet_01v8 ad=0 pd=0 as=0 ps=0 w=0.65 l=0.15
X1068 v3_four_channel_output_load_integration_0/combined_n v3_four_channel_output_load_integration_0/v3_four_channel_shared_support_integration_0/v3_four_channel_bias_reference_distribution_0/v3_four_channel_phase_distribution_0/v3_four_channel_output_collection_0/v3_four_channel_placement_0/v3_channel_selector_late_promotion_3/v3_selector_route_pilot_0/group1_lo_p v3_four_channel_output_load_integration_0/v3_four_channel_shared_support_integration_0/v3_four_channel_bias_reference_distribution_0/v3_four_channel_phase_distribution_0/v3_four_channel_output_collection_0/v3_four_channel_placement_0/v3_channel_selector_late_promotion_3/v3_channel_input_bias_late_promotion_0/a_7038_14978# VGND sky130_fd_pr__nfet_01v8 ad=0 pd=0 as=0 ps=0 w=0.65 l=0.15
X1069 v3_four_channel_output_load_integration_0/v3_four_channel_shared_support_integration_0/v3_four_channel_bias_reference_distribution_0/v3_four_channel_phase_distribution_0/v3_four_channel_output_collection_0/v3_four_channel_placement_0/v3_channel_selector_late_promotion_3/v3_channel_input_bias_late_promotion_0/a_7462_19422# v3_four_channel_output_load_integration_0/v3_four_channel_shared_support_integration_0/v3_four_channel_bias_reference_distribution_0/v3_four_channel_phase_distribution_0/v3_four_channel_output_collection_0/v3_four_channel_placement_0/v3_channel_selector_late_promotion_3/v3_selector_route_pilot_0/group2_lo_p v3_four_channel_output_load_integration_0/combined_n VGND sky130_fd_pr__nfet_01v8 ad=0 pd=0 as=0 ps=0 w=0.65 l=0.15
X1070 v3_four_channel_output_load_integration_0/v3_four_channel_shared_support_integration_0/v3_four_channel_bias_reference_distribution_0/v3_four_channel_phase_distribution_0/v3_four_channel_output_collection_0/v3_four_channel_placement_0/v3_channel_selector_late_promotion_3/v3_channel_input_bias_late_promotion_0/a_4678_7422# v3_four_channel_output_load_integration_0/v3_four_channel_shared_support_integration_0/v3_four_channel_bias_reference_distribution_0/v3_four_channel_phase_distribution_0/v3_four_channel_output_collection_0/v3_four_channel_placement_0/v3_channel_selector_late_promotion_3/element_input v3_four_channel_output_load_integration_0/v3_four_channel_shared_support_integration_0/v3_four_channel_bias_reference_distribution_0/v3_four_channel_phase_distribution_0/v3_four_channel_output_collection_0/v3_four_channel_placement_0/v3_channel_selector_late_promotion_3/v3_channel_input_bias_late_promotion_0/a_4432_6978# VGND sky130_fd_pr__nfet_01v8 ad=0 pd=0 as=1.9575 ps=15.24 w=0.84 l=0.6
X1071 v3_four_channel_output_load_integration_0/combined_p v3_four_channel_output_load_integration_0/v3_four_channel_shared_support_integration_0/v3_four_channel_bias_reference_distribution_0/v3_four_channel_phase_distribution_0/v3_four_channel_output_collection_0/v3_four_channel_placement_0/v3_channel_selector_late_promotion_3/v3_selector_route_pilot_0/group3_lo_n v3_four_channel_output_load_integration_0/v3_four_channel_shared_support_integration_0/v3_four_channel_bias_reference_distribution_0/v3_four_channel_phase_distribution_0/v3_four_channel_output_collection_0/v3_four_channel_placement_0/v3_channel_selector_late_promotion_3/v3_channel_input_bias_late_promotion_0/a_5646_6978# VGND sky130_fd_pr__nfet_01v8 ad=0 pd=0 as=0 ps=0 w=0.65 l=0.15
X1072 v3_four_channel_output_load_integration_0/v3_four_channel_shared_support_integration_0/v3_four_channel_bias_reference_distribution_0/v3_four_channel_phase_distribution_0/v3_four_channel_output_collection_0/v3_four_channel_placement_0/v3_channel_selector_late_promotion_3/v3_channel_input_bias_late_promotion_0/a_4678_7422# v3_four_channel_output_load_integration_0/v3_four_channel_shared_support_integration_0/v3_four_channel_bias_reference_distribution_0/v3_four_channel_phase_distribution_0/v3_four_channel_output_collection_0/v3_four_channel_placement_0/v3_channel_selector_late_promotion_3/v3_selector_route_pilot_0/group3_lo_n v3_four_channel_output_load_integration_0/combined_n VGND sky130_fd_pr__nfet_01v8 ad=0 pd=0 as=0 ps=0 w=0.65 l=0.15
X1073 v3_four_channel_output_load_integration_0/v3_four_channel_shared_support_integration_0/v3_four_channel_bias_reference_distribution_0/v3_four_channel_phase_distribution_0/v3_four_channel_output_collection_0/v3_four_channel_placement_0/v3_channel_selector_late_promotion_3/v3_channel_input_bias_late_promotion_0/a_6070_11422# v3_four_channel_output_load_integration_0/v3_four_channel_shared_support_integration_0/v3_four_channel_bias_reference_distribution_0/v3_four_channel_phase_distribution_0/v3_four_channel_output_collection_0/v3_four_channel_placement_0/v3_channel_selector_late_promotion_3/element_input v3_four_channel_output_load_integration_0/v3_four_channel_shared_support_integration_0/v3_four_channel_bias_reference_distribution_0/v3_four_channel_phase_distribution_0/v3_four_channel_output_collection_0/v3_four_channel_placement_0/v3_channel_selector_late_promotion_3/v3_channel_input_bias_late_promotion_0/a_5824_10978# VGND sky130_fd_pr__nfet_01v8 ad=0 pd=0 as=0 ps=0 w=0.84 l=0.6
X1074 v3_four_channel_output_load_integration_0/v3_four_channel_shared_support_integration_0/v3_four_channel_bias_reference_distribution_0/v3_four_channel_phase_distribution_0/v3_four_channel_output_collection_0/v3_four_channel_placement_0/v3_channel_selector_late_promotion_3/v3_channel_input_bias_late_promotion_0/a_6070_11422# v3_four_channel_output_load_integration_0/v3_four_channel_shared_support_integration_0/v3_four_channel_bias_reference_distribution_0/v3_four_channel_phase_distribution_0/v3_four_channel_output_collection_0/v3_four_channel_placement_0/v3_channel_selector_late_promotion_3/v3_selector_route_pilot_0/group3_lo_n v3_four_channel_output_load_integration_0/combined_n VGND sky130_fd_pr__nfet_01v8 ad=0 pd=0 as=0 ps=0 w=0.65 l=0.15
X1075 v3_four_channel_output_load_integration_0/v3_four_channel_shared_support_integration_0/v3_four_channel_bias_reference_distribution_0/v3_four_channel_phase_distribution_0/v3_four_channel_output_collection_0/v3_four_channel_placement_0/v3_channel_selector_late_promotion_3/v3_channel_input_bias_late_promotion_0/a_4382_21688# v3_four_channel_output_load_integration_0/v3_four_channel_shared_support_integration_0/v3_four_channel_bias_reference_distribution_0/v3_four_channel_phase_distribution_0/v3_four_channel_output_collection_0/v3_four_channel_placement_0/v3_channel_selector_late_promotion_3/element_input v3_four_channel_output_load_integration_0/v3_four_channel_shared_support_integration_0/v3_four_channel_bias_reference_distribution_0/v3_four_channel_phase_distribution_0/v3_four_channel_output_collection_0/v3_four_channel_placement_0/v3_channel_selector_late_promotion_3/v3_channel_input_bias_late_promotion_0/a_4254_22978# VGND sky130_fd_pr__nfet_01v8 ad=0 pd=0 as=0 ps=0 w=0.84 l=0.6
X1076 v3_four_channel_output_load_integration_0/v3_four_channel_shared_support_integration_0/v3_four_channel_bias_reference_distribution_0/v3_four_channel_phase_distribution_0/v3_four_channel_output_collection_0/v3_four_channel_placement_0/v3_channel_selector_late_promotion_3/v3_channel_input_bias_late_promotion_0/a_4678_23422# v3_four_channel_output_load_integration_0/v3_four_channel_shared_support_integration_0/v3_four_channel_bias_reference_distribution_0/v3_four_channel_phase_distribution_0/v3_four_channel_output_collection_0/v3_four_channel_placement_0/v3_channel_selector_late_promotion_3/v3_selector_route_pilot_0/group3_lo_n v3_four_channel_output_load_integration_0/combined_p VGND sky130_fd_pr__nfet_01v8 ad=0 pd=0 as=0 ps=0 w=0.65 l=0.15
X1077 v3_four_channel_output_load_integration_0/combined_p v3_four_channel_output_load_integration_0/v3_four_channel_shared_support_integration_0/v3_four_channel_bias_reference_distribution_0/v3_four_channel_phase_distribution_0/v3_four_channel_output_collection_0/v3_four_channel_placement_0/v3_channel_selector_late_promotion_3/v3_selector_route_pilot_0/group3_lo_n v3_four_channel_output_load_integration_0/v3_four_channel_shared_support_integration_0/v3_four_channel_bias_reference_distribution_0/v3_four_channel_phase_distribution_0/v3_four_channel_output_collection_0/v3_four_channel_placement_0/v3_channel_selector_late_promotion_3/v3_channel_input_bias_late_promotion_0/a_4254_6978# VGND sky130_fd_pr__nfet_01v8 ad=0 pd=0 as=0 ps=0 w=0.65 l=0.15
X1078 v3_four_channel_output_load_integration_0/v3_four_channel_shared_support_integration_0/v3_four_channel_bias_reference_distribution_0/v3_four_channel_phase_distribution_0/v3_four_channel_output_collection_0/v3_four_channel_placement_0/v3_channel_selector_late_promotion_3/v3_channel_input_bias_late_promotion_0/a_5774_13688# v3_four_channel_output_load_integration_0/v3_four_channel_shared_support_integration_0/v3_four_channel_bias_reference_distribution_0/v3_four_channel_phase_distribution_0/v3_four_channel_output_collection_0/v3_four_channel_placement_0/v3_channel_selector_late_promotion_3/element_input v3_four_channel_output_load_integration_0/v3_four_channel_shared_support_integration_0/v3_four_channel_bias_reference_distribution_0/v3_four_channel_phase_distribution_0/v3_four_channel_output_collection_0/v3_four_channel_placement_0/v3_channel_selector_late_promotion_3/v3_channel_input_bias_late_promotion_0/a_5646_14978# VGND sky130_fd_pr__nfet_01v8 ad=0 pd=0 as=0 ps=0 w=0.84 l=0.6
X1079 v3_four_channel_output_load_integration_0/combined_p v3_four_channel_output_load_integration_0/v3_four_channel_shared_support_integration_0/v3_four_channel_bias_reference_distribution_0/v3_four_channel_phase_distribution_0/v3_four_channel_output_collection_0/v3_four_channel_placement_0/v3_channel_selector_late_promotion_3/v3_selector_route_pilot_0/group3_lo_p v3_four_channel_output_load_integration_0/v3_four_channel_shared_support_integration_0/v3_four_channel_bias_reference_distribution_0/v3_four_channel_phase_distribution_0/v3_four_channel_output_collection_0/v3_four_channel_placement_0/v3_channel_selector_late_promotion_3/v3_channel_input_bias_late_promotion_0/a_7038_22978# VGND sky130_fd_pr__nfet_01v8 ad=0 pd=0 as=0 ps=0 w=0.65 l=0.15
X1080 v3_four_channel_output_load_integration_0/v3_four_channel_shared_support_integration_0/v3_four_channel_bias_reference_distribution_0/v3_four_channel_phase_distribution_0/v3_four_channel_output_collection_0/v3_four_channel_placement_0/v3_channel_selector_late_promotion_3/v3_channel_input_bias_late_promotion_0/a_7462_7422# v3_four_channel_output_load_integration_0/v3_four_channel_shared_support_integration_0/v3_four_channel_bias_reference_distribution_0/v3_four_channel_phase_distribution_0/v3_four_channel_output_collection_0/v3_four_channel_placement_0/v3_channel_selector_late_promotion_3/element_input v3_four_channel_output_load_integration_0/v3_four_channel_shared_support_integration_0/v3_four_channel_bias_reference_distribution_0/v3_four_channel_phase_distribution_0/v3_four_channel_output_collection_0/v3_four_channel_placement_0/v3_channel_selector_late_promotion_3/v3_channel_input_bias_late_promotion_0/a_7216_6978# VGND sky130_fd_pr__nfet_01v8 ad=0 pd=0 as=0 ps=0 w=0.84 l=0.6
X1081 v3_four_channel_output_load_integration_0/v3_four_channel_shared_support_integration_0/v3_four_channel_bias_reference_distribution_0/v3_four_channel_phase_distribution_0/v3_four_channel_output_collection_0/v3_four_channel_placement_0/v3_channel_selector_late_promotion_3/v3_channel_input_bias_late_promotion_0/a_4432_10978# v3_four_channel_output_load_integration_0/v3_four_channel_shared_support_integration_0/v3_tail_bias_support_block_0/vbias VGND VGND sky130_fd_pr__nfet_01v8 ad=0 pd=0 as=0 ps=0 w=5.07 l=1
X1082 v3_four_channel_output_load_integration_0/v3_four_channel_shared_support_integration_0/v3_four_channel_bias_reference_distribution_0/v3_four_channel_phase_distribution_0/v3_four_channel_output_collection_0/v3_four_channel_placement_0/v3_channel_selector_late_promotion_3/v3_channel_input_bias_late_promotion_0/a_7462_7422# v3_four_channel_output_load_integration_0/v3_four_channel_shared_support_integration_0/v3_four_channel_bias_reference_distribution_0/v3_four_channel_phase_distribution_0/v3_four_channel_output_collection_0/v3_four_channel_placement_0/v3_channel_selector_late_promotion_3/v3_selector_route_pilot_0/group3_lo_n v3_four_channel_output_load_integration_0/combined_n VGND sky130_fd_pr__nfet_01v8 ad=0 pd=0 as=0 ps=0 w=0.65 l=0.15
X1083 VGND v3_four_channel_output_load_integration_0/v3_four_channel_shared_support_integration_0/v3_tail_bias_support_block_0/vbias v3_four_channel_output_load_integration_0/v3_four_channel_shared_support_integration_0/v3_four_channel_bias_reference_distribution_0/v3_four_channel_phase_distribution_0/v3_four_channel_output_collection_0/v3_four_channel_placement_0/v3_channel_selector_late_promotion_3/v3_channel_input_bias_late_promotion_0/a_4382_17688# VGND sky130_fd_pr__nfet_01v8 ad=0 pd=0 as=0 ps=0 w=5.07 l=1
X1084 v3_four_channel_output_load_integration_0/combined_p v3_four_channel_output_load_integration_0/v3_four_channel_shared_support_integration_0/v3_four_channel_bias_reference_distribution_0/v3_four_channel_phase_distribution_0/v3_four_channel_output_collection_0/v3_four_channel_placement_0/v3_channel_selector_late_promotion_3/v3_selector_route_pilot_0/group3_lo_n v3_four_channel_output_load_integration_0/v3_four_channel_shared_support_integration_0/v3_four_channel_bias_reference_distribution_0/v3_four_channel_phase_distribution_0/v3_four_channel_output_collection_0/v3_four_channel_placement_0/v3_channel_selector_late_promotion_3/v3_channel_input_bias_late_promotion_0/a_7038_6978# VGND sky130_fd_pr__nfet_01v8 ad=0 pd=0 as=0 ps=0 w=0.65 l=0.15
X1085 v3_four_channel_output_load_integration_0/combined_n v3_four_channel_output_load_integration_0/v3_four_channel_shared_support_integration_0/v3_four_channel_bias_reference_distribution_0/v3_four_channel_phase_distribution_0/v3_four_channel_output_collection_0/v3_four_channel_placement_0/v3_channel_selector_late_promotion_3/v3_selector_route_pilot_0/group2_lo_p v3_four_channel_output_load_integration_0/v3_four_channel_shared_support_integration_0/v3_four_channel_bias_reference_distribution_0/v3_four_channel_phase_distribution_0/v3_four_channel_output_collection_0/v3_four_channel_placement_0/v3_channel_selector_late_promotion_3/v3_channel_input_bias_late_promotion_0/a_4254_10978# VGND sky130_fd_pr__nfet_01v8 ad=0 pd=0 as=0 ps=0 w=0.65 l=0.15
X1086 v3_four_channel_output_load_integration_0/v3_four_channel_shared_support_integration_0/v3_four_channel_bias_reference_distribution_0/v3_four_channel_phase_distribution_0/v3_four_channel_output_collection_0/v3_four_channel_placement_0/v3_channel_selector_late_promotion_3/v3_channel_input_bias_late_promotion_0/a_7462_11422# v3_four_channel_output_load_integration_0/v3_four_channel_shared_support_integration_0/v3_four_channel_bias_reference_distribution_0/v3_four_channel_phase_distribution_0/v3_four_channel_output_collection_0/v3_four_channel_placement_0/v3_channel_selector_late_promotion_3/v3_selector_route_pilot_0/group2_lo_p v3_four_channel_output_load_integration_0/combined_p VGND sky130_fd_pr__nfet_01v8 ad=0 pd=0 as=0 ps=0 w=0.65 l=0.15
X1087 v3_four_channel_output_load_integration_0/v3_four_channel_shared_support_integration_0/v3_four_channel_bias_reference_distribution_0/v3_four_channel_phase_distribution_0/v3_four_channel_output_collection_0/v3_four_channel_placement_0/v3_channel_selector_late_promotion_3/v3_channel_input_bias_late_promotion_0/a_7166_21688# v3_four_channel_output_load_integration_0/v3_four_channel_shared_support_integration_0/v3_four_channel_bias_reference_distribution_0/v3_four_channel_phase_distribution_0/v3_four_channel_output_collection_0/v3_four_channel_placement_0/v3_channel_selector_late_promotion_3/element_input v3_four_channel_output_load_integration_0/v3_four_channel_shared_support_integration_0/v3_four_channel_bias_reference_distribution_0/v3_four_channel_phase_distribution_0/v3_four_channel_output_collection_0/v3_four_channel_placement_0/v3_channel_selector_late_promotion_3/v3_channel_input_bias_late_promotion_0/a_7038_22978# VGND sky130_fd_pr__nfet_01v8 ad=0 pd=0 as=0 ps=0 w=0.84 l=0.6
X1088 v3_four_channel_output_load_integration_0/combined_n v3_four_channel_output_load_integration_0/v3_four_channel_shared_support_integration_0/v3_four_channel_bias_reference_distribution_0/v3_four_channel_phase_distribution_0/v3_four_channel_output_collection_0/v3_four_channel_placement_0/v3_channel_selector_late_promotion_3/v3_selector_route_pilot_0/group3_lo_n v3_four_channel_output_load_integration_0/v3_four_channel_shared_support_integration_0/v3_four_channel_bias_reference_distribution_0/v3_four_channel_phase_distribution_0/v3_four_channel_output_collection_0/v3_four_channel_placement_0/v3_channel_selector_late_promotion_3/v3_channel_input_bias_late_promotion_0/a_5646_22978# VGND sky130_fd_pr__nfet_01v8 ad=0 pd=0 as=0 ps=0 w=0.65 l=0.15
X1089 v3_four_channel_output_load_integration_0/v3_four_channel_shared_support_integration_0/v3_four_channel_bias_reference_distribution_0/v3_four_channel_phase_distribution_0/v3_four_channel_output_collection_0/v3_four_channel_placement_0/v3_channel_selector_late_promotion_3/v3_channel_input_bias_late_promotion_0/a_4678_11422# v3_four_channel_output_load_integration_0/v3_four_channel_shared_support_integration_0/v3_four_channel_bias_reference_distribution_0/v3_four_channel_phase_distribution_0/v3_four_channel_output_collection_0/v3_four_channel_placement_0/v3_channel_selector_late_promotion_3/element_input v3_four_channel_output_load_integration_0/v3_four_channel_shared_support_integration_0/v3_four_channel_bias_reference_distribution_0/v3_four_channel_phase_distribution_0/v3_four_channel_output_collection_0/v3_four_channel_placement_0/v3_channel_selector_late_promotion_3/v3_channel_input_bias_late_promotion_0/a_4432_10978# VGND sky130_fd_pr__nfet_01v8 ad=0 pd=0 as=0 ps=0 w=0.84 l=0.6
X1090 v3_four_channel_output_load_integration_0/v3_four_channel_shared_support_integration_0/v3_four_channel_bias_reference_distribution_0/v3_four_channel_phase_distribution_0/v3_four_channel_output_collection_0/v3_four_channel_placement_0/v3_channel_selector_late_promotion_3/v3_channel_input_bias_late_promotion_0/a_6070_23422# v3_four_channel_output_load_integration_0/v3_four_channel_shared_support_integration_0/v3_vcm_support_block_0/ref v3_four_channel_output_load_integration_0/v3_four_channel_shared_support_integration_0/v3_four_channel_bias_reference_distribution_0/v3_four_channel_phase_distribution_0/v3_four_channel_output_collection_0/v3_four_channel_placement_0/v3_channel_selector_late_promotion_3/v3_channel_input_bias_late_promotion_0/a_5774_21688# VGND sky130_fd_pr__nfet_01v8 ad=0 pd=0 as=0 ps=0 w=0.84 l=0.6
X1091 v3_four_channel_output_load_integration_0/v3_four_channel_shared_support_integration_0/v3_four_channel_bias_reference_distribution_0/v3_four_channel_phase_distribution_0/v3_four_channel_output_collection_0/v3_four_channel_placement_0/v3_channel_selector_late_promotion_3/v3_channel_input_bias_late_promotion_0/a_6070_23422# v3_four_channel_output_load_integration_0/v3_four_channel_shared_support_integration_0/v3_four_channel_bias_reference_distribution_0/v3_four_channel_phase_distribution_0/v3_four_channel_output_collection_0/v3_four_channel_placement_0/v3_channel_selector_late_promotion_3/v3_selector_route_pilot_0/group3_lo_p v3_four_channel_output_load_integration_0/combined_n VGND sky130_fd_pr__nfet_01v8 ad=0 pd=0 as=0 ps=0 w=0.65 l=0.15
X1092 v3_four_channel_output_load_integration_0/v3_four_channel_shared_support_integration_0/v3_four_channel_bias_reference_distribution_0/v3_four_channel_phase_distribution_0/v3_four_channel_output_collection_0/v3_four_channel_placement_0/v3_channel_selector_late_promotion_3/v3_channel_input_bias_late_promotion_0/a_4678_11422# v3_four_channel_output_load_integration_0/v3_four_channel_shared_support_integration_0/v3_four_channel_bias_reference_distribution_0/v3_four_channel_phase_distribution_0/v3_four_channel_output_collection_0/v3_four_channel_placement_0/v3_channel_selector_late_promotion_3/v3_selector_route_pilot_0/group2_lo_n v3_four_channel_output_load_integration_0/combined_n VGND sky130_fd_pr__nfet_01v8 ad=0 pd=0 as=0 ps=0 w=0.65 l=0.15
X1093 v3_four_channel_output_load_integration_0/v3_four_channel_shared_support_integration_0/v3_four_channel_bias_reference_distribution_0/v3_four_channel_phase_distribution_0/v3_four_channel_output_collection_0/v3_four_channel_placement_0/v3_channel_selector_late_promotion_3/v3_channel_input_bias_late_promotion_0/a_7462_15422# v3_four_channel_output_load_integration_0/v3_four_channel_shared_support_integration_0/v3_four_channel_bias_reference_distribution_0/v3_four_channel_phase_distribution_0/v3_four_channel_output_collection_0/v3_four_channel_placement_0/v3_channel_selector_late_promotion_3/element_input v3_four_channel_output_load_integration_0/v3_four_channel_shared_support_integration_0/v3_four_channel_bias_reference_distribution_0/v3_four_channel_phase_distribution_0/v3_four_channel_output_collection_0/v3_four_channel_placement_0/v3_channel_selector_late_promotion_3/v3_channel_input_bias_late_promotion_0/a_7216_14978# VGND sky130_fd_pr__nfet_01v8 ad=0 pd=0 as=0 ps=0 w=0.84 l=0.6
X1094 v3_four_channel_output_load_integration_0/v3_four_channel_shared_support_integration_0/v3_four_channel_bias_reference_distribution_0/v3_four_channel_phase_distribution_0/v3_four_channel_output_collection_0/v3_four_channel_placement_0/v3_channel_selector_late_promotion_3/v3_channel_input_bias_late_promotion_0/a_6070_7422# v3_four_channel_output_load_integration_0/v3_four_channel_shared_support_integration_0/v3_four_channel_bias_reference_distribution_0/v3_four_channel_phase_distribution_0/v3_four_channel_output_collection_0/v3_four_channel_placement_0/v3_channel_selector_late_promotion_3/v3_selector_route_pilot_0/group3_lo_p v3_four_channel_output_load_integration_0/combined_p VGND sky130_fd_pr__nfet_01v8 ad=0 pd=0 as=0 ps=0 w=0.65 l=0.15
X1095 v3_four_channel_output_load_integration_0/combined_n v3_four_channel_output_load_integration_0/v3_four_channel_shared_support_integration_0/v3_four_channel_bias_reference_distribution_0/v3_four_channel_phase_distribution_0/v3_four_channel_output_collection_0/v3_four_channel_placement_0/v3_channel_selector_late_promotion_3/v3_selector_route_pilot_0/group2_lo_p v3_four_channel_output_load_integration_0/v3_four_channel_shared_support_integration_0/v3_four_channel_bias_reference_distribution_0/v3_four_channel_phase_distribution_0/v3_four_channel_output_collection_0/v3_four_channel_placement_0/v3_channel_selector_late_promotion_3/v3_channel_input_bias_late_promotion_0/a_7038_10978# VGND sky130_fd_pr__nfet_01v8 ad=0 pd=0 as=0 ps=0 w=0.65 l=0.15
X1096 v3_four_channel_output_load_integration_0/v3_four_channel_shared_support_integration_0/v3_four_channel_bias_reference_distribution_0/v3_four_channel_phase_distribution_0/v3_four_channel_output_collection_0/v3_four_channel_placement_0/v3_channel_selector_late_promotion_3/v3_channel_input_bias_late_promotion_0/a_7462_15422# v3_four_channel_output_load_integration_0/v3_four_channel_shared_support_integration_0/v3_four_channel_bias_reference_distribution_0/v3_four_channel_phase_distribution_0/v3_four_channel_output_collection_0/v3_four_channel_placement_0/v3_channel_selector_late_promotion_3/v3_selector_route_pilot_0/group1_lo_n v3_four_channel_output_load_integration_0/combined_n VGND sky130_fd_pr__nfet_01v8 ad=0 pd=0 as=0 ps=0 w=0.65 l=0.15
X1097 v3_four_channel_output_load_integration_0/v3_four_channel_shared_support_integration_0/v3_four_channel_bias_reference_distribution_0/v3_four_channel_phase_distribution_0/v3_four_channel_output_collection_0/v3_four_channel_placement_0/v3_channel_selector_late_promotion_3/v3_channel_input_bias_late_promotion_0/a_4432_6978# v3_four_channel_output_load_integration_0/v3_four_channel_shared_support_integration_0/v3_vcm_support_block_0/ref v3_four_channel_output_load_integration_0/v3_four_channel_shared_support_integration_0/v3_four_channel_bias_reference_distribution_0/v3_four_channel_phase_distribution_0/v3_four_channel_output_collection_0/v3_four_channel_placement_0/v3_channel_selector_late_promotion_3/v3_channel_input_bias_late_promotion_0/a_4254_6978# VGND sky130_fd_pr__nfet_01v8 ad=0 pd=0 as=0 ps=0 w=0.84 l=0.6
X1098 v3_four_channel_output_load_integration_0/v3_four_channel_shared_support_integration_0/v3_four_channel_bias_reference_distribution_0/v3_four_channel_phase_distribution_0/v3_four_channel_output_collection_0/v3_four_channel_placement_0/v3_channel_selector_late_promotion_3/v3_channel_input_bias_late_promotion_0/a_5824_10978# v3_four_channel_output_load_integration_0/v3_four_channel_shared_support_integration_0/v3_vcm_support_block_0/ref v3_four_channel_output_load_integration_0/v3_four_channel_shared_support_integration_0/v3_four_channel_bias_reference_distribution_0/v3_four_channel_phase_distribution_0/v3_four_channel_output_collection_0/v3_four_channel_placement_0/v3_channel_selector_late_promotion_3/v3_channel_input_bias_late_promotion_0/a_5646_10978# VGND sky130_fd_pr__nfet_01v8 ad=0 pd=0 as=0 ps=0 w=0.84 l=0.6
X1099 v3_four_channel_output_load_integration_0/combined_n v3_four_channel_output_load_integration_0/v3_four_channel_shared_support_integration_0/v3_four_channel_bias_reference_distribution_0/v3_four_channel_phase_distribution_0/v3_four_channel_output_collection_0/v3_four_channel_placement_0/v3_channel_selector_late_promotion_3/v3_selector_route_pilot_0/group3_lo_n v3_four_channel_output_load_integration_0/v3_four_channel_shared_support_integration_0/v3_four_channel_bias_reference_distribution_0/v3_four_channel_phase_distribution_0/v3_four_channel_output_collection_0/v3_four_channel_placement_0/v3_channel_selector_late_promotion_3/v3_channel_input_bias_late_promotion_0/a_4254_22978# VGND sky130_fd_pr__nfet_01v8 ad=0 pd=0 as=0 ps=0 w=0.65 l=0.15
X1100 v3_four_channel_output_load_integration_0/v3_four_channel_shared_support_integration_0/v3_four_channel_bias_reference_distribution_0/v3_four_channel_phase_distribution_0/v3_four_channel_output_collection_0/v3_four_channel_placement_0/v3_channel_selector_late_promotion_3/v3_channel_input_bias_late_promotion_0/a_7462_23422# v3_four_channel_output_load_integration_0/v3_four_channel_shared_support_integration_0/v3_four_channel_bias_reference_distribution_0/v3_four_channel_phase_distribution_0/v3_four_channel_output_collection_0/v3_four_channel_placement_0/v3_channel_selector_late_promotion_3/v3_selector_route_pilot_0/group3_lo_n v3_four_channel_output_load_integration_0/combined_p VGND sky130_fd_pr__nfet_01v8 ad=0 pd=0 as=0 ps=0 w=0.65 l=0.15
X1101 v3_four_channel_output_load_integration_0/v3_four_channel_shared_support_integration_0/v3_four_channel_bias_reference_distribution_0/v3_four_channel_phase_distribution_0/v3_four_channel_output_collection_0/v3_four_channel_placement_0/v3_channel_selector_late_promotion_3/v3_channel_input_bias_late_promotion_0/a_4432_6978# v3_four_channel_output_load_integration_0/v3_four_channel_shared_support_integration_0/v3_tail_bias_support_block_0/vbias VGND VGND sky130_fd_pr__nfet_01v8 ad=0 pd=0 as=0 ps=0 w=5.07 l=1
X1102 v3_four_channel_output_load_integration_0/v3_four_channel_shared_support_integration_0/v3_four_channel_bias_reference_distribution_0/v3_four_channel_phase_distribution_0/v3_four_channel_output_collection_0/v3_four_channel_placement_0/v3_channel_selector_late_promotion_3/v3_channel_input_bias_late_promotion_0/a_7216_6978# v3_four_channel_output_load_integration_0/v3_four_channel_shared_support_integration_0/v3_vcm_support_block_0/ref v3_four_channel_output_load_integration_0/v3_four_channel_shared_support_integration_0/v3_four_channel_bias_reference_distribution_0/v3_four_channel_phase_distribution_0/v3_four_channel_output_collection_0/v3_four_channel_placement_0/v3_channel_selector_late_promotion_3/v3_channel_input_bias_late_promotion_0/a_7038_6978# VGND sky130_fd_pr__nfet_01v8 ad=0 pd=0 as=0 ps=0 w=0.84 l=0.6
X1103 v3_four_channel_output_load_integration_0/combined_n v3_four_channel_output_load_integration_0/v3_four_channel_shared_support_integration_0/v3_four_channel_bias_reference_distribution_0/v3_four_channel_phase_distribution_0/v3_four_channel_output_collection_0/v3_four_channel_placement_0/v3_channel_selector_late_promotion_3/v3_selector_route_pilot_0/group3_lo_p v3_four_channel_output_load_integration_0/v3_four_channel_shared_support_integration_0/v3_four_channel_bias_reference_distribution_0/v3_four_channel_phase_distribution_0/v3_four_channel_output_collection_0/v3_four_channel_placement_0/v3_channel_selector_late_promotion_3/v3_channel_input_bias_late_promotion_0/a_5646_6978# VGND sky130_fd_pr__nfet_01v8 ad=0 pd=0 as=0 ps=0 w=0.65 l=0.15
X1104 VGND v3_four_channel_output_load_integration_0/v3_four_channel_shared_support_integration_0/v3_tail_bias_support_block_0/vbias v3_four_channel_output_load_integration_0/v3_four_channel_shared_support_integration_0/v3_four_channel_bias_reference_distribution_0/v3_four_channel_phase_distribution_0/v3_four_channel_output_collection_0/v3_four_channel_placement_0/v3_channel_selector_late_promotion_3/v3_channel_input_bias_late_promotion_0/a_4382_13688# VGND sky130_fd_pr__nfet_01v8 ad=0 pd=0 as=0 ps=0 w=5.07 l=1
X1105 VDPWR v3_four_channel_output_load_integration_0/v3_four_channel_shared_support_integration_0/v3_four_channel_bias_reference_distribution_0/v3_four_channel_phase_distribution_0/v3_four_channel_output_collection_0/v3_four_channel_placement_0/v3_channel_selector_late_promotion_3/v3_selector_route_pilot_0/G1_MUX_POS/a_505_21# v3_four_channel_output_load_integration_0/v3_four_channel_shared_support_integration_0/v3_four_channel_bias_reference_distribution_0/v3_four_channel_phase_distribution_0/v3_four_channel_output_collection_0/v3_four_channel_placement_0/v3_channel_selector_late_promotion_3/v3_selector_route_pilot_0/G1_MUX_POS/a_535_374# VDPWR sky130_fd_pr__pfet_01v8_hvt ad=0 pd=0 as=0.0882 ps=1.26 w=0.42 l=0.15
X1106 v3_four_channel_output_load_integration_0/v3_four_channel_shared_support_integration_0/v3_four_channel_bias_reference_distribution_0/v3_four_channel_phase_distribution_0/v3_four_channel_output_collection_0/v3_four_channel_placement_0/v3_channel_selector_late_promotion_3/v3_selector_route_pilot_0/G1_MUX_POS/a_505_21# v3_four_channel_output_load_integration_0/v3_four_channel_shared_support_integration_0/v3_four_channel_bias_reference_distribution_0/v3_four_channel_phase_distribution_0/v3_four_channel_output_collection_0/v3_four_channel_placement_0/v3_channel_selector_late_promotion_3/group1_bit0 VDPWR VDPWR sky130_fd_pr__pfet_01v8_hvt ad=0.1176 pd=1.4 as=0 ps=0 w=0.42 l=0.15
X1107 v3_four_channel_output_load_integration_0/v3_four_channel_shared_support_integration_0/v3_four_channel_bias_reference_distribution_0/v3_four_channel_phase_distribution_0/v3_four_channel_output_collection_0/v3_four_channel_placement_0/v3_channel_selector_late_promotion_3/v3_selector_route_pilot_0/G1_MUX_POS/a_218_374# v3_four_channel_output_load_integration_0/v3_four_channel_shared_support_integration_0/v3_four_channel_bias_reference_distribution_0/v3_four_channel_phase_distribution_0/v3_four_channel_output_collection_0/v3_four_channel_placement_0/v3_channel_selector_late_promotion_3/group1_bit0 VDPWR VDPWR sky130_fd_pr__pfet_01v8_hvt ad=0.1533 pd=1.57 as=0 ps=0 w=0.42 l=0.15
X1108 VGND v3_four_channel_output_load_integration_0/v3_four_channel_shared_support_integration_0/v3_four_channel_bias_reference_distribution_0/v3_four_channel_phase_distribution_0/v3_four_channel_output_collection_0/v3_four_channel_placement_0/v3_channel_selector_late_promotion_3/v3_selector_route_pilot_0/G1_MUX_POS/a_505_21# v3_four_channel_output_load_integration_0/v3_four_channel_shared_support_integration_0/v3_four_channel_bias_reference_distribution_0/v3_four_channel_phase_distribution_0/v3_four_channel_output_collection_0/v3_four_channel_placement_0/v3_channel_selector_late_promotion_3/v3_selector_route_pilot_0/G1_MUX_POS/a_439_47# VGND sky130_fd_pr__nfet_01v8 ad=0 pd=0 as=0.1386 ps=1.5 w=0.42 l=0.15
X1109 v3_four_channel_output_load_integration_0/v3_four_channel_shared_support_integration_0/v3_four_channel_bias_reference_distribution_0/v3_four_channel_phase_distribution_0/v3_four_channel_output_collection_0/v3_four_channel_placement_0/v3_channel_selector_late_promotion_3/v3_selector_route_pilot_0/G1_MUX_POS/a_76_199# v3_four_channel_output_load_integration_0/v3_four_channel_shared_support_integration_0/v3_four_channel_bias_reference_distribution_0/v3_four_channel_phase_distribution_0/phase_0 v3_four_channel_output_load_integration_0/v3_four_channel_shared_support_integration_0/v3_four_channel_bias_reference_distribution_0/v3_four_channel_phase_distribution_0/v3_four_channel_output_collection_0/v3_four_channel_placement_0/v3_channel_selector_late_promotion_3/v3_selector_route_pilot_0/G1_MUX_POS/a_218_374# VDPWR sky130_fd_pr__pfet_01v8_hvt ad=0.3864 pd=2.68 as=0 ps=0 w=0.42 l=0.15
X1110 v3_four_channel_output_load_integration_0/v3_four_channel_shared_support_integration_0/v3_four_channel_bias_reference_distribution_0/v3_four_channel_phase_distribution_0/v3_four_channel_output_collection_0/v3_four_channel_placement_0/v3_channel_selector_late_promotion_3/v3_selector_route_pilot_0/G1_MUX_POS/a_505_21# v3_four_channel_output_load_integration_0/v3_four_channel_shared_support_integration_0/v3_four_channel_bias_reference_distribution_0/v3_four_channel_phase_distribution_0/v3_four_channel_output_collection_0/v3_four_channel_placement_0/v3_channel_selector_late_promotion_3/group1_bit0 VGND VGND sky130_fd_pr__nfet_01v8 ad=0.1092 pd=1.36 as=0 ps=0 w=0.42 l=0.15
X1111 v3_four_channel_output_load_integration_0/v3_four_channel_shared_support_integration_0/v3_four_channel_bias_reference_distribution_0/v3_four_channel_phase_distribution_0/v3_four_channel_output_collection_0/v3_four_channel_placement_0/v3_channel_selector_late_promotion_3/v3_selector_route_pilot_0/G1_MUX_POS/a_439_47# v3_four_channel_output_load_integration_0/v3_four_channel_shared_support_integration_0/v3_four_channel_bias_reference_distribution_0/v3_four_channel_phase_distribution_0/phase_0 v3_four_channel_output_load_integration_0/v3_four_channel_shared_support_integration_0/v3_four_channel_bias_reference_distribution_0/v3_four_channel_phase_distribution_0/v3_four_channel_output_collection_0/v3_four_channel_placement_0/v3_channel_selector_late_promotion_3/v3_selector_route_pilot_0/G1_MUX_POS/a_76_199# VGND sky130_fd_pr__nfet_01v8 ad=0 pd=0 as=0.1995 ps=1.79 w=0.42 l=0.15
X1112 v3_four_channel_output_load_integration_0/v3_four_channel_shared_support_integration_0/v3_four_channel_bias_reference_distribution_0/v3_four_channel_phase_distribution_0/v3_four_channel_output_collection_0/v3_four_channel_placement_0/v3_channel_selector_late_promotion_3/v3_selector_route_pilot_0/G1_MUX_POS/a_535_374# v3_four_channel_output_load_integration_0/v3_four_channel_shared_support_integration_0/v3_four_channel_bias_reference_distribution_0/v3_four_channel_phase_distribution_0/phase_90 v3_four_channel_output_load_integration_0/v3_four_channel_shared_support_integration_0/v3_four_channel_bias_reference_distribution_0/v3_four_channel_phase_distribution_0/v3_four_channel_output_collection_0/v3_four_channel_placement_0/v3_channel_selector_late_promotion_3/v3_selector_route_pilot_0/G1_MUX_POS/a_76_199# VDPWR sky130_fd_pr__pfet_01v8_hvt ad=0 pd=0 as=0 ps=0 w=0.42 l=0.15
X1113 v3_four_channel_output_load_integration_0/v3_four_channel_shared_support_integration_0/v3_four_channel_bias_reference_distribution_0/v3_four_channel_phase_distribution_0/v3_four_channel_output_collection_0/v3_four_channel_placement_0/v3_channel_selector_late_promotion_3/v3_selector_route_pilot_0/G1_MUX_POS/a_76_199# v3_four_channel_output_load_integration_0/v3_four_channel_shared_support_integration_0/v3_four_channel_bias_reference_distribution_0/v3_four_channel_phase_distribution_0/phase_90 v3_four_channel_output_load_integration_0/v3_four_channel_shared_support_integration_0/v3_four_channel_bias_reference_distribution_0/v3_four_channel_phase_distribution_0/v3_four_channel_output_collection_0/v3_four_channel_placement_0/v3_channel_selector_late_promotion_3/v3_selector_route_pilot_0/G1_MUX_POS/a_218_47# VGND sky130_fd_pr__nfet_01v8 ad=0 pd=0 as=0.1386 ps=1.5 w=0.42 l=0.15
X1114 v3_four_channel_output_load_integration_0/v3_four_channel_shared_support_integration_0/v3_four_channel_bias_reference_distribution_0/v3_four_channel_phase_distribution_0/v3_four_channel_output_collection_0/v3_four_channel_placement_0/v3_channel_selector_late_promotion_3/v3_selector_route_pilot_0/G1_MUX_POS/a_218_47# v3_four_channel_output_load_integration_0/v3_four_channel_shared_support_integration_0/v3_four_channel_bias_reference_distribution_0/v3_four_channel_phase_distribution_0/v3_four_channel_output_collection_0/v3_four_channel_placement_0/v3_channel_selector_late_promotion_3/group1_bit0 VGND VGND sky130_fd_pr__nfet_01v8 ad=0 pd=0 as=0 ps=0 w=0.42 l=0.15
X1115 VDPWR v3_four_channel_output_load_integration_0/v3_four_channel_shared_support_integration_0/v3_four_channel_bias_reference_distribution_0/v3_four_channel_phase_distribution_0/v3_four_channel_output_collection_0/v3_four_channel_placement_0/v3_channel_selector_late_promotion_3/v3_selector_route_pilot_0/G1_MUX_POS/a_76_199# v3_four_channel_output_load_integration_0/v3_four_channel_shared_support_integration_0/v3_four_channel_bias_reference_distribution_0/v3_four_channel_phase_distribution_0/v3_four_channel_output_collection_0/v3_four_channel_placement_0/v3_channel_selector_late_promotion_3/v3_selector_route_pilot_0/G1_MUX_POS/X VDPWR sky130_fd_pr__pfet_01v8_hvt ad=0 pd=0 as=0.26 ps=2.52 w=1 l=0.15
X1116 VGND v3_four_channel_output_load_integration_0/v3_four_channel_shared_support_integration_0/v3_four_channel_bias_reference_distribution_0/v3_four_channel_phase_distribution_0/v3_four_channel_output_collection_0/v3_four_channel_placement_0/v3_channel_selector_late_promotion_3/v3_selector_route_pilot_0/G1_MUX_POS/a_76_199# v3_four_channel_output_load_integration_0/v3_four_channel_shared_support_integration_0/v3_four_channel_bias_reference_distribution_0/v3_four_channel_phase_distribution_0/v3_four_channel_output_collection_0/v3_four_channel_placement_0/v3_channel_selector_late_promotion_3/v3_selector_route_pilot_0/G1_MUX_POS/X VGND sky130_fd_pr__nfet_01v8 ad=0 pd=0 as=0.169 ps=1.82 w=0.65 l=0.15
X1117 VDPWR v3_four_channel_output_load_integration_0/v3_four_channel_shared_support_integration_0/v3_four_channel_bias_reference_distribution_0/v3_four_channel_phase_distribution_0/v3_four_channel_output_collection_0/v3_four_channel_placement_0/v3_channel_selector_late_promotion_3/v3_selector_route_pilot_0/G3_MUX_AXIS/a_505_21# v3_four_channel_output_load_integration_0/v3_four_channel_shared_support_integration_0/v3_four_channel_bias_reference_distribution_0/v3_four_channel_phase_distribution_0/v3_four_channel_output_collection_0/v3_four_channel_placement_0/v3_channel_selector_late_promotion_3/v3_selector_route_pilot_0/G3_MUX_AXIS/a_535_374# VDPWR sky130_fd_pr__pfet_01v8_hvt ad=0 pd=0 as=0.0882 ps=1.26 w=0.42 l=0.15
X1118 v3_four_channel_output_load_integration_0/v3_four_channel_shared_support_integration_0/v3_four_channel_bias_reference_distribution_0/v3_four_channel_phase_distribution_0/v3_four_channel_output_collection_0/v3_four_channel_placement_0/v3_channel_selector_late_promotion_3/v3_selector_route_pilot_0/G3_MUX_AXIS/a_505_21# v3_four_channel_output_load_integration_0/v3_four_channel_shared_support_integration_0/v3_four_channel_bias_reference_distribution_0/v3_four_channel_phase_distribution_0/v3_four_channel_output_collection_0/v3_four_channel_placement_0/v3_channel_selector_late_promotion_3/group3_bit1 VDPWR VDPWR sky130_fd_pr__pfet_01v8_hvt ad=0.1176 pd=1.4 as=0 ps=0 w=0.42 l=0.15
X1119 v3_four_channel_output_load_integration_0/v3_four_channel_shared_support_integration_0/v3_four_channel_bias_reference_distribution_0/v3_four_channel_phase_distribution_0/v3_four_channel_output_collection_0/v3_four_channel_placement_0/v3_channel_selector_late_promotion_3/v3_selector_route_pilot_0/G3_MUX_AXIS/a_218_374# v3_four_channel_output_load_integration_0/v3_four_channel_shared_support_integration_0/v3_four_channel_bias_reference_distribution_0/v3_four_channel_phase_distribution_0/v3_four_channel_output_collection_0/v3_four_channel_placement_0/v3_channel_selector_late_promotion_3/group3_bit1 VDPWR VDPWR sky130_fd_pr__pfet_01v8_hvt ad=0.1533 pd=1.57 as=0 ps=0 w=0.42 l=0.15
X1120 VGND v3_four_channel_output_load_integration_0/v3_four_channel_shared_support_integration_0/v3_four_channel_bias_reference_distribution_0/v3_four_channel_phase_distribution_0/v3_four_channel_output_collection_0/v3_four_channel_placement_0/v3_channel_selector_late_promotion_3/v3_selector_route_pilot_0/G3_MUX_AXIS/a_505_21# v3_four_channel_output_load_integration_0/v3_four_channel_shared_support_integration_0/v3_four_channel_bias_reference_distribution_0/v3_four_channel_phase_distribution_0/v3_four_channel_output_collection_0/v3_four_channel_placement_0/v3_channel_selector_late_promotion_3/v3_selector_route_pilot_0/G3_MUX_AXIS/a_439_47# VGND sky130_fd_pr__nfet_01v8 ad=0 pd=0 as=0.1386 ps=1.5 w=0.42 l=0.15
X1121 v3_four_channel_output_load_integration_0/v3_four_channel_shared_support_integration_0/v3_four_channel_bias_reference_distribution_0/v3_four_channel_phase_distribution_0/v3_four_channel_output_collection_0/v3_four_channel_placement_0/v3_channel_selector_late_promotion_3/v3_selector_route_pilot_0/G3_MUX_AXIS/a_76_199# v3_four_channel_output_load_integration_0/v3_four_channel_shared_support_integration_0/v3_four_channel_bias_reference_distribution_0/v3_four_channel_phase_distribution_0/v3_four_channel_output_collection_0/v3_four_channel_placement_0/v3_channel_selector_late_promotion_3/v3_selector_route_pilot_0/G3_MUX_POS/X v3_four_channel_output_load_integration_0/v3_four_channel_shared_support_integration_0/v3_four_channel_bias_reference_distribution_0/v3_four_channel_phase_distribution_0/v3_four_channel_output_collection_0/v3_four_channel_placement_0/v3_channel_selector_late_promotion_3/v3_selector_route_pilot_0/G3_MUX_AXIS/a_218_374# VDPWR sky130_fd_pr__pfet_01v8_hvt ad=0.3864 pd=2.68 as=0 ps=0 w=0.42 l=0.15
X1122 v3_four_channel_output_load_integration_0/v3_four_channel_shared_support_integration_0/v3_four_channel_bias_reference_distribution_0/v3_four_channel_phase_distribution_0/v3_four_channel_output_collection_0/v3_four_channel_placement_0/v3_channel_selector_late_promotion_3/v3_selector_route_pilot_0/G3_MUX_AXIS/a_505_21# v3_four_channel_output_load_integration_0/v3_four_channel_shared_support_integration_0/v3_four_channel_bias_reference_distribution_0/v3_four_channel_phase_distribution_0/v3_four_channel_output_collection_0/v3_four_channel_placement_0/v3_channel_selector_late_promotion_3/group3_bit1 VGND VGND sky130_fd_pr__nfet_01v8 ad=0.1092 pd=1.36 as=0 ps=0 w=0.42 l=0.15
X1123 v3_four_channel_output_load_integration_0/v3_four_channel_shared_support_integration_0/v3_four_channel_bias_reference_distribution_0/v3_four_channel_phase_distribution_0/v3_four_channel_output_collection_0/v3_four_channel_placement_0/v3_channel_selector_late_promotion_3/v3_selector_route_pilot_0/G3_MUX_AXIS/a_439_47# v3_four_channel_output_load_integration_0/v3_four_channel_shared_support_integration_0/v3_four_channel_bias_reference_distribution_0/v3_four_channel_phase_distribution_0/v3_four_channel_output_collection_0/v3_four_channel_placement_0/v3_channel_selector_late_promotion_3/v3_selector_route_pilot_0/G3_MUX_POS/X v3_four_channel_output_load_integration_0/v3_four_channel_shared_support_integration_0/v3_four_channel_bias_reference_distribution_0/v3_four_channel_phase_distribution_0/v3_four_channel_output_collection_0/v3_four_channel_placement_0/v3_channel_selector_late_promotion_3/v3_selector_route_pilot_0/G3_MUX_AXIS/a_76_199# VGND sky130_fd_pr__nfet_01v8 ad=0 pd=0 as=0.1995 ps=1.79 w=0.42 l=0.15
X1124 v3_four_channel_output_load_integration_0/v3_four_channel_shared_support_integration_0/v3_four_channel_bias_reference_distribution_0/v3_four_channel_phase_distribution_0/v3_four_channel_output_collection_0/v3_four_channel_placement_0/v3_channel_selector_late_promotion_3/v3_selector_route_pilot_0/G3_MUX_AXIS/a_535_374# v3_four_channel_output_load_integration_0/v3_four_channel_shared_support_integration_0/v3_four_channel_bias_reference_distribution_0/v3_four_channel_phase_distribution_0/v3_four_channel_output_collection_0/v3_four_channel_placement_0/v3_channel_selector_late_promotion_3/v3_selector_route_pilot_0/G3_MUX_NEG/X v3_four_channel_output_load_integration_0/v3_four_channel_shared_support_integration_0/v3_four_channel_bias_reference_distribution_0/v3_four_channel_phase_distribution_0/v3_four_channel_output_collection_0/v3_four_channel_placement_0/v3_channel_selector_late_promotion_3/v3_selector_route_pilot_0/G3_MUX_AXIS/a_76_199# VDPWR sky130_fd_pr__pfet_01v8_hvt ad=0 pd=0 as=0 ps=0 w=0.42 l=0.15
X1125 v3_four_channel_output_load_integration_0/v3_four_channel_shared_support_integration_0/v3_four_channel_bias_reference_distribution_0/v3_four_channel_phase_distribution_0/v3_four_channel_output_collection_0/v3_four_channel_placement_0/v3_channel_selector_late_promotion_3/v3_selector_route_pilot_0/G3_MUX_AXIS/a_76_199# v3_four_channel_output_load_integration_0/v3_four_channel_shared_support_integration_0/v3_four_channel_bias_reference_distribution_0/v3_four_channel_phase_distribution_0/v3_four_channel_output_collection_0/v3_four_channel_placement_0/v3_channel_selector_late_promotion_3/v3_selector_route_pilot_0/G3_MUX_NEG/X v3_four_channel_output_load_integration_0/v3_four_channel_shared_support_integration_0/v3_four_channel_bias_reference_distribution_0/v3_four_channel_phase_distribution_0/v3_four_channel_output_collection_0/v3_four_channel_placement_0/v3_channel_selector_late_promotion_3/v3_selector_route_pilot_0/G3_MUX_AXIS/a_218_47# VGND sky130_fd_pr__nfet_01v8 ad=0 pd=0 as=0.1386 ps=1.5 w=0.42 l=0.15
X1126 v3_four_channel_output_load_integration_0/v3_four_channel_shared_support_integration_0/v3_four_channel_bias_reference_distribution_0/v3_four_channel_phase_distribution_0/v3_four_channel_output_collection_0/v3_four_channel_placement_0/v3_channel_selector_late_promotion_3/v3_selector_route_pilot_0/G3_MUX_AXIS/a_218_47# v3_four_channel_output_load_integration_0/v3_four_channel_shared_support_integration_0/v3_four_channel_bias_reference_distribution_0/v3_four_channel_phase_distribution_0/v3_four_channel_output_collection_0/v3_four_channel_placement_0/v3_channel_selector_late_promotion_3/group3_bit1 VGND VGND sky130_fd_pr__nfet_01v8 ad=0 pd=0 as=0 ps=0 w=0.42 l=0.15
X1127 VDPWR v3_four_channel_output_load_integration_0/v3_four_channel_shared_support_integration_0/v3_four_channel_bias_reference_distribution_0/v3_four_channel_phase_distribution_0/v3_four_channel_output_collection_0/v3_four_channel_placement_0/v3_channel_selector_late_promotion_3/v3_selector_route_pilot_0/G3_MUX_AXIS/a_76_199# v3_four_channel_output_load_integration_0/v3_four_channel_shared_support_integration_0/v3_four_channel_bias_reference_distribution_0/v3_four_channel_phase_distribution_0/v3_four_channel_output_collection_0/v3_four_channel_placement_0/v3_channel_selector_late_promotion_3/v3_selector_route_pilot_0/G3_MUX_AXIS/X VDPWR sky130_fd_pr__pfet_01v8_hvt ad=0 pd=0 as=0.26 ps=2.52 w=1 l=0.15
X1128 VGND v3_four_channel_output_load_integration_0/v3_four_channel_shared_support_integration_0/v3_four_channel_bias_reference_distribution_0/v3_four_channel_phase_distribution_0/v3_four_channel_output_collection_0/v3_four_channel_placement_0/v3_channel_selector_late_promotion_3/v3_selector_route_pilot_0/G3_MUX_AXIS/a_76_199# v3_four_channel_output_load_integration_0/v3_four_channel_shared_support_integration_0/v3_four_channel_bias_reference_distribution_0/v3_four_channel_phase_distribution_0/v3_four_channel_output_collection_0/v3_four_channel_placement_0/v3_channel_selector_late_promotion_3/v3_selector_route_pilot_0/G3_MUX_AXIS/X VGND sky130_fd_pr__nfet_01v8 ad=0 pd=0 as=0.169 ps=1.82 w=0.65 l=0.15
X1129 VDPWR v3_four_channel_output_load_integration_0/v3_four_channel_shared_support_integration_0/v3_four_channel_bias_reference_distribution_0/v3_four_channel_phase_distribution_0/v3_four_channel_output_collection_0/v3_four_channel_placement_0/v3_channel_selector_late_promotion_3/channel_enable v3_four_channel_output_load_integration_0/v3_four_channel_shared_support_integration_0/v3_four_channel_bias_reference_distribution_0/v3_four_channel_phase_distribution_0/v3_four_channel_output_collection_0/v3_four_channel_placement_0/v3_channel_selector_late_promotion_3/v3_selector_route_pilot_0/ENABLE_ANDNOT/a_207_413# VDPWR sky130_fd_pr__pfet_01v8_hvt ad=0 pd=0 as=0.1218 ps=1.42 w=0.42 l=0.15
X1130 v3_four_channel_output_load_integration_0/v3_four_channel_shared_support_integration_0/v3_four_channel_bias_reference_distribution_0/v3_four_channel_phase_distribution_0/v3_four_channel_output_collection_0/v3_four_channel_placement_0/v3_channel_selector_late_promotion_3/v3_selector_route_pilot_0/G3_LO_P_AND/B v3_four_channel_output_load_integration_0/v3_four_channel_shared_support_integration_0/v3_four_channel_bias_reference_distribution_0/v3_four_channel_phase_distribution_0/v3_four_channel_output_collection_0/v3_four_channel_placement_0/v3_channel_selector_late_promotion_3/v3_selector_route_pilot_0/ENABLE_ANDNOT/a_207_413# VDPWR VDPWR sky130_fd_pr__pfet_01v8_hvt ad=0.26 pd=2.52 as=0 ps=0 w=1 l=0.15
X1131 v3_four_channel_output_load_integration_0/v3_four_channel_shared_support_integration_0/v3_four_channel_bias_reference_distribution_0/v3_four_channel_phase_distribution_0/v3_four_channel_output_collection_0/v3_four_channel_placement_0/v3_channel_selector_late_promotion_3/v3_selector_route_pilot_0/ENABLE_ANDNOT/a_297_47# v3_four_channel_output_load_integration_0/v3_four_channel_shared_support_integration_0/v3_four_channel_bias_reference_distribution_0/v3_four_channel_phase_distribution_0/v3_four_channel_output_collection_0/v3_four_channel_placement_0/v3_channel_selector_late_promotion_3/v3_selector_route_pilot_0/ENABLE_ANDNOT/a_27_413# v3_four_channel_output_load_integration_0/v3_four_channel_shared_support_integration_0/v3_four_channel_bias_reference_distribution_0/v3_four_channel_phase_distribution_0/v3_four_channel_output_collection_0/v3_four_channel_placement_0/v3_channel_selector_late_promotion_3/v3_selector_route_pilot_0/ENABLE_ANDNOT/a_207_413# VGND sky130_fd_pr__nfet_01v8 ad=0.1008 pd=1.32 as=0.1092 ps=1.36 w=0.42 l=0.15
X1132 v3_four_channel_output_load_integration_0/v3_four_channel_shared_support_integration_0/v3_four_channel_bias_reference_distribution_0/v3_four_channel_phase_distribution_0/v3_four_channel_output_collection_0/v3_four_channel_placement_0/v3_channel_selector_late_promotion_3/v3_selector_route_pilot_0/G3_LO_P_AND/B v3_four_channel_output_load_integration_0/v3_four_channel_shared_support_integration_0/v3_four_channel_bias_reference_distribution_0/v3_four_channel_phase_distribution_0/v3_four_channel_output_collection_0/v3_four_channel_placement_0/v3_channel_selector_late_promotion_3/v3_selector_route_pilot_0/ENABLE_ANDNOT/a_207_413# VGND VGND sky130_fd_pr__nfet_01v8 ad=0.169 pd=1.82 as=0 ps=0 w=0.65 l=0.15
X1133 v3_four_channel_output_load_integration_0/v3_four_channel_shared_support_integration_0/v3_four_channel_bias_reference_distribution_0/v3_four_channel_phase_distribution_0/v3_four_channel_output_collection_0/v3_four_channel_placement_0/v3_channel_selector_late_promotion_3/v3_selector_route_pilot_0/ENABLE_ANDNOT/a_207_413# v3_four_channel_output_load_integration_0/v3_four_channel_shared_support_integration_0/v3_four_channel_bias_reference_distribution_0/v3_four_channel_phase_distribution_0/v3_four_channel_output_collection_0/v3_four_channel_placement_0/v3_channel_selector_late_promotion_3/v3_selector_route_pilot_0/ENABLE_ANDNOT/a_27_413# VDPWR VDPWR sky130_fd_pr__pfet_01v8_hvt ad=0 pd=0 as=0 ps=0 w=0.42 l=0.15
X1134 VDPWR v3_four_channel_output_load_integration_0/v3_four_channel_shared_support_integration_0/v3_four_channel_bias_reference_distribution_0/v3_four_channel_phase_distribution_0/v3_four_channel_output_collection_0/v3_four_channel_placement_0/v3_channel_selector_late_promotion_3/mixers_blank v3_four_channel_output_load_integration_0/v3_four_channel_shared_support_integration_0/v3_four_channel_bias_reference_distribution_0/v3_four_channel_phase_distribution_0/v3_four_channel_output_collection_0/v3_four_channel_placement_0/v3_channel_selector_late_promotion_3/v3_selector_route_pilot_0/ENABLE_ANDNOT/a_27_413# VDPWR sky130_fd_pr__pfet_01v8_hvt ad=0 pd=0 as=0.1092 ps=1.36 w=0.42 l=0.15
X1135 VGND v3_four_channel_output_load_integration_0/v3_four_channel_shared_support_integration_0/v3_four_channel_bias_reference_distribution_0/v3_four_channel_phase_distribution_0/v3_four_channel_output_collection_0/v3_four_channel_placement_0/v3_channel_selector_late_promotion_3/channel_enable v3_four_channel_output_load_integration_0/v3_four_channel_shared_support_integration_0/v3_four_channel_bias_reference_distribution_0/v3_four_channel_phase_distribution_0/v3_four_channel_output_collection_0/v3_four_channel_placement_0/v3_channel_selector_late_promotion_3/v3_selector_route_pilot_0/ENABLE_ANDNOT/a_297_47# VGND sky130_fd_pr__nfet_01v8 ad=0 pd=0 as=0 ps=0 w=0.42 l=0.15
X1136 v3_four_channel_output_load_integration_0/v3_four_channel_shared_support_integration_0/v3_four_channel_bias_reference_distribution_0/v3_four_channel_phase_distribution_0/v3_four_channel_output_collection_0/v3_four_channel_placement_0/v3_channel_selector_late_promotion_3/v3_selector_route_pilot_0/ENABLE_ANDNOT/a_27_413# v3_four_channel_output_load_integration_0/v3_four_channel_shared_support_integration_0/v3_four_channel_bias_reference_distribution_0/v3_four_channel_phase_distribution_0/v3_four_channel_output_collection_0/v3_four_channel_placement_0/v3_channel_selector_late_promotion_3/mixers_blank VGND VGND sky130_fd_pr__nfet_01v8 ad=0.1092 pd=1.36 as=0 ps=0 w=0.42 l=0.15
X1137 VDPWR v3_four_channel_output_load_integration_0/v3_four_channel_shared_support_integration_0/v3_four_channel_bias_reference_distribution_0/v3_four_channel_phase_distribution_0/v3_four_channel_output_collection_0/v3_four_channel_placement_0/v3_channel_selector_late_promotion_3/v3_selector_route_pilot_0/G1_MUX_NEG/a_505_21# v3_four_channel_output_load_integration_0/v3_four_channel_shared_support_integration_0/v3_four_channel_bias_reference_distribution_0/v3_four_channel_phase_distribution_0/v3_four_channel_output_collection_0/v3_four_channel_placement_0/v3_channel_selector_late_promotion_3/v3_selector_route_pilot_0/G1_MUX_NEG/a_535_374# VDPWR sky130_fd_pr__pfet_01v8_hvt ad=0 pd=0 as=0.0882 ps=1.26 w=0.42 l=0.15
X1138 v3_four_channel_output_load_integration_0/v3_four_channel_shared_support_integration_0/v3_four_channel_bias_reference_distribution_0/v3_four_channel_phase_distribution_0/v3_four_channel_output_collection_0/v3_four_channel_placement_0/v3_channel_selector_late_promotion_3/v3_selector_route_pilot_0/G1_MUX_NEG/a_505_21# v3_four_channel_output_load_integration_0/v3_four_channel_shared_support_integration_0/v3_four_channel_bias_reference_distribution_0/v3_four_channel_phase_distribution_0/v3_four_channel_output_collection_0/v3_four_channel_placement_0/v3_channel_selector_late_promotion_3/group1_bit0 VDPWR VDPWR sky130_fd_pr__pfet_01v8_hvt ad=0.1176 pd=1.4 as=0 ps=0 w=0.42 l=0.15
X1139 v3_four_channel_output_load_integration_0/v3_four_channel_shared_support_integration_0/v3_four_channel_bias_reference_distribution_0/v3_four_channel_phase_distribution_0/v3_four_channel_output_collection_0/v3_four_channel_placement_0/v3_channel_selector_late_promotion_3/v3_selector_route_pilot_0/G1_MUX_NEG/a_218_374# v3_four_channel_output_load_integration_0/v3_four_channel_shared_support_integration_0/v3_four_channel_bias_reference_distribution_0/v3_four_channel_phase_distribution_0/v3_four_channel_output_collection_0/v3_four_channel_placement_0/v3_channel_selector_late_promotion_3/group1_bit0 VDPWR VDPWR sky130_fd_pr__pfet_01v8_hvt ad=0.1533 pd=1.57 as=0 ps=0 w=0.42 l=0.15
X1140 VGND v3_four_channel_output_load_integration_0/v3_four_channel_shared_support_integration_0/v3_four_channel_bias_reference_distribution_0/v3_four_channel_phase_distribution_0/v3_four_channel_output_collection_0/v3_four_channel_placement_0/v3_channel_selector_late_promotion_3/v3_selector_route_pilot_0/G1_MUX_NEG/a_505_21# v3_four_channel_output_load_integration_0/v3_four_channel_shared_support_integration_0/v3_four_channel_bias_reference_distribution_0/v3_four_channel_phase_distribution_0/v3_four_channel_output_collection_0/v3_four_channel_placement_0/v3_channel_selector_late_promotion_3/v3_selector_route_pilot_0/G1_MUX_NEG/a_439_47# VGND sky130_fd_pr__nfet_01v8 ad=0 pd=0 as=0.1386 ps=1.5 w=0.42 l=0.15
X1141 v3_four_channel_output_load_integration_0/v3_four_channel_shared_support_integration_0/v3_four_channel_bias_reference_distribution_0/v3_four_channel_phase_distribution_0/v3_four_channel_output_collection_0/v3_four_channel_placement_0/v3_channel_selector_late_promotion_3/v3_selector_route_pilot_0/G1_MUX_NEG/a_76_199# v3_four_channel_output_load_integration_0/v3_four_channel_shared_support_integration_0/v3_four_channel_bias_reference_distribution_0/v3_four_channel_phase_distribution_0/phase_180 v3_four_channel_output_load_integration_0/v3_four_channel_shared_support_integration_0/v3_four_channel_bias_reference_distribution_0/v3_four_channel_phase_distribution_0/v3_four_channel_output_collection_0/v3_four_channel_placement_0/v3_channel_selector_late_promotion_3/v3_selector_route_pilot_0/G1_MUX_NEG/a_218_374# VDPWR sky130_fd_pr__pfet_01v8_hvt ad=0.3864 pd=2.68 as=0 ps=0 w=0.42 l=0.15
X1142 v3_four_channel_output_load_integration_0/v3_four_channel_shared_support_integration_0/v3_four_channel_bias_reference_distribution_0/v3_four_channel_phase_distribution_0/v3_four_channel_output_collection_0/v3_four_channel_placement_0/v3_channel_selector_late_promotion_3/v3_selector_route_pilot_0/G1_MUX_NEG/a_505_21# v3_four_channel_output_load_integration_0/v3_four_channel_shared_support_integration_0/v3_four_channel_bias_reference_distribution_0/v3_four_channel_phase_distribution_0/v3_four_channel_output_collection_0/v3_four_channel_placement_0/v3_channel_selector_late_promotion_3/group1_bit0 VGND VGND sky130_fd_pr__nfet_01v8 ad=0.1092 pd=1.36 as=0 ps=0 w=0.42 l=0.15
X1143 v3_four_channel_output_load_integration_0/v3_four_channel_shared_support_integration_0/v3_four_channel_bias_reference_distribution_0/v3_four_channel_phase_distribution_0/v3_four_channel_output_collection_0/v3_four_channel_placement_0/v3_channel_selector_late_promotion_3/v3_selector_route_pilot_0/G1_MUX_NEG/a_439_47# v3_four_channel_output_load_integration_0/v3_four_channel_shared_support_integration_0/v3_four_channel_bias_reference_distribution_0/v3_four_channel_phase_distribution_0/phase_180 v3_four_channel_output_load_integration_0/v3_four_channel_shared_support_integration_0/v3_four_channel_bias_reference_distribution_0/v3_four_channel_phase_distribution_0/v3_four_channel_output_collection_0/v3_four_channel_placement_0/v3_channel_selector_late_promotion_3/v3_selector_route_pilot_0/G1_MUX_NEG/a_76_199# VGND sky130_fd_pr__nfet_01v8 ad=0 pd=0 as=0.1995 ps=1.79 w=0.42 l=0.15
X1144 v3_four_channel_output_load_integration_0/v3_four_channel_shared_support_integration_0/v3_four_channel_bias_reference_distribution_0/v3_four_channel_phase_distribution_0/v3_four_channel_output_collection_0/v3_four_channel_placement_0/v3_channel_selector_late_promotion_3/v3_selector_route_pilot_0/G1_MUX_NEG/a_535_374# v3_four_channel_output_load_integration_0/v3_four_channel_shared_support_integration_0/v3_four_channel_bias_reference_distribution_0/v3_four_channel_phase_distribution_0/phase_270 v3_four_channel_output_load_integration_0/v3_four_channel_shared_support_integration_0/v3_four_channel_bias_reference_distribution_0/v3_four_channel_phase_distribution_0/v3_four_channel_output_collection_0/v3_four_channel_placement_0/v3_channel_selector_late_promotion_3/v3_selector_route_pilot_0/G1_MUX_NEG/a_76_199# VDPWR sky130_fd_pr__pfet_01v8_hvt ad=0 pd=0 as=0 ps=0 w=0.42 l=0.15
X1145 v3_four_channel_output_load_integration_0/v3_four_channel_shared_support_integration_0/v3_four_channel_bias_reference_distribution_0/v3_four_channel_phase_distribution_0/v3_four_channel_output_collection_0/v3_four_channel_placement_0/v3_channel_selector_late_promotion_3/v3_selector_route_pilot_0/G1_MUX_NEG/a_76_199# v3_four_channel_output_load_integration_0/v3_four_channel_shared_support_integration_0/v3_four_channel_bias_reference_distribution_0/v3_four_channel_phase_distribution_0/phase_270 v3_four_channel_output_load_integration_0/v3_four_channel_shared_support_integration_0/v3_four_channel_bias_reference_distribution_0/v3_four_channel_phase_distribution_0/v3_four_channel_output_collection_0/v3_four_channel_placement_0/v3_channel_selector_late_promotion_3/v3_selector_route_pilot_0/G1_MUX_NEG/a_218_47# VGND sky130_fd_pr__nfet_01v8 ad=0 pd=0 as=0.1386 ps=1.5 w=0.42 l=0.15
X1146 v3_four_channel_output_load_integration_0/v3_four_channel_shared_support_integration_0/v3_four_channel_bias_reference_distribution_0/v3_four_channel_phase_distribution_0/v3_four_channel_output_collection_0/v3_four_channel_placement_0/v3_channel_selector_late_promotion_3/v3_selector_route_pilot_0/G1_MUX_NEG/a_218_47# v3_four_channel_output_load_integration_0/v3_four_channel_shared_support_integration_0/v3_four_channel_bias_reference_distribution_0/v3_four_channel_phase_distribution_0/v3_four_channel_output_collection_0/v3_four_channel_placement_0/v3_channel_selector_late_promotion_3/group1_bit0 VGND VGND sky130_fd_pr__nfet_01v8 ad=0 pd=0 as=0 ps=0 w=0.42 l=0.15
X1147 VDPWR v3_four_channel_output_load_integration_0/v3_four_channel_shared_support_integration_0/v3_four_channel_bias_reference_distribution_0/v3_four_channel_phase_distribution_0/v3_four_channel_output_collection_0/v3_four_channel_placement_0/v3_channel_selector_late_promotion_3/v3_selector_route_pilot_0/G1_MUX_NEG/a_76_199# v3_four_channel_output_load_integration_0/v3_four_channel_shared_support_integration_0/v3_four_channel_bias_reference_distribution_0/v3_four_channel_phase_distribution_0/v3_four_channel_output_collection_0/v3_four_channel_placement_0/v3_channel_selector_late_promotion_3/v3_selector_route_pilot_0/G1_MUX_NEG/X VDPWR sky130_fd_pr__pfet_01v8_hvt ad=0 pd=0 as=0.26 ps=2.52 w=1 l=0.15
X1148 VGND v3_four_channel_output_load_integration_0/v3_four_channel_shared_support_integration_0/v3_four_channel_bias_reference_distribution_0/v3_four_channel_phase_distribution_0/v3_four_channel_output_collection_0/v3_four_channel_placement_0/v3_channel_selector_late_promotion_3/v3_selector_route_pilot_0/G1_MUX_NEG/a_76_199# v3_four_channel_output_load_integration_0/v3_four_channel_shared_support_integration_0/v3_four_channel_bias_reference_distribution_0/v3_four_channel_phase_distribution_0/v3_four_channel_output_collection_0/v3_four_channel_placement_0/v3_channel_selector_late_promotion_3/v3_selector_route_pilot_0/G1_MUX_NEG/X VGND sky130_fd_pr__nfet_01v8 ad=0 pd=0 as=0.169 ps=1.82 w=0.65 l=0.15
X1149 VDPWR v3_four_channel_output_load_integration_0/v3_four_channel_shared_support_integration_0/v3_four_channel_bias_reference_distribution_0/v3_four_channel_phase_distribution_0/v3_four_channel_output_collection_0/v3_four_channel_placement_0/v3_channel_selector_late_promotion_3/v3_selector_route_pilot_0/G3_LO_P_AND/B v3_four_channel_output_load_integration_0/v3_four_channel_shared_support_integration_0/v3_four_channel_bias_reference_distribution_0/v3_four_channel_phase_distribution_0/v3_four_channel_output_collection_0/v3_four_channel_placement_0/v3_channel_selector_late_promotion_3/v3_selector_route_pilot_0/G1_LO_P_AND/a_59_75# VDPWR sky130_fd_pr__pfet_01v8_hvt ad=0 pd=0 as=0.1134 ps=1.38 w=0.42 l=0.15
X1150 v3_four_channel_output_load_integration_0/v3_four_channel_shared_support_integration_0/v3_four_channel_bias_reference_distribution_0/v3_four_channel_phase_distribution_0/v3_four_channel_output_collection_0/v3_four_channel_placement_0/v3_channel_selector_late_promotion_3/v3_selector_route_pilot_0/group1_lo_p v3_four_channel_output_load_integration_0/v3_four_channel_shared_support_integration_0/v3_four_channel_bias_reference_distribution_0/v3_four_channel_phase_distribution_0/v3_four_channel_output_collection_0/v3_four_channel_placement_0/v3_channel_selector_late_promotion_3/v3_selector_route_pilot_0/G1_LO_P_AND/a_59_75# VDPWR VDPWR sky130_fd_pr__pfet_01v8_hvt ad=0.475 pd=2.95 as=0 ps=0 w=1 l=0.15
X1151 VGND v3_four_channel_output_load_integration_0/v3_four_channel_shared_support_integration_0/v3_four_channel_bias_reference_distribution_0/v3_four_channel_phase_distribution_0/v3_four_channel_output_collection_0/v3_four_channel_placement_0/v3_channel_selector_late_promotion_3/v3_selector_route_pilot_0/G3_LO_P_AND/B v3_four_channel_output_load_integration_0/v3_four_channel_shared_support_integration_0/v3_four_channel_bias_reference_distribution_0/v3_four_channel_phase_distribution_0/v3_four_channel_output_collection_0/v3_four_channel_placement_0/v3_channel_selector_late_promotion_3/v3_selector_route_pilot_0/G1_LO_P_AND/a_145_75# VGND sky130_fd_pr__nfet_01v8 ad=0 pd=0 as=0.1134 ps=1.38 w=0.42 l=0.15
X1152 v3_four_channel_output_load_integration_0/v3_four_channel_shared_support_integration_0/v3_four_channel_bias_reference_distribution_0/v3_four_channel_phase_distribution_0/v3_four_channel_output_collection_0/v3_four_channel_placement_0/v3_channel_selector_late_promotion_3/v3_selector_route_pilot_0/G1_LO_P_AND/a_59_75# v3_four_channel_output_load_integration_0/v3_four_channel_shared_support_integration_0/v3_four_channel_bias_reference_distribution_0/v3_four_channel_phase_distribution_0/v3_four_channel_output_collection_0/v3_four_channel_placement_0/v3_channel_selector_late_promotion_3/v3_selector_route_pilot_0/G1_MUX_AXIS/X VDPWR VDPWR sky130_fd_pr__pfet_01v8_hvt ad=0 pd=0 as=0 ps=0 w=0.42 l=0.15
X1153 v3_four_channel_output_load_integration_0/v3_four_channel_shared_support_integration_0/v3_four_channel_bias_reference_distribution_0/v3_four_channel_phase_distribution_0/v3_four_channel_output_collection_0/v3_four_channel_placement_0/v3_channel_selector_late_promotion_3/v3_selector_route_pilot_0/group1_lo_p v3_four_channel_output_load_integration_0/v3_four_channel_shared_support_integration_0/v3_four_channel_bias_reference_distribution_0/v3_four_channel_phase_distribution_0/v3_four_channel_output_collection_0/v3_four_channel_placement_0/v3_channel_selector_late_promotion_3/v3_selector_route_pilot_0/G1_LO_P_AND/a_59_75# VGND VGND sky130_fd_pr__nfet_01v8 ad=0.182 pd=1.86 as=0 ps=0 w=0.65 l=0.15
X1154 v3_four_channel_output_load_integration_0/v3_four_channel_shared_support_integration_0/v3_four_channel_bias_reference_distribution_0/v3_four_channel_phase_distribution_0/v3_four_channel_output_collection_0/v3_four_channel_placement_0/v3_channel_selector_late_promotion_3/v3_selector_route_pilot_0/G1_LO_P_AND/a_145_75# v3_four_channel_output_load_integration_0/v3_four_channel_shared_support_integration_0/v3_four_channel_bias_reference_distribution_0/v3_four_channel_phase_distribution_0/v3_four_channel_output_collection_0/v3_four_channel_placement_0/v3_channel_selector_late_promotion_3/v3_selector_route_pilot_0/G1_MUX_AXIS/X v3_four_channel_output_load_integration_0/v3_four_channel_shared_support_integration_0/v3_four_channel_bias_reference_distribution_0/v3_four_channel_phase_distribution_0/v3_four_channel_output_collection_0/v3_four_channel_placement_0/v3_channel_selector_late_promotion_3/v3_selector_route_pilot_0/G1_LO_P_AND/a_59_75# VGND sky130_fd_pr__nfet_01v8 ad=0 pd=0 as=0.1176 ps=1.4 w=0.42 l=0.15
X1155 VDPWR v3_four_channel_output_load_integration_0/v3_four_channel_shared_support_integration_0/v3_four_channel_bias_reference_distribution_0/v3_four_channel_phase_distribution_0/v3_four_channel_output_collection_0/v3_four_channel_placement_0/v3_channel_selector_late_promotion_3/v3_selector_route_pilot_0/G0_MUX_POS/a_505_21# v3_four_channel_output_load_integration_0/v3_four_channel_shared_support_integration_0/v3_four_channel_bias_reference_distribution_0/v3_four_channel_phase_distribution_0/v3_four_channel_output_collection_0/v3_four_channel_placement_0/v3_channel_selector_late_promotion_3/v3_selector_route_pilot_0/G0_MUX_POS/a_535_374# VDPWR sky130_fd_pr__pfet_01v8_hvt ad=0 pd=0 as=0.0882 ps=1.26 w=0.42 l=0.15
X1156 v3_four_channel_output_load_integration_0/v3_four_channel_shared_support_integration_0/v3_four_channel_bias_reference_distribution_0/v3_four_channel_phase_distribution_0/v3_four_channel_output_collection_0/v3_four_channel_placement_0/v3_channel_selector_late_promotion_3/v3_selector_route_pilot_0/G0_MUX_POS/a_505_21# v3_four_channel_output_load_integration_0/v3_four_channel_shared_support_integration_0/v3_four_channel_bias_reference_distribution_0/v3_four_channel_phase_distribution_0/v3_four_channel_output_collection_0/v3_four_channel_placement_0/v3_channel_selector_late_promotion_3/group0_bit0 VDPWR VDPWR sky130_fd_pr__pfet_01v8_hvt ad=0.1176 pd=1.4 as=0 ps=0 w=0.42 l=0.15
X1157 v3_four_channel_output_load_integration_0/v3_four_channel_shared_support_integration_0/v3_four_channel_bias_reference_distribution_0/v3_four_channel_phase_distribution_0/v3_four_channel_output_collection_0/v3_four_channel_placement_0/v3_channel_selector_late_promotion_3/v3_selector_route_pilot_0/G0_MUX_POS/a_218_374# v3_four_channel_output_load_integration_0/v3_four_channel_shared_support_integration_0/v3_four_channel_bias_reference_distribution_0/v3_four_channel_phase_distribution_0/v3_four_channel_output_collection_0/v3_four_channel_placement_0/v3_channel_selector_late_promotion_3/group0_bit0 VDPWR VDPWR sky130_fd_pr__pfet_01v8_hvt ad=0.1533 pd=1.57 as=0 ps=0 w=0.42 l=0.15
X1158 VGND v3_four_channel_output_load_integration_0/v3_four_channel_shared_support_integration_0/v3_four_channel_bias_reference_distribution_0/v3_four_channel_phase_distribution_0/v3_four_channel_output_collection_0/v3_four_channel_placement_0/v3_channel_selector_late_promotion_3/v3_selector_route_pilot_0/G0_MUX_POS/a_505_21# v3_four_channel_output_load_integration_0/v3_four_channel_shared_support_integration_0/v3_four_channel_bias_reference_distribution_0/v3_four_channel_phase_distribution_0/v3_four_channel_output_collection_0/v3_four_channel_placement_0/v3_channel_selector_late_promotion_3/v3_selector_route_pilot_0/G0_MUX_POS/a_439_47# VGND sky130_fd_pr__nfet_01v8 ad=0 pd=0 as=0.1386 ps=1.5 w=0.42 l=0.15
X1159 v3_four_channel_output_load_integration_0/v3_four_channel_shared_support_integration_0/v3_four_channel_bias_reference_distribution_0/v3_four_channel_phase_distribution_0/v3_four_channel_output_collection_0/v3_four_channel_placement_0/v3_channel_selector_late_promotion_3/v3_selector_route_pilot_0/G0_MUX_POS/a_76_199# v3_four_channel_output_load_integration_0/v3_four_channel_shared_support_integration_0/v3_four_channel_bias_reference_distribution_0/v3_four_channel_phase_distribution_0/phase_0 v3_four_channel_output_load_integration_0/v3_four_channel_shared_support_integration_0/v3_four_channel_bias_reference_distribution_0/v3_four_channel_phase_distribution_0/v3_four_channel_output_collection_0/v3_four_channel_placement_0/v3_channel_selector_late_promotion_3/v3_selector_route_pilot_0/G0_MUX_POS/a_218_374# VDPWR sky130_fd_pr__pfet_01v8_hvt ad=0.3864 pd=2.68 as=0 ps=0 w=0.42 l=0.15
X1160 v3_four_channel_output_load_integration_0/v3_four_channel_shared_support_integration_0/v3_four_channel_bias_reference_distribution_0/v3_four_channel_phase_distribution_0/v3_four_channel_output_collection_0/v3_four_channel_placement_0/v3_channel_selector_late_promotion_3/v3_selector_route_pilot_0/G0_MUX_POS/a_505_21# v3_four_channel_output_load_integration_0/v3_four_channel_shared_support_integration_0/v3_four_channel_bias_reference_distribution_0/v3_four_channel_phase_distribution_0/v3_four_channel_output_collection_0/v3_four_channel_placement_0/v3_channel_selector_late_promotion_3/group0_bit0 VGND VGND sky130_fd_pr__nfet_01v8 ad=0.1092 pd=1.36 as=0 ps=0 w=0.42 l=0.15
X1161 v3_four_channel_output_load_integration_0/v3_four_channel_shared_support_integration_0/v3_four_channel_bias_reference_distribution_0/v3_four_channel_phase_distribution_0/v3_four_channel_output_collection_0/v3_four_channel_placement_0/v3_channel_selector_late_promotion_3/v3_selector_route_pilot_0/G0_MUX_POS/a_439_47# v3_four_channel_output_load_integration_0/v3_four_channel_shared_support_integration_0/v3_four_channel_bias_reference_distribution_0/v3_four_channel_phase_distribution_0/phase_0 v3_four_channel_output_load_integration_0/v3_four_channel_shared_support_integration_0/v3_four_channel_bias_reference_distribution_0/v3_four_channel_phase_distribution_0/v3_four_channel_output_collection_0/v3_four_channel_placement_0/v3_channel_selector_late_promotion_3/v3_selector_route_pilot_0/G0_MUX_POS/a_76_199# VGND sky130_fd_pr__nfet_01v8 ad=0 pd=0 as=0.1995 ps=1.79 w=0.42 l=0.15
X1162 v3_four_channel_output_load_integration_0/v3_four_channel_shared_support_integration_0/v3_four_channel_bias_reference_distribution_0/v3_four_channel_phase_distribution_0/v3_four_channel_output_collection_0/v3_four_channel_placement_0/v3_channel_selector_late_promotion_3/v3_selector_route_pilot_0/G0_MUX_POS/a_535_374# v3_four_channel_output_load_integration_0/v3_four_channel_shared_support_integration_0/v3_four_channel_bias_reference_distribution_0/v3_four_channel_phase_distribution_0/phase_90 v3_four_channel_output_load_integration_0/v3_four_channel_shared_support_integration_0/v3_four_channel_bias_reference_distribution_0/v3_four_channel_phase_distribution_0/v3_four_channel_output_collection_0/v3_four_channel_placement_0/v3_channel_selector_late_promotion_3/v3_selector_route_pilot_0/G0_MUX_POS/a_76_199# VDPWR sky130_fd_pr__pfet_01v8_hvt ad=0 pd=0 as=0 ps=0 w=0.42 l=0.15
X1163 v3_four_channel_output_load_integration_0/v3_four_channel_shared_support_integration_0/v3_four_channel_bias_reference_distribution_0/v3_four_channel_phase_distribution_0/v3_four_channel_output_collection_0/v3_four_channel_placement_0/v3_channel_selector_late_promotion_3/v3_selector_route_pilot_0/G0_MUX_POS/a_76_199# v3_four_channel_output_load_integration_0/v3_four_channel_shared_support_integration_0/v3_four_channel_bias_reference_distribution_0/v3_four_channel_phase_distribution_0/phase_90 v3_four_channel_output_load_integration_0/v3_four_channel_shared_support_integration_0/v3_four_channel_bias_reference_distribution_0/v3_four_channel_phase_distribution_0/v3_four_channel_output_collection_0/v3_four_channel_placement_0/v3_channel_selector_late_promotion_3/v3_selector_route_pilot_0/G0_MUX_POS/a_218_47# VGND sky130_fd_pr__nfet_01v8 ad=0 pd=0 as=0.1386 ps=1.5 w=0.42 l=0.15
X1164 v3_four_channel_output_load_integration_0/v3_four_channel_shared_support_integration_0/v3_four_channel_bias_reference_distribution_0/v3_four_channel_phase_distribution_0/v3_four_channel_output_collection_0/v3_four_channel_placement_0/v3_channel_selector_late_promotion_3/v3_selector_route_pilot_0/G0_MUX_POS/a_218_47# v3_four_channel_output_load_integration_0/v3_four_channel_shared_support_integration_0/v3_four_channel_bias_reference_distribution_0/v3_four_channel_phase_distribution_0/v3_four_channel_output_collection_0/v3_four_channel_placement_0/v3_channel_selector_late_promotion_3/group0_bit0 VGND VGND sky130_fd_pr__nfet_01v8 ad=0 pd=0 as=0 ps=0 w=0.42 l=0.15
X1165 VDPWR v3_four_channel_output_load_integration_0/v3_four_channel_shared_support_integration_0/v3_four_channel_bias_reference_distribution_0/v3_four_channel_phase_distribution_0/v3_four_channel_output_collection_0/v3_four_channel_placement_0/v3_channel_selector_late_promotion_3/v3_selector_route_pilot_0/G0_MUX_POS/a_76_199# v3_four_channel_output_load_integration_0/v3_four_channel_shared_support_integration_0/v3_four_channel_bias_reference_distribution_0/v3_four_channel_phase_distribution_0/v3_four_channel_output_collection_0/v3_four_channel_placement_0/v3_channel_selector_late_promotion_3/v3_selector_route_pilot_0/G0_MUX_POS/X VDPWR sky130_fd_pr__pfet_01v8_hvt ad=0 pd=0 as=0.26 ps=2.52 w=1 l=0.15
X1166 VGND v3_four_channel_output_load_integration_0/v3_four_channel_shared_support_integration_0/v3_four_channel_bias_reference_distribution_0/v3_four_channel_phase_distribution_0/v3_four_channel_output_collection_0/v3_four_channel_placement_0/v3_channel_selector_late_promotion_3/v3_selector_route_pilot_0/G0_MUX_POS/a_76_199# v3_four_channel_output_load_integration_0/v3_four_channel_shared_support_integration_0/v3_four_channel_bias_reference_distribution_0/v3_four_channel_phase_distribution_0/v3_four_channel_output_collection_0/v3_four_channel_placement_0/v3_channel_selector_late_promotion_3/v3_selector_route_pilot_0/G0_MUX_POS/X VGND sky130_fd_pr__nfet_01v8 ad=0 pd=0 as=0.169 ps=1.82 w=0.65 l=0.15
X1167 VDPWR v3_four_channel_output_load_integration_0/v3_four_channel_shared_support_integration_0/v3_four_channel_bias_reference_distribution_0/v3_four_channel_phase_distribution_0/v3_four_channel_output_collection_0/v3_four_channel_placement_0/v3_channel_selector_late_promotion_3/v3_selector_route_pilot_0/G0_MUX_NEG/a_505_21# v3_four_channel_output_load_integration_0/v3_four_channel_shared_support_integration_0/v3_four_channel_bias_reference_distribution_0/v3_four_channel_phase_distribution_0/v3_four_channel_output_collection_0/v3_four_channel_placement_0/v3_channel_selector_late_promotion_3/v3_selector_route_pilot_0/G0_MUX_NEG/a_535_374# VDPWR sky130_fd_pr__pfet_01v8_hvt ad=0 pd=0 as=0.0882 ps=1.26 w=0.42 l=0.15
X1168 v3_four_channel_output_load_integration_0/v3_four_channel_shared_support_integration_0/v3_four_channel_bias_reference_distribution_0/v3_four_channel_phase_distribution_0/v3_four_channel_output_collection_0/v3_four_channel_placement_0/v3_channel_selector_late_promotion_3/v3_selector_route_pilot_0/G0_MUX_NEG/a_505_21# v3_four_channel_output_load_integration_0/v3_four_channel_shared_support_integration_0/v3_four_channel_bias_reference_distribution_0/v3_four_channel_phase_distribution_0/v3_four_channel_output_collection_0/v3_four_channel_placement_0/v3_channel_selector_late_promotion_3/group0_bit0 VDPWR VDPWR sky130_fd_pr__pfet_01v8_hvt ad=0.1176 pd=1.4 as=0 ps=0 w=0.42 l=0.15
X1169 v3_four_channel_output_load_integration_0/v3_four_channel_shared_support_integration_0/v3_four_channel_bias_reference_distribution_0/v3_four_channel_phase_distribution_0/v3_four_channel_output_collection_0/v3_four_channel_placement_0/v3_channel_selector_late_promotion_3/v3_selector_route_pilot_0/G0_MUX_NEG/a_218_374# v3_four_channel_output_load_integration_0/v3_four_channel_shared_support_integration_0/v3_four_channel_bias_reference_distribution_0/v3_four_channel_phase_distribution_0/v3_four_channel_output_collection_0/v3_four_channel_placement_0/v3_channel_selector_late_promotion_3/group0_bit0 VDPWR VDPWR sky130_fd_pr__pfet_01v8_hvt ad=0.1533 pd=1.57 as=0 ps=0 w=0.42 l=0.15
X1170 VGND v3_four_channel_output_load_integration_0/v3_four_channel_shared_support_integration_0/v3_four_channel_bias_reference_distribution_0/v3_four_channel_phase_distribution_0/v3_four_channel_output_collection_0/v3_four_channel_placement_0/v3_channel_selector_late_promotion_3/v3_selector_route_pilot_0/G0_MUX_NEG/a_505_21# v3_four_channel_output_load_integration_0/v3_four_channel_shared_support_integration_0/v3_four_channel_bias_reference_distribution_0/v3_four_channel_phase_distribution_0/v3_four_channel_output_collection_0/v3_four_channel_placement_0/v3_channel_selector_late_promotion_3/v3_selector_route_pilot_0/G0_MUX_NEG/a_439_47# VGND sky130_fd_pr__nfet_01v8 ad=0 pd=0 as=0.1386 ps=1.5 w=0.42 l=0.15
X1171 v3_four_channel_output_load_integration_0/v3_four_channel_shared_support_integration_0/v3_four_channel_bias_reference_distribution_0/v3_four_channel_phase_distribution_0/v3_four_channel_output_collection_0/v3_four_channel_placement_0/v3_channel_selector_late_promotion_3/v3_selector_route_pilot_0/G0_MUX_NEG/a_76_199# v3_four_channel_output_load_integration_0/v3_four_channel_shared_support_integration_0/v3_four_channel_bias_reference_distribution_0/v3_four_channel_phase_distribution_0/phase_180 v3_four_channel_output_load_integration_0/v3_four_channel_shared_support_integration_0/v3_four_channel_bias_reference_distribution_0/v3_four_channel_phase_distribution_0/v3_four_channel_output_collection_0/v3_four_channel_placement_0/v3_channel_selector_late_promotion_3/v3_selector_route_pilot_0/G0_MUX_NEG/a_218_374# VDPWR sky130_fd_pr__pfet_01v8_hvt ad=0.3864 pd=2.68 as=0 ps=0 w=0.42 l=0.15
X1172 v3_four_channel_output_load_integration_0/v3_four_channel_shared_support_integration_0/v3_four_channel_bias_reference_distribution_0/v3_four_channel_phase_distribution_0/v3_four_channel_output_collection_0/v3_four_channel_placement_0/v3_channel_selector_late_promotion_3/v3_selector_route_pilot_0/G0_MUX_NEG/a_505_21# v3_four_channel_output_load_integration_0/v3_four_channel_shared_support_integration_0/v3_four_channel_bias_reference_distribution_0/v3_four_channel_phase_distribution_0/v3_four_channel_output_collection_0/v3_four_channel_placement_0/v3_channel_selector_late_promotion_3/group0_bit0 VGND VGND sky130_fd_pr__nfet_01v8 ad=0.1092 pd=1.36 as=0 ps=0 w=0.42 l=0.15
X1173 v3_four_channel_output_load_integration_0/v3_four_channel_shared_support_integration_0/v3_four_channel_bias_reference_distribution_0/v3_four_channel_phase_distribution_0/v3_four_channel_output_collection_0/v3_four_channel_placement_0/v3_channel_selector_late_promotion_3/v3_selector_route_pilot_0/G0_MUX_NEG/a_439_47# v3_four_channel_output_load_integration_0/v3_four_channel_shared_support_integration_0/v3_four_channel_bias_reference_distribution_0/v3_four_channel_phase_distribution_0/phase_180 v3_four_channel_output_load_integration_0/v3_four_channel_shared_support_integration_0/v3_four_channel_bias_reference_distribution_0/v3_four_channel_phase_distribution_0/v3_four_channel_output_collection_0/v3_four_channel_placement_0/v3_channel_selector_late_promotion_3/v3_selector_route_pilot_0/G0_MUX_NEG/a_76_199# VGND sky130_fd_pr__nfet_01v8 ad=0 pd=0 as=0.1995 ps=1.79 w=0.42 l=0.15
X1174 v3_four_channel_output_load_integration_0/v3_four_channel_shared_support_integration_0/v3_four_channel_bias_reference_distribution_0/v3_four_channel_phase_distribution_0/v3_four_channel_output_collection_0/v3_four_channel_placement_0/v3_channel_selector_late_promotion_3/v3_selector_route_pilot_0/G0_MUX_NEG/a_535_374# v3_four_channel_output_load_integration_0/v3_four_channel_shared_support_integration_0/v3_four_channel_bias_reference_distribution_0/v3_four_channel_phase_distribution_0/phase_270 v3_four_channel_output_load_integration_0/v3_four_channel_shared_support_integration_0/v3_four_channel_bias_reference_distribution_0/v3_four_channel_phase_distribution_0/v3_four_channel_output_collection_0/v3_four_channel_placement_0/v3_channel_selector_late_promotion_3/v3_selector_route_pilot_0/G0_MUX_NEG/a_76_199# VDPWR sky130_fd_pr__pfet_01v8_hvt ad=0 pd=0 as=0 ps=0 w=0.42 l=0.15
X1175 v3_four_channel_output_load_integration_0/v3_four_channel_shared_support_integration_0/v3_four_channel_bias_reference_distribution_0/v3_four_channel_phase_distribution_0/v3_four_channel_output_collection_0/v3_four_channel_placement_0/v3_channel_selector_late_promotion_3/v3_selector_route_pilot_0/G0_MUX_NEG/a_76_199# v3_four_channel_output_load_integration_0/v3_four_channel_shared_support_integration_0/v3_four_channel_bias_reference_distribution_0/v3_four_channel_phase_distribution_0/phase_270 v3_four_channel_output_load_integration_0/v3_four_channel_shared_support_integration_0/v3_four_channel_bias_reference_distribution_0/v3_four_channel_phase_distribution_0/v3_four_channel_output_collection_0/v3_four_channel_placement_0/v3_channel_selector_late_promotion_3/v3_selector_route_pilot_0/G0_MUX_NEG/a_218_47# VGND sky130_fd_pr__nfet_01v8 ad=0 pd=0 as=0.1386 ps=1.5 w=0.42 l=0.15
X1176 v3_four_channel_output_load_integration_0/v3_four_channel_shared_support_integration_0/v3_four_channel_bias_reference_distribution_0/v3_four_channel_phase_distribution_0/v3_four_channel_output_collection_0/v3_four_channel_placement_0/v3_channel_selector_late_promotion_3/v3_selector_route_pilot_0/G0_MUX_NEG/a_218_47# v3_four_channel_output_load_integration_0/v3_four_channel_shared_support_integration_0/v3_four_channel_bias_reference_distribution_0/v3_four_channel_phase_distribution_0/v3_four_channel_output_collection_0/v3_four_channel_placement_0/v3_channel_selector_late_promotion_3/group0_bit0 VGND VGND sky130_fd_pr__nfet_01v8 ad=0 pd=0 as=0 ps=0 w=0.42 l=0.15
X1177 VDPWR v3_four_channel_output_load_integration_0/v3_four_channel_shared_support_integration_0/v3_four_channel_bias_reference_distribution_0/v3_four_channel_phase_distribution_0/v3_four_channel_output_collection_0/v3_four_channel_placement_0/v3_channel_selector_late_promotion_3/v3_selector_route_pilot_0/G0_MUX_NEG/a_76_199# v3_four_channel_output_load_integration_0/v3_four_channel_shared_support_integration_0/v3_four_channel_bias_reference_distribution_0/v3_four_channel_phase_distribution_0/v3_four_channel_output_collection_0/v3_four_channel_placement_0/v3_channel_selector_late_promotion_3/v3_selector_route_pilot_0/G0_MUX_NEG/X VDPWR sky130_fd_pr__pfet_01v8_hvt ad=0 pd=0 as=0.26 ps=2.52 w=1 l=0.15
X1178 VGND v3_four_channel_output_load_integration_0/v3_four_channel_shared_support_integration_0/v3_four_channel_bias_reference_distribution_0/v3_four_channel_phase_distribution_0/v3_four_channel_output_collection_0/v3_four_channel_placement_0/v3_channel_selector_late_promotion_3/v3_selector_route_pilot_0/G0_MUX_NEG/a_76_199# v3_four_channel_output_load_integration_0/v3_four_channel_shared_support_integration_0/v3_four_channel_bias_reference_distribution_0/v3_four_channel_phase_distribution_0/v3_four_channel_output_collection_0/v3_four_channel_placement_0/v3_channel_selector_late_promotion_3/v3_selector_route_pilot_0/G0_MUX_NEG/X VGND sky130_fd_pr__nfet_01v8 ad=0 pd=0 as=0.169 ps=1.82 w=0.65 l=0.15
X1179 VDPWR v3_four_channel_output_load_integration_0/v3_four_channel_shared_support_integration_0/v3_four_channel_bias_reference_distribution_0/v3_four_channel_phase_distribution_0/v3_four_channel_output_collection_0/v3_four_channel_placement_0/v3_channel_selector_late_promotion_3/v3_selector_route_pilot_0/G2_MUX_AXIS/a_505_21# v3_four_channel_output_load_integration_0/v3_four_channel_shared_support_integration_0/v3_four_channel_bias_reference_distribution_0/v3_four_channel_phase_distribution_0/v3_four_channel_output_collection_0/v3_four_channel_placement_0/v3_channel_selector_late_promotion_3/v3_selector_route_pilot_0/G2_MUX_AXIS/a_535_374# VDPWR sky130_fd_pr__pfet_01v8_hvt ad=0 pd=0 as=0.0882 ps=1.26 w=0.42 l=0.15
X1180 v3_four_channel_output_load_integration_0/v3_four_channel_shared_support_integration_0/v3_four_channel_bias_reference_distribution_0/v3_four_channel_phase_distribution_0/v3_four_channel_output_collection_0/v3_four_channel_placement_0/v3_channel_selector_late_promotion_3/v3_selector_route_pilot_0/G2_MUX_AXIS/a_505_21# v3_four_channel_output_load_integration_0/v3_four_channel_shared_support_integration_0/v3_four_channel_bias_reference_distribution_0/v3_four_channel_phase_distribution_0/v3_four_channel_output_collection_0/v3_four_channel_placement_0/v3_channel_selector_late_promotion_3/group2_bit1 VDPWR VDPWR sky130_fd_pr__pfet_01v8_hvt ad=0.1176 pd=1.4 as=0 ps=0 w=0.42 l=0.15
X1181 v3_four_channel_output_load_integration_0/v3_four_channel_shared_support_integration_0/v3_four_channel_bias_reference_distribution_0/v3_four_channel_phase_distribution_0/v3_four_channel_output_collection_0/v3_four_channel_placement_0/v3_channel_selector_late_promotion_3/v3_selector_route_pilot_0/G2_MUX_AXIS/a_218_374# v3_four_channel_output_load_integration_0/v3_four_channel_shared_support_integration_0/v3_four_channel_bias_reference_distribution_0/v3_four_channel_phase_distribution_0/v3_four_channel_output_collection_0/v3_four_channel_placement_0/v3_channel_selector_late_promotion_3/group2_bit1 VDPWR VDPWR sky130_fd_pr__pfet_01v8_hvt ad=0.1533 pd=1.57 as=0 ps=0 w=0.42 l=0.15
X1182 VGND v3_four_channel_output_load_integration_0/v3_four_channel_shared_support_integration_0/v3_four_channel_bias_reference_distribution_0/v3_four_channel_phase_distribution_0/v3_four_channel_output_collection_0/v3_four_channel_placement_0/v3_channel_selector_late_promotion_3/v3_selector_route_pilot_0/G2_MUX_AXIS/a_505_21# v3_four_channel_output_load_integration_0/v3_four_channel_shared_support_integration_0/v3_four_channel_bias_reference_distribution_0/v3_four_channel_phase_distribution_0/v3_four_channel_output_collection_0/v3_four_channel_placement_0/v3_channel_selector_late_promotion_3/v3_selector_route_pilot_0/G2_MUX_AXIS/a_439_47# VGND sky130_fd_pr__nfet_01v8 ad=0 pd=0 as=0.1386 ps=1.5 w=0.42 l=0.15
X1183 v3_four_channel_output_load_integration_0/v3_four_channel_shared_support_integration_0/v3_four_channel_bias_reference_distribution_0/v3_four_channel_phase_distribution_0/v3_four_channel_output_collection_0/v3_four_channel_placement_0/v3_channel_selector_late_promotion_3/v3_selector_route_pilot_0/G2_MUX_AXIS/a_76_199# v3_four_channel_output_load_integration_0/v3_four_channel_shared_support_integration_0/v3_four_channel_bias_reference_distribution_0/v3_four_channel_phase_distribution_0/v3_four_channel_output_collection_0/v3_four_channel_placement_0/v3_channel_selector_late_promotion_3/v3_selector_route_pilot_0/G2_MUX_POS/X v3_four_channel_output_load_integration_0/v3_four_channel_shared_support_integration_0/v3_four_channel_bias_reference_distribution_0/v3_four_channel_phase_distribution_0/v3_four_channel_output_collection_0/v3_four_channel_placement_0/v3_channel_selector_late_promotion_3/v3_selector_route_pilot_0/G2_MUX_AXIS/a_218_374# VDPWR sky130_fd_pr__pfet_01v8_hvt ad=0.3864 pd=2.68 as=0 ps=0 w=0.42 l=0.15
X1184 v3_four_channel_output_load_integration_0/v3_four_channel_shared_support_integration_0/v3_four_channel_bias_reference_distribution_0/v3_four_channel_phase_distribution_0/v3_four_channel_output_collection_0/v3_four_channel_placement_0/v3_channel_selector_late_promotion_3/v3_selector_route_pilot_0/G2_MUX_AXIS/a_505_21# v3_four_channel_output_load_integration_0/v3_four_channel_shared_support_integration_0/v3_four_channel_bias_reference_distribution_0/v3_four_channel_phase_distribution_0/v3_four_channel_output_collection_0/v3_four_channel_placement_0/v3_channel_selector_late_promotion_3/group2_bit1 VGND VGND sky130_fd_pr__nfet_01v8 ad=0.1092 pd=1.36 as=0 ps=0 w=0.42 l=0.15
X1185 v3_four_channel_output_load_integration_0/v3_four_channel_shared_support_integration_0/v3_four_channel_bias_reference_distribution_0/v3_four_channel_phase_distribution_0/v3_four_channel_output_collection_0/v3_four_channel_placement_0/v3_channel_selector_late_promotion_3/v3_selector_route_pilot_0/G2_MUX_AXIS/a_439_47# v3_four_channel_output_load_integration_0/v3_four_channel_shared_support_integration_0/v3_four_channel_bias_reference_distribution_0/v3_four_channel_phase_distribution_0/v3_four_channel_output_collection_0/v3_four_channel_placement_0/v3_channel_selector_late_promotion_3/v3_selector_route_pilot_0/G2_MUX_POS/X v3_four_channel_output_load_integration_0/v3_four_channel_shared_support_integration_0/v3_four_channel_bias_reference_distribution_0/v3_four_channel_phase_distribution_0/v3_four_channel_output_collection_0/v3_four_channel_placement_0/v3_channel_selector_late_promotion_3/v3_selector_route_pilot_0/G2_MUX_AXIS/a_76_199# VGND sky130_fd_pr__nfet_01v8 ad=0 pd=0 as=0.1995 ps=1.79 w=0.42 l=0.15
X1186 v3_four_channel_output_load_integration_0/v3_four_channel_shared_support_integration_0/v3_four_channel_bias_reference_distribution_0/v3_four_channel_phase_distribution_0/v3_four_channel_output_collection_0/v3_four_channel_placement_0/v3_channel_selector_late_promotion_3/v3_selector_route_pilot_0/G2_MUX_AXIS/a_535_374# v3_four_channel_output_load_integration_0/v3_four_channel_shared_support_integration_0/v3_four_channel_bias_reference_distribution_0/v3_four_channel_phase_distribution_0/v3_four_channel_output_collection_0/v3_four_channel_placement_0/v3_channel_selector_late_promotion_3/v3_selector_route_pilot_0/G2_MUX_NEG/X v3_four_channel_output_load_integration_0/v3_four_channel_shared_support_integration_0/v3_four_channel_bias_reference_distribution_0/v3_four_channel_phase_distribution_0/v3_four_channel_output_collection_0/v3_four_channel_placement_0/v3_channel_selector_late_promotion_3/v3_selector_route_pilot_0/G2_MUX_AXIS/a_76_199# VDPWR sky130_fd_pr__pfet_01v8_hvt ad=0 pd=0 as=0 ps=0 w=0.42 l=0.15
X1187 v3_four_channel_output_load_integration_0/v3_four_channel_shared_support_integration_0/v3_four_channel_bias_reference_distribution_0/v3_four_channel_phase_distribution_0/v3_four_channel_output_collection_0/v3_four_channel_placement_0/v3_channel_selector_late_promotion_3/v3_selector_route_pilot_0/G2_MUX_AXIS/a_76_199# v3_four_channel_output_load_integration_0/v3_four_channel_shared_support_integration_0/v3_four_channel_bias_reference_distribution_0/v3_four_channel_phase_distribution_0/v3_four_channel_output_collection_0/v3_four_channel_placement_0/v3_channel_selector_late_promotion_3/v3_selector_route_pilot_0/G2_MUX_NEG/X v3_four_channel_output_load_integration_0/v3_four_channel_shared_support_integration_0/v3_four_channel_bias_reference_distribution_0/v3_four_channel_phase_distribution_0/v3_four_channel_output_collection_0/v3_four_channel_placement_0/v3_channel_selector_late_promotion_3/v3_selector_route_pilot_0/G2_MUX_AXIS/a_218_47# VGND sky130_fd_pr__nfet_01v8 ad=0 pd=0 as=0.1386 ps=1.5 w=0.42 l=0.15
X1188 v3_four_channel_output_load_integration_0/v3_four_channel_shared_support_integration_0/v3_four_channel_bias_reference_distribution_0/v3_four_channel_phase_distribution_0/v3_four_channel_output_collection_0/v3_four_channel_placement_0/v3_channel_selector_late_promotion_3/v3_selector_route_pilot_0/G2_MUX_AXIS/a_218_47# v3_four_channel_output_load_integration_0/v3_four_channel_shared_support_integration_0/v3_four_channel_bias_reference_distribution_0/v3_four_channel_phase_distribution_0/v3_four_channel_output_collection_0/v3_four_channel_placement_0/v3_channel_selector_late_promotion_3/group2_bit1 VGND VGND sky130_fd_pr__nfet_01v8 ad=0 pd=0 as=0 ps=0 w=0.42 l=0.15
X1189 VDPWR v3_four_channel_output_load_integration_0/v3_four_channel_shared_support_integration_0/v3_four_channel_bias_reference_distribution_0/v3_four_channel_phase_distribution_0/v3_four_channel_output_collection_0/v3_four_channel_placement_0/v3_channel_selector_late_promotion_3/v3_selector_route_pilot_0/G2_MUX_AXIS/a_76_199# v3_four_channel_output_load_integration_0/v3_four_channel_shared_support_integration_0/v3_four_channel_bias_reference_distribution_0/v3_four_channel_phase_distribution_0/v3_four_channel_output_collection_0/v3_four_channel_placement_0/v3_channel_selector_late_promotion_3/v3_selector_route_pilot_0/G2_MUX_AXIS/X VDPWR sky130_fd_pr__pfet_01v8_hvt ad=0 pd=0 as=0.26 ps=2.52 w=1 l=0.15
X1190 VGND v3_four_channel_output_load_integration_0/v3_four_channel_shared_support_integration_0/v3_four_channel_bias_reference_distribution_0/v3_four_channel_phase_distribution_0/v3_four_channel_output_collection_0/v3_four_channel_placement_0/v3_channel_selector_late_promotion_3/v3_selector_route_pilot_0/G2_MUX_AXIS/a_76_199# v3_four_channel_output_load_integration_0/v3_four_channel_shared_support_integration_0/v3_four_channel_bias_reference_distribution_0/v3_four_channel_phase_distribution_0/v3_four_channel_output_collection_0/v3_four_channel_placement_0/v3_channel_selector_late_promotion_3/v3_selector_route_pilot_0/G2_MUX_AXIS/X VGND sky130_fd_pr__nfet_01v8 ad=0 pd=0 as=0.169 ps=1.82 w=0.65 l=0.15
X1191 VDPWR v3_four_channel_output_load_integration_0/v3_four_channel_shared_support_integration_0/v3_four_channel_bias_reference_distribution_0/v3_four_channel_phase_distribution_0/v3_four_channel_output_collection_0/v3_four_channel_placement_0/v3_channel_selector_late_promotion_3/v3_selector_route_pilot_0/G3_MUX_POS/a_505_21# v3_four_channel_output_load_integration_0/v3_four_channel_shared_support_integration_0/v3_four_channel_bias_reference_distribution_0/v3_four_channel_phase_distribution_0/v3_four_channel_output_collection_0/v3_four_channel_placement_0/v3_channel_selector_late_promotion_3/v3_selector_route_pilot_0/G3_MUX_POS/a_535_374# VDPWR sky130_fd_pr__pfet_01v8_hvt ad=0 pd=0 as=0.0882 ps=1.26 w=0.42 l=0.15
X1192 v3_four_channel_output_load_integration_0/v3_four_channel_shared_support_integration_0/v3_four_channel_bias_reference_distribution_0/v3_four_channel_phase_distribution_0/v3_four_channel_output_collection_0/v3_four_channel_placement_0/v3_channel_selector_late_promotion_3/v3_selector_route_pilot_0/G3_MUX_POS/a_505_21# v3_four_channel_output_load_integration_0/v3_four_channel_shared_support_integration_0/v3_four_channel_bias_reference_distribution_0/v3_four_channel_phase_distribution_0/v3_four_channel_output_collection_0/v3_four_channel_placement_0/v3_channel_selector_late_promotion_3/group3_bit0 VDPWR VDPWR sky130_fd_pr__pfet_01v8_hvt ad=0.1176 pd=1.4 as=0 ps=0 w=0.42 l=0.15
X1193 v3_four_channel_output_load_integration_0/v3_four_channel_shared_support_integration_0/v3_four_channel_bias_reference_distribution_0/v3_four_channel_phase_distribution_0/v3_four_channel_output_collection_0/v3_four_channel_placement_0/v3_channel_selector_late_promotion_3/v3_selector_route_pilot_0/G3_MUX_POS/a_218_374# v3_four_channel_output_load_integration_0/v3_four_channel_shared_support_integration_0/v3_four_channel_bias_reference_distribution_0/v3_four_channel_phase_distribution_0/v3_four_channel_output_collection_0/v3_four_channel_placement_0/v3_channel_selector_late_promotion_3/group3_bit0 VDPWR VDPWR sky130_fd_pr__pfet_01v8_hvt ad=0.1533 pd=1.57 as=0 ps=0 w=0.42 l=0.15
X1194 VGND v3_four_channel_output_load_integration_0/v3_four_channel_shared_support_integration_0/v3_four_channel_bias_reference_distribution_0/v3_four_channel_phase_distribution_0/v3_four_channel_output_collection_0/v3_four_channel_placement_0/v3_channel_selector_late_promotion_3/v3_selector_route_pilot_0/G3_MUX_POS/a_505_21# v3_four_channel_output_load_integration_0/v3_four_channel_shared_support_integration_0/v3_four_channel_bias_reference_distribution_0/v3_four_channel_phase_distribution_0/v3_four_channel_output_collection_0/v3_four_channel_placement_0/v3_channel_selector_late_promotion_3/v3_selector_route_pilot_0/G3_MUX_POS/a_439_47# VGND sky130_fd_pr__nfet_01v8 ad=0 pd=0 as=0.1386 ps=1.5 w=0.42 l=0.15
X1195 v3_four_channel_output_load_integration_0/v3_four_channel_shared_support_integration_0/v3_four_channel_bias_reference_distribution_0/v3_four_channel_phase_distribution_0/v3_four_channel_output_collection_0/v3_four_channel_placement_0/v3_channel_selector_late_promotion_3/v3_selector_route_pilot_0/G3_MUX_POS/a_76_199# v3_four_channel_output_load_integration_0/v3_four_channel_shared_support_integration_0/v3_four_channel_bias_reference_distribution_0/v3_four_channel_phase_distribution_0/phase_0 v3_four_channel_output_load_integration_0/v3_four_channel_shared_support_integration_0/v3_four_channel_bias_reference_distribution_0/v3_four_channel_phase_distribution_0/v3_four_channel_output_collection_0/v3_four_channel_placement_0/v3_channel_selector_late_promotion_3/v3_selector_route_pilot_0/G3_MUX_POS/a_218_374# VDPWR sky130_fd_pr__pfet_01v8_hvt ad=0.3864 pd=2.68 as=0 ps=0 w=0.42 l=0.15
X1196 v3_four_channel_output_load_integration_0/v3_four_channel_shared_support_integration_0/v3_four_channel_bias_reference_distribution_0/v3_four_channel_phase_distribution_0/v3_four_channel_output_collection_0/v3_four_channel_placement_0/v3_channel_selector_late_promotion_3/v3_selector_route_pilot_0/G3_MUX_POS/a_505_21# v3_four_channel_output_load_integration_0/v3_four_channel_shared_support_integration_0/v3_four_channel_bias_reference_distribution_0/v3_four_channel_phase_distribution_0/v3_four_channel_output_collection_0/v3_four_channel_placement_0/v3_channel_selector_late_promotion_3/group3_bit0 VGND VGND sky130_fd_pr__nfet_01v8 ad=0.1092 pd=1.36 as=0 ps=0 w=0.42 l=0.15
X1197 v3_four_channel_output_load_integration_0/v3_four_channel_shared_support_integration_0/v3_four_channel_bias_reference_distribution_0/v3_four_channel_phase_distribution_0/v3_four_channel_output_collection_0/v3_four_channel_placement_0/v3_channel_selector_late_promotion_3/v3_selector_route_pilot_0/G3_MUX_POS/a_439_47# v3_four_channel_output_load_integration_0/v3_four_channel_shared_support_integration_0/v3_four_channel_bias_reference_distribution_0/v3_four_channel_phase_distribution_0/phase_0 v3_four_channel_output_load_integration_0/v3_four_channel_shared_support_integration_0/v3_four_channel_bias_reference_distribution_0/v3_four_channel_phase_distribution_0/v3_four_channel_output_collection_0/v3_four_channel_placement_0/v3_channel_selector_late_promotion_3/v3_selector_route_pilot_0/G3_MUX_POS/a_76_199# VGND sky130_fd_pr__nfet_01v8 ad=0 pd=0 as=0.1995 ps=1.79 w=0.42 l=0.15
X1198 v3_four_channel_output_load_integration_0/v3_four_channel_shared_support_integration_0/v3_four_channel_bias_reference_distribution_0/v3_four_channel_phase_distribution_0/v3_four_channel_output_collection_0/v3_four_channel_placement_0/v3_channel_selector_late_promotion_3/v3_selector_route_pilot_0/G3_MUX_POS/a_535_374# v3_four_channel_output_load_integration_0/v3_four_channel_shared_support_integration_0/v3_four_channel_bias_reference_distribution_0/v3_four_channel_phase_distribution_0/phase_90 v3_four_channel_output_load_integration_0/v3_four_channel_shared_support_integration_0/v3_four_channel_bias_reference_distribution_0/v3_four_channel_phase_distribution_0/v3_four_channel_output_collection_0/v3_four_channel_placement_0/v3_channel_selector_late_promotion_3/v3_selector_route_pilot_0/G3_MUX_POS/a_76_199# VDPWR sky130_fd_pr__pfet_01v8_hvt ad=0 pd=0 as=0 ps=0 w=0.42 l=0.15
X1199 v3_four_channel_output_load_integration_0/v3_four_channel_shared_support_integration_0/v3_four_channel_bias_reference_distribution_0/v3_four_channel_phase_distribution_0/v3_four_channel_output_collection_0/v3_four_channel_placement_0/v3_channel_selector_late_promotion_3/v3_selector_route_pilot_0/G3_MUX_POS/a_76_199# v3_four_channel_output_load_integration_0/v3_four_channel_shared_support_integration_0/v3_four_channel_bias_reference_distribution_0/v3_four_channel_phase_distribution_0/phase_90 v3_four_channel_output_load_integration_0/v3_four_channel_shared_support_integration_0/v3_four_channel_bias_reference_distribution_0/v3_four_channel_phase_distribution_0/v3_four_channel_output_collection_0/v3_four_channel_placement_0/v3_channel_selector_late_promotion_3/v3_selector_route_pilot_0/G3_MUX_POS/a_218_47# VGND sky130_fd_pr__nfet_01v8 ad=0 pd=0 as=0.1386 ps=1.5 w=0.42 l=0.15
X1200 v3_four_channel_output_load_integration_0/v3_four_channel_shared_support_integration_0/v3_four_channel_bias_reference_distribution_0/v3_four_channel_phase_distribution_0/v3_four_channel_output_collection_0/v3_four_channel_placement_0/v3_channel_selector_late_promotion_3/v3_selector_route_pilot_0/G3_MUX_POS/a_218_47# v3_four_channel_output_load_integration_0/v3_four_channel_shared_support_integration_0/v3_four_channel_bias_reference_distribution_0/v3_four_channel_phase_distribution_0/v3_four_channel_output_collection_0/v3_four_channel_placement_0/v3_channel_selector_late_promotion_3/group3_bit0 VGND VGND sky130_fd_pr__nfet_01v8 ad=0 pd=0 as=0 ps=0 w=0.42 l=0.15
X1201 VDPWR v3_four_channel_output_load_integration_0/v3_four_channel_shared_support_integration_0/v3_four_channel_bias_reference_distribution_0/v3_four_channel_phase_distribution_0/v3_four_channel_output_collection_0/v3_four_channel_placement_0/v3_channel_selector_late_promotion_3/v3_selector_route_pilot_0/G3_MUX_POS/a_76_199# v3_four_channel_output_load_integration_0/v3_four_channel_shared_support_integration_0/v3_four_channel_bias_reference_distribution_0/v3_four_channel_phase_distribution_0/v3_four_channel_output_collection_0/v3_four_channel_placement_0/v3_channel_selector_late_promotion_3/v3_selector_route_pilot_0/G3_MUX_POS/X VDPWR sky130_fd_pr__pfet_01v8_hvt ad=0 pd=0 as=0.26 ps=2.52 w=1 l=0.15
X1202 VGND v3_four_channel_output_load_integration_0/v3_four_channel_shared_support_integration_0/v3_four_channel_bias_reference_distribution_0/v3_four_channel_phase_distribution_0/v3_four_channel_output_collection_0/v3_four_channel_placement_0/v3_channel_selector_late_promotion_3/v3_selector_route_pilot_0/G3_MUX_POS/a_76_199# v3_four_channel_output_load_integration_0/v3_four_channel_shared_support_integration_0/v3_four_channel_bias_reference_distribution_0/v3_four_channel_phase_distribution_0/v3_four_channel_output_collection_0/v3_four_channel_placement_0/v3_channel_selector_late_promotion_3/v3_selector_route_pilot_0/G3_MUX_POS/X VGND sky130_fd_pr__nfet_01v8 ad=0 pd=0 as=0.169 ps=1.82 w=0.65 l=0.15
X1203 VDPWR v3_four_channel_output_load_integration_0/v3_four_channel_shared_support_integration_0/v3_four_channel_bias_reference_distribution_0/v3_four_channel_phase_distribution_0/v3_four_channel_output_collection_0/v3_four_channel_placement_0/v3_channel_selector_late_promotion_3/v3_selector_route_pilot_0/G3_MUX_NEG/a_505_21# v3_four_channel_output_load_integration_0/v3_four_channel_shared_support_integration_0/v3_four_channel_bias_reference_distribution_0/v3_four_channel_phase_distribution_0/v3_four_channel_output_collection_0/v3_four_channel_placement_0/v3_channel_selector_late_promotion_3/v3_selector_route_pilot_0/G3_MUX_NEG/a_535_374# VDPWR sky130_fd_pr__pfet_01v8_hvt ad=0 pd=0 as=0.0882 ps=1.26 w=0.42 l=0.15
X1204 v3_four_channel_output_load_integration_0/v3_four_channel_shared_support_integration_0/v3_four_channel_bias_reference_distribution_0/v3_four_channel_phase_distribution_0/v3_four_channel_output_collection_0/v3_four_channel_placement_0/v3_channel_selector_late_promotion_3/v3_selector_route_pilot_0/G3_MUX_NEG/a_505_21# v3_four_channel_output_load_integration_0/v3_four_channel_shared_support_integration_0/v3_four_channel_bias_reference_distribution_0/v3_four_channel_phase_distribution_0/v3_four_channel_output_collection_0/v3_four_channel_placement_0/v3_channel_selector_late_promotion_3/group3_bit0 VDPWR VDPWR sky130_fd_pr__pfet_01v8_hvt ad=0.1176 pd=1.4 as=0 ps=0 w=0.42 l=0.15
X1205 v3_four_channel_output_load_integration_0/v3_four_channel_shared_support_integration_0/v3_four_channel_bias_reference_distribution_0/v3_four_channel_phase_distribution_0/v3_four_channel_output_collection_0/v3_four_channel_placement_0/v3_channel_selector_late_promotion_3/v3_selector_route_pilot_0/G3_MUX_NEG/a_218_374# v3_four_channel_output_load_integration_0/v3_four_channel_shared_support_integration_0/v3_four_channel_bias_reference_distribution_0/v3_four_channel_phase_distribution_0/v3_four_channel_output_collection_0/v3_four_channel_placement_0/v3_channel_selector_late_promotion_3/group3_bit0 VDPWR VDPWR sky130_fd_pr__pfet_01v8_hvt ad=0.1533 pd=1.57 as=0 ps=0 w=0.42 l=0.15
X1206 VGND v3_four_channel_output_load_integration_0/v3_four_channel_shared_support_integration_0/v3_four_channel_bias_reference_distribution_0/v3_four_channel_phase_distribution_0/v3_four_channel_output_collection_0/v3_four_channel_placement_0/v3_channel_selector_late_promotion_3/v3_selector_route_pilot_0/G3_MUX_NEG/a_505_21# v3_four_channel_output_load_integration_0/v3_four_channel_shared_support_integration_0/v3_four_channel_bias_reference_distribution_0/v3_four_channel_phase_distribution_0/v3_four_channel_output_collection_0/v3_four_channel_placement_0/v3_channel_selector_late_promotion_3/v3_selector_route_pilot_0/G3_MUX_NEG/a_439_47# VGND sky130_fd_pr__nfet_01v8 ad=0 pd=0 as=0.1386 ps=1.5 w=0.42 l=0.15
X1207 v3_four_channel_output_load_integration_0/v3_four_channel_shared_support_integration_0/v3_four_channel_bias_reference_distribution_0/v3_four_channel_phase_distribution_0/v3_four_channel_output_collection_0/v3_four_channel_placement_0/v3_channel_selector_late_promotion_3/v3_selector_route_pilot_0/G3_MUX_NEG/a_76_199# v3_four_channel_output_load_integration_0/v3_four_channel_shared_support_integration_0/v3_four_channel_bias_reference_distribution_0/v3_four_channel_phase_distribution_0/phase_180 v3_four_channel_output_load_integration_0/v3_four_channel_shared_support_integration_0/v3_four_channel_bias_reference_distribution_0/v3_four_channel_phase_distribution_0/v3_four_channel_output_collection_0/v3_four_channel_placement_0/v3_channel_selector_late_promotion_3/v3_selector_route_pilot_0/G3_MUX_NEG/a_218_374# VDPWR sky130_fd_pr__pfet_01v8_hvt ad=0.3864 pd=2.68 as=0 ps=0 w=0.42 l=0.15
X1208 v3_four_channel_output_load_integration_0/v3_four_channel_shared_support_integration_0/v3_four_channel_bias_reference_distribution_0/v3_four_channel_phase_distribution_0/v3_four_channel_output_collection_0/v3_four_channel_placement_0/v3_channel_selector_late_promotion_3/v3_selector_route_pilot_0/G3_MUX_NEG/a_505_21# v3_four_channel_output_load_integration_0/v3_four_channel_shared_support_integration_0/v3_four_channel_bias_reference_distribution_0/v3_four_channel_phase_distribution_0/v3_four_channel_output_collection_0/v3_four_channel_placement_0/v3_channel_selector_late_promotion_3/group3_bit0 VGND VGND sky130_fd_pr__nfet_01v8 ad=0.1092 pd=1.36 as=0 ps=0 w=0.42 l=0.15
X1209 v3_four_channel_output_load_integration_0/v3_four_channel_shared_support_integration_0/v3_four_channel_bias_reference_distribution_0/v3_four_channel_phase_distribution_0/v3_four_channel_output_collection_0/v3_four_channel_placement_0/v3_channel_selector_late_promotion_3/v3_selector_route_pilot_0/G3_MUX_NEG/a_439_47# v3_four_channel_output_load_integration_0/v3_four_channel_shared_support_integration_0/v3_four_channel_bias_reference_distribution_0/v3_four_channel_phase_distribution_0/phase_180 v3_four_channel_output_load_integration_0/v3_four_channel_shared_support_integration_0/v3_four_channel_bias_reference_distribution_0/v3_four_channel_phase_distribution_0/v3_four_channel_output_collection_0/v3_four_channel_placement_0/v3_channel_selector_late_promotion_3/v3_selector_route_pilot_0/G3_MUX_NEG/a_76_199# VGND sky130_fd_pr__nfet_01v8 ad=0 pd=0 as=0.1995 ps=1.79 w=0.42 l=0.15
X1210 v3_four_channel_output_load_integration_0/v3_four_channel_shared_support_integration_0/v3_four_channel_bias_reference_distribution_0/v3_four_channel_phase_distribution_0/v3_four_channel_output_collection_0/v3_four_channel_placement_0/v3_channel_selector_late_promotion_3/v3_selector_route_pilot_0/G3_MUX_NEG/a_535_374# v3_four_channel_output_load_integration_0/v3_four_channel_shared_support_integration_0/v3_four_channel_bias_reference_distribution_0/v3_four_channel_phase_distribution_0/phase_270 v3_four_channel_output_load_integration_0/v3_four_channel_shared_support_integration_0/v3_four_channel_bias_reference_distribution_0/v3_four_channel_phase_distribution_0/v3_four_channel_output_collection_0/v3_four_channel_placement_0/v3_channel_selector_late_promotion_3/v3_selector_route_pilot_0/G3_MUX_NEG/a_76_199# VDPWR sky130_fd_pr__pfet_01v8_hvt ad=0 pd=0 as=0 ps=0 w=0.42 l=0.15
X1211 v3_four_channel_output_load_integration_0/v3_four_channel_shared_support_integration_0/v3_four_channel_bias_reference_distribution_0/v3_four_channel_phase_distribution_0/v3_four_channel_output_collection_0/v3_four_channel_placement_0/v3_channel_selector_late_promotion_3/v3_selector_route_pilot_0/G3_MUX_NEG/a_76_199# v3_four_channel_output_load_integration_0/v3_four_channel_shared_support_integration_0/v3_four_channel_bias_reference_distribution_0/v3_four_channel_phase_distribution_0/phase_270 v3_four_channel_output_load_integration_0/v3_four_channel_shared_support_integration_0/v3_four_channel_bias_reference_distribution_0/v3_four_channel_phase_distribution_0/v3_four_channel_output_collection_0/v3_four_channel_placement_0/v3_channel_selector_late_promotion_3/v3_selector_route_pilot_0/G3_MUX_NEG/a_218_47# VGND sky130_fd_pr__nfet_01v8 ad=0 pd=0 as=0.1386 ps=1.5 w=0.42 l=0.15
X1212 v3_four_channel_output_load_integration_0/v3_four_channel_shared_support_integration_0/v3_four_channel_bias_reference_distribution_0/v3_four_channel_phase_distribution_0/v3_four_channel_output_collection_0/v3_four_channel_placement_0/v3_channel_selector_late_promotion_3/v3_selector_route_pilot_0/G3_MUX_NEG/a_218_47# v3_four_channel_output_load_integration_0/v3_four_channel_shared_support_integration_0/v3_four_channel_bias_reference_distribution_0/v3_four_channel_phase_distribution_0/v3_four_channel_output_collection_0/v3_four_channel_placement_0/v3_channel_selector_late_promotion_3/group3_bit0 VGND VGND sky130_fd_pr__nfet_01v8 ad=0 pd=0 as=0 ps=0 w=0.42 l=0.15
X1213 VDPWR v3_four_channel_output_load_integration_0/v3_four_channel_shared_support_integration_0/v3_four_channel_bias_reference_distribution_0/v3_four_channel_phase_distribution_0/v3_four_channel_output_collection_0/v3_four_channel_placement_0/v3_channel_selector_late_promotion_3/v3_selector_route_pilot_0/G3_MUX_NEG/a_76_199# v3_four_channel_output_load_integration_0/v3_four_channel_shared_support_integration_0/v3_four_channel_bias_reference_distribution_0/v3_four_channel_phase_distribution_0/v3_four_channel_output_collection_0/v3_four_channel_placement_0/v3_channel_selector_late_promotion_3/v3_selector_route_pilot_0/G3_MUX_NEG/X VDPWR sky130_fd_pr__pfet_01v8_hvt ad=0 pd=0 as=0.26 ps=2.52 w=1 l=0.15
X1214 VGND v3_four_channel_output_load_integration_0/v3_four_channel_shared_support_integration_0/v3_four_channel_bias_reference_distribution_0/v3_four_channel_phase_distribution_0/v3_four_channel_output_collection_0/v3_four_channel_placement_0/v3_channel_selector_late_promotion_3/v3_selector_route_pilot_0/G3_MUX_NEG/a_76_199# v3_four_channel_output_load_integration_0/v3_four_channel_shared_support_integration_0/v3_four_channel_bias_reference_distribution_0/v3_four_channel_phase_distribution_0/v3_four_channel_output_collection_0/v3_four_channel_placement_0/v3_channel_selector_late_promotion_3/v3_selector_route_pilot_0/G3_MUX_NEG/X VGND sky130_fd_pr__nfet_01v8 ad=0 pd=0 as=0.169 ps=1.82 w=0.65 l=0.15
X1215 VDPWR v3_four_channel_output_load_integration_0/v3_four_channel_shared_support_integration_0/v3_four_channel_bias_reference_distribution_0/v3_four_channel_phase_distribution_0/v3_four_channel_output_collection_0/v3_four_channel_placement_0/v3_channel_selector_late_promotion_3/v3_selector_route_pilot_0/G3_LO_P_AND/B v3_four_channel_output_load_integration_0/v3_four_channel_shared_support_integration_0/v3_four_channel_bias_reference_distribution_0/v3_four_channel_phase_distribution_0/v3_four_channel_output_collection_0/v3_four_channel_placement_0/v3_channel_selector_late_promotion_3/v3_selector_route_pilot_0/G0_LO_P_AND/a_59_75# VDPWR sky130_fd_pr__pfet_01v8_hvt ad=0 pd=0 as=0.1134 ps=1.38 w=0.42 l=0.15
X1216 v3_four_channel_output_load_integration_0/v3_four_channel_shared_support_integration_0/v3_four_channel_bias_reference_distribution_0/v3_four_channel_phase_distribution_0/v3_four_channel_output_collection_0/v3_four_channel_placement_0/v3_channel_selector_late_promotion_3/v3_selector_route_pilot_0/group0_lo_p v3_four_channel_output_load_integration_0/v3_four_channel_shared_support_integration_0/v3_four_channel_bias_reference_distribution_0/v3_four_channel_phase_distribution_0/v3_four_channel_output_collection_0/v3_four_channel_placement_0/v3_channel_selector_late_promotion_3/v3_selector_route_pilot_0/G0_LO_P_AND/a_59_75# VDPWR VDPWR sky130_fd_pr__pfet_01v8_hvt ad=0.475 pd=2.95 as=0 ps=0 w=1 l=0.15
X1217 VGND v3_four_channel_output_load_integration_0/v3_four_channel_shared_support_integration_0/v3_four_channel_bias_reference_distribution_0/v3_four_channel_phase_distribution_0/v3_four_channel_output_collection_0/v3_four_channel_placement_0/v3_channel_selector_late_promotion_3/v3_selector_route_pilot_0/G3_LO_P_AND/B v3_four_channel_output_load_integration_0/v3_four_channel_shared_support_integration_0/v3_four_channel_bias_reference_distribution_0/v3_four_channel_phase_distribution_0/v3_four_channel_output_collection_0/v3_four_channel_placement_0/v3_channel_selector_late_promotion_3/v3_selector_route_pilot_0/G0_LO_P_AND/a_145_75# VGND sky130_fd_pr__nfet_01v8 ad=0 pd=0 as=0.1134 ps=1.38 w=0.42 l=0.15
X1218 v3_four_channel_output_load_integration_0/v3_four_channel_shared_support_integration_0/v3_four_channel_bias_reference_distribution_0/v3_four_channel_phase_distribution_0/v3_four_channel_output_collection_0/v3_four_channel_placement_0/v3_channel_selector_late_promotion_3/v3_selector_route_pilot_0/G0_LO_P_AND/a_59_75# v3_four_channel_output_load_integration_0/v3_four_channel_shared_support_integration_0/v3_four_channel_bias_reference_distribution_0/v3_four_channel_phase_distribution_0/v3_four_channel_output_collection_0/v3_four_channel_placement_0/v3_channel_selector_late_promotion_3/v3_selector_route_pilot_0/G0_MUX_AXIS/X VDPWR VDPWR sky130_fd_pr__pfet_01v8_hvt ad=0 pd=0 as=0 ps=0 w=0.42 l=0.15
X1219 v3_four_channel_output_load_integration_0/v3_four_channel_shared_support_integration_0/v3_four_channel_bias_reference_distribution_0/v3_four_channel_phase_distribution_0/v3_four_channel_output_collection_0/v3_four_channel_placement_0/v3_channel_selector_late_promotion_3/v3_selector_route_pilot_0/group0_lo_p v3_four_channel_output_load_integration_0/v3_four_channel_shared_support_integration_0/v3_four_channel_bias_reference_distribution_0/v3_four_channel_phase_distribution_0/v3_four_channel_output_collection_0/v3_four_channel_placement_0/v3_channel_selector_late_promotion_3/v3_selector_route_pilot_0/G0_LO_P_AND/a_59_75# VGND VGND sky130_fd_pr__nfet_01v8 ad=0.182 pd=1.86 as=0 ps=0 w=0.65 l=0.15
X1220 v3_four_channel_output_load_integration_0/v3_four_channel_shared_support_integration_0/v3_four_channel_bias_reference_distribution_0/v3_four_channel_phase_distribution_0/v3_four_channel_output_collection_0/v3_four_channel_placement_0/v3_channel_selector_late_promotion_3/v3_selector_route_pilot_0/G0_LO_P_AND/a_145_75# v3_four_channel_output_load_integration_0/v3_four_channel_shared_support_integration_0/v3_four_channel_bias_reference_distribution_0/v3_four_channel_phase_distribution_0/v3_four_channel_output_collection_0/v3_four_channel_placement_0/v3_channel_selector_late_promotion_3/v3_selector_route_pilot_0/G0_MUX_AXIS/X v3_four_channel_output_load_integration_0/v3_four_channel_shared_support_integration_0/v3_four_channel_bias_reference_distribution_0/v3_four_channel_phase_distribution_0/v3_four_channel_output_collection_0/v3_four_channel_placement_0/v3_channel_selector_late_promotion_3/v3_selector_route_pilot_0/G0_LO_P_AND/a_59_75# VGND sky130_fd_pr__nfet_01v8 ad=0 pd=0 as=0.1176 ps=1.4 w=0.42 l=0.15
X1221 VDPWR v3_four_channel_output_load_integration_0/v3_four_channel_shared_support_integration_0/v3_four_channel_bias_reference_distribution_0/v3_four_channel_phase_distribution_0/v3_four_channel_output_collection_0/v3_four_channel_placement_0/v3_channel_selector_late_promotion_3/v3_selector_route_pilot_0/G3_LO_P_AND/B v3_four_channel_output_load_integration_0/v3_four_channel_shared_support_integration_0/v3_four_channel_bias_reference_distribution_0/v3_four_channel_phase_distribution_0/v3_four_channel_output_collection_0/v3_four_channel_placement_0/v3_channel_selector_late_promotion_3/v3_selector_route_pilot_0/G3_LO_N_ANDNOT/a_207_413# VDPWR sky130_fd_pr__pfet_01v8_hvt ad=0 pd=0 as=0.1218 ps=1.42 w=0.42 l=0.15
X1222 v3_four_channel_output_load_integration_0/v3_four_channel_shared_support_integration_0/v3_four_channel_bias_reference_distribution_0/v3_four_channel_phase_distribution_0/v3_four_channel_output_collection_0/v3_four_channel_placement_0/v3_channel_selector_late_promotion_3/v3_selector_route_pilot_0/group3_lo_n v3_four_channel_output_load_integration_0/v3_four_channel_shared_support_integration_0/v3_four_channel_bias_reference_distribution_0/v3_four_channel_phase_distribution_0/v3_four_channel_output_collection_0/v3_four_channel_placement_0/v3_channel_selector_late_promotion_3/v3_selector_route_pilot_0/G3_LO_N_ANDNOT/a_207_413# VDPWR VDPWR sky130_fd_pr__pfet_01v8_hvt ad=0.26 pd=2.52 as=0 ps=0 w=1 l=0.15
X1223 v3_four_channel_output_load_integration_0/v3_four_channel_shared_support_integration_0/v3_four_channel_bias_reference_distribution_0/v3_four_channel_phase_distribution_0/v3_four_channel_output_collection_0/v3_four_channel_placement_0/v3_channel_selector_late_promotion_3/v3_selector_route_pilot_0/G3_LO_N_ANDNOT/a_297_47# v3_four_channel_output_load_integration_0/v3_four_channel_shared_support_integration_0/v3_four_channel_bias_reference_distribution_0/v3_four_channel_phase_distribution_0/v3_four_channel_output_collection_0/v3_four_channel_placement_0/v3_channel_selector_late_promotion_3/v3_selector_route_pilot_0/G3_LO_N_ANDNOT/a_27_413# v3_four_channel_output_load_integration_0/v3_four_channel_shared_support_integration_0/v3_four_channel_bias_reference_distribution_0/v3_four_channel_phase_distribution_0/v3_four_channel_output_collection_0/v3_four_channel_placement_0/v3_channel_selector_late_promotion_3/v3_selector_route_pilot_0/G3_LO_N_ANDNOT/a_207_413# VGND sky130_fd_pr__nfet_01v8 ad=0.1008 pd=1.32 as=0.1092 ps=1.36 w=0.42 l=0.15
X1224 v3_four_channel_output_load_integration_0/v3_four_channel_shared_support_integration_0/v3_four_channel_bias_reference_distribution_0/v3_four_channel_phase_distribution_0/v3_four_channel_output_collection_0/v3_four_channel_placement_0/v3_channel_selector_late_promotion_3/v3_selector_route_pilot_0/group3_lo_n v3_four_channel_output_load_integration_0/v3_four_channel_shared_support_integration_0/v3_four_channel_bias_reference_distribution_0/v3_four_channel_phase_distribution_0/v3_four_channel_output_collection_0/v3_four_channel_placement_0/v3_channel_selector_late_promotion_3/v3_selector_route_pilot_0/G3_LO_N_ANDNOT/a_207_413# VGND VGND sky130_fd_pr__nfet_01v8 ad=0.169 pd=1.82 as=0 ps=0 w=0.65 l=0.15
X1225 v3_four_channel_output_load_integration_0/v3_four_channel_shared_support_integration_0/v3_four_channel_bias_reference_distribution_0/v3_four_channel_phase_distribution_0/v3_four_channel_output_collection_0/v3_four_channel_placement_0/v3_channel_selector_late_promotion_3/v3_selector_route_pilot_0/G3_LO_N_ANDNOT/a_207_413# v3_four_channel_output_load_integration_0/v3_four_channel_shared_support_integration_0/v3_four_channel_bias_reference_distribution_0/v3_four_channel_phase_distribution_0/v3_four_channel_output_collection_0/v3_four_channel_placement_0/v3_channel_selector_late_promotion_3/v3_selector_route_pilot_0/G3_LO_N_ANDNOT/a_27_413# VDPWR VDPWR sky130_fd_pr__pfet_01v8_hvt ad=0 pd=0 as=0 ps=0 w=0.42 l=0.15
X1226 VDPWR v3_four_channel_output_load_integration_0/v3_four_channel_shared_support_integration_0/v3_four_channel_bias_reference_distribution_0/v3_four_channel_phase_distribution_0/v3_four_channel_output_collection_0/v3_four_channel_placement_0/v3_channel_selector_late_promotion_3/v3_selector_route_pilot_0/G3_MUX_AXIS/X v3_four_channel_output_load_integration_0/v3_four_channel_shared_support_integration_0/v3_four_channel_bias_reference_distribution_0/v3_four_channel_phase_distribution_0/v3_four_channel_output_collection_0/v3_four_channel_placement_0/v3_channel_selector_late_promotion_3/v3_selector_route_pilot_0/G3_LO_N_ANDNOT/a_27_413# VDPWR sky130_fd_pr__pfet_01v8_hvt ad=0 pd=0 as=0.1092 ps=1.36 w=0.42 l=0.15
X1227 VGND v3_four_channel_output_load_integration_0/v3_four_channel_shared_support_integration_0/v3_four_channel_bias_reference_distribution_0/v3_four_channel_phase_distribution_0/v3_four_channel_output_collection_0/v3_four_channel_placement_0/v3_channel_selector_late_promotion_3/v3_selector_route_pilot_0/G3_LO_P_AND/B v3_four_channel_output_load_integration_0/v3_four_channel_shared_support_integration_0/v3_four_channel_bias_reference_distribution_0/v3_four_channel_phase_distribution_0/v3_four_channel_output_collection_0/v3_four_channel_placement_0/v3_channel_selector_late_promotion_3/v3_selector_route_pilot_0/G3_LO_N_ANDNOT/a_297_47# VGND sky130_fd_pr__nfet_01v8 ad=0 pd=0 as=0 ps=0 w=0.42 l=0.15
X1228 v3_four_channel_output_load_integration_0/v3_four_channel_shared_support_integration_0/v3_four_channel_bias_reference_distribution_0/v3_four_channel_phase_distribution_0/v3_four_channel_output_collection_0/v3_four_channel_placement_0/v3_channel_selector_late_promotion_3/v3_selector_route_pilot_0/G3_LO_N_ANDNOT/a_27_413# v3_four_channel_output_load_integration_0/v3_four_channel_shared_support_integration_0/v3_four_channel_bias_reference_distribution_0/v3_four_channel_phase_distribution_0/v3_four_channel_output_collection_0/v3_four_channel_placement_0/v3_channel_selector_late_promotion_3/v3_selector_route_pilot_0/G3_MUX_AXIS/X VGND VGND sky130_fd_pr__nfet_01v8 ad=0.1092 pd=1.36 as=0 ps=0 w=0.42 l=0.15
X1229 VDPWR v3_four_channel_output_load_integration_0/v3_four_channel_shared_support_integration_0/v3_four_channel_bias_reference_distribution_0/v3_four_channel_phase_distribution_0/v3_four_channel_output_collection_0/v3_four_channel_placement_0/v3_channel_selector_late_promotion_3/v3_selector_route_pilot_0/G3_LO_P_AND/B v3_four_channel_output_load_integration_0/v3_four_channel_shared_support_integration_0/v3_four_channel_bias_reference_distribution_0/v3_four_channel_phase_distribution_0/v3_four_channel_output_collection_0/v3_four_channel_placement_0/v3_channel_selector_late_promotion_3/v3_selector_route_pilot_0/G2_LO_N_ANDNOT/a_207_413# VDPWR sky130_fd_pr__pfet_01v8_hvt ad=0 pd=0 as=0.1218 ps=1.42 w=0.42 l=0.15
X1230 v3_four_channel_output_load_integration_0/v3_four_channel_shared_support_integration_0/v3_four_channel_bias_reference_distribution_0/v3_four_channel_phase_distribution_0/v3_four_channel_output_collection_0/v3_four_channel_placement_0/v3_channel_selector_late_promotion_3/v3_selector_route_pilot_0/group2_lo_n v3_four_channel_output_load_integration_0/v3_four_channel_shared_support_integration_0/v3_four_channel_bias_reference_distribution_0/v3_four_channel_phase_distribution_0/v3_four_channel_output_collection_0/v3_four_channel_placement_0/v3_channel_selector_late_promotion_3/v3_selector_route_pilot_0/G2_LO_N_ANDNOT/a_207_413# VDPWR VDPWR sky130_fd_pr__pfet_01v8_hvt ad=0.26 pd=2.52 as=0 ps=0 w=1 l=0.15
X1231 v3_four_channel_output_load_integration_0/v3_four_channel_shared_support_integration_0/v3_four_channel_bias_reference_distribution_0/v3_four_channel_phase_distribution_0/v3_four_channel_output_collection_0/v3_four_channel_placement_0/v3_channel_selector_late_promotion_3/v3_selector_route_pilot_0/G2_LO_N_ANDNOT/a_297_47# v3_four_channel_output_load_integration_0/v3_four_channel_shared_support_integration_0/v3_four_channel_bias_reference_distribution_0/v3_four_channel_phase_distribution_0/v3_four_channel_output_collection_0/v3_four_channel_placement_0/v3_channel_selector_late_promotion_3/v3_selector_route_pilot_0/G2_LO_N_ANDNOT/a_27_413# v3_four_channel_output_load_integration_0/v3_four_channel_shared_support_integration_0/v3_four_channel_bias_reference_distribution_0/v3_four_channel_phase_distribution_0/v3_four_channel_output_collection_0/v3_four_channel_placement_0/v3_channel_selector_late_promotion_3/v3_selector_route_pilot_0/G2_LO_N_ANDNOT/a_207_413# VGND sky130_fd_pr__nfet_01v8 ad=0.1008 pd=1.32 as=0.1092 ps=1.36 w=0.42 l=0.15
X1232 v3_four_channel_output_load_integration_0/v3_four_channel_shared_support_integration_0/v3_four_channel_bias_reference_distribution_0/v3_four_channel_phase_distribution_0/v3_four_channel_output_collection_0/v3_four_channel_placement_0/v3_channel_selector_late_promotion_3/v3_selector_route_pilot_0/group2_lo_n v3_four_channel_output_load_integration_0/v3_four_channel_shared_support_integration_0/v3_four_channel_bias_reference_distribution_0/v3_four_channel_phase_distribution_0/v3_four_channel_output_collection_0/v3_four_channel_placement_0/v3_channel_selector_late_promotion_3/v3_selector_route_pilot_0/G2_LO_N_ANDNOT/a_207_413# VGND VGND sky130_fd_pr__nfet_01v8 ad=0.169 pd=1.82 as=0 ps=0 w=0.65 l=0.15
X1233 v3_four_channel_output_load_integration_0/v3_four_channel_shared_support_integration_0/v3_four_channel_bias_reference_distribution_0/v3_four_channel_phase_distribution_0/v3_four_channel_output_collection_0/v3_four_channel_placement_0/v3_channel_selector_late_promotion_3/v3_selector_route_pilot_0/G2_LO_N_ANDNOT/a_207_413# v3_four_channel_output_load_integration_0/v3_four_channel_shared_support_integration_0/v3_four_channel_bias_reference_distribution_0/v3_four_channel_phase_distribution_0/v3_four_channel_output_collection_0/v3_four_channel_placement_0/v3_channel_selector_late_promotion_3/v3_selector_route_pilot_0/G2_LO_N_ANDNOT/a_27_413# VDPWR VDPWR sky130_fd_pr__pfet_01v8_hvt ad=0 pd=0 as=0 ps=0 w=0.42 l=0.15
X1234 VDPWR v3_four_channel_output_load_integration_0/v3_four_channel_shared_support_integration_0/v3_four_channel_bias_reference_distribution_0/v3_four_channel_phase_distribution_0/v3_four_channel_output_collection_0/v3_four_channel_placement_0/v3_channel_selector_late_promotion_3/v3_selector_route_pilot_0/G2_MUX_AXIS/X v3_four_channel_output_load_integration_0/v3_four_channel_shared_support_integration_0/v3_four_channel_bias_reference_distribution_0/v3_four_channel_phase_distribution_0/v3_four_channel_output_collection_0/v3_four_channel_placement_0/v3_channel_selector_late_promotion_3/v3_selector_route_pilot_0/G2_LO_N_ANDNOT/a_27_413# VDPWR sky130_fd_pr__pfet_01v8_hvt ad=0 pd=0 as=0.1092 ps=1.36 w=0.42 l=0.15
X1235 VGND v3_four_channel_output_load_integration_0/v3_four_channel_shared_support_integration_0/v3_four_channel_bias_reference_distribution_0/v3_four_channel_phase_distribution_0/v3_four_channel_output_collection_0/v3_four_channel_placement_0/v3_channel_selector_late_promotion_3/v3_selector_route_pilot_0/G3_LO_P_AND/B v3_four_channel_output_load_integration_0/v3_four_channel_shared_support_integration_0/v3_four_channel_bias_reference_distribution_0/v3_four_channel_phase_distribution_0/v3_four_channel_output_collection_0/v3_four_channel_placement_0/v3_channel_selector_late_promotion_3/v3_selector_route_pilot_0/G2_LO_N_ANDNOT/a_297_47# VGND sky130_fd_pr__nfet_01v8 ad=0 pd=0 as=0 ps=0 w=0.42 l=0.15
X1236 v3_four_channel_output_load_integration_0/v3_four_channel_shared_support_integration_0/v3_four_channel_bias_reference_distribution_0/v3_four_channel_phase_distribution_0/v3_four_channel_output_collection_0/v3_four_channel_placement_0/v3_channel_selector_late_promotion_3/v3_selector_route_pilot_0/G2_LO_N_ANDNOT/a_27_413# v3_four_channel_output_load_integration_0/v3_four_channel_shared_support_integration_0/v3_four_channel_bias_reference_distribution_0/v3_four_channel_phase_distribution_0/v3_four_channel_output_collection_0/v3_four_channel_placement_0/v3_channel_selector_late_promotion_3/v3_selector_route_pilot_0/G2_MUX_AXIS/X VGND VGND sky130_fd_pr__nfet_01v8 ad=0.1092 pd=1.36 as=0 ps=0 w=0.42 l=0.15
X1237 VDPWR v3_four_channel_output_load_integration_0/v3_four_channel_shared_support_integration_0/v3_four_channel_bias_reference_distribution_0/v3_four_channel_phase_distribution_0/v3_four_channel_output_collection_0/v3_four_channel_placement_0/v3_channel_selector_late_promotion_3/v3_selector_route_pilot_0/G3_LO_P_AND/B v3_four_channel_output_load_integration_0/v3_four_channel_shared_support_integration_0/v3_four_channel_bias_reference_distribution_0/v3_four_channel_phase_distribution_0/v3_four_channel_output_collection_0/v3_four_channel_placement_0/v3_channel_selector_late_promotion_3/v3_selector_route_pilot_0/G0_LO_N_ANDNOT/a_207_413# VDPWR sky130_fd_pr__pfet_01v8_hvt ad=0 pd=0 as=0.1218 ps=1.42 w=0.42 l=0.15
X1238 v3_four_channel_output_load_integration_0/v3_four_channel_shared_support_integration_0/v3_four_channel_bias_reference_distribution_0/v3_four_channel_phase_distribution_0/v3_four_channel_output_collection_0/v3_four_channel_placement_0/v3_channel_selector_late_promotion_3/v3_selector_route_pilot_0/group0_lo_n v3_four_channel_output_load_integration_0/v3_four_channel_shared_support_integration_0/v3_four_channel_bias_reference_distribution_0/v3_four_channel_phase_distribution_0/v3_four_channel_output_collection_0/v3_four_channel_placement_0/v3_channel_selector_late_promotion_3/v3_selector_route_pilot_0/G0_LO_N_ANDNOT/a_207_413# VDPWR VDPWR sky130_fd_pr__pfet_01v8_hvt ad=0.26 pd=2.52 as=0 ps=0 w=1 l=0.15
X1239 v3_four_channel_output_load_integration_0/v3_four_channel_shared_support_integration_0/v3_four_channel_bias_reference_distribution_0/v3_four_channel_phase_distribution_0/v3_four_channel_output_collection_0/v3_four_channel_placement_0/v3_channel_selector_late_promotion_3/v3_selector_route_pilot_0/G0_LO_N_ANDNOT/a_297_47# v3_four_channel_output_load_integration_0/v3_four_channel_shared_support_integration_0/v3_four_channel_bias_reference_distribution_0/v3_four_channel_phase_distribution_0/v3_four_channel_output_collection_0/v3_four_channel_placement_0/v3_channel_selector_late_promotion_3/v3_selector_route_pilot_0/G0_LO_N_ANDNOT/a_27_413# v3_four_channel_output_load_integration_0/v3_four_channel_shared_support_integration_0/v3_four_channel_bias_reference_distribution_0/v3_four_channel_phase_distribution_0/v3_four_channel_output_collection_0/v3_four_channel_placement_0/v3_channel_selector_late_promotion_3/v3_selector_route_pilot_0/G0_LO_N_ANDNOT/a_207_413# VGND sky130_fd_pr__nfet_01v8 ad=0.1008 pd=1.32 as=0.1092 ps=1.36 w=0.42 l=0.15
X1240 v3_four_channel_output_load_integration_0/v3_four_channel_shared_support_integration_0/v3_four_channel_bias_reference_distribution_0/v3_four_channel_phase_distribution_0/v3_four_channel_output_collection_0/v3_four_channel_placement_0/v3_channel_selector_late_promotion_3/v3_selector_route_pilot_0/group0_lo_n v3_four_channel_output_load_integration_0/v3_four_channel_shared_support_integration_0/v3_four_channel_bias_reference_distribution_0/v3_four_channel_phase_distribution_0/v3_four_channel_output_collection_0/v3_four_channel_placement_0/v3_channel_selector_late_promotion_3/v3_selector_route_pilot_0/G0_LO_N_ANDNOT/a_207_413# VGND VGND sky130_fd_pr__nfet_01v8 ad=0.169 pd=1.82 as=0 ps=0 w=0.65 l=0.15
X1241 v3_four_channel_output_load_integration_0/v3_four_channel_shared_support_integration_0/v3_four_channel_bias_reference_distribution_0/v3_four_channel_phase_distribution_0/v3_four_channel_output_collection_0/v3_four_channel_placement_0/v3_channel_selector_late_promotion_3/v3_selector_route_pilot_0/G0_LO_N_ANDNOT/a_207_413# v3_four_channel_output_load_integration_0/v3_four_channel_shared_support_integration_0/v3_four_channel_bias_reference_distribution_0/v3_four_channel_phase_distribution_0/v3_four_channel_output_collection_0/v3_four_channel_placement_0/v3_channel_selector_late_promotion_3/v3_selector_route_pilot_0/G0_LO_N_ANDNOT/a_27_413# VDPWR VDPWR sky130_fd_pr__pfet_01v8_hvt ad=0 pd=0 as=0 ps=0 w=0.42 l=0.15
X1242 VDPWR v3_four_channel_output_load_integration_0/v3_four_channel_shared_support_integration_0/v3_four_channel_bias_reference_distribution_0/v3_four_channel_phase_distribution_0/v3_four_channel_output_collection_0/v3_four_channel_placement_0/v3_channel_selector_late_promotion_3/v3_selector_route_pilot_0/G0_MUX_AXIS/X v3_four_channel_output_load_integration_0/v3_four_channel_shared_support_integration_0/v3_four_channel_bias_reference_distribution_0/v3_four_channel_phase_distribution_0/v3_four_channel_output_collection_0/v3_four_channel_placement_0/v3_channel_selector_late_promotion_3/v3_selector_route_pilot_0/G0_LO_N_ANDNOT/a_27_413# VDPWR sky130_fd_pr__pfet_01v8_hvt ad=0 pd=0 as=0.1092 ps=1.36 w=0.42 l=0.15
X1243 VGND v3_four_channel_output_load_integration_0/v3_four_channel_shared_support_integration_0/v3_four_channel_bias_reference_distribution_0/v3_four_channel_phase_distribution_0/v3_four_channel_output_collection_0/v3_four_channel_placement_0/v3_channel_selector_late_promotion_3/v3_selector_route_pilot_0/G3_LO_P_AND/B v3_four_channel_output_load_integration_0/v3_four_channel_shared_support_integration_0/v3_four_channel_bias_reference_distribution_0/v3_four_channel_phase_distribution_0/v3_four_channel_output_collection_0/v3_four_channel_placement_0/v3_channel_selector_late_promotion_3/v3_selector_route_pilot_0/G0_LO_N_ANDNOT/a_297_47# VGND sky130_fd_pr__nfet_01v8 ad=0 pd=0 as=0 ps=0 w=0.42 l=0.15
X1244 v3_four_channel_output_load_integration_0/v3_four_channel_shared_support_integration_0/v3_four_channel_bias_reference_distribution_0/v3_four_channel_phase_distribution_0/v3_four_channel_output_collection_0/v3_four_channel_placement_0/v3_channel_selector_late_promotion_3/v3_selector_route_pilot_0/G0_LO_N_ANDNOT/a_27_413# v3_four_channel_output_load_integration_0/v3_four_channel_shared_support_integration_0/v3_four_channel_bias_reference_distribution_0/v3_four_channel_phase_distribution_0/v3_four_channel_output_collection_0/v3_four_channel_placement_0/v3_channel_selector_late_promotion_3/v3_selector_route_pilot_0/G0_MUX_AXIS/X VGND VGND sky130_fd_pr__nfet_01v8 ad=0.1092 pd=1.36 as=0 ps=0 w=0.42 l=0.15
X1245 VDPWR v3_four_channel_output_load_integration_0/v3_four_channel_shared_support_integration_0/v3_four_channel_bias_reference_distribution_0/v3_four_channel_phase_distribution_0/v3_four_channel_output_collection_0/v3_four_channel_placement_0/v3_channel_selector_late_promotion_3/v3_selector_route_pilot_0/G1_MUX_AXIS/a_505_21# v3_four_channel_output_load_integration_0/v3_four_channel_shared_support_integration_0/v3_four_channel_bias_reference_distribution_0/v3_four_channel_phase_distribution_0/v3_four_channel_output_collection_0/v3_four_channel_placement_0/v3_channel_selector_late_promotion_3/v3_selector_route_pilot_0/G1_MUX_AXIS/a_535_374# VDPWR sky130_fd_pr__pfet_01v8_hvt ad=0 pd=0 as=0.0882 ps=1.26 w=0.42 l=0.15
X1246 v3_four_channel_output_load_integration_0/v3_four_channel_shared_support_integration_0/v3_four_channel_bias_reference_distribution_0/v3_four_channel_phase_distribution_0/v3_four_channel_output_collection_0/v3_four_channel_placement_0/v3_channel_selector_late_promotion_3/v3_selector_route_pilot_0/G1_MUX_AXIS/a_505_21# v3_four_channel_output_load_integration_0/v3_four_channel_shared_support_integration_0/v3_four_channel_bias_reference_distribution_0/v3_four_channel_phase_distribution_0/v3_four_channel_output_collection_0/v3_four_channel_placement_0/v3_channel_selector_late_promotion_3/group1_bit1 VDPWR VDPWR sky130_fd_pr__pfet_01v8_hvt ad=0.1176 pd=1.4 as=0 ps=0 w=0.42 l=0.15
X1247 v3_four_channel_output_load_integration_0/v3_four_channel_shared_support_integration_0/v3_four_channel_bias_reference_distribution_0/v3_four_channel_phase_distribution_0/v3_four_channel_output_collection_0/v3_four_channel_placement_0/v3_channel_selector_late_promotion_3/v3_selector_route_pilot_0/G1_MUX_AXIS/a_218_374# v3_four_channel_output_load_integration_0/v3_four_channel_shared_support_integration_0/v3_four_channel_bias_reference_distribution_0/v3_four_channel_phase_distribution_0/v3_four_channel_output_collection_0/v3_four_channel_placement_0/v3_channel_selector_late_promotion_3/group1_bit1 VDPWR VDPWR sky130_fd_pr__pfet_01v8_hvt ad=0.1533 pd=1.57 as=0 ps=0 w=0.42 l=0.15
X1248 VGND v3_four_channel_output_load_integration_0/v3_four_channel_shared_support_integration_0/v3_four_channel_bias_reference_distribution_0/v3_four_channel_phase_distribution_0/v3_four_channel_output_collection_0/v3_four_channel_placement_0/v3_channel_selector_late_promotion_3/v3_selector_route_pilot_0/G1_MUX_AXIS/a_505_21# v3_four_channel_output_load_integration_0/v3_four_channel_shared_support_integration_0/v3_four_channel_bias_reference_distribution_0/v3_four_channel_phase_distribution_0/v3_four_channel_output_collection_0/v3_four_channel_placement_0/v3_channel_selector_late_promotion_3/v3_selector_route_pilot_0/G1_MUX_AXIS/a_439_47# VGND sky130_fd_pr__nfet_01v8 ad=0 pd=0 as=0.1386 ps=1.5 w=0.42 l=0.15
X1249 v3_four_channel_output_load_integration_0/v3_four_channel_shared_support_integration_0/v3_four_channel_bias_reference_distribution_0/v3_four_channel_phase_distribution_0/v3_four_channel_output_collection_0/v3_four_channel_placement_0/v3_channel_selector_late_promotion_3/v3_selector_route_pilot_0/G1_MUX_AXIS/a_76_199# v3_four_channel_output_load_integration_0/v3_four_channel_shared_support_integration_0/v3_four_channel_bias_reference_distribution_0/v3_four_channel_phase_distribution_0/v3_four_channel_output_collection_0/v3_four_channel_placement_0/v3_channel_selector_late_promotion_3/v3_selector_route_pilot_0/G1_MUX_POS/X v3_four_channel_output_load_integration_0/v3_four_channel_shared_support_integration_0/v3_four_channel_bias_reference_distribution_0/v3_four_channel_phase_distribution_0/v3_four_channel_output_collection_0/v3_four_channel_placement_0/v3_channel_selector_late_promotion_3/v3_selector_route_pilot_0/G1_MUX_AXIS/a_218_374# VDPWR sky130_fd_pr__pfet_01v8_hvt ad=0.3864 pd=2.68 as=0 ps=0 w=0.42 l=0.15
X1250 v3_four_channel_output_load_integration_0/v3_four_channel_shared_support_integration_0/v3_four_channel_bias_reference_distribution_0/v3_four_channel_phase_distribution_0/v3_four_channel_output_collection_0/v3_four_channel_placement_0/v3_channel_selector_late_promotion_3/v3_selector_route_pilot_0/G1_MUX_AXIS/a_505_21# v3_four_channel_output_load_integration_0/v3_four_channel_shared_support_integration_0/v3_four_channel_bias_reference_distribution_0/v3_four_channel_phase_distribution_0/v3_four_channel_output_collection_0/v3_four_channel_placement_0/v3_channel_selector_late_promotion_3/group1_bit1 VGND VGND sky130_fd_pr__nfet_01v8 ad=0.1092 pd=1.36 as=0 ps=0 w=0.42 l=0.15
X1251 v3_four_channel_output_load_integration_0/v3_four_channel_shared_support_integration_0/v3_four_channel_bias_reference_distribution_0/v3_four_channel_phase_distribution_0/v3_four_channel_output_collection_0/v3_four_channel_placement_0/v3_channel_selector_late_promotion_3/v3_selector_route_pilot_0/G1_MUX_AXIS/a_439_47# v3_four_channel_output_load_integration_0/v3_four_channel_shared_support_integration_0/v3_four_channel_bias_reference_distribution_0/v3_four_channel_phase_distribution_0/v3_four_channel_output_collection_0/v3_four_channel_placement_0/v3_channel_selector_late_promotion_3/v3_selector_route_pilot_0/G1_MUX_POS/X v3_four_channel_output_load_integration_0/v3_four_channel_shared_support_integration_0/v3_four_channel_bias_reference_distribution_0/v3_four_channel_phase_distribution_0/v3_four_channel_output_collection_0/v3_four_channel_placement_0/v3_channel_selector_late_promotion_3/v3_selector_route_pilot_0/G1_MUX_AXIS/a_76_199# VGND sky130_fd_pr__nfet_01v8 ad=0 pd=0 as=0.1995 ps=1.79 w=0.42 l=0.15
X1252 v3_four_channel_output_load_integration_0/v3_four_channel_shared_support_integration_0/v3_four_channel_bias_reference_distribution_0/v3_four_channel_phase_distribution_0/v3_four_channel_output_collection_0/v3_four_channel_placement_0/v3_channel_selector_late_promotion_3/v3_selector_route_pilot_0/G1_MUX_AXIS/a_535_374# v3_four_channel_output_load_integration_0/v3_four_channel_shared_support_integration_0/v3_four_channel_bias_reference_distribution_0/v3_four_channel_phase_distribution_0/v3_four_channel_output_collection_0/v3_four_channel_placement_0/v3_channel_selector_late_promotion_3/v3_selector_route_pilot_0/G1_MUX_NEG/X v3_four_channel_output_load_integration_0/v3_four_channel_shared_support_integration_0/v3_four_channel_bias_reference_distribution_0/v3_four_channel_phase_distribution_0/v3_four_channel_output_collection_0/v3_four_channel_placement_0/v3_channel_selector_late_promotion_3/v3_selector_route_pilot_0/G1_MUX_AXIS/a_76_199# VDPWR sky130_fd_pr__pfet_01v8_hvt ad=0 pd=0 as=0 ps=0 w=0.42 l=0.15
X1253 v3_four_channel_output_load_integration_0/v3_four_channel_shared_support_integration_0/v3_four_channel_bias_reference_distribution_0/v3_four_channel_phase_distribution_0/v3_four_channel_output_collection_0/v3_four_channel_placement_0/v3_channel_selector_late_promotion_3/v3_selector_route_pilot_0/G1_MUX_AXIS/a_76_199# v3_four_channel_output_load_integration_0/v3_four_channel_shared_support_integration_0/v3_four_channel_bias_reference_distribution_0/v3_four_channel_phase_distribution_0/v3_four_channel_output_collection_0/v3_four_channel_placement_0/v3_channel_selector_late_promotion_3/v3_selector_route_pilot_0/G1_MUX_NEG/X v3_four_channel_output_load_integration_0/v3_four_channel_shared_support_integration_0/v3_four_channel_bias_reference_distribution_0/v3_four_channel_phase_distribution_0/v3_four_channel_output_collection_0/v3_four_channel_placement_0/v3_channel_selector_late_promotion_3/v3_selector_route_pilot_0/G1_MUX_AXIS/a_218_47# VGND sky130_fd_pr__nfet_01v8 ad=0 pd=0 as=0.1386 ps=1.5 w=0.42 l=0.15
X1254 v3_four_channel_output_load_integration_0/v3_four_channel_shared_support_integration_0/v3_four_channel_bias_reference_distribution_0/v3_four_channel_phase_distribution_0/v3_four_channel_output_collection_0/v3_four_channel_placement_0/v3_channel_selector_late_promotion_3/v3_selector_route_pilot_0/G1_MUX_AXIS/a_218_47# v3_four_channel_output_load_integration_0/v3_four_channel_shared_support_integration_0/v3_four_channel_bias_reference_distribution_0/v3_four_channel_phase_distribution_0/v3_four_channel_output_collection_0/v3_four_channel_placement_0/v3_channel_selector_late_promotion_3/group1_bit1 VGND VGND sky130_fd_pr__nfet_01v8 ad=0 pd=0 as=0 ps=0 w=0.42 l=0.15
X1255 VDPWR v3_four_channel_output_load_integration_0/v3_four_channel_shared_support_integration_0/v3_four_channel_bias_reference_distribution_0/v3_four_channel_phase_distribution_0/v3_four_channel_output_collection_0/v3_four_channel_placement_0/v3_channel_selector_late_promotion_3/v3_selector_route_pilot_0/G1_MUX_AXIS/a_76_199# v3_four_channel_output_load_integration_0/v3_four_channel_shared_support_integration_0/v3_four_channel_bias_reference_distribution_0/v3_four_channel_phase_distribution_0/v3_four_channel_output_collection_0/v3_four_channel_placement_0/v3_channel_selector_late_promotion_3/v3_selector_route_pilot_0/G1_MUX_AXIS/X VDPWR sky130_fd_pr__pfet_01v8_hvt ad=0 pd=0 as=0.26 ps=2.52 w=1 l=0.15
X1256 VGND v3_four_channel_output_load_integration_0/v3_four_channel_shared_support_integration_0/v3_four_channel_bias_reference_distribution_0/v3_four_channel_phase_distribution_0/v3_four_channel_output_collection_0/v3_four_channel_placement_0/v3_channel_selector_late_promotion_3/v3_selector_route_pilot_0/G1_MUX_AXIS/a_76_199# v3_four_channel_output_load_integration_0/v3_four_channel_shared_support_integration_0/v3_four_channel_bias_reference_distribution_0/v3_four_channel_phase_distribution_0/v3_four_channel_output_collection_0/v3_four_channel_placement_0/v3_channel_selector_late_promotion_3/v3_selector_route_pilot_0/G1_MUX_AXIS/X VGND sky130_fd_pr__nfet_01v8 ad=0 pd=0 as=0.169 ps=1.82 w=0.65 l=0.15
X1257 VDPWR v3_four_channel_output_load_integration_0/v3_four_channel_shared_support_integration_0/v3_four_channel_bias_reference_distribution_0/v3_four_channel_phase_distribution_0/v3_four_channel_output_collection_0/v3_four_channel_placement_0/v3_channel_selector_late_promotion_3/v3_selector_route_pilot_0/G3_LO_P_AND/B v3_four_channel_output_load_integration_0/v3_four_channel_shared_support_integration_0/v3_four_channel_bias_reference_distribution_0/v3_four_channel_phase_distribution_0/v3_four_channel_output_collection_0/v3_four_channel_placement_0/v3_channel_selector_late_promotion_3/v3_selector_route_pilot_0/G1_LO_N_ANDNOT/a_207_413# VDPWR sky130_fd_pr__pfet_01v8_hvt ad=0 pd=0 as=0.1218 ps=1.42 w=0.42 l=0.15
X1258 v3_four_channel_output_load_integration_0/v3_four_channel_shared_support_integration_0/v3_four_channel_bias_reference_distribution_0/v3_four_channel_phase_distribution_0/v3_four_channel_output_collection_0/v3_four_channel_placement_0/v3_channel_selector_late_promotion_3/v3_selector_route_pilot_0/group1_lo_n v3_four_channel_output_load_integration_0/v3_four_channel_shared_support_integration_0/v3_four_channel_bias_reference_distribution_0/v3_four_channel_phase_distribution_0/v3_four_channel_output_collection_0/v3_four_channel_placement_0/v3_channel_selector_late_promotion_3/v3_selector_route_pilot_0/G1_LO_N_ANDNOT/a_207_413# VDPWR VDPWR sky130_fd_pr__pfet_01v8_hvt ad=0.26 pd=2.52 as=0 ps=0 w=1 l=0.15
X1259 v3_four_channel_output_load_integration_0/v3_four_channel_shared_support_integration_0/v3_four_channel_bias_reference_distribution_0/v3_four_channel_phase_distribution_0/v3_four_channel_output_collection_0/v3_four_channel_placement_0/v3_channel_selector_late_promotion_3/v3_selector_route_pilot_0/G1_LO_N_ANDNOT/a_297_47# v3_four_channel_output_load_integration_0/v3_four_channel_shared_support_integration_0/v3_four_channel_bias_reference_distribution_0/v3_four_channel_phase_distribution_0/v3_four_channel_output_collection_0/v3_four_channel_placement_0/v3_channel_selector_late_promotion_3/v3_selector_route_pilot_0/G1_LO_N_ANDNOT/a_27_413# v3_four_channel_output_load_integration_0/v3_four_channel_shared_support_integration_0/v3_four_channel_bias_reference_distribution_0/v3_four_channel_phase_distribution_0/v3_four_channel_output_collection_0/v3_four_channel_placement_0/v3_channel_selector_late_promotion_3/v3_selector_route_pilot_0/G1_LO_N_ANDNOT/a_207_413# VGND sky130_fd_pr__nfet_01v8 ad=0.1008 pd=1.32 as=0.1092 ps=1.36 w=0.42 l=0.15
X1260 v3_four_channel_output_load_integration_0/v3_four_channel_shared_support_integration_0/v3_four_channel_bias_reference_distribution_0/v3_four_channel_phase_distribution_0/v3_four_channel_output_collection_0/v3_four_channel_placement_0/v3_channel_selector_late_promotion_3/v3_selector_route_pilot_0/group1_lo_n v3_four_channel_output_load_integration_0/v3_four_channel_shared_support_integration_0/v3_four_channel_bias_reference_distribution_0/v3_four_channel_phase_distribution_0/v3_four_channel_output_collection_0/v3_four_channel_placement_0/v3_channel_selector_late_promotion_3/v3_selector_route_pilot_0/G1_LO_N_ANDNOT/a_207_413# VGND VGND sky130_fd_pr__nfet_01v8 ad=0.169 pd=1.82 as=0 ps=0 w=0.65 l=0.15
X1261 v3_four_channel_output_load_integration_0/v3_four_channel_shared_support_integration_0/v3_four_channel_bias_reference_distribution_0/v3_four_channel_phase_distribution_0/v3_four_channel_output_collection_0/v3_four_channel_placement_0/v3_channel_selector_late_promotion_3/v3_selector_route_pilot_0/G1_LO_N_ANDNOT/a_207_413# v3_four_channel_output_load_integration_0/v3_four_channel_shared_support_integration_0/v3_four_channel_bias_reference_distribution_0/v3_four_channel_phase_distribution_0/v3_four_channel_output_collection_0/v3_four_channel_placement_0/v3_channel_selector_late_promotion_3/v3_selector_route_pilot_0/G1_LO_N_ANDNOT/a_27_413# VDPWR VDPWR sky130_fd_pr__pfet_01v8_hvt ad=0 pd=0 as=0 ps=0 w=0.42 l=0.15
X1262 VDPWR v3_four_channel_output_load_integration_0/v3_four_channel_shared_support_integration_0/v3_four_channel_bias_reference_distribution_0/v3_four_channel_phase_distribution_0/v3_four_channel_output_collection_0/v3_four_channel_placement_0/v3_channel_selector_late_promotion_3/v3_selector_route_pilot_0/G1_MUX_AXIS/X v3_four_channel_output_load_integration_0/v3_four_channel_shared_support_integration_0/v3_four_channel_bias_reference_distribution_0/v3_four_channel_phase_distribution_0/v3_four_channel_output_collection_0/v3_four_channel_placement_0/v3_channel_selector_late_promotion_3/v3_selector_route_pilot_0/G1_LO_N_ANDNOT/a_27_413# VDPWR sky130_fd_pr__pfet_01v8_hvt ad=0 pd=0 as=0.1092 ps=1.36 w=0.42 l=0.15
X1263 VGND v3_four_channel_output_load_integration_0/v3_four_channel_shared_support_integration_0/v3_four_channel_bias_reference_distribution_0/v3_four_channel_phase_distribution_0/v3_four_channel_output_collection_0/v3_four_channel_placement_0/v3_channel_selector_late_promotion_3/v3_selector_route_pilot_0/G3_LO_P_AND/B v3_four_channel_output_load_integration_0/v3_four_channel_shared_support_integration_0/v3_four_channel_bias_reference_distribution_0/v3_four_channel_phase_distribution_0/v3_four_channel_output_collection_0/v3_four_channel_placement_0/v3_channel_selector_late_promotion_3/v3_selector_route_pilot_0/G1_LO_N_ANDNOT/a_297_47# VGND sky130_fd_pr__nfet_01v8 ad=0 pd=0 as=0 ps=0 w=0.42 l=0.15
X1264 v3_four_channel_output_load_integration_0/v3_four_channel_shared_support_integration_0/v3_four_channel_bias_reference_distribution_0/v3_four_channel_phase_distribution_0/v3_four_channel_output_collection_0/v3_four_channel_placement_0/v3_channel_selector_late_promotion_3/v3_selector_route_pilot_0/G1_LO_N_ANDNOT/a_27_413# v3_four_channel_output_load_integration_0/v3_four_channel_shared_support_integration_0/v3_four_channel_bias_reference_distribution_0/v3_four_channel_phase_distribution_0/v3_four_channel_output_collection_0/v3_four_channel_placement_0/v3_channel_selector_late_promotion_3/v3_selector_route_pilot_0/G1_MUX_AXIS/X VGND VGND sky130_fd_pr__nfet_01v8 ad=0.1092 pd=1.36 as=0 ps=0 w=0.42 l=0.15
X1265 VDPWR v3_four_channel_output_load_integration_0/v3_four_channel_shared_support_integration_0/v3_four_channel_bias_reference_distribution_0/v3_four_channel_phase_distribution_0/v3_four_channel_output_collection_0/v3_four_channel_placement_0/v3_channel_selector_late_promotion_3/v3_selector_route_pilot_0/G3_LO_P_AND/B v3_four_channel_output_load_integration_0/v3_four_channel_shared_support_integration_0/v3_four_channel_bias_reference_distribution_0/v3_four_channel_phase_distribution_0/v3_four_channel_output_collection_0/v3_four_channel_placement_0/v3_channel_selector_late_promotion_3/v3_selector_route_pilot_0/G3_LO_P_AND/a_59_75# VDPWR sky130_fd_pr__pfet_01v8_hvt ad=0 pd=0 as=0.1134 ps=1.38 w=0.42 l=0.15
X1266 v3_four_channel_output_load_integration_0/v3_four_channel_shared_support_integration_0/v3_four_channel_bias_reference_distribution_0/v3_four_channel_phase_distribution_0/v3_four_channel_output_collection_0/v3_four_channel_placement_0/v3_channel_selector_late_promotion_3/v3_selector_route_pilot_0/group3_lo_p v3_four_channel_output_load_integration_0/v3_four_channel_shared_support_integration_0/v3_four_channel_bias_reference_distribution_0/v3_four_channel_phase_distribution_0/v3_four_channel_output_collection_0/v3_four_channel_placement_0/v3_channel_selector_late_promotion_3/v3_selector_route_pilot_0/G3_LO_P_AND/a_59_75# VDPWR VDPWR sky130_fd_pr__pfet_01v8_hvt ad=0.475 pd=2.95 as=0 ps=0 w=1 l=0.15
X1267 VGND v3_four_channel_output_load_integration_0/v3_four_channel_shared_support_integration_0/v3_four_channel_bias_reference_distribution_0/v3_four_channel_phase_distribution_0/v3_four_channel_output_collection_0/v3_four_channel_placement_0/v3_channel_selector_late_promotion_3/v3_selector_route_pilot_0/G3_LO_P_AND/B v3_four_channel_output_load_integration_0/v3_four_channel_shared_support_integration_0/v3_four_channel_bias_reference_distribution_0/v3_four_channel_phase_distribution_0/v3_four_channel_output_collection_0/v3_four_channel_placement_0/v3_channel_selector_late_promotion_3/v3_selector_route_pilot_0/G3_LO_P_AND/a_145_75# VGND sky130_fd_pr__nfet_01v8 ad=0 pd=0 as=0.1134 ps=1.38 w=0.42 l=0.15
X1268 v3_four_channel_output_load_integration_0/v3_four_channel_shared_support_integration_0/v3_four_channel_bias_reference_distribution_0/v3_four_channel_phase_distribution_0/v3_four_channel_output_collection_0/v3_four_channel_placement_0/v3_channel_selector_late_promotion_3/v3_selector_route_pilot_0/G3_LO_P_AND/a_59_75# v3_four_channel_output_load_integration_0/v3_four_channel_shared_support_integration_0/v3_four_channel_bias_reference_distribution_0/v3_four_channel_phase_distribution_0/v3_four_channel_output_collection_0/v3_four_channel_placement_0/v3_channel_selector_late_promotion_3/v3_selector_route_pilot_0/G3_MUX_AXIS/X VDPWR VDPWR sky130_fd_pr__pfet_01v8_hvt ad=0 pd=0 as=0 ps=0 w=0.42 l=0.15
X1269 v3_four_channel_output_load_integration_0/v3_four_channel_shared_support_integration_0/v3_four_channel_bias_reference_distribution_0/v3_four_channel_phase_distribution_0/v3_four_channel_output_collection_0/v3_four_channel_placement_0/v3_channel_selector_late_promotion_3/v3_selector_route_pilot_0/group3_lo_p v3_four_channel_output_load_integration_0/v3_four_channel_shared_support_integration_0/v3_four_channel_bias_reference_distribution_0/v3_four_channel_phase_distribution_0/v3_four_channel_output_collection_0/v3_four_channel_placement_0/v3_channel_selector_late_promotion_3/v3_selector_route_pilot_0/G3_LO_P_AND/a_59_75# VGND VGND sky130_fd_pr__nfet_01v8 ad=0.182 pd=1.86 as=0 ps=0 w=0.65 l=0.15
X1270 v3_four_channel_output_load_integration_0/v3_four_channel_shared_support_integration_0/v3_four_channel_bias_reference_distribution_0/v3_four_channel_phase_distribution_0/v3_four_channel_output_collection_0/v3_four_channel_placement_0/v3_channel_selector_late_promotion_3/v3_selector_route_pilot_0/G3_LO_P_AND/a_145_75# v3_four_channel_output_load_integration_0/v3_four_channel_shared_support_integration_0/v3_four_channel_bias_reference_distribution_0/v3_four_channel_phase_distribution_0/v3_four_channel_output_collection_0/v3_four_channel_placement_0/v3_channel_selector_late_promotion_3/v3_selector_route_pilot_0/G3_MUX_AXIS/X v3_four_channel_output_load_integration_0/v3_four_channel_shared_support_integration_0/v3_four_channel_bias_reference_distribution_0/v3_four_channel_phase_distribution_0/v3_four_channel_output_collection_0/v3_four_channel_placement_0/v3_channel_selector_late_promotion_3/v3_selector_route_pilot_0/G3_LO_P_AND/a_59_75# VGND sky130_fd_pr__nfet_01v8 ad=0 pd=0 as=0.1176 ps=1.4 w=0.42 l=0.15
X1271 VDPWR v3_four_channel_output_load_integration_0/v3_four_channel_shared_support_integration_0/v3_four_channel_bias_reference_distribution_0/v3_four_channel_phase_distribution_0/v3_four_channel_output_collection_0/v3_four_channel_placement_0/v3_channel_selector_late_promotion_3/v3_selector_route_pilot_0/G2_MUX_POS/a_505_21# v3_four_channel_output_load_integration_0/v3_four_channel_shared_support_integration_0/v3_four_channel_bias_reference_distribution_0/v3_four_channel_phase_distribution_0/v3_four_channel_output_collection_0/v3_four_channel_placement_0/v3_channel_selector_late_promotion_3/v3_selector_route_pilot_0/G2_MUX_POS/a_535_374# VDPWR sky130_fd_pr__pfet_01v8_hvt ad=0 pd=0 as=0.0882 ps=1.26 w=0.42 l=0.15
X1272 v3_four_channel_output_load_integration_0/v3_four_channel_shared_support_integration_0/v3_four_channel_bias_reference_distribution_0/v3_four_channel_phase_distribution_0/v3_four_channel_output_collection_0/v3_four_channel_placement_0/v3_channel_selector_late_promotion_3/v3_selector_route_pilot_0/G2_MUX_POS/a_505_21# v3_four_channel_output_load_integration_0/v3_four_channel_shared_support_integration_0/v3_four_channel_bias_reference_distribution_0/v3_four_channel_phase_distribution_0/v3_four_channel_output_collection_0/v3_four_channel_placement_0/v3_channel_selector_late_promotion_3/group2_bit0 VDPWR VDPWR sky130_fd_pr__pfet_01v8_hvt ad=0.1176 pd=1.4 as=0 ps=0 w=0.42 l=0.15
X1273 v3_four_channel_output_load_integration_0/v3_four_channel_shared_support_integration_0/v3_four_channel_bias_reference_distribution_0/v3_four_channel_phase_distribution_0/v3_four_channel_output_collection_0/v3_four_channel_placement_0/v3_channel_selector_late_promotion_3/v3_selector_route_pilot_0/G2_MUX_POS/a_218_374# v3_four_channel_output_load_integration_0/v3_four_channel_shared_support_integration_0/v3_four_channel_bias_reference_distribution_0/v3_four_channel_phase_distribution_0/v3_four_channel_output_collection_0/v3_four_channel_placement_0/v3_channel_selector_late_promotion_3/group2_bit0 VDPWR VDPWR sky130_fd_pr__pfet_01v8_hvt ad=0.1533 pd=1.57 as=0 ps=0 w=0.42 l=0.15
X1274 VGND v3_four_channel_output_load_integration_0/v3_four_channel_shared_support_integration_0/v3_four_channel_bias_reference_distribution_0/v3_four_channel_phase_distribution_0/v3_four_channel_output_collection_0/v3_four_channel_placement_0/v3_channel_selector_late_promotion_3/v3_selector_route_pilot_0/G2_MUX_POS/a_505_21# v3_four_channel_output_load_integration_0/v3_four_channel_shared_support_integration_0/v3_four_channel_bias_reference_distribution_0/v3_four_channel_phase_distribution_0/v3_four_channel_output_collection_0/v3_four_channel_placement_0/v3_channel_selector_late_promotion_3/v3_selector_route_pilot_0/G2_MUX_POS/a_439_47# VGND sky130_fd_pr__nfet_01v8 ad=0 pd=0 as=0.1386 ps=1.5 w=0.42 l=0.15
X1275 v3_four_channel_output_load_integration_0/v3_four_channel_shared_support_integration_0/v3_four_channel_bias_reference_distribution_0/v3_four_channel_phase_distribution_0/v3_four_channel_output_collection_0/v3_four_channel_placement_0/v3_channel_selector_late_promotion_3/v3_selector_route_pilot_0/G2_MUX_POS/a_76_199# v3_four_channel_output_load_integration_0/v3_four_channel_shared_support_integration_0/v3_four_channel_bias_reference_distribution_0/v3_four_channel_phase_distribution_0/phase_0 v3_four_channel_output_load_integration_0/v3_four_channel_shared_support_integration_0/v3_four_channel_bias_reference_distribution_0/v3_four_channel_phase_distribution_0/v3_four_channel_output_collection_0/v3_four_channel_placement_0/v3_channel_selector_late_promotion_3/v3_selector_route_pilot_0/G2_MUX_POS/a_218_374# VDPWR sky130_fd_pr__pfet_01v8_hvt ad=0.3864 pd=2.68 as=0 ps=0 w=0.42 l=0.15
X1276 v3_four_channel_output_load_integration_0/v3_four_channel_shared_support_integration_0/v3_four_channel_bias_reference_distribution_0/v3_four_channel_phase_distribution_0/v3_four_channel_output_collection_0/v3_four_channel_placement_0/v3_channel_selector_late_promotion_3/v3_selector_route_pilot_0/G2_MUX_POS/a_505_21# v3_four_channel_output_load_integration_0/v3_four_channel_shared_support_integration_0/v3_four_channel_bias_reference_distribution_0/v3_four_channel_phase_distribution_0/v3_four_channel_output_collection_0/v3_four_channel_placement_0/v3_channel_selector_late_promotion_3/group2_bit0 VGND VGND sky130_fd_pr__nfet_01v8 ad=0.1092 pd=1.36 as=0 ps=0 w=0.42 l=0.15
X1277 v3_four_channel_output_load_integration_0/v3_four_channel_shared_support_integration_0/v3_four_channel_bias_reference_distribution_0/v3_four_channel_phase_distribution_0/v3_four_channel_output_collection_0/v3_four_channel_placement_0/v3_channel_selector_late_promotion_3/v3_selector_route_pilot_0/G2_MUX_POS/a_439_47# v3_four_channel_output_load_integration_0/v3_four_channel_shared_support_integration_0/v3_four_channel_bias_reference_distribution_0/v3_four_channel_phase_distribution_0/phase_0 v3_four_channel_output_load_integration_0/v3_four_channel_shared_support_integration_0/v3_four_channel_bias_reference_distribution_0/v3_four_channel_phase_distribution_0/v3_four_channel_output_collection_0/v3_four_channel_placement_0/v3_channel_selector_late_promotion_3/v3_selector_route_pilot_0/G2_MUX_POS/a_76_199# VGND sky130_fd_pr__nfet_01v8 ad=0 pd=0 as=0.1995 ps=1.79 w=0.42 l=0.15
X1278 v3_four_channel_output_load_integration_0/v3_four_channel_shared_support_integration_0/v3_four_channel_bias_reference_distribution_0/v3_four_channel_phase_distribution_0/v3_four_channel_output_collection_0/v3_four_channel_placement_0/v3_channel_selector_late_promotion_3/v3_selector_route_pilot_0/G2_MUX_POS/a_535_374# v3_four_channel_output_load_integration_0/v3_four_channel_shared_support_integration_0/v3_four_channel_bias_reference_distribution_0/v3_four_channel_phase_distribution_0/phase_90 v3_four_channel_output_load_integration_0/v3_four_channel_shared_support_integration_0/v3_four_channel_bias_reference_distribution_0/v3_four_channel_phase_distribution_0/v3_four_channel_output_collection_0/v3_four_channel_placement_0/v3_channel_selector_late_promotion_3/v3_selector_route_pilot_0/G2_MUX_POS/a_76_199# VDPWR sky130_fd_pr__pfet_01v8_hvt ad=0 pd=0 as=0 ps=0 w=0.42 l=0.15
X1279 v3_four_channel_output_load_integration_0/v3_four_channel_shared_support_integration_0/v3_four_channel_bias_reference_distribution_0/v3_four_channel_phase_distribution_0/v3_four_channel_output_collection_0/v3_four_channel_placement_0/v3_channel_selector_late_promotion_3/v3_selector_route_pilot_0/G2_MUX_POS/a_76_199# v3_four_channel_output_load_integration_0/v3_four_channel_shared_support_integration_0/v3_four_channel_bias_reference_distribution_0/v3_four_channel_phase_distribution_0/phase_90 v3_four_channel_output_load_integration_0/v3_four_channel_shared_support_integration_0/v3_four_channel_bias_reference_distribution_0/v3_four_channel_phase_distribution_0/v3_four_channel_output_collection_0/v3_four_channel_placement_0/v3_channel_selector_late_promotion_3/v3_selector_route_pilot_0/G2_MUX_POS/a_218_47# VGND sky130_fd_pr__nfet_01v8 ad=0 pd=0 as=0.1386 ps=1.5 w=0.42 l=0.15
X1280 v3_four_channel_output_load_integration_0/v3_four_channel_shared_support_integration_0/v3_four_channel_bias_reference_distribution_0/v3_four_channel_phase_distribution_0/v3_four_channel_output_collection_0/v3_four_channel_placement_0/v3_channel_selector_late_promotion_3/v3_selector_route_pilot_0/G2_MUX_POS/a_218_47# v3_four_channel_output_load_integration_0/v3_four_channel_shared_support_integration_0/v3_four_channel_bias_reference_distribution_0/v3_four_channel_phase_distribution_0/v3_four_channel_output_collection_0/v3_four_channel_placement_0/v3_channel_selector_late_promotion_3/group2_bit0 VGND VGND sky130_fd_pr__nfet_01v8 ad=0 pd=0 as=0 ps=0 w=0.42 l=0.15
X1281 VDPWR v3_four_channel_output_load_integration_0/v3_four_channel_shared_support_integration_0/v3_four_channel_bias_reference_distribution_0/v3_four_channel_phase_distribution_0/v3_four_channel_output_collection_0/v3_four_channel_placement_0/v3_channel_selector_late_promotion_3/v3_selector_route_pilot_0/G2_MUX_POS/a_76_199# v3_four_channel_output_load_integration_0/v3_four_channel_shared_support_integration_0/v3_four_channel_bias_reference_distribution_0/v3_four_channel_phase_distribution_0/v3_four_channel_output_collection_0/v3_four_channel_placement_0/v3_channel_selector_late_promotion_3/v3_selector_route_pilot_0/G2_MUX_POS/X VDPWR sky130_fd_pr__pfet_01v8_hvt ad=0 pd=0 as=0.26 ps=2.52 w=1 l=0.15
X1282 VGND v3_four_channel_output_load_integration_0/v3_four_channel_shared_support_integration_0/v3_four_channel_bias_reference_distribution_0/v3_four_channel_phase_distribution_0/v3_four_channel_output_collection_0/v3_four_channel_placement_0/v3_channel_selector_late_promotion_3/v3_selector_route_pilot_0/G2_MUX_POS/a_76_199# v3_four_channel_output_load_integration_0/v3_four_channel_shared_support_integration_0/v3_four_channel_bias_reference_distribution_0/v3_four_channel_phase_distribution_0/v3_four_channel_output_collection_0/v3_four_channel_placement_0/v3_channel_selector_late_promotion_3/v3_selector_route_pilot_0/G2_MUX_POS/X VGND sky130_fd_pr__nfet_01v8 ad=0 pd=0 as=0.169 ps=1.82 w=0.65 l=0.15
X1283 VDPWR v3_four_channel_output_load_integration_0/v3_four_channel_shared_support_integration_0/v3_four_channel_bias_reference_distribution_0/v3_four_channel_phase_distribution_0/v3_four_channel_output_collection_0/v3_four_channel_placement_0/v3_channel_selector_late_promotion_3/v3_selector_route_pilot_0/G2_MUX_NEG/a_505_21# v3_four_channel_output_load_integration_0/v3_four_channel_shared_support_integration_0/v3_four_channel_bias_reference_distribution_0/v3_four_channel_phase_distribution_0/v3_four_channel_output_collection_0/v3_four_channel_placement_0/v3_channel_selector_late_promotion_3/v3_selector_route_pilot_0/G2_MUX_NEG/a_535_374# VDPWR sky130_fd_pr__pfet_01v8_hvt ad=0 pd=0 as=0.0882 ps=1.26 w=0.42 l=0.15
X1284 v3_four_channel_output_load_integration_0/v3_four_channel_shared_support_integration_0/v3_four_channel_bias_reference_distribution_0/v3_four_channel_phase_distribution_0/v3_four_channel_output_collection_0/v3_four_channel_placement_0/v3_channel_selector_late_promotion_3/v3_selector_route_pilot_0/G2_MUX_NEG/a_505_21# v3_four_channel_output_load_integration_0/v3_four_channel_shared_support_integration_0/v3_four_channel_bias_reference_distribution_0/v3_four_channel_phase_distribution_0/v3_four_channel_output_collection_0/v3_four_channel_placement_0/v3_channel_selector_late_promotion_3/group2_bit0 VDPWR VDPWR sky130_fd_pr__pfet_01v8_hvt ad=0.1176 pd=1.4 as=0 ps=0 w=0.42 l=0.15
X1285 v3_four_channel_output_load_integration_0/v3_four_channel_shared_support_integration_0/v3_four_channel_bias_reference_distribution_0/v3_four_channel_phase_distribution_0/v3_four_channel_output_collection_0/v3_four_channel_placement_0/v3_channel_selector_late_promotion_3/v3_selector_route_pilot_0/G2_MUX_NEG/a_218_374# v3_four_channel_output_load_integration_0/v3_four_channel_shared_support_integration_0/v3_four_channel_bias_reference_distribution_0/v3_four_channel_phase_distribution_0/v3_four_channel_output_collection_0/v3_four_channel_placement_0/v3_channel_selector_late_promotion_3/group2_bit0 VDPWR VDPWR sky130_fd_pr__pfet_01v8_hvt ad=0.1533 pd=1.57 as=0 ps=0 w=0.42 l=0.15
X1286 VGND v3_four_channel_output_load_integration_0/v3_four_channel_shared_support_integration_0/v3_four_channel_bias_reference_distribution_0/v3_four_channel_phase_distribution_0/v3_four_channel_output_collection_0/v3_four_channel_placement_0/v3_channel_selector_late_promotion_3/v3_selector_route_pilot_0/G2_MUX_NEG/a_505_21# v3_four_channel_output_load_integration_0/v3_four_channel_shared_support_integration_0/v3_four_channel_bias_reference_distribution_0/v3_four_channel_phase_distribution_0/v3_four_channel_output_collection_0/v3_four_channel_placement_0/v3_channel_selector_late_promotion_3/v3_selector_route_pilot_0/G2_MUX_NEG/a_439_47# VGND sky130_fd_pr__nfet_01v8 ad=0 pd=0 as=0.1386 ps=1.5 w=0.42 l=0.15
X1287 v3_four_channel_output_load_integration_0/v3_four_channel_shared_support_integration_0/v3_four_channel_bias_reference_distribution_0/v3_four_channel_phase_distribution_0/v3_four_channel_output_collection_0/v3_four_channel_placement_0/v3_channel_selector_late_promotion_3/v3_selector_route_pilot_0/G2_MUX_NEG/a_76_199# v3_four_channel_output_load_integration_0/v3_four_channel_shared_support_integration_0/v3_four_channel_bias_reference_distribution_0/v3_four_channel_phase_distribution_0/phase_180 v3_four_channel_output_load_integration_0/v3_four_channel_shared_support_integration_0/v3_four_channel_bias_reference_distribution_0/v3_four_channel_phase_distribution_0/v3_four_channel_output_collection_0/v3_four_channel_placement_0/v3_channel_selector_late_promotion_3/v3_selector_route_pilot_0/G2_MUX_NEG/a_218_374# VDPWR sky130_fd_pr__pfet_01v8_hvt ad=0.3864 pd=2.68 as=0 ps=0 w=0.42 l=0.15
X1288 v3_four_channel_output_load_integration_0/v3_four_channel_shared_support_integration_0/v3_four_channel_bias_reference_distribution_0/v3_four_channel_phase_distribution_0/v3_four_channel_output_collection_0/v3_four_channel_placement_0/v3_channel_selector_late_promotion_3/v3_selector_route_pilot_0/G2_MUX_NEG/a_505_21# v3_four_channel_output_load_integration_0/v3_four_channel_shared_support_integration_0/v3_four_channel_bias_reference_distribution_0/v3_four_channel_phase_distribution_0/v3_four_channel_output_collection_0/v3_four_channel_placement_0/v3_channel_selector_late_promotion_3/group2_bit0 VGND VGND sky130_fd_pr__nfet_01v8 ad=0.1092 pd=1.36 as=0 ps=0 w=0.42 l=0.15
X1289 v3_four_channel_output_load_integration_0/v3_four_channel_shared_support_integration_0/v3_four_channel_bias_reference_distribution_0/v3_four_channel_phase_distribution_0/v3_four_channel_output_collection_0/v3_four_channel_placement_0/v3_channel_selector_late_promotion_3/v3_selector_route_pilot_0/G2_MUX_NEG/a_439_47# v3_four_channel_output_load_integration_0/v3_four_channel_shared_support_integration_0/v3_four_channel_bias_reference_distribution_0/v3_four_channel_phase_distribution_0/phase_180 v3_four_channel_output_load_integration_0/v3_four_channel_shared_support_integration_0/v3_four_channel_bias_reference_distribution_0/v3_four_channel_phase_distribution_0/v3_four_channel_output_collection_0/v3_four_channel_placement_0/v3_channel_selector_late_promotion_3/v3_selector_route_pilot_0/G2_MUX_NEG/a_76_199# VGND sky130_fd_pr__nfet_01v8 ad=0 pd=0 as=0.1995 ps=1.79 w=0.42 l=0.15
X1290 v3_four_channel_output_load_integration_0/v3_four_channel_shared_support_integration_0/v3_four_channel_bias_reference_distribution_0/v3_four_channel_phase_distribution_0/v3_four_channel_output_collection_0/v3_four_channel_placement_0/v3_channel_selector_late_promotion_3/v3_selector_route_pilot_0/G2_MUX_NEG/a_535_374# v3_four_channel_output_load_integration_0/v3_four_channel_shared_support_integration_0/v3_four_channel_bias_reference_distribution_0/v3_four_channel_phase_distribution_0/phase_270 v3_four_channel_output_load_integration_0/v3_four_channel_shared_support_integration_0/v3_four_channel_bias_reference_distribution_0/v3_four_channel_phase_distribution_0/v3_four_channel_output_collection_0/v3_four_channel_placement_0/v3_channel_selector_late_promotion_3/v3_selector_route_pilot_0/G2_MUX_NEG/a_76_199# VDPWR sky130_fd_pr__pfet_01v8_hvt ad=0 pd=0 as=0 ps=0 w=0.42 l=0.15
X1291 v3_four_channel_output_load_integration_0/v3_four_channel_shared_support_integration_0/v3_four_channel_bias_reference_distribution_0/v3_four_channel_phase_distribution_0/v3_four_channel_output_collection_0/v3_four_channel_placement_0/v3_channel_selector_late_promotion_3/v3_selector_route_pilot_0/G2_MUX_NEG/a_76_199# v3_four_channel_output_load_integration_0/v3_four_channel_shared_support_integration_0/v3_four_channel_bias_reference_distribution_0/v3_four_channel_phase_distribution_0/phase_270 v3_four_channel_output_load_integration_0/v3_four_channel_shared_support_integration_0/v3_four_channel_bias_reference_distribution_0/v3_four_channel_phase_distribution_0/v3_four_channel_output_collection_0/v3_four_channel_placement_0/v3_channel_selector_late_promotion_3/v3_selector_route_pilot_0/G2_MUX_NEG/a_218_47# VGND sky130_fd_pr__nfet_01v8 ad=0 pd=0 as=0.1386 ps=1.5 w=0.42 l=0.15
X1292 v3_four_channel_output_load_integration_0/v3_four_channel_shared_support_integration_0/v3_four_channel_bias_reference_distribution_0/v3_four_channel_phase_distribution_0/v3_four_channel_output_collection_0/v3_four_channel_placement_0/v3_channel_selector_late_promotion_3/v3_selector_route_pilot_0/G2_MUX_NEG/a_218_47# v3_four_channel_output_load_integration_0/v3_four_channel_shared_support_integration_0/v3_four_channel_bias_reference_distribution_0/v3_four_channel_phase_distribution_0/v3_four_channel_output_collection_0/v3_four_channel_placement_0/v3_channel_selector_late_promotion_3/group2_bit0 VGND VGND sky130_fd_pr__nfet_01v8 ad=0 pd=0 as=0 ps=0 w=0.42 l=0.15
X1293 VDPWR v3_four_channel_output_load_integration_0/v3_four_channel_shared_support_integration_0/v3_four_channel_bias_reference_distribution_0/v3_four_channel_phase_distribution_0/v3_four_channel_output_collection_0/v3_four_channel_placement_0/v3_channel_selector_late_promotion_3/v3_selector_route_pilot_0/G2_MUX_NEG/a_76_199# v3_four_channel_output_load_integration_0/v3_four_channel_shared_support_integration_0/v3_four_channel_bias_reference_distribution_0/v3_four_channel_phase_distribution_0/v3_four_channel_output_collection_0/v3_four_channel_placement_0/v3_channel_selector_late_promotion_3/v3_selector_route_pilot_0/G2_MUX_NEG/X VDPWR sky130_fd_pr__pfet_01v8_hvt ad=0 pd=0 as=0.26 ps=2.52 w=1 l=0.15
X1294 VGND v3_four_channel_output_load_integration_0/v3_four_channel_shared_support_integration_0/v3_four_channel_bias_reference_distribution_0/v3_four_channel_phase_distribution_0/v3_four_channel_output_collection_0/v3_four_channel_placement_0/v3_channel_selector_late_promotion_3/v3_selector_route_pilot_0/G2_MUX_NEG/a_76_199# v3_four_channel_output_load_integration_0/v3_four_channel_shared_support_integration_0/v3_four_channel_bias_reference_distribution_0/v3_four_channel_phase_distribution_0/v3_four_channel_output_collection_0/v3_four_channel_placement_0/v3_channel_selector_late_promotion_3/v3_selector_route_pilot_0/G2_MUX_NEG/X VGND sky130_fd_pr__nfet_01v8 ad=0 pd=0 as=0.169 ps=1.82 w=0.65 l=0.15
X1295 VDPWR v3_four_channel_output_load_integration_0/v3_four_channel_shared_support_integration_0/v3_four_channel_bias_reference_distribution_0/v3_four_channel_phase_distribution_0/v3_four_channel_output_collection_0/v3_four_channel_placement_0/v3_channel_selector_late_promotion_3/v3_selector_route_pilot_0/G0_MUX_AXIS/a_505_21# v3_four_channel_output_load_integration_0/v3_four_channel_shared_support_integration_0/v3_four_channel_bias_reference_distribution_0/v3_four_channel_phase_distribution_0/v3_four_channel_output_collection_0/v3_four_channel_placement_0/v3_channel_selector_late_promotion_3/v3_selector_route_pilot_0/G0_MUX_AXIS/a_535_374# VDPWR sky130_fd_pr__pfet_01v8_hvt ad=0 pd=0 as=0.0882 ps=1.26 w=0.42 l=0.15
X1296 v3_four_channel_output_load_integration_0/v3_four_channel_shared_support_integration_0/v3_four_channel_bias_reference_distribution_0/v3_four_channel_phase_distribution_0/v3_four_channel_output_collection_0/v3_four_channel_placement_0/v3_channel_selector_late_promotion_3/v3_selector_route_pilot_0/G0_MUX_AXIS/a_505_21# v3_four_channel_output_load_integration_0/v3_four_channel_shared_support_integration_0/v3_four_channel_bias_reference_distribution_0/v3_four_channel_phase_distribution_0/v3_four_channel_output_collection_0/v3_four_channel_placement_0/v3_channel_selector_late_promotion_3/group0_bit1 VDPWR VDPWR sky130_fd_pr__pfet_01v8_hvt ad=0.1176 pd=1.4 as=0 ps=0 w=0.42 l=0.15
X1297 v3_four_channel_output_load_integration_0/v3_four_channel_shared_support_integration_0/v3_four_channel_bias_reference_distribution_0/v3_four_channel_phase_distribution_0/v3_four_channel_output_collection_0/v3_four_channel_placement_0/v3_channel_selector_late_promotion_3/v3_selector_route_pilot_0/G0_MUX_AXIS/a_218_374# v3_four_channel_output_load_integration_0/v3_four_channel_shared_support_integration_0/v3_four_channel_bias_reference_distribution_0/v3_four_channel_phase_distribution_0/v3_four_channel_output_collection_0/v3_four_channel_placement_0/v3_channel_selector_late_promotion_3/group0_bit1 VDPWR VDPWR sky130_fd_pr__pfet_01v8_hvt ad=0.1533 pd=1.57 as=0 ps=0 w=0.42 l=0.15
X1298 VGND v3_four_channel_output_load_integration_0/v3_four_channel_shared_support_integration_0/v3_four_channel_bias_reference_distribution_0/v3_four_channel_phase_distribution_0/v3_four_channel_output_collection_0/v3_four_channel_placement_0/v3_channel_selector_late_promotion_3/v3_selector_route_pilot_0/G0_MUX_AXIS/a_505_21# v3_four_channel_output_load_integration_0/v3_four_channel_shared_support_integration_0/v3_four_channel_bias_reference_distribution_0/v3_four_channel_phase_distribution_0/v3_four_channel_output_collection_0/v3_four_channel_placement_0/v3_channel_selector_late_promotion_3/v3_selector_route_pilot_0/G0_MUX_AXIS/a_439_47# VGND sky130_fd_pr__nfet_01v8 ad=0 pd=0 as=0.1386 ps=1.5 w=0.42 l=0.15
X1299 v3_four_channel_output_load_integration_0/v3_four_channel_shared_support_integration_0/v3_four_channel_bias_reference_distribution_0/v3_four_channel_phase_distribution_0/v3_four_channel_output_collection_0/v3_four_channel_placement_0/v3_channel_selector_late_promotion_3/v3_selector_route_pilot_0/G0_MUX_AXIS/a_76_199# v3_four_channel_output_load_integration_0/v3_four_channel_shared_support_integration_0/v3_four_channel_bias_reference_distribution_0/v3_four_channel_phase_distribution_0/v3_four_channel_output_collection_0/v3_four_channel_placement_0/v3_channel_selector_late_promotion_3/v3_selector_route_pilot_0/G0_MUX_POS/X v3_four_channel_output_load_integration_0/v3_four_channel_shared_support_integration_0/v3_four_channel_bias_reference_distribution_0/v3_four_channel_phase_distribution_0/v3_four_channel_output_collection_0/v3_four_channel_placement_0/v3_channel_selector_late_promotion_3/v3_selector_route_pilot_0/G0_MUX_AXIS/a_218_374# VDPWR sky130_fd_pr__pfet_01v8_hvt ad=0.3864 pd=2.68 as=0 ps=0 w=0.42 l=0.15
X1300 v3_four_channel_output_load_integration_0/v3_four_channel_shared_support_integration_0/v3_four_channel_bias_reference_distribution_0/v3_four_channel_phase_distribution_0/v3_four_channel_output_collection_0/v3_four_channel_placement_0/v3_channel_selector_late_promotion_3/v3_selector_route_pilot_0/G0_MUX_AXIS/a_505_21# v3_four_channel_output_load_integration_0/v3_four_channel_shared_support_integration_0/v3_four_channel_bias_reference_distribution_0/v3_four_channel_phase_distribution_0/v3_four_channel_output_collection_0/v3_four_channel_placement_0/v3_channel_selector_late_promotion_3/group0_bit1 VGND VGND sky130_fd_pr__nfet_01v8 ad=0.1092 pd=1.36 as=0 ps=0 w=0.42 l=0.15
X1301 v3_four_channel_output_load_integration_0/v3_four_channel_shared_support_integration_0/v3_four_channel_bias_reference_distribution_0/v3_four_channel_phase_distribution_0/v3_four_channel_output_collection_0/v3_four_channel_placement_0/v3_channel_selector_late_promotion_3/v3_selector_route_pilot_0/G0_MUX_AXIS/a_439_47# v3_four_channel_output_load_integration_0/v3_four_channel_shared_support_integration_0/v3_four_channel_bias_reference_distribution_0/v3_four_channel_phase_distribution_0/v3_four_channel_output_collection_0/v3_four_channel_placement_0/v3_channel_selector_late_promotion_3/v3_selector_route_pilot_0/G0_MUX_POS/X v3_four_channel_output_load_integration_0/v3_four_channel_shared_support_integration_0/v3_four_channel_bias_reference_distribution_0/v3_four_channel_phase_distribution_0/v3_four_channel_output_collection_0/v3_four_channel_placement_0/v3_channel_selector_late_promotion_3/v3_selector_route_pilot_0/G0_MUX_AXIS/a_76_199# VGND sky130_fd_pr__nfet_01v8 ad=0 pd=0 as=0.1995 ps=1.79 w=0.42 l=0.15
X1302 v3_four_channel_output_load_integration_0/v3_four_channel_shared_support_integration_0/v3_four_channel_bias_reference_distribution_0/v3_four_channel_phase_distribution_0/v3_four_channel_output_collection_0/v3_four_channel_placement_0/v3_channel_selector_late_promotion_3/v3_selector_route_pilot_0/G0_MUX_AXIS/a_535_374# v3_four_channel_output_load_integration_0/v3_four_channel_shared_support_integration_0/v3_four_channel_bias_reference_distribution_0/v3_four_channel_phase_distribution_0/v3_four_channel_output_collection_0/v3_four_channel_placement_0/v3_channel_selector_late_promotion_3/v3_selector_route_pilot_0/G0_MUX_NEG/X v3_four_channel_output_load_integration_0/v3_four_channel_shared_support_integration_0/v3_four_channel_bias_reference_distribution_0/v3_four_channel_phase_distribution_0/v3_four_channel_output_collection_0/v3_four_channel_placement_0/v3_channel_selector_late_promotion_3/v3_selector_route_pilot_0/G0_MUX_AXIS/a_76_199# VDPWR sky130_fd_pr__pfet_01v8_hvt ad=0 pd=0 as=0 ps=0 w=0.42 l=0.15
X1303 v3_four_channel_output_load_integration_0/v3_four_channel_shared_support_integration_0/v3_four_channel_bias_reference_distribution_0/v3_four_channel_phase_distribution_0/v3_four_channel_output_collection_0/v3_four_channel_placement_0/v3_channel_selector_late_promotion_3/v3_selector_route_pilot_0/G0_MUX_AXIS/a_76_199# v3_four_channel_output_load_integration_0/v3_four_channel_shared_support_integration_0/v3_four_channel_bias_reference_distribution_0/v3_four_channel_phase_distribution_0/v3_four_channel_output_collection_0/v3_four_channel_placement_0/v3_channel_selector_late_promotion_3/v3_selector_route_pilot_0/G0_MUX_NEG/X v3_four_channel_output_load_integration_0/v3_four_channel_shared_support_integration_0/v3_four_channel_bias_reference_distribution_0/v3_four_channel_phase_distribution_0/v3_four_channel_output_collection_0/v3_four_channel_placement_0/v3_channel_selector_late_promotion_3/v3_selector_route_pilot_0/G0_MUX_AXIS/a_218_47# VGND sky130_fd_pr__nfet_01v8 ad=0 pd=0 as=0.1386 ps=1.5 w=0.42 l=0.15
X1304 v3_four_channel_output_load_integration_0/v3_four_channel_shared_support_integration_0/v3_four_channel_bias_reference_distribution_0/v3_four_channel_phase_distribution_0/v3_four_channel_output_collection_0/v3_four_channel_placement_0/v3_channel_selector_late_promotion_3/v3_selector_route_pilot_0/G0_MUX_AXIS/a_218_47# v3_four_channel_output_load_integration_0/v3_four_channel_shared_support_integration_0/v3_four_channel_bias_reference_distribution_0/v3_four_channel_phase_distribution_0/v3_four_channel_output_collection_0/v3_four_channel_placement_0/v3_channel_selector_late_promotion_3/group0_bit1 VGND VGND sky130_fd_pr__nfet_01v8 ad=0 pd=0 as=0 ps=0 w=0.42 l=0.15
X1305 VDPWR v3_four_channel_output_load_integration_0/v3_four_channel_shared_support_integration_0/v3_four_channel_bias_reference_distribution_0/v3_four_channel_phase_distribution_0/v3_four_channel_output_collection_0/v3_four_channel_placement_0/v3_channel_selector_late_promotion_3/v3_selector_route_pilot_0/G0_MUX_AXIS/a_76_199# v3_four_channel_output_load_integration_0/v3_four_channel_shared_support_integration_0/v3_four_channel_bias_reference_distribution_0/v3_four_channel_phase_distribution_0/v3_four_channel_output_collection_0/v3_four_channel_placement_0/v3_channel_selector_late_promotion_3/v3_selector_route_pilot_0/G0_MUX_AXIS/X VDPWR sky130_fd_pr__pfet_01v8_hvt ad=0 pd=0 as=0.26 ps=2.52 w=1 l=0.15
X1306 VGND v3_four_channel_output_load_integration_0/v3_four_channel_shared_support_integration_0/v3_four_channel_bias_reference_distribution_0/v3_four_channel_phase_distribution_0/v3_four_channel_output_collection_0/v3_four_channel_placement_0/v3_channel_selector_late_promotion_3/v3_selector_route_pilot_0/G0_MUX_AXIS/a_76_199# v3_four_channel_output_load_integration_0/v3_four_channel_shared_support_integration_0/v3_four_channel_bias_reference_distribution_0/v3_four_channel_phase_distribution_0/v3_four_channel_output_collection_0/v3_four_channel_placement_0/v3_channel_selector_late_promotion_3/v3_selector_route_pilot_0/G0_MUX_AXIS/X VGND sky130_fd_pr__nfet_01v8 ad=0 pd=0 as=0.169 ps=1.82 w=0.65 l=0.15
X1307 VDPWR v3_four_channel_output_load_integration_0/v3_four_channel_shared_support_integration_0/v3_four_channel_bias_reference_distribution_0/v3_four_channel_phase_distribution_0/v3_four_channel_output_collection_0/v3_four_channel_placement_0/v3_channel_selector_late_promotion_3/v3_selector_route_pilot_0/G3_LO_P_AND/B v3_four_channel_output_load_integration_0/v3_four_channel_shared_support_integration_0/v3_four_channel_bias_reference_distribution_0/v3_four_channel_phase_distribution_0/v3_four_channel_output_collection_0/v3_four_channel_placement_0/v3_channel_selector_late_promotion_3/v3_selector_route_pilot_0/G2_LO_P_AND/a_59_75# VDPWR sky130_fd_pr__pfet_01v8_hvt ad=0 pd=0 as=0.1134 ps=1.38 w=0.42 l=0.15
X1308 v3_four_channel_output_load_integration_0/v3_four_channel_shared_support_integration_0/v3_four_channel_bias_reference_distribution_0/v3_four_channel_phase_distribution_0/v3_four_channel_output_collection_0/v3_four_channel_placement_0/v3_channel_selector_late_promotion_3/v3_selector_route_pilot_0/group2_lo_p v3_four_channel_output_load_integration_0/v3_four_channel_shared_support_integration_0/v3_four_channel_bias_reference_distribution_0/v3_four_channel_phase_distribution_0/v3_four_channel_output_collection_0/v3_four_channel_placement_0/v3_channel_selector_late_promotion_3/v3_selector_route_pilot_0/G2_LO_P_AND/a_59_75# VDPWR VDPWR sky130_fd_pr__pfet_01v8_hvt ad=0.475 pd=2.95 as=0 ps=0 w=1 l=0.15
X1309 VGND v3_four_channel_output_load_integration_0/v3_four_channel_shared_support_integration_0/v3_four_channel_bias_reference_distribution_0/v3_four_channel_phase_distribution_0/v3_four_channel_output_collection_0/v3_four_channel_placement_0/v3_channel_selector_late_promotion_3/v3_selector_route_pilot_0/G3_LO_P_AND/B v3_four_channel_output_load_integration_0/v3_four_channel_shared_support_integration_0/v3_four_channel_bias_reference_distribution_0/v3_four_channel_phase_distribution_0/v3_four_channel_output_collection_0/v3_four_channel_placement_0/v3_channel_selector_late_promotion_3/v3_selector_route_pilot_0/G2_LO_P_AND/a_145_75# VGND sky130_fd_pr__nfet_01v8 ad=0 pd=0 as=0.1134 ps=1.38 w=0.42 l=0.15
X1310 v3_four_channel_output_load_integration_0/v3_four_channel_shared_support_integration_0/v3_four_channel_bias_reference_distribution_0/v3_four_channel_phase_distribution_0/v3_four_channel_output_collection_0/v3_four_channel_placement_0/v3_channel_selector_late_promotion_3/v3_selector_route_pilot_0/G2_LO_P_AND/a_59_75# v3_four_channel_output_load_integration_0/v3_four_channel_shared_support_integration_0/v3_four_channel_bias_reference_distribution_0/v3_four_channel_phase_distribution_0/v3_four_channel_output_collection_0/v3_four_channel_placement_0/v3_channel_selector_late_promotion_3/v3_selector_route_pilot_0/G2_MUX_AXIS/X VDPWR VDPWR sky130_fd_pr__pfet_01v8_hvt ad=0 pd=0 as=0 ps=0 w=0.42 l=0.15
X1311 v3_four_channel_output_load_integration_0/v3_four_channel_shared_support_integration_0/v3_four_channel_bias_reference_distribution_0/v3_four_channel_phase_distribution_0/v3_four_channel_output_collection_0/v3_four_channel_placement_0/v3_channel_selector_late_promotion_3/v3_selector_route_pilot_0/group2_lo_p v3_four_channel_output_load_integration_0/v3_four_channel_shared_support_integration_0/v3_four_channel_bias_reference_distribution_0/v3_four_channel_phase_distribution_0/v3_four_channel_output_collection_0/v3_four_channel_placement_0/v3_channel_selector_late_promotion_3/v3_selector_route_pilot_0/G2_LO_P_AND/a_59_75# VGND VGND sky130_fd_pr__nfet_01v8 ad=0.182 pd=1.86 as=0 ps=0 w=0.65 l=0.15
X1312 v3_four_channel_output_load_integration_0/v3_four_channel_shared_support_integration_0/v3_four_channel_bias_reference_distribution_0/v3_four_channel_phase_distribution_0/v3_four_channel_output_collection_0/v3_four_channel_placement_0/v3_channel_selector_late_promotion_3/v3_selector_route_pilot_0/G2_LO_P_AND/a_145_75# v3_four_channel_output_load_integration_0/v3_four_channel_shared_support_integration_0/v3_four_channel_bias_reference_distribution_0/v3_four_channel_phase_distribution_0/v3_four_channel_output_collection_0/v3_four_channel_placement_0/v3_channel_selector_late_promotion_3/v3_selector_route_pilot_0/G2_MUX_AXIS/X v3_four_channel_output_load_integration_0/v3_four_channel_shared_support_integration_0/v3_four_channel_bias_reference_distribution_0/v3_four_channel_phase_distribution_0/v3_four_channel_output_collection_0/v3_four_channel_placement_0/v3_channel_selector_late_promotion_3/v3_selector_route_pilot_0/G2_LO_P_AND/a_59_75# VGND sky130_fd_pr__nfet_01v8 ad=0 pd=0 as=0.1176 ps=1.4 w=0.42 l=0.15
X1313 VDPWR v3_four_channel_output_load_integration_0/combined_p VGND sky130_fd_pr__res_high_po_1p41 l=11.61
X1314 VDPWR v3_four_channel_output_load_integration_0/combined_n VGND sky130_fd_pr__res_high_po_1p41 l=11.61
