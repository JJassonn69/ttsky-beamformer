* NGSPICE file created from v3_four_ch_output_tied.ext - technology: sky130A

X0 VDPWR sky130_fd_sc_hd__mux2_1_104/a_505_21# sky130_fd_sc_hd__mux2_1_104/a_535_374# VDPWR sky130_fd_pr__pfet_01v8_hvt ad=0.0693 pd=0.75 as=0.0441 ps=0.63 w=0.42 l=0.15
X1 sky130_fd_sc_hd__mux2_1_104/a_505_21# V3R002 VDPWR VDPWR sky130_fd_pr__pfet_01v8_hvt ad=0.1176 pd=1.4 as=0.0693 ps=0.75 w=0.42 l=0.15
X2 sky130_fd_sc_hd__mux2_1_104/a_218_374# V3R002 VDPWR VDPWR sky130_fd_pr__pfet_01v8_hvt ad=0.07665 pd=0.785 as=0.15835 ps=1.395 w=0.42 l=0.15
X3 VGND sky130_fd_sc_hd__mux2_1_104/a_505_21# sky130_fd_sc_hd__mux2_1_104/a_439_47# VGND sky130_fd_pr__nfet_01v8 ad=0.1449 pd=1.11 as=0.0693 ps=0.75 w=0.42 l=0.15
X4 sky130_fd_sc_hd__mux2_1_104/a_76_199# V3R247 sky130_fd_sc_hd__mux2_1_104/a_218_374# VDPWR sky130_fd_pr__pfet_01v8_hvt ad=0.1932 pd=1.34 as=0.07665 ps=0.785 w=0.42 l=0.15
X5 sky130_fd_sc_hd__mux2_1_104/a_505_21# V3R002 VGND VGND sky130_fd_pr__nfet_01v8 ad=0.1092 pd=1.36 as=0.1449 ps=1.11 w=0.42 l=0.15
X6 sky130_fd_sc_hd__mux2_1_104/a_439_47# V3R247 sky130_fd_sc_hd__mux2_1_104/a_76_199# VGND sky130_fd_pr__nfet_01v8 ad=0.0693 pd=0.75 as=0.09975 ps=0.895 w=0.42 l=0.15
X7 sky130_fd_sc_hd__mux2_1_104/a_535_374# V3R255 sky130_fd_sc_hd__mux2_1_104/a_76_199# VDPWR sky130_fd_pr__pfet_01v8_hvt ad=0.0441 pd=0.63 as=0.1932 ps=1.34 w=0.42 l=0.15
X8 sky130_fd_sc_hd__mux2_1_104/a_76_199# V3R255 sky130_fd_sc_hd__mux2_1_104/a_218_47# VGND sky130_fd_pr__nfet_01v8 ad=0.09975 pd=0.895 as=0.0693 ps=0.75 w=0.42 l=0.15
X9 sky130_fd_sc_hd__mux2_1_104/a_218_47# V3R002 VGND VGND sky130_fd_pr__nfet_01v8 ad=0.0693 pd=0.75 as=0.11285 ps=1.045 w=0.42 l=0.15
X10 VDPWR sky130_fd_sc_hd__mux2_1_104/a_76_199# V3R256 VDPWR sky130_fd_pr__pfet_01v8_hvt ad=0.15835 pd=1.395 as=0.26 ps=2.52 w=1 l=0.15
X11 VGND sky130_fd_sc_hd__mux2_1_104/a_76_199# V3R256 VGND sky130_fd_pr__nfet_01v8 ad=0.11285 pd=1.045 as=0.169 ps=1.82 w=0.65 l=0.15
X12 VDPWR V3R203 sky130_fd_sc_hd__and2_1_10/a_59_75# VDPWR sky130_fd_pr__pfet_01v8_hvt ad=0.16655 pd=1.39 as=0.0567 ps=0.69 w=0.42 l=0.15
X13 V3R263 sky130_fd_sc_hd__and2_1_10/a_59_75# VDPWR VDPWR sky130_fd_pr__pfet_01v8_hvt ad=0.475 pd=2.95 as=0.16655 ps=1.39 w=1 l=0.15
X14 VGND V3R203 sky130_fd_sc_hd__and2_1_10/a_145_75# VGND sky130_fd_pr__nfet_01v8 ad=0.1118 pd=1.04 as=0.0567 ps=0.69 w=0.42 l=0.15
X15 sky130_fd_sc_hd__and2_1_10/a_59_75# V3R076 VDPWR VDPWR sky130_fd_pr__pfet_01v8_hvt ad=0.0567 pd=0.69 as=0.1176 ps=1.4 w=0.42 l=0.15
X16 V3R263 sky130_fd_sc_hd__and2_1_10/a_59_75# VGND VGND sky130_fd_pr__nfet_01v8 ad=0.182 pd=1.86 as=0.1118 ps=1.04 w=0.65 l=0.15
X17 sky130_fd_sc_hd__and2_1_10/a_145_75# V3R076 sky130_fd_sc_hd__and2_1_10/a_59_75# VGND sky130_fd_pr__nfet_01v8 ad=0.0567 pd=0.69 as=0.1176 ps=1.4 w=0.42 l=0.15
X18 VDPWR V3R004 sky130_fd_sc_hd__and2b_1_11/a_207_413# VDPWR sky130_fd_pr__pfet_01v8_hvt ad=0.2279 pd=1.74 as=0.0609 ps=0.71 w=0.42 l=0.15
X19 V3R069 sky130_fd_sc_hd__and2b_1_11/a_207_413# VDPWR VDPWR sky130_fd_pr__pfet_01v8_hvt ad=0.26 pd=2.52 as=0.2279 ps=1.74 w=1 l=0.15
X20 sky130_fd_sc_hd__and2b_1_11/a_297_47# sky130_fd_sc_hd__and2b_1_11/a_27_413# sky130_fd_sc_hd__and2b_1_11/a_207_413# VGND sky130_fd_pr__nfet_01v8 ad=0.0504 pd=0.66 as=0.1092 ps=1.36 w=0.42 l=0.15
X21 V3R069 sky130_fd_sc_hd__and2b_1_11/a_207_413# VGND VGND sky130_fd_pr__nfet_01v8 ad=0.169 pd=1.82 as=0.1013 ps=0.99 w=0.65 l=0.15
X22 sky130_fd_sc_hd__and2b_1_11/a_207_413# sky130_fd_sc_hd__and2b_1_11/a_27_413# VDPWR VDPWR sky130_fd_pr__pfet_01v8_hvt ad=0.0609 pd=0.71 as=0.0714 ps=0.76 w=0.42 l=0.15
X23 VDPWR V3R238 sky130_fd_sc_hd__and2b_1_11/a_27_413# VDPWR sky130_fd_pr__pfet_01v8_hvt ad=0.0714 pd=0.76 as=0.1092 ps=1.36 w=0.42 l=0.15
X24 VGND V3R004 sky130_fd_sc_hd__and2b_1_11/a_297_47# VGND sky130_fd_pr__nfet_01v8 ad=0.1013 pd=0.99 as=0.0504 ps=0.66 w=0.42 l=0.15
X25 sky130_fd_sc_hd__and2b_1_11/a_27_413# V3R238 VGND VGND sky130_fd_pr__nfet_01v8 ad=0.1092 pd=1.36 as=0.1092 ps=1.36 w=0.42 l=0.15
X26 sky130_fd_sc_hd__dfrtp_1_12/a_805_47# sky130_fd_sc_hd__dfrtp_1_12/a_761_289# sky130_fd_sc_hd__dfrtp_1_12/a_639_47# VGND sky130_fd_pr__nfet_01v8 ad=0.0441 pd=0.63 as=0.1401 ps=1.1 w=0.42 l=0.15
X27 sky130_fd_sc_hd__dfrtp_1_12/a_1217_47# sky130_fd_sc_hd__dfrtp_1_12/a_27_47# sky130_fd_sc_hd__dfrtp_1_12/a_1108_47# VGND sky130_fd_pr__special_nfet_01v8 ad=0.0669 pd=0.75 as=0.0711 ps=0.755 w=0.36 l=0.15
X28 sky130_fd_sc_hd__dfrtp_1_12/a_1283_21# sky130_fd_sc_hd__dfrtp_1_12/a_1108_47# sky130_fd_sc_hd__dfrtp_1_12/a_1462_47# VGND sky130_fd_pr__nfet_01v8 ad=0.1092 pd=1.36 as=0.06405 ps=0.725 w=0.42 l=0.15
X29 sky130_fd_sc_hd__dfrtp_1_12/a_651_413# sky130_fd_sc_hd__dfrtp_1_12/a_27_47# sky130_fd_sc_hd__dfrtp_1_12/a_543_47# VDPWR sky130_fd_pr__pfet_01v8_hvt ad=0.1155 pd=0.97 as=0.07245 ps=0.765 w=0.42 l=0.15
X30 sky130_fd_sc_hd__dfrtp_1_12/a_1108_47# sky130_fd_sc_hd__dfrtp_1_12/a_193_47# sky130_fd_sc_hd__dfrtp_1_12/a_761_289# VGND sky130_fd_pr__special_nfet_01v8 ad=0.0711 pd=0.755 as=0.0999 ps=0.985 w=0.36 l=0.15
X31 VGND V3R301 sky130_fd_sc_hd__dfrtp_1_12/a_805_47# VGND sky130_fd_pr__nfet_01v8 ad=0.1346 pd=1.15 as=0.0441 ps=0.63 w=0.42 l=0.15
X32 V3R031 sky130_fd_sc_hd__dfrtp_1_12/a_1283_21# VDPWR VDPWR sky130_fd_pr__pfet_01v8_hvt ad=0.26 pd=2.52 as=0.3012 ps=2.66 w=1 l=0.15
X33 VDPWR V3R082 sky130_fd_sc_hd__dfrtp_1_12/a_27_47# VDPWR sky130_fd_pr__pfet_01v8_hvt ad=0.0864 pd=0.91 as=0.1664 ps=1.8 w=0.64 l=0.15
X34 sky130_fd_sc_hd__dfrtp_1_12/a_448_47# V3R146 VDPWR VDPWR sky130_fd_pr__pfet_01v8_hvt ad=0.0651 pd=0.73 as=0.1092 ps=1.36 w=0.42 l=0.15
X35 sky130_fd_sc_hd__dfrtp_1_12/a_761_289# sky130_fd_sc_hd__dfrtp_1_12/a_543_47# VGND VGND sky130_fd_pr__nfet_01v8 ad=0.0999 pd=0.985 as=0.1346 ps=1.15 w=0.64 l=0.15
X36 sky130_fd_sc_hd__dfrtp_1_12/a_193_47# sky130_fd_sc_hd__dfrtp_1_12/a_27_47# VGND VGND sky130_fd_pr__nfet_01v8 ad=0.1092 pd=1.36 as=0.0567 ps=0.69 w=0.42 l=0.15
X37 sky130_fd_sc_hd__dfrtp_1_12/a_1108_47# sky130_fd_sc_hd__dfrtp_1_12/a_27_47# sky130_fd_sc_hd__dfrtp_1_12/a_761_289# VDPWR sky130_fd_pr__pfet_01v8_hvt ad=0.0588 pd=0.7 as=0.12915 ps=1.185 w=0.42 l=0.15
X38 sky130_fd_sc_hd__dfrtp_1_12/a_1462_47# V3R301 VGND VGND sky130_fd_pr__nfet_01v8 ad=0.06405 pd=0.725 as=0.12495 ps=1.015 w=0.42 l=0.15
X39 sky130_fd_sc_hd__dfrtp_1_12/a_543_47# sky130_fd_sc_hd__dfrtp_1_12/a_27_47# sky130_fd_sc_hd__dfrtp_1_12/a_448_47# VGND sky130_fd_pr__special_nfet_01v8 ad=0.0594 pd=0.69 as=0.066 ps=0.745 w=0.36 l=0.15
X40 sky130_fd_sc_hd__dfrtp_1_12/a_543_47# sky130_fd_sc_hd__dfrtp_1_12/a_193_47# sky130_fd_sc_hd__dfrtp_1_12/a_448_47# VDPWR sky130_fd_pr__pfet_01v8_hvt ad=0.07245 pd=0.765 as=0.0651 ps=0.73 w=0.42 l=0.15
X41 sky130_fd_sc_hd__dfrtp_1_12/a_448_47# V3R146 VGND VGND sky130_fd_pr__nfet_01v8 ad=0.066 pd=0.745 as=0.2205 ps=1.89 w=0.42 l=0.15
X42 VDPWR sky130_fd_sc_hd__dfrtp_1_12/a_1283_21# sky130_fd_sc_hd__dfrtp_1_12/a_1270_413# VDPWR sky130_fd_pr__pfet_01v8_hvt ad=0.0819 pd=0.81 as=0.0567 ps=0.69 w=0.42 l=0.15
X43 VDPWR sky130_fd_sc_hd__dfrtp_1_12/a_1108_47# sky130_fd_sc_hd__dfrtp_1_12/a_1283_21# VDPWR sky130_fd_pr__pfet_01v8_hvt ad=0.1134 pd=1.38 as=0.0567 ps=0.69 w=0.42 l=0.15
X44 sky130_fd_sc_hd__dfrtp_1_12/a_1270_413# sky130_fd_sc_hd__dfrtp_1_12/a_193_47# sky130_fd_sc_hd__dfrtp_1_12/a_1108_47# VDPWR sky130_fd_pr__pfet_01v8_hvt ad=0.0567 pd=0.69 as=0.0588 ps=0.7 w=0.42 l=0.15
X45 sky130_fd_sc_hd__dfrtp_1_12/a_193_47# sky130_fd_sc_hd__dfrtp_1_12/a_27_47# VDPWR VDPWR sky130_fd_pr__pfet_01v8_hvt ad=0.1664 pd=1.8 as=0.0864 ps=0.91 w=0.64 l=0.15
X46 sky130_fd_sc_hd__dfrtp_1_12/a_1283_21# V3R301 VDPWR VDPWR sky130_fd_pr__pfet_01v8_hvt ad=0.0567 pd=0.69 as=0.0819 ps=0.81 w=0.42 l=0.15
X47 VDPWR sky130_fd_sc_hd__dfrtp_1_12/a_761_289# sky130_fd_sc_hd__dfrtp_1_12/a_651_413# VDPWR sky130_fd_pr__pfet_01v8_hvt ad=0.07035 pd=0.755 as=0.1155 ps=0.97 w=0.42 l=0.15
X48 V3R031 sky130_fd_sc_hd__dfrtp_1_12/a_1283_21# VGND VGND sky130_fd_pr__nfet_01v8 ad=0.169 pd=1.82 as=0.2087 ps=2.02 w=0.65 l=0.15
X49 sky130_fd_sc_hd__dfrtp_1_12/a_639_47# sky130_fd_sc_hd__dfrtp_1_12/a_193_47# sky130_fd_sc_hd__dfrtp_1_12/a_543_47# VGND sky130_fd_pr__special_nfet_01v8 ad=0.1401 pd=1.1 as=0.0594 ps=0.69 w=0.36 l=0.15
X50 VGND sky130_fd_sc_hd__dfrtp_1_12/a_1283_21# sky130_fd_sc_hd__dfrtp_1_12/a_1217_47# VGND sky130_fd_pr__nfet_01v8 ad=0.12495 pd=1.015 as=0.0669 ps=0.75 w=0.42 l=0.15
X51 sky130_fd_sc_hd__dfrtp_1_12/a_651_413# V3R301 VDPWR VDPWR sky130_fd_pr__pfet_01v8_hvt ad=0.1092 pd=1.36 as=0.07035 ps=0.755 w=0.42 l=0.15
X52 VGND V3R082 sky130_fd_sc_hd__dfrtp_1_12/a_27_47# VGND sky130_fd_pr__nfet_01v8 ad=0.0567 pd=0.69 as=0.1092 ps=1.36 w=0.42 l=0.15
X53 sky130_fd_sc_hd__dfrtp_1_12/a_761_289# sky130_fd_sc_hd__dfrtp_1_12/a_543_47# VDPWR VDPWR sky130_fd_pr__pfet_01v8_hvt ad=0.12915 pd=1.185 as=0.2184 ps=2.2 w=0.84 l=0.15
X54 sky130_fd_sc_hd__dfrtp_1_23/a_805_47# sky130_fd_sc_hd__dfrtp_1_23/a_761_289# sky130_fd_sc_hd__dfrtp_1_23/a_639_47# VGND sky130_fd_pr__nfet_01v8 ad=0.0882 pd=1.26 as=0.2802 ps=2.2 w=0.42 l=0.15
X55 sky130_fd_sc_hd__dfrtp_1_23/a_1217_47# sky130_fd_sc_hd__dfrtp_1_23/a_27_47# sky130_fd_sc_hd__dfrtp_1_23/a_1108_47# VGND sky130_fd_pr__special_nfet_01v8 ad=0.1338 pd=1.5 as=0.1422 ps=1.51 w=0.36 l=0.15
X56 sky130_fd_sc_hd__dfrtp_1_23/a_1283_21# sky130_fd_sc_hd__dfrtp_1_23/a_1108_47# sky130_fd_sc_hd__dfrtp_1_23/a_1462_47# VGND sky130_fd_pr__nfet_01v8 ad=0.1092 pd=1.36 as=0.1281 ps=1.45 w=0.42 l=0.15
X57 sky130_fd_sc_hd__dfrtp_1_23/a_651_413# sky130_fd_sc_hd__dfrtp_1_23/a_27_47# sky130_fd_sc_hd__dfrtp_1_23/a_543_47# VDPWR sky130_fd_pr__pfet_01v8_hvt ad=0.3402 pd=3.3 as=0.1449 ps=1.53 w=0.42 l=0.15
X58 sky130_fd_sc_hd__dfrtp_1_23/a_1108_47# sky130_fd_sc_hd__dfrtp_1_23/a_193_47# sky130_fd_sc_hd__dfrtp_1_23/a_761_289# VGND sky130_fd_pr__special_nfet_01v8 ad=0 pd=0 as=0.1998 ps=1.97 w=0.36 l=0.15
X59 VGND V3R299 sky130_fd_sc_hd__dfrtp_1_23/a_805_47# VGND sky130_fd_pr__nfet_01v8 ad=367.92319 pd=3.1147k as=0 ps=0 w=0.42 l=0.15
X60 V3R166 sky130_fd_sc_hd__dfrtp_1_23/a_1283_21# VDPWR VDPWR sky130_fd_pr__pfet_01v8_hvt ad=0.26 pd=2.52 as=257.2738 ps=2.50625k w=1 l=0.15
X61 VDPWR V3R056 sky130_fd_sc_hd__dfrtp_1_23/a_27_47# VDPWR sky130_fd_pr__pfet_01v8_hvt ad=0 pd=0 as=0.1664 ps=1.8 w=0.64 l=0.15
X62 sky130_fd_sc_hd__dfrtp_1_23/a_448_47# V3R110 VDPWR VDPWR sky130_fd_pr__pfet_01v8_hvt ad=0.1302 pd=1.46 as=0 ps=0 w=0.42 l=0.15
X63 sky130_fd_sc_hd__dfrtp_1_23/a_761_289# sky130_fd_sc_hd__dfrtp_1_23/a_543_47# VGND VGND sky130_fd_pr__nfet_01v8 ad=0 pd=0 as=0 ps=0 w=0.64 l=0.15
X64 sky130_fd_sc_hd__dfrtp_1_23/a_193_47# sky130_fd_sc_hd__dfrtp_1_23/a_27_47# VGND VGND sky130_fd_pr__nfet_01v8 ad=0.1092 pd=1.36 as=0 ps=0 w=0.42 l=0.15
X65 sky130_fd_sc_hd__dfrtp_1_23/a_1108_47# sky130_fd_sc_hd__dfrtp_1_23/a_27_47# sky130_fd_sc_hd__dfrtp_1_23/a_761_289# VDPWR sky130_fd_pr__pfet_01v8_hvt ad=0.1176 pd=1.4 as=0.2583 ps=2.37 w=0.42 l=0.15
X66 sky130_fd_sc_hd__dfrtp_1_23/a_1462_47# V3R299 VGND VGND sky130_fd_pr__nfet_01v8 ad=0 pd=0 as=0 ps=0 w=0.42 l=0.15
X67 sky130_fd_sc_hd__dfrtp_1_23/a_543_47# sky130_fd_sc_hd__dfrtp_1_23/a_27_47# sky130_fd_sc_hd__dfrtp_1_23/a_448_47# VGND sky130_fd_pr__special_nfet_01v8 ad=0.1188 pd=1.38 as=0.132 ps=1.49 w=0.36 l=0.15
X68 sky130_fd_sc_hd__dfrtp_1_23/a_543_47# sky130_fd_sc_hd__dfrtp_1_23/a_193_47# sky130_fd_sc_hd__dfrtp_1_23/a_448_47# VDPWR sky130_fd_pr__pfet_01v8_hvt ad=0 pd=0 as=0 ps=0 w=0.42 l=0.15
X69 sky130_fd_sc_hd__dfrtp_1_23/a_448_47# V3R110 VGND VGND sky130_fd_pr__nfet_01v8 ad=0 pd=0 as=0 ps=0 w=0.42 l=0.15
X70 VDPWR sky130_fd_sc_hd__dfrtp_1_23/a_1283_21# sky130_fd_sc_hd__dfrtp_1_23/a_1270_413# VDPWR sky130_fd_pr__pfet_01v8_hvt ad=0 pd=0 as=0.1134 ps=1.38 w=0.42 l=0.15
X71 VDPWR sky130_fd_sc_hd__dfrtp_1_23/a_1108_47# sky130_fd_sc_hd__dfrtp_1_23/a_1283_21# VDPWR sky130_fd_pr__pfet_01v8_hvt ad=0 pd=0 as=0.1134 ps=1.38 w=0.42 l=0.15
X72 sky130_fd_sc_hd__dfrtp_1_23/a_1270_413# sky130_fd_sc_hd__dfrtp_1_23/a_193_47# sky130_fd_sc_hd__dfrtp_1_23/a_1108_47# VDPWR sky130_fd_pr__pfet_01v8_hvt ad=0 pd=0 as=0 ps=0 w=0.42 l=0.15
X73 sky130_fd_sc_hd__dfrtp_1_23/a_193_47# sky130_fd_sc_hd__dfrtp_1_23/a_27_47# VDPWR VDPWR sky130_fd_pr__pfet_01v8_hvt ad=0.1664 pd=1.8 as=0 ps=0 w=0.64 l=0.15
X74 sky130_fd_sc_hd__dfrtp_1_23/a_1283_21# V3R299 VDPWR VDPWR sky130_fd_pr__pfet_01v8_hvt ad=0 pd=0 as=0 ps=0 w=0.42 l=0.15
X75 VDPWR sky130_fd_sc_hd__dfrtp_1_23/a_761_289# sky130_fd_sc_hd__dfrtp_1_23/a_651_413# VDPWR sky130_fd_pr__pfet_01v8_hvt ad=0 pd=0 as=0 ps=0 w=0.42 l=0.15
X76 V3R166 sky130_fd_sc_hd__dfrtp_1_23/a_1283_21# VGND VGND sky130_fd_pr__nfet_01v8 ad=0.169 pd=1.82 as=0 ps=0 w=0.65 l=0.15
X77 sky130_fd_sc_hd__dfrtp_1_23/a_639_47# sky130_fd_sc_hd__dfrtp_1_23/a_193_47# sky130_fd_sc_hd__dfrtp_1_23/a_543_47# VGND sky130_fd_pr__special_nfet_01v8 ad=0 pd=0 as=0 ps=0 w=0.36 l=0.15
X78 VGND sky130_fd_sc_hd__dfrtp_1_23/a_1283_21# sky130_fd_sc_hd__dfrtp_1_23/a_1217_47# VGND sky130_fd_pr__nfet_01v8 ad=0 pd=0 as=0 ps=0 w=0.42 l=0.15
X79 sky130_fd_sc_hd__dfrtp_1_23/a_651_413# V3R299 VDPWR VDPWR sky130_fd_pr__pfet_01v8_hvt ad=0 pd=0 as=0 ps=0 w=0.42 l=0.15
X80 VGND V3R056 sky130_fd_sc_hd__dfrtp_1_23/a_27_47# VGND sky130_fd_pr__nfet_01v8 ad=0 pd=0 as=0.1092 ps=1.36 w=0.42 l=0.15
X81 sky130_fd_sc_hd__dfrtp_1_23/a_761_289# sky130_fd_sc_hd__dfrtp_1_23/a_543_47# VDPWR VDPWR sky130_fd_pr__pfet_01v8_hvt ad=0 pd=0 as=0 ps=0 w=0.84 l=0.15
X82 sky130_fd_sc_hd__dfrtp_1_67/a_805_47# sky130_fd_sc_hd__dfrtp_1_67/a_761_289# sky130_fd_sc_hd__dfrtp_1_67/a_639_47# VGND sky130_fd_pr__nfet_01v8 ad=0.0882 pd=1.26 as=0.2802 ps=2.2 w=0.42 l=0.15
X83 sky130_fd_sc_hd__dfrtp_1_67/a_1217_47# sky130_fd_sc_hd__dfrtp_1_67/a_27_47# sky130_fd_sc_hd__dfrtp_1_67/a_1108_47# VGND sky130_fd_pr__special_nfet_01v8 ad=0.1338 pd=1.5 as=0.1422 ps=1.51 w=0.36 l=0.15
X84 sky130_fd_sc_hd__dfrtp_1_67/a_1283_21# sky130_fd_sc_hd__dfrtp_1_67/a_1108_47# sky130_fd_sc_hd__dfrtp_1_67/a_1462_47# VGND sky130_fd_pr__nfet_01v8 ad=0.1092 pd=1.36 as=0.1281 ps=1.45 w=0.42 l=0.15
X85 sky130_fd_sc_hd__dfrtp_1_67/a_651_413# sky130_fd_sc_hd__dfrtp_1_67/a_27_47# sky130_fd_sc_hd__dfrtp_1_67/a_543_47# VDPWR sky130_fd_pr__pfet_01v8_hvt ad=0.3402 pd=3.3 as=0.1449 ps=1.53 w=0.42 l=0.15
X86 sky130_fd_sc_hd__dfrtp_1_67/a_1108_47# sky130_fd_sc_hd__dfrtp_1_67/a_193_47# sky130_fd_sc_hd__dfrtp_1_67/a_761_289# VGND sky130_fd_pr__special_nfet_01v8 ad=0 pd=0 as=0.1998 ps=1.97 w=0.36 l=0.15
X87 VGND V3R302 sky130_fd_sc_hd__dfrtp_1_67/a_805_47# VGND sky130_fd_pr__nfet_01v8 ad=0 pd=0 as=0 ps=0 w=0.42 l=0.15
X88 V3R065 sky130_fd_sc_hd__dfrtp_1_67/a_1283_21# VDPWR VDPWR sky130_fd_pr__pfet_01v8_hvt ad=0.26 pd=2.52 as=0 ps=0 w=1 l=0.15
X89 VDPWR V3R083 sky130_fd_sc_hd__dfrtp_1_67/a_27_47# VDPWR sky130_fd_pr__pfet_01v8_hvt ad=0 pd=0 as=0.1664 ps=1.8 w=0.64 l=0.15
X90 sky130_fd_sc_hd__dfrtp_1_67/a_448_47# V3R058 VDPWR VDPWR sky130_fd_pr__pfet_01v8_hvt ad=0.1302 pd=1.46 as=0 ps=0 w=0.42 l=0.15
X91 sky130_fd_sc_hd__dfrtp_1_67/a_761_289# sky130_fd_sc_hd__dfrtp_1_67/a_543_47# VGND VGND sky130_fd_pr__nfet_01v8 ad=0 pd=0 as=0 ps=0 w=0.64 l=0.15
X92 sky130_fd_sc_hd__dfrtp_1_67/a_193_47# sky130_fd_sc_hd__dfrtp_1_67/a_27_47# VGND VGND sky130_fd_pr__nfet_01v8 ad=0.1092 pd=1.36 as=0 ps=0 w=0.42 l=0.15
X93 sky130_fd_sc_hd__dfrtp_1_67/a_1108_47# sky130_fd_sc_hd__dfrtp_1_67/a_27_47# sky130_fd_sc_hd__dfrtp_1_67/a_761_289# VDPWR sky130_fd_pr__pfet_01v8_hvt ad=0.1176 pd=1.4 as=0.2583 ps=2.37 w=0.42 l=0.15
X94 sky130_fd_sc_hd__dfrtp_1_67/a_1462_47# V3R302 VGND VGND sky130_fd_pr__nfet_01v8 ad=0 pd=0 as=0 ps=0 w=0.42 l=0.15
X95 sky130_fd_sc_hd__dfrtp_1_67/a_543_47# sky130_fd_sc_hd__dfrtp_1_67/a_27_47# sky130_fd_sc_hd__dfrtp_1_67/a_448_47# VGND sky130_fd_pr__special_nfet_01v8 ad=0.1188 pd=1.38 as=0.132 ps=1.49 w=0.36 l=0.15
X96 sky130_fd_sc_hd__dfrtp_1_67/a_543_47# sky130_fd_sc_hd__dfrtp_1_67/a_193_47# sky130_fd_sc_hd__dfrtp_1_67/a_448_47# VDPWR sky130_fd_pr__pfet_01v8_hvt ad=0 pd=0 as=0 ps=0 w=0.42 l=0.15
X97 sky130_fd_sc_hd__dfrtp_1_67/a_448_47# V3R058 VGND VGND sky130_fd_pr__nfet_01v8 ad=0 pd=0 as=0 ps=0 w=0.42 l=0.15
X98 VDPWR sky130_fd_sc_hd__dfrtp_1_67/a_1283_21# sky130_fd_sc_hd__dfrtp_1_67/a_1270_413# VDPWR sky130_fd_pr__pfet_01v8_hvt ad=0 pd=0 as=0.1134 ps=1.38 w=0.42 l=0.15
X99 VDPWR sky130_fd_sc_hd__dfrtp_1_67/a_1108_47# sky130_fd_sc_hd__dfrtp_1_67/a_1283_21# VDPWR sky130_fd_pr__pfet_01v8_hvt ad=0 pd=0 as=0.1134 ps=1.38 w=0.42 l=0.15
X100 sky130_fd_sc_hd__dfrtp_1_67/a_1270_413# sky130_fd_sc_hd__dfrtp_1_67/a_193_47# sky130_fd_sc_hd__dfrtp_1_67/a_1108_47# VDPWR sky130_fd_pr__pfet_01v8_hvt ad=0 pd=0 as=0 ps=0 w=0.42 l=0.15
X101 sky130_fd_sc_hd__dfrtp_1_67/a_193_47# sky130_fd_sc_hd__dfrtp_1_67/a_27_47# VDPWR VDPWR sky130_fd_pr__pfet_01v8_hvt ad=0.1664 pd=1.8 as=0 ps=0 w=0.64 l=0.15
X102 sky130_fd_sc_hd__dfrtp_1_67/a_1283_21# V3R302 VDPWR VDPWR sky130_fd_pr__pfet_01v8_hvt ad=0 pd=0 as=0 ps=0 w=0.42 l=0.15
X103 VDPWR sky130_fd_sc_hd__dfrtp_1_67/a_761_289# sky130_fd_sc_hd__dfrtp_1_67/a_651_413# VDPWR sky130_fd_pr__pfet_01v8_hvt ad=0 pd=0 as=0 ps=0 w=0.42 l=0.15
X104 V3R065 sky130_fd_sc_hd__dfrtp_1_67/a_1283_21# VGND VGND sky130_fd_pr__nfet_01v8 ad=0.169 pd=1.82 as=0 ps=0 w=0.65 l=0.15
X105 sky130_fd_sc_hd__dfrtp_1_67/a_639_47# sky130_fd_sc_hd__dfrtp_1_67/a_193_47# sky130_fd_sc_hd__dfrtp_1_67/a_543_47# VGND sky130_fd_pr__special_nfet_01v8 ad=0 pd=0 as=0 ps=0 w=0.36 l=0.15
X106 VGND sky130_fd_sc_hd__dfrtp_1_67/a_1283_21# sky130_fd_sc_hd__dfrtp_1_67/a_1217_47# VGND sky130_fd_pr__nfet_01v8 ad=0 pd=0 as=0 ps=0 w=0.42 l=0.15
X107 sky130_fd_sc_hd__dfrtp_1_67/a_651_413# V3R302 VDPWR VDPWR sky130_fd_pr__pfet_01v8_hvt ad=0 pd=0 as=0 ps=0 w=0.42 l=0.15
X108 VGND V3R083 sky130_fd_sc_hd__dfrtp_1_67/a_27_47# VGND sky130_fd_pr__nfet_01v8 ad=0 pd=0 as=0.1092 ps=1.36 w=0.42 l=0.15
X109 sky130_fd_sc_hd__dfrtp_1_67/a_761_289# sky130_fd_sc_hd__dfrtp_1_67/a_543_47# VDPWR VDPWR sky130_fd_pr__pfet_01v8_hvt ad=0 pd=0 as=0 ps=0 w=0.84 l=0.15
X110 sky130_fd_sc_hd__dfrtp_1_56/a_805_47# sky130_fd_sc_hd__dfrtp_1_56/a_761_289# sky130_fd_sc_hd__dfrtp_1_56/a_639_47# VGND sky130_fd_pr__nfet_01v8 ad=0.0882 pd=1.26 as=0.2802 ps=2.2 w=0.42 l=0.15
X111 sky130_fd_sc_hd__dfrtp_1_56/a_1217_47# sky130_fd_sc_hd__dfrtp_1_56/a_27_47# sky130_fd_sc_hd__dfrtp_1_56/a_1108_47# VGND sky130_fd_pr__special_nfet_01v8 ad=0.1338 pd=1.5 as=0.1422 ps=1.51 w=0.36 l=0.15
X112 sky130_fd_sc_hd__dfrtp_1_56/a_1283_21# sky130_fd_sc_hd__dfrtp_1_56/a_1108_47# sky130_fd_sc_hd__dfrtp_1_56/a_1462_47# VGND sky130_fd_pr__nfet_01v8 ad=0.1092 pd=1.36 as=0.1281 ps=1.45 w=0.42 l=0.15
X113 sky130_fd_sc_hd__dfrtp_1_56/a_651_413# sky130_fd_sc_hd__dfrtp_1_56/a_27_47# sky130_fd_sc_hd__dfrtp_1_56/a_543_47# VDPWR sky130_fd_pr__pfet_01v8_hvt ad=0.3402 pd=3.3 as=0.1449 ps=1.53 w=0.42 l=0.15
X114 sky130_fd_sc_hd__dfrtp_1_56/a_1108_47# sky130_fd_sc_hd__dfrtp_1_56/a_193_47# sky130_fd_sc_hd__dfrtp_1_56/a_761_289# VGND sky130_fd_pr__special_nfet_01v8 ad=0 pd=0 as=0.1998 ps=1.97 w=0.36 l=0.15
X115 VGND V3R298 sky130_fd_sc_hd__dfrtp_1_56/a_805_47# VGND sky130_fd_pr__nfet_01v8 ad=0 pd=0 as=0 ps=0 w=0.42 l=0.15
X116 V3R155 sky130_fd_sc_hd__dfrtp_1_56/a_1283_21# VDPWR VDPWR sky130_fd_pr__pfet_01v8_hvt ad=0.26 pd=2.52 as=0 ps=0 w=1 l=0.15
X117 VDPWR V3R055 sky130_fd_sc_hd__dfrtp_1_56/a_27_47# VDPWR sky130_fd_pr__pfet_01v8_hvt ad=0 pd=0 as=0.1664 ps=1.8 w=0.64 l=0.15
X118 sky130_fd_sc_hd__dfrtp_1_56/a_448_47# V3R100 VDPWR VDPWR sky130_fd_pr__pfet_01v8_hvt ad=0.1302 pd=1.46 as=0 ps=0 w=0.42 l=0.15
X119 sky130_fd_sc_hd__dfrtp_1_56/a_761_289# sky130_fd_sc_hd__dfrtp_1_56/a_543_47# VGND VGND sky130_fd_pr__nfet_01v8 ad=0 pd=0 as=0 ps=0 w=0.64 l=0.15
X120 sky130_fd_sc_hd__dfrtp_1_56/a_193_47# sky130_fd_sc_hd__dfrtp_1_56/a_27_47# VGND VGND sky130_fd_pr__nfet_01v8 ad=0.1092 pd=1.36 as=0 ps=0 w=0.42 l=0.15
X121 sky130_fd_sc_hd__dfrtp_1_56/a_1108_47# sky130_fd_sc_hd__dfrtp_1_56/a_27_47# sky130_fd_sc_hd__dfrtp_1_56/a_761_289# VDPWR sky130_fd_pr__pfet_01v8_hvt ad=0.1176 pd=1.4 as=0.2583 ps=2.37 w=0.42 l=0.15
X122 sky130_fd_sc_hd__dfrtp_1_56/a_1462_47# V3R298 VGND VGND sky130_fd_pr__nfet_01v8 ad=0 pd=0 as=0 ps=0 w=0.42 l=0.15
X123 sky130_fd_sc_hd__dfrtp_1_56/a_543_47# sky130_fd_sc_hd__dfrtp_1_56/a_27_47# sky130_fd_sc_hd__dfrtp_1_56/a_448_47# VGND sky130_fd_pr__special_nfet_01v8 ad=0.1188 pd=1.38 as=0.132 ps=1.49 w=0.36 l=0.15
X124 sky130_fd_sc_hd__dfrtp_1_56/a_543_47# sky130_fd_sc_hd__dfrtp_1_56/a_193_47# sky130_fd_sc_hd__dfrtp_1_56/a_448_47# VDPWR sky130_fd_pr__pfet_01v8_hvt ad=0 pd=0 as=0 ps=0 w=0.42 l=0.15
X125 sky130_fd_sc_hd__dfrtp_1_56/a_448_47# V3R100 VGND VGND sky130_fd_pr__nfet_01v8 ad=0 pd=0 as=0 ps=0 w=0.42 l=0.15
X126 VDPWR sky130_fd_sc_hd__dfrtp_1_56/a_1283_21# sky130_fd_sc_hd__dfrtp_1_56/a_1270_413# VDPWR sky130_fd_pr__pfet_01v8_hvt ad=0 pd=0 as=0.1134 ps=1.38 w=0.42 l=0.15
X127 VDPWR sky130_fd_sc_hd__dfrtp_1_56/a_1108_47# sky130_fd_sc_hd__dfrtp_1_56/a_1283_21# VDPWR sky130_fd_pr__pfet_01v8_hvt ad=0 pd=0 as=0.1134 ps=1.38 w=0.42 l=0.15
X128 sky130_fd_sc_hd__dfrtp_1_56/a_1270_413# sky130_fd_sc_hd__dfrtp_1_56/a_193_47# sky130_fd_sc_hd__dfrtp_1_56/a_1108_47# VDPWR sky130_fd_pr__pfet_01v8_hvt ad=0 pd=0 as=0 ps=0 w=0.42 l=0.15
X129 sky130_fd_sc_hd__dfrtp_1_56/a_193_47# sky130_fd_sc_hd__dfrtp_1_56/a_27_47# VDPWR VDPWR sky130_fd_pr__pfet_01v8_hvt ad=0.1664 pd=1.8 as=0 ps=0 w=0.64 l=0.15
X130 sky130_fd_sc_hd__dfrtp_1_56/a_1283_21# V3R298 VDPWR VDPWR sky130_fd_pr__pfet_01v8_hvt ad=0 pd=0 as=0 ps=0 w=0.42 l=0.15
X131 VDPWR sky130_fd_sc_hd__dfrtp_1_56/a_761_289# sky130_fd_sc_hd__dfrtp_1_56/a_651_413# VDPWR sky130_fd_pr__pfet_01v8_hvt ad=0 pd=0 as=0 ps=0 w=0.42 l=0.15
X132 V3R155 sky130_fd_sc_hd__dfrtp_1_56/a_1283_21# VGND VGND sky130_fd_pr__nfet_01v8 ad=0.169 pd=1.82 as=0 ps=0 w=0.65 l=0.15
X133 sky130_fd_sc_hd__dfrtp_1_56/a_639_47# sky130_fd_sc_hd__dfrtp_1_56/a_193_47# sky130_fd_sc_hd__dfrtp_1_56/a_543_47# VGND sky130_fd_pr__special_nfet_01v8 ad=0 pd=0 as=0 ps=0 w=0.36 l=0.15
X134 VGND sky130_fd_sc_hd__dfrtp_1_56/a_1283_21# sky130_fd_sc_hd__dfrtp_1_56/a_1217_47# VGND sky130_fd_pr__nfet_01v8 ad=0 pd=0 as=0 ps=0 w=0.42 l=0.15
X135 sky130_fd_sc_hd__dfrtp_1_56/a_651_413# V3R298 VDPWR VDPWR sky130_fd_pr__pfet_01v8_hvt ad=0 pd=0 as=0 ps=0 w=0.42 l=0.15
X136 VGND V3R055 sky130_fd_sc_hd__dfrtp_1_56/a_27_47# VGND sky130_fd_pr__nfet_01v8 ad=0 pd=0 as=0.1092 ps=1.36 w=0.42 l=0.15
X137 sky130_fd_sc_hd__dfrtp_1_56/a_761_289# sky130_fd_sc_hd__dfrtp_1_56/a_543_47# VDPWR VDPWR sky130_fd_pr__pfet_01v8_hvt ad=0 pd=0 as=0 ps=0 w=0.84 l=0.15
X138 sky130_fd_sc_hd__dfrtp_1_45/a_805_47# sky130_fd_sc_hd__dfrtp_1_45/a_761_289# sky130_fd_sc_hd__dfrtp_1_45/a_639_47# VGND sky130_fd_pr__nfet_01v8 ad=0.0882 pd=1.26 as=0.2802 ps=2.2 w=0.42 l=0.15
X139 sky130_fd_sc_hd__dfrtp_1_45/a_1217_47# sky130_fd_sc_hd__dfrtp_1_45/a_27_47# sky130_fd_sc_hd__dfrtp_1_45/a_1108_47# VGND sky130_fd_pr__special_nfet_01v8 ad=0.1338 pd=1.5 as=0.1422 ps=1.51 w=0.36 l=0.15
X140 sky130_fd_sc_hd__dfrtp_1_45/a_1283_21# sky130_fd_sc_hd__dfrtp_1_45/a_1108_47# sky130_fd_sc_hd__dfrtp_1_45/a_1462_47# VGND sky130_fd_pr__nfet_01v8 ad=0.1092 pd=1.36 as=0.1281 ps=1.45 w=0.42 l=0.15
X141 sky130_fd_sc_hd__dfrtp_1_45/a_651_413# sky130_fd_sc_hd__dfrtp_1_45/a_27_47# sky130_fd_sc_hd__dfrtp_1_45/a_543_47# VDPWR sky130_fd_pr__pfet_01v8_hvt ad=0.3402 pd=3.3 as=0.1449 ps=1.53 w=0.42 l=0.15
X142 sky130_fd_sc_hd__dfrtp_1_45/a_1108_47# sky130_fd_sc_hd__dfrtp_1_45/a_193_47# sky130_fd_sc_hd__dfrtp_1_45/a_761_289# VGND sky130_fd_pr__special_nfet_01v8 ad=0 pd=0 as=0.1998 ps=1.97 w=0.36 l=0.15
X143 VGND V3R301 sky130_fd_sc_hd__dfrtp_1_45/a_805_47# VGND sky130_fd_pr__nfet_01v8 ad=0 pd=0 as=0 ps=0 w=0.42 l=0.15
X144 V3R020 sky130_fd_sc_hd__dfrtp_1_45/a_1283_21# VDPWR VDPWR sky130_fd_pr__pfet_01v8_hvt ad=0.26 pd=2.52 as=0 ps=0 w=1 l=0.15
X145 VDPWR V3R082 sky130_fd_sc_hd__dfrtp_1_45/a_27_47# VDPWR sky130_fd_pr__pfet_01v8_hvt ad=0 pd=0 as=0.1664 ps=1.8 w=0.64 l=0.15
X146 sky130_fd_sc_hd__dfrtp_1_45/a_448_47# V3R136 VDPWR VDPWR sky130_fd_pr__pfet_01v8_hvt ad=0.1302 pd=1.46 as=0 ps=0 w=0.42 l=0.15
X147 sky130_fd_sc_hd__dfrtp_1_45/a_761_289# sky130_fd_sc_hd__dfrtp_1_45/a_543_47# VGND VGND sky130_fd_pr__nfet_01v8 ad=0 pd=0 as=0 ps=0 w=0.64 l=0.15
X148 sky130_fd_sc_hd__dfrtp_1_45/a_193_47# sky130_fd_sc_hd__dfrtp_1_45/a_27_47# VGND VGND sky130_fd_pr__nfet_01v8 ad=0.1092 pd=1.36 as=0 ps=0 w=0.42 l=0.15
X149 sky130_fd_sc_hd__dfrtp_1_45/a_1108_47# sky130_fd_sc_hd__dfrtp_1_45/a_27_47# sky130_fd_sc_hd__dfrtp_1_45/a_761_289# VDPWR sky130_fd_pr__pfet_01v8_hvt ad=0.1176 pd=1.4 as=0.2583 ps=2.37 w=0.42 l=0.15
X150 sky130_fd_sc_hd__dfrtp_1_45/a_1462_47# V3R301 VGND VGND sky130_fd_pr__nfet_01v8 ad=0 pd=0 as=0 ps=0 w=0.42 l=0.15
X151 sky130_fd_sc_hd__dfrtp_1_45/a_543_47# sky130_fd_sc_hd__dfrtp_1_45/a_27_47# sky130_fd_sc_hd__dfrtp_1_45/a_448_47# VGND sky130_fd_pr__special_nfet_01v8 ad=0.1188 pd=1.38 as=0.132 ps=1.49 w=0.36 l=0.15
X152 sky130_fd_sc_hd__dfrtp_1_45/a_543_47# sky130_fd_sc_hd__dfrtp_1_45/a_193_47# sky130_fd_sc_hd__dfrtp_1_45/a_448_47# VDPWR sky130_fd_pr__pfet_01v8_hvt ad=0 pd=0 as=0 ps=0 w=0.42 l=0.15
X153 sky130_fd_sc_hd__dfrtp_1_45/a_448_47# V3R136 VGND VGND sky130_fd_pr__nfet_01v8 ad=0 pd=0 as=0 ps=0 w=0.42 l=0.15
X154 VDPWR sky130_fd_sc_hd__dfrtp_1_45/a_1283_21# sky130_fd_sc_hd__dfrtp_1_45/a_1270_413# VDPWR sky130_fd_pr__pfet_01v8_hvt ad=0 pd=0 as=0.1134 ps=1.38 w=0.42 l=0.15
X155 VDPWR sky130_fd_sc_hd__dfrtp_1_45/a_1108_47# sky130_fd_sc_hd__dfrtp_1_45/a_1283_21# VDPWR sky130_fd_pr__pfet_01v8_hvt ad=0 pd=0 as=0.1134 ps=1.38 w=0.42 l=0.15
X156 sky130_fd_sc_hd__dfrtp_1_45/a_1270_413# sky130_fd_sc_hd__dfrtp_1_45/a_193_47# sky130_fd_sc_hd__dfrtp_1_45/a_1108_47# VDPWR sky130_fd_pr__pfet_01v8_hvt ad=0 pd=0 as=0 ps=0 w=0.42 l=0.15
X157 sky130_fd_sc_hd__dfrtp_1_45/a_193_47# sky130_fd_sc_hd__dfrtp_1_45/a_27_47# VDPWR VDPWR sky130_fd_pr__pfet_01v8_hvt ad=0.1664 pd=1.8 as=0 ps=0 w=0.64 l=0.15
X158 sky130_fd_sc_hd__dfrtp_1_45/a_1283_21# V3R301 VDPWR VDPWR sky130_fd_pr__pfet_01v8_hvt ad=0 pd=0 as=0 ps=0 w=0.42 l=0.15
X159 VDPWR sky130_fd_sc_hd__dfrtp_1_45/a_761_289# sky130_fd_sc_hd__dfrtp_1_45/a_651_413# VDPWR sky130_fd_pr__pfet_01v8_hvt ad=0 pd=0 as=0 ps=0 w=0.42 l=0.15
X160 V3R020 sky130_fd_sc_hd__dfrtp_1_45/a_1283_21# VGND VGND sky130_fd_pr__nfet_01v8 ad=0.169 pd=1.82 as=0 ps=0 w=0.65 l=0.15
X161 sky130_fd_sc_hd__dfrtp_1_45/a_639_47# sky130_fd_sc_hd__dfrtp_1_45/a_193_47# sky130_fd_sc_hd__dfrtp_1_45/a_543_47# VGND sky130_fd_pr__special_nfet_01v8 ad=0 pd=0 as=0 ps=0 w=0.36 l=0.15
X162 VGND sky130_fd_sc_hd__dfrtp_1_45/a_1283_21# sky130_fd_sc_hd__dfrtp_1_45/a_1217_47# VGND sky130_fd_pr__nfet_01v8 ad=0 pd=0 as=0 ps=0 w=0.42 l=0.15
X163 sky130_fd_sc_hd__dfrtp_1_45/a_651_413# V3R301 VDPWR VDPWR sky130_fd_pr__pfet_01v8_hvt ad=0 pd=0 as=0 ps=0 w=0.42 l=0.15
X164 VGND V3R082 sky130_fd_sc_hd__dfrtp_1_45/a_27_47# VGND sky130_fd_pr__nfet_01v8 ad=0 pd=0 as=0.1092 ps=1.36 w=0.42 l=0.15
X165 sky130_fd_sc_hd__dfrtp_1_45/a_761_289# sky130_fd_sc_hd__dfrtp_1_45/a_543_47# VDPWR VDPWR sky130_fd_pr__pfet_01v8_hvt ad=0 pd=0 as=0 ps=0 w=0.84 l=0.15
X166 sky130_fd_sc_hd__dfrtp_1_34/a_805_47# sky130_fd_sc_hd__dfrtp_1_34/a_761_289# sky130_fd_sc_hd__dfrtp_1_34/a_639_47# VGND sky130_fd_pr__nfet_01v8 ad=0.0882 pd=1.26 as=0.2802 ps=2.2 w=0.42 l=0.15
X167 sky130_fd_sc_hd__dfrtp_1_34/a_1217_47# sky130_fd_sc_hd__dfrtp_1_34/a_27_47# sky130_fd_sc_hd__dfrtp_1_34/a_1108_47# VGND sky130_fd_pr__special_nfet_01v8 ad=0.1338 pd=1.5 as=0.1422 ps=1.51 w=0.36 l=0.15
X168 sky130_fd_sc_hd__dfrtp_1_34/a_1283_21# sky130_fd_sc_hd__dfrtp_1_34/a_1108_47# sky130_fd_sc_hd__dfrtp_1_34/a_1462_47# VGND sky130_fd_pr__nfet_01v8 ad=0.1092 pd=1.36 as=0.1281 ps=1.45 w=0.42 l=0.15
X169 sky130_fd_sc_hd__dfrtp_1_34/a_651_413# sky130_fd_sc_hd__dfrtp_1_34/a_27_47# sky130_fd_sc_hd__dfrtp_1_34/a_543_47# VDPWR sky130_fd_pr__pfet_01v8_hvt ad=0.3402 pd=3.3 as=0.1449 ps=1.53 w=0.42 l=0.15
X170 sky130_fd_sc_hd__dfrtp_1_34/a_1108_47# sky130_fd_sc_hd__dfrtp_1_34/a_193_47# sky130_fd_sc_hd__dfrtp_1_34/a_761_289# VGND sky130_fd_pr__special_nfet_01v8 ad=0 pd=0 as=0.1998 ps=1.97 w=0.36 l=0.15
X171 VGND V3R303 sky130_fd_sc_hd__dfrtp_1_34/a_805_47# VGND sky130_fd_pr__nfet_01v8 ad=0 pd=0 as=0 ps=0 w=0.42 l=0.15
X172 V3R079 sky130_fd_sc_hd__dfrtp_1_34/a_1283_21# VDPWR VDPWR sky130_fd_pr__pfet_01v8_hvt ad=0.26 pd=2.52 as=0 ps=0 w=1 l=0.15
X173 VDPWR V3R084 sky130_fd_sc_hd__dfrtp_1_34/a_27_47# VDPWR sky130_fd_pr__pfet_01v8_hvt ad=0 pd=0 as=0.1664 ps=1.8 w=0.64 l=0.15
X174 sky130_fd_sc_hd__dfrtp_1_34/a_448_47# V3R202 VDPWR VDPWR sky130_fd_pr__pfet_01v8_hvt ad=0.1302 pd=1.46 as=0 ps=0 w=0.42 l=0.15
X175 sky130_fd_sc_hd__dfrtp_1_34/a_761_289# sky130_fd_sc_hd__dfrtp_1_34/a_543_47# VGND VGND sky130_fd_pr__nfet_01v8 ad=0 pd=0 as=0 ps=0 w=0.64 l=0.15
X176 sky130_fd_sc_hd__dfrtp_1_34/a_193_47# sky130_fd_sc_hd__dfrtp_1_34/a_27_47# VGND VGND sky130_fd_pr__nfet_01v8 ad=0.1092 pd=1.36 as=0 ps=0 w=0.42 l=0.15
X177 sky130_fd_sc_hd__dfrtp_1_34/a_1108_47# sky130_fd_sc_hd__dfrtp_1_34/a_27_47# sky130_fd_sc_hd__dfrtp_1_34/a_761_289# VDPWR sky130_fd_pr__pfet_01v8_hvt ad=0.1176 pd=1.4 as=0.2583 ps=2.37 w=0.42 l=0.15
X178 sky130_fd_sc_hd__dfrtp_1_34/a_1462_47# V3R303 VGND VGND sky130_fd_pr__nfet_01v8 ad=0 pd=0 as=0 ps=0 w=0.42 l=0.15
X179 sky130_fd_sc_hd__dfrtp_1_34/a_543_47# sky130_fd_sc_hd__dfrtp_1_34/a_27_47# sky130_fd_sc_hd__dfrtp_1_34/a_448_47# VGND sky130_fd_pr__special_nfet_01v8 ad=0.1188 pd=1.38 as=0.132 ps=1.49 w=0.36 l=0.15
X180 sky130_fd_sc_hd__dfrtp_1_34/a_543_47# sky130_fd_sc_hd__dfrtp_1_34/a_193_47# sky130_fd_sc_hd__dfrtp_1_34/a_448_47# VDPWR sky130_fd_pr__pfet_01v8_hvt ad=0 pd=0 as=0 ps=0 w=0.42 l=0.15
X181 sky130_fd_sc_hd__dfrtp_1_34/a_448_47# V3R202 VGND VGND sky130_fd_pr__nfet_01v8 ad=0 pd=0 as=0 ps=0 w=0.42 l=0.15
X182 VDPWR sky130_fd_sc_hd__dfrtp_1_34/a_1283_21# sky130_fd_sc_hd__dfrtp_1_34/a_1270_413# VDPWR sky130_fd_pr__pfet_01v8_hvt ad=0 pd=0 as=0.1134 ps=1.38 w=0.42 l=0.15
X183 VDPWR sky130_fd_sc_hd__dfrtp_1_34/a_1108_47# sky130_fd_sc_hd__dfrtp_1_34/a_1283_21# VDPWR sky130_fd_pr__pfet_01v8_hvt ad=0 pd=0 as=0.1134 ps=1.38 w=0.42 l=0.15
X184 sky130_fd_sc_hd__dfrtp_1_34/a_1270_413# sky130_fd_sc_hd__dfrtp_1_34/a_193_47# sky130_fd_sc_hd__dfrtp_1_34/a_1108_47# VDPWR sky130_fd_pr__pfet_01v8_hvt ad=0 pd=0 as=0 ps=0 w=0.42 l=0.15
X185 sky130_fd_sc_hd__dfrtp_1_34/a_193_47# sky130_fd_sc_hd__dfrtp_1_34/a_27_47# VDPWR VDPWR sky130_fd_pr__pfet_01v8_hvt ad=0.1664 pd=1.8 as=0 ps=0 w=0.64 l=0.15
X186 sky130_fd_sc_hd__dfrtp_1_34/a_1283_21# V3R303 VDPWR VDPWR sky130_fd_pr__pfet_01v8_hvt ad=0 pd=0 as=0 ps=0 w=0.42 l=0.15
X187 VDPWR sky130_fd_sc_hd__dfrtp_1_34/a_761_289# sky130_fd_sc_hd__dfrtp_1_34/a_651_413# VDPWR sky130_fd_pr__pfet_01v8_hvt ad=0 pd=0 as=0 ps=0 w=0.42 l=0.15
X188 V3R079 sky130_fd_sc_hd__dfrtp_1_34/a_1283_21# VGND VGND sky130_fd_pr__nfet_01v8 ad=0.169 pd=1.82 as=0 ps=0 w=0.65 l=0.15
X189 sky130_fd_sc_hd__dfrtp_1_34/a_639_47# sky130_fd_sc_hd__dfrtp_1_34/a_193_47# sky130_fd_sc_hd__dfrtp_1_34/a_543_47# VGND sky130_fd_pr__special_nfet_01v8 ad=0 pd=0 as=0 ps=0 w=0.36 l=0.15
X190 VGND sky130_fd_sc_hd__dfrtp_1_34/a_1283_21# sky130_fd_sc_hd__dfrtp_1_34/a_1217_47# VGND sky130_fd_pr__nfet_01v8 ad=0 pd=0 as=0 ps=0 w=0.42 l=0.15
X191 sky130_fd_sc_hd__dfrtp_1_34/a_651_413# V3R303 VDPWR VDPWR sky130_fd_pr__pfet_01v8_hvt ad=0 pd=0 as=0 ps=0 w=0.42 l=0.15
X192 VGND V3R084 sky130_fd_sc_hd__dfrtp_1_34/a_27_47# VGND sky130_fd_pr__nfet_01v8 ad=0 pd=0 as=0.1092 ps=1.36 w=0.42 l=0.15
X193 sky130_fd_sc_hd__dfrtp_1_34/a_761_289# sky130_fd_sc_hd__dfrtp_1_34/a_543_47# VDPWR VDPWR sky130_fd_pr__pfet_01v8_hvt ad=0 pd=0 as=0 ps=0 w=0.84 l=0.15
X194 sky130_fd_sc_hd__dfrtp_1_78/a_805_47# sky130_fd_sc_hd__dfrtp_1_78/a_761_289# sky130_fd_sc_hd__dfrtp_1_78/a_639_47# VGND sky130_fd_pr__nfet_01v8 ad=0.0882 pd=1.26 as=0.2802 ps=2.2 w=0.42 l=0.15
X195 sky130_fd_sc_hd__dfrtp_1_78/a_1217_47# sky130_fd_sc_hd__dfrtp_1_78/a_27_47# sky130_fd_sc_hd__dfrtp_1_78/a_1108_47# VGND sky130_fd_pr__special_nfet_01v8 ad=0.1338 pd=1.5 as=0.1422 ps=1.51 w=0.36 l=0.15
X196 sky130_fd_sc_hd__dfrtp_1_78/a_1283_21# sky130_fd_sc_hd__dfrtp_1_78/a_1108_47# sky130_fd_sc_hd__dfrtp_1_78/a_1462_47# VGND sky130_fd_pr__nfet_01v8 ad=0.1092 pd=1.36 as=0.1281 ps=1.45 w=0.42 l=0.15
X197 sky130_fd_sc_hd__dfrtp_1_78/a_651_413# sky130_fd_sc_hd__dfrtp_1_78/a_27_47# sky130_fd_sc_hd__dfrtp_1_78/a_543_47# VDPWR sky130_fd_pr__pfet_01v8_hvt ad=0.3402 pd=3.3 as=0.1449 ps=1.53 w=0.42 l=0.15
X198 sky130_fd_sc_hd__dfrtp_1_78/a_1108_47# sky130_fd_sc_hd__dfrtp_1_78/a_193_47# sky130_fd_sc_hd__dfrtp_1_78/a_761_289# VGND sky130_fd_pr__special_nfet_01v8 ad=0 pd=0 as=0.1998 ps=1.97 w=0.36 l=0.15
X199 VGND V3R298 sky130_fd_sc_hd__dfrtp_1_78/a_805_47# VGND sky130_fd_pr__nfet_01v8 ad=0 pd=0 as=0 ps=0 w=0.42 l=0.15
X200 V3R176 sky130_fd_sc_hd__dfrtp_1_78/a_1283_21# VDPWR VDPWR sky130_fd_pr__pfet_01v8_hvt ad=0.26 pd=2.52 as=0 ps=0 w=1 l=0.15
X201 VDPWR V3R055 sky130_fd_sc_hd__dfrtp_1_78/a_27_47# VDPWR sky130_fd_pr__pfet_01v8_hvt ad=0 pd=0 as=0.1664 ps=1.8 w=0.64 l=0.15
X202 sky130_fd_sc_hd__dfrtp_1_78/a_448_47# V3R090 VDPWR VDPWR sky130_fd_pr__pfet_01v8_hvt ad=0.1302 pd=1.46 as=0 ps=0 w=0.42 l=0.15
X203 sky130_fd_sc_hd__dfrtp_1_78/a_761_289# sky130_fd_sc_hd__dfrtp_1_78/a_543_47# VGND VGND sky130_fd_pr__nfet_01v8 ad=0 pd=0 as=0 ps=0 w=0.64 l=0.15
X204 sky130_fd_sc_hd__dfrtp_1_78/a_193_47# sky130_fd_sc_hd__dfrtp_1_78/a_27_47# VGND VGND sky130_fd_pr__nfet_01v8 ad=0.1092 pd=1.36 as=0 ps=0 w=0.42 l=0.15
X205 sky130_fd_sc_hd__dfrtp_1_78/a_1108_47# sky130_fd_sc_hd__dfrtp_1_78/a_27_47# sky130_fd_sc_hd__dfrtp_1_78/a_761_289# VDPWR sky130_fd_pr__pfet_01v8_hvt ad=0.1176 pd=1.4 as=0.2583 ps=2.37 w=0.42 l=0.15
X206 sky130_fd_sc_hd__dfrtp_1_78/a_1462_47# V3R298 VGND VGND sky130_fd_pr__nfet_01v8 ad=0 pd=0 as=0 ps=0 w=0.42 l=0.15
X207 sky130_fd_sc_hd__dfrtp_1_78/a_543_47# sky130_fd_sc_hd__dfrtp_1_78/a_27_47# sky130_fd_sc_hd__dfrtp_1_78/a_448_47# VGND sky130_fd_pr__special_nfet_01v8 ad=0.1188 pd=1.38 as=0.132 ps=1.49 w=0.36 l=0.15
X208 sky130_fd_sc_hd__dfrtp_1_78/a_543_47# sky130_fd_sc_hd__dfrtp_1_78/a_193_47# sky130_fd_sc_hd__dfrtp_1_78/a_448_47# VDPWR sky130_fd_pr__pfet_01v8_hvt ad=0 pd=0 as=0 ps=0 w=0.42 l=0.15
X209 sky130_fd_sc_hd__dfrtp_1_78/a_448_47# V3R090 VGND VGND sky130_fd_pr__nfet_01v8 ad=0 pd=0 as=0 ps=0 w=0.42 l=0.15
X210 VDPWR sky130_fd_sc_hd__dfrtp_1_78/a_1283_21# sky130_fd_sc_hd__dfrtp_1_78/a_1270_413# VDPWR sky130_fd_pr__pfet_01v8_hvt ad=0 pd=0 as=0.1134 ps=1.38 w=0.42 l=0.15
X211 VDPWR sky130_fd_sc_hd__dfrtp_1_78/a_1108_47# sky130_fd_sc_hd__dfrtp_1_78/a_1283_21# VDPWR sky130_fd_pr__pfet_01v8_hvt ad=0 pd=0 as=0.1134 ps=1.38 w=0.42 l=0.15
X212 sky130_fd_sc_hd__dfrtp_1_78/a_1270_413# sky130_fd_sc_hd__dfrtp_1_78/a_193_47# sky130_fd_sc_hd__dfrtp_1_78/a_1108_47# VDPWR sky130_fd_pr__pfet_01v8_hvt ad=0 pd=0 as=0 ps=0 w=0.42 l=0.15
X213 sky130_fd_sc_hd__dfrtp_1_78/a_193_47# sky130_fd_sc_hd__dfrtp_1_78/a_27_47# VDPWR VDPWR sky130_fd_pr__pfet_01v8_hvt ad=0.1664 pd=1.8 as=0 ps=0 w=0.64 l=0.15
X214 sky130_fd_sc_hd__dfrtp_1_78/a_1283_21# V3R298 VDPWR VDPWR sky130_fd_pr__pfet_01v8_hvt ad=0 pd=0 as=0 ps=0 w=0.42 l=0.15
X215 VDPWR sky130_fd_sc_hd__dfrtp_1_78/a_761_289# sky130_fd_sc_hd__dfrtp_1_78/a_651_413# VDPWR sky130_fd_pr__pfet_01v8_hvt ad=0 pd=0 as=0 ps=0 w=0.42 l=0.15
X216 V3R176 sky130_fd_sc_hd__dfrtp_1_78/a_1283_21# VGND VGND sky130_fd_pr__nfet_01v8 ad=0.169 pd=1.82 as=0 ps=0 w=0.65 l=0.15
X217 sky130_fd_sc_hd__dfrtp_1_78/a_639_47# sky130_fd_sc_hd__dfrtp_1_78/a_193_47# sky130_fd_sc_hd__dfrtp_1_78/a_543_47# VGND sky130_fd_pr__special_nfet_01v8 ad=0 pd=0 as=0 ps=0 w=0.36 l=0.15
X218 VGND sky130_fd_sc_hd__dfrtp_1_78/a_1283_21# sky130_fd_sc_hd__dfrtp_1_78/a_1217_47# VGND sky130_fd_pr__nfet_01v8 ad=0 pd=0 as=0 ps=0 w=0.42 l=0.15
X219 sky130_fd_sc_hd__dfrtp_1_78/a_651_413# V3R298 VDPWR VDPWR sky130_fd_pr__pfet_01v8_hvt ad=0 pd=0 as=0 ps=0 w=0.42 l=0.15
X220 VGND V3R055 sky130_fd_sc_hd__dfrtp_1_78/a_27_47# VGND sky130_fd_pr__nfet_01v8 ad=0 pd=0 as=0.1092 ps=1.36 w=0.42 l=0.15
X221 sky130_fd_sc_hd__dfrtp_1_78/a_761_289# sky130_fd_sc_hd__dfrtp_1_78/a_543_47# VDPWR VDPWR sky130_fd_pr__pfet_01v8_hvt ad=0 pd=0 as=0 ps=0 w=0.84 l=0.15
X222 VDPWR sky130_fd_sc_hd__mux2_1_4/a_505_21# sky130_fd_sc_hd__mux2_1_4/a_535_374# VDPWR sky130_fd_pr__pfet_01v8_hvt ad=0 pd=0 as=0.0882 ps=1.26 w=0.42 l=0.15
X223 sky130_fd_sc_hd__mux2_1_4/a_505_21# V3R010 VDPWR VDPWR sky130_fd_pr__pfet_01v8_hvt ad=0.1176 pd=1.4 as=0 ps=0 w=0.42 l=0.15
X224 sky130_fd_sc_hd__mux2_1_4/a_218_374# V3R010 VDPWR VDPWR sky130_fd_pr__pfet_01v8_hvt ad=0.1533 pd=1.57 as=0 ps=0 w=0.42 l=0.15
X225 VGND sky130_fd_sc_hd__mux2_1_4/a_505_21# sky130_fd_sc_hd__mux2_1_4/a_439_47# VGND sky130_fd_pr__nfet_01v8 ad=0 pd=0 as=0.1386 ps=1.5 w=0.42 l=0.15
X226 sky130_fd_sc_hd__mux2_1_4/a_76_199# V3R260 sky130_fd_sc_hd__mux2_1_4/a_218_374# VDPWR sky130_fd_pr__pfet_01v8_hvt ad=0.3864 pd=2.68 as=0 ps=0 w=0.42 l=0.15
X227 sky130_fd_sc_hd__mux2_1_4/a_505_21# V3R010 VGND VGND sky130_fd_pr__nfet_01v8 ad=0.1092 pd=1.36 as=0 ps=0 w=0.42 l=0.15
X228 sky130_fd_sc_hd__mux2_1_4/a_439_47# V3R260 sky130_fd_sc_hd__mux2_1_4/a_76_199# VGND sky130_fd_pr__nfet_01v8 ad=0 pd=0 as=0.1995 ps=1.79 w=0.42 l=0.15
X229 sky130_fd_sc_hd__mux2_1_4/a_535_374# V3R035 sky130_fd_sc_hd__mux2_1_4/a_76_199# VDPWR sky130_fd_pr__pfet_01v8_hvt ad=0 pd=0 as=0 ps=0 w=0.42 l=0.15
X230 sky130_fd_sc_hd__mux2_1_4/a_76_199# V3R035 sky130_fd_sc_hd__mux2_1_4/a_218_47# VGND sky130_fd_pr__nfet_01v8 ad=0 pd=0 as=0.1386 ps=1.5 w=0.42 l=0.15
X231 sky130_fd_sc_hd__mux2_1_4/a_218_47# V3R010 VGND VGND sky130_fd_pr__nfet_01v8 ad=0 pd=0 as=0 ps=0 w=0.42 l=0.15
X232 VDPWR sky130_fd_sc_hd__mux2_1_4/a_76_199# V3R230 VDPWR sky130_fd_pr__pfet_01v8_hvt ad=0 pd=0 as=0.26 ps=2.52 w=1 l=0.15
X233 VGND sky130_fd_sc_hd__mux2_1_4/a_76_199# V3R230 VGND sky130_fd_pr__nfet_01v8 ad=0 pd=0 as=0.169 ps=1.82 w=0.65 l=0.15
X234 V3R280 sky130_fd_sc_hd__xor2_1_3/a_35_297# sky130_fd_sc_hd__xor2_1_3/a_285_297# VDPWR sky130_fd_pr__pfet_01v8_hvt ad=0.3 pd=2.6 as=0.26 ps=2.52 w=1 l=0.15
X235 V3R280 V3R078 sky130_fd_sc_hd__xor2_1_3/a_285_47# VGND sky130_fd_pr__nfet_01v8 ad=0.25025 pd=1.42 as=0.08775 ps=0.92 w=0.65 l=0.15
X236 sky130_fd_sc_hd__xor2_1_3/a_35_297# V3R078 VGND VGND sky130_fd_pr__nfet_01v8 ad=0.08775 pd=0.92 as=0.169 ps=1.82 w=0.65 l=0.15
X237 sky130_fd_sc_hd__xor2_1_3/a_117_297# V3R078 sky130_fd_sc_hd__xor2_1_3/a_35_297# VDPWR sky130_fd_pr__pfet_01v8_hvt ad=0.135 pd=1.27 as=0.26 ps=2.52 w=1 l=0.15
X238 VDPWR V3R078 sky130_fd_sc_hd__xor2_1_3/a_285_297# VDPWR sky130_fd_pr__pfet_01v8_hvt ad=0.26 pd=2.52 as=0.135 ps=1.27 w=1 l=0.15
X239 VGND V3R005 sky130_fd_sc_hd__xor2_1_3/a_35_297# VGND sky130_fd_pr__nfet_01v8 ad=0.08775 pd=0.92 as=0.08775 ps=0.92 w=0.65 l=0.15
X240 VGND sky130_fd_sc_hd__xor2_1_3/a_35_297# V3R280 VGND sky130_fd_pr__nfet_01v8 ad=0.208 pd=1.94 as=0.25025 ps=1.42 w=0.65 l=0.15
X241 sky130_fd_sc_hd__xor2_1_3/a_285_297# V3R005 VDPWR VDPWR sky130_fd_pr__pfet_01v8_hvt ad=0.135 pd=1.27 as=0.135 ps=1.27 w=1 l=0.15
X242 VDPWR V3R005 sky130_fd_sc_hd__xor2_1_3/a_117_297# VDPWR sky130_fd_pr__pfet_01v8_hvt ad=0.135 pd=1.27 as=0.135 ps=1.27 w=1 l=0.15
X243 sky130_fd_sc_hd__xor2_1_3/a_285_47# V3R005 VGND VGND sky130_fd_pr__nfet_01v8 ad=0.08775 pd=0.92 as=0.08775 ps=0.92 w=0.65 l=0.15
X244 VDPWR V3R008 sky130_fd_sc_hd__and2_1_11/a_59_75# VDPWR sky130_fd_pr__pfet_01v8_hvt ad=0 pd=0 as=0.1134 ps=1.38 w=0.42 l=0.15
X245 V3R217 sky130_fd_sc_hd__and2_1_11/a_59_75# VDPWR VDPWR sky130_fd_pr__pfet_01v8_hvt ad=0.475 pd=2.95 as=0 ps=0 w=1 l=0.15
X246 VGND V3R008 sky130_fd_sc_hd__and2_1_11/a_145_75# VGND sky130_fd_pr__nfet_01v8 ad=0 pd=0 as=0.1134 ps=1.38 w=0.42 l=0.15
X247 sky130_fd_sc_hd__and2_1_11/a_59_75# V3R022 VDPWR VDPWR sky130_fd_pr__pfet_01v8_hvt ad=0 pd=0 as=0 ps=0 w=0.42 l=0.15
X248 V3R217 sky130_fd_sc_hd__and2_1_11/a_59_75# VGND VGND sky130_fd_pr__nfet_01v8 ad=0.182 pd=1.86 as=0 ps=0 w=0.65 l=0.15
X249 sky130_fd_sc_hd__and2_1_11/a_145_75# V3R022 sky130_fd_sc_hd__and2_1_11/a_59_75# VGND sky130_fd_pr__nfet_01v8 ad=0 pd=0 as=0.1176 ps=1.4 w=0.42 l=0.15
X250 VDPWR V3R289 sky130_fd_sc_hd__and2b_1_12/a_207_413# VDPWR sky130_fd_pr__pfet_01v8_hvt ad=0 pd=0 as=0.1218 ps=1.42 w=0.42 l=0.15
X251 V3R240 sky130_fd_sc_hd__and2b_1_12/a_207_413# VDPWR VDPWR sky130_fd_pr__pfet_01v8_hvt ad=0.26 pd=2.52 as=0 ps=0 w=1 l=0.15
X252 sky130_fd_sc_hd__and2b_1_12/a_297_47# sky130_fd_sc_hd__and2b_1_12/a_27_413# sky130_fd_sc_hd__and2b_1_12/a_207_413# VGND sky130_fd_pr__nfet_01v8 ad=0.1008 pd=1.32 as=0.1092 ps=1.36 w=0.42 l=0.15
X253 V3R240 sky130_fd_sc_hd__and2b_1_12/a_207_413# VGND VGND sky130_fd_pr__nfet_01v8 ad=0.169 pd=1.82 as=0 ps=0 w=0.65 l=0.15
X254 sky130_fd_sc_hd__and2b_1_12/a_207_413# sky130_fd_sc_hd__and2b_1_12/a_27_413# VDPWR VDPWR sky130_fd_pr__pfet_01v8_hvt ad=0 pd=0 as=0 ps=0 w=0.42 l=0.15
X255 VDPWR V3R239 sky130_fd_sc_hd__and2b_1_12/a_27_413# VDPWR sky130_fd_pr__pfet_01v8_hvt ad=0 pd=0 as=0.1092 ps=1.36 w=0.42 l=0.15
X256 VGND V3R289 sky130_fd_sc_hd__and2b_1_12/a_297_47# VGND sky130_fd_pr__nfet_01v8 ad=0 pd=0 as=0 ps=0 w=0.42 l=0.15
X257 sky130_fd_sc_hd__and2b_1_12/a_27_413# V3R239 VGND VGND sky130_fd_pr__nfet_01v8 ad=0.1092 pd=1.36 as=0 ps=0 w=0.42 l=0.15
X258 sky130_fd_sc_hd__dfrtp_1_13/a_805_47# sky130_fd_sc_hd__dfrtp_1_13/a_761_289# sky130_fd_sc_hd__dfrtp_1_13/a_639_47# VGND sky130_fd_pr__nfet_01v8 ad=0.0882 pd=1.26 as=0.2802 ps=2.2 w=0.42 l=0.15
X259 sky130_fd_sc_hd__dfrtp_1_13/a_1217_47# sky130_fd_sc_hd__dfrtp_1_13/a_27_47# sky130_fd_sc_hd__dfrtp_1_13/a_1108_47# VGND sky130_fd_pr__special_nfet_01v8 ad=0.1338 pd=1.5 as=0.1422 ps=1.51 w=0.36 l=0.15
X260 sky130_fd_sc_hd__dfrtp_1_13/a_1283_21# sky130_fd_sc_hd__dfrtp_1_13/a_1108_47# sky130_fd_sc_hd__dfrtp_1_13/a_1462_47# VGND sky130_fd_pr__nfet_01v8 ad=0.1092 pd=1.36 as=0.1281 ps=1.45 w=0.42 l=0.15
X261 sky130_fd_sc_hd__dfrtp_1_13/a_651_413# sky130_fd_sc_hd__dfrtp_1_13/a_27_47# sky130_fd_sc_hd__dfrtp_1_13/a_543_47# VDPWR sky130_fd_pr__pfet_01v8_hvt ad=0.3402 pd=3.3 as=0.1449 ps=1.53 w=0.42 l=0.15
X262 sky130_fd_sc_hd__dfrtp_1_13/a_1108_47# sky130_fd_sc_hd__dfrtp_1_13/a_193_47# sky130_fd_sc_hd__dfrtp_1_13/a_761_289# VGND sky130_fd_pr__special_nfet_01v8 ad=0 pd=0 as=0.1998 ps=1.97 w=0.36 l=0.15
X263 VGND V3R299 sky130_fd_sc_hd__dfrtp_1_13/a_805_47# VGND sky130_fd_pr__nfet_01v8 ad=0 pd=0 as=0 ps=0 w=0.42 l=0.15
X264 V3R171 sky130_fd_sc_hd__dfrtp_1_13/a_1283_21# VDPWR VDPWR sky130_fd_pr__pfet_01v8_hvt ad=0.26 pd=2.52 as=0 ps=0 w=1 l=0.15
X265 VDPWR V3R056 sky130_fd_sc_hd__dfrtp_1_13/a_27_47# VDPWR sky130_fd_pr__pfet_01v8_hvt ad=0 pd=0 as=0.1664 ps=1.8 w=0.64 l=0.15
X266 sky130_fd_sc_hd__dfrtp_1_13/a_448_47# V3R115 VDPWR VDPWR sky130_fd_pr__pfet_01v8_hvt ad=0.1302 pd=1.46 as=0 ps=0 w=0.42 l=0.15
X267 sky130_fd_sc_hd__dfrtp_1_13/a_761_289# sky130_fd_sc_hd__dfrtp_1_13/a_543_47# VGND VGND sky130_fd_pr__nfet_01v8 ad=0 pd=0 as=0 ps=0 w=0.64 l=0.15
X268 sky130_fd_sc_hd__dfrtp_1_13/a_193_47# sky130_fd_sc_hd__dfrtp_1_13/a_27_47# VGND VGND sky130_fd_pr__nfet_01v8 ad=0.1092 pd=1.36 as=0 ps=0 w=0.42 l=0.15
X269 sky130_fd_sc_hd__dfrtp_1_13/a_1108_47# sky130_fd_sc_hd__dfrtp_1_13/a_27_47# sky130_fd_sc_hd__dfrtp_1_13/a_761_289# VDPWR sky130_fd_pr__pfet_01v8_hvt ad=0.1176 pd=1.4 as=0.2583 ps=2.37 w=0.42 l=0.15
X270 sky130_fd_sc_hd__dfrtp_1_13/a_1462_47# V3R299 VGND VGND sky130_fd_pr__nfet_01v8 ad=0 pd=0 as=0 ps=0 w=0.42 l=0.15
X271 sky130_fd_sc_hd__dfrtp_1_13/a_543_47# sky130_fd_sc_hd__dfrtp_1_13/a_27_47# sky130_fd_sc_hd__dfrtp_1_13/a_448_47# VGND sky130_fd_pr__special_nfet_01v8 ad=0.1188 pd=1.38 as=0.132 ps=1.49 w=0.36 l=0.15
X272 sky130_fd_sc_hd__dfrtp_1_13/a_543_47# sky130_fd_sc_hd__dfrtp_1_13/a_193_47# sky130_fd_sc_hd__dfrtp_1_13/a_448_47# VDPWR sky130_fd_pr__pfet_01v8_hvt ad=0 pd=0 as=0 ps=0 w=0.42 l=0.15
X273 sky130_fd_sc_hd__dfrtp_1_13/a_448_47# V3R115 VGND VGND sky130_fd_pr__nfet_01v8 ad=0 pd=0 as=0 ps=0 w=0.42 l=0.15
X274 VDPWR sky130_fd_sc_hd__dfrtp_1_13/a_1283_21# sky130_fd_sc_hd__dfrtp_1_13/a_1270_413# VDPWR sky130_fd_pr__pfet_01v8_hvt ad=0 pd=0 as=0.1134 ps=1.38 w=0.42 l=0.15
X275 VDPWR sky130_fd_sc_hd__dfrtp_1_13/a_1108_47# sky130_fd_sc_hd__dfrtp_1_13/a_1283_21# VDPWR sky130_fd_pr__pfet_01v8_hvt ad=0 pd=0 as=0.1134 ps=1.38 w=0.42 l=0.15
X276 sky130_fd_sc_hd__dfrtp_1_13/a_1270_413# sky130_fd_sc_hd__dfrtp_1_13/a_193_47# sky130_fd_sc_hd__dfrtp_1_13/a_1108_47# VDPWR sky130_fd_pr__pfet_01v8_hvt ad=0 pd=0 as=0 ps=0 w=0.42 l=0.15
X277 sky130_fd_sc_hd__dfrtp_1_13/a_193_47# sky130_fd_sc_hd__dfrtp_1_13/a_27_47# VDPWR VDPWR sky130_fd_pr__pfet_01v8_hvt ad=0.1664 pd=1.8 as=0 ps=0 w=0.64 l=0.15
X278 sky130_fd_sc_hd__dfrtp_1_13/a_1283_21# V3R299 VDPWR VDPWR sky130_fd_pr__pfet_01v8_hvt ad=0 pd=0 as=0 ps=0 w=0.42 l=0.15
X279 VDPWR sky130_fd_sc_hd__dfrtp_1_13/a_761_289# sky130_fd_sc_hd__dfrtp_1_13/a_651_413# VDPWR sky130_fd_pr__pfet_01v8_hvt ad=0 pd=0 as=0 ps=0 w=0.42 l=0.15
X280 V3R171 sky130_fd_sc_hd__dfrtp_1_13/a_1283_21# VGND VGND sky130_fd_pr__nfet_01v8 ad=0.169 pd=1.82 as=0 ps=0 w=0.65 l=0.15
X281 sky130_fd_sc_hd__dfrtp_1_13/a_639_47# sky130_fd_sc_hd__dfrtp_1_13/a_193_47# sky130_fd_sc_hd__dfrtp_1_13/a_543_47# VGND sky130_fd_pr__special_nfet_01v8 ad=0 pd=0 as=0 ps=0 w=0.36 l=0.15
X282 VGND sky130_fd_sc_hd__dfrtp_1_13/a_1283_21# sky130_fd_sc_hd__dfrtp_1_13/a_1217_47# VGND sky130_fd_pr__nfet_01v8 ad=0 pd=0 as=0 ps=0 w=0.42 l=0.15
X283 sky130_fd_sc_hd__dfrtp_1_13/a_651_413# V3R299 VDPWR VDPWR sky130_fd_pr__pfet_01v8_hvt ad=0 pd=0 as=0 ps=0 w=0.42 l=0.15
X284 VGND V3R056 sky130_fd_sc_hd__dfrtp_1_13/a_27_47# VGND sky130_fd_pr__nfet_01v8 ad=0 pd=0 as=0.1092 ps=1.36 w=0.42 l=0.15
X285 sky130_fd_sc_hd__dfrtp_1_13/a_761_289# sky130_fd_sc_hd__dfrtp_1_13/a_543_47# VDPWR VDPWR sky130_fd_pr__pfet_01v8_hvt ad=0 pd=0 as=0 ps=0 w=0.84 l=0.15
X286 sky130_fd_sc_hd__dfrtp_1_79/a_805_47# sky130_fd_sc_hd__dfrtp_1_79/a_761_289# sky130_fd_sc_hd__dfrtp_1_79/a_639_47# VGND sky130_fd_pr__nfet_01v8 ad=0.0882 pd=1.26 as=0.2802 ps=2.2 w=0.42 l=0.15
X287 sky130_fd_sc_hd__dfrtp_1_79/a_1217_47# sky130_fd_sc_hd__dfrtp_1_79/a_27_47# sky130_fd_sc_hd__dfrtp_1_79/a_1108_47# VGND sky130_fd_pr__special_nfet_01v8 ad=0.1338 pd=1.5 as=0.1422 ps=1.51 w=0.36 l=0.15
X288 sky130_fd_sc_hd__dfrtp_1_79/a_1283_21# sky130_fd_sc_hd__dfrtp_1_79/a_1108_47# sky130_fd_sc_hd__dfrtp_1_79/a_1462_47# VGND sky130_fd_pr__nfet_01v8 ad=0.1092 pd=1.36 as=0.1281 ps=1.45 w=0.42 l=0.15
X289 sky130_fd_sc_hd__dfrtp_1_79/a_651_413# sky130_fd_sc_hd__dfrtp_1_79/a_27_47# sky130_fd_sc_hd__dfrtp_1_79/a_543_47# VDPWR sky130_fd_pr__pfet_01v8_hvt ad=0.3402 pd=3.3 as=0.1449 ps=1.53 w=0.42 l=0.15
X290 sky130_fd_sc_hd__dfrtp_1_79/a_1108_47# sky130_fd_sc_hd__dfrtp_1_79/a_193_47# sky130_fd_sc_hd__dfrtp_1_79/a_761_289# VGND sky130_fd_pr__special_nfet_01v8 ad=0 pd=0 as=0.1998 ps=1.97 w=0.36 l=0.15
X291 VGND V3R300 sky130_fd_sc_hd__dfrtp_1_79/a_805_47# VGND sky130_fd_pr__nfet_01v8 ad=0 pd=0 as=0 ps=0 w=0.42 l=0.15
X292 V3R037 sky130_fd_sc_hd__dfrtp_1_79/a_1283_21# VDPWR VDPWR sky130_fd_pr__pfet_01v8_hvt ad=0.26 pd=2.52 as=0 ps=0 w=1 l=0.15
X293 VDPWR V3R081 sky130_fd_sc_hd__dfrtp_1_79/a_27_47# VDPWR sky130_fd_pr__pfet_01v8_hvt ad=0 pd=0 as=0.1664 ps=1.8 w=0.64 l=0.15
X294 sky130_fd_sc_hd__dfrtp_1_79/a_448_47# V3R122 VDPWR VDPWR sky130_fd_pr__pfet_01v8_hvt ad=0.1302 pd=1.46 as=0 ps=0 w=0.42 l=0.15
X295 sky130_fd_sc_hd__dfrtp_1_79/a_761_289# sky130_fd_sc_hd__dfrtp_1_79/a_543_47# VGND VGND sky130_fd_pr__nfet_01v8 ad=0 pd=0 as=0 ps=0 w=0.64 l=0.15
X296 sky130_fd_sc_hd__dfrtp_1_79/a_193_47# sky130_fd_sc_hd__dfrtp_1_79/a_27_47# VGND VGND sky130_fd_pr__nfet_01v8 ad=0.1092 pd=1.36 as=0 ps=0 w=0.42 l=0.15
X297 sky130_fd_sc_hd__dfrtp_1_79/a_1108_47# sky130_fd_sc_hd__dfrtp_1_79/a_27_47# sky130_fd_sc_hd__dfrtp_1_79/a_761_289# VDPWR sky130_fd_pr__pfet_01v8_hvt ad=0.1176 pd=1.4 as=0.2583 ps=2.37 w=0.42 l=0.15
X298 sky130_fd_sc_hd__dfrtp_1_79/a_1462_47# V3R300 VGND VGND sky130_fd_pr__nfet_01v8 ad=0 pd=0 as=0 ps=0 w=0.42 l=0.15
X299 sky130_fd_sc_hd__dfrtp_1_79/a_543_47# sky130_fd_sc_hd__dfrtp_1_79/a_27_47# sky130_fd_sc_hd__dfrtp_1_79/a_448_47# VGND sky130_fd_pr__special_nfet_01v8 ad=0.1188 pd=1.38 as=0.132 ps=1.49 w=0.36 l=0.15
X300 sky130_fd_sc_hd__dfrtp_1_79/a_543_47# sky130_fd_sc_hd__dfrtp_1_79/a_193_47# sky130_fd_sc_hd__dfrtp_1_79/a_448_47# VDPWR sky130_fd_pr__pfet_01v8_hvt ad=0 pd=0 as=0 ps=0 w=0.42 l=0.15
X301 sky130_fd_sc_hd__dfrtp_1_79/a_448_47# V3R122 VGND VGND sky130_fd_pr__nfet_01v8 ad=0 pd=0 as=0 ps=0 w=0.42 l=0.15
X302 VDPWR sky130_fd_sc_hd__dfrtp_1_79/a_1283_21# sky130_fd_sc_hd__dfrtp_1_79/a_1270_413# VDPWR sky130_fd_pr__pfet_01v8_hvt ad=0 pd=0 as=0.1134 ps=1.38 w=0.42 l=0.15
X303 VDPWR sky130_fd_sc_hd__dfrtp_1_79/a_1108_47# sky130_fd_sc_hd__dfrtp_1_79/a_1283_21# VDPWR sky130_fd_pr__pfet_01v8_hvt ad=0 pd=0 as=0.1134 ps=1.38 w=0.42 l=0.15
X304 sky130_fd_sc_hd__dfrtp_1_79/a_1270_413# sky130_fd_sc_hd__dfrtp_1_79/a_193_47# sky130_fd_sc_hd__dfrtp_1_79/a_1108_47# VDPWR sky130_fd_pr__pfet_01v8_hvt ad=0 pd=0 as=0 ps=0 w=0.42 l=0.15
X305 sky130_fd_sc_hd__dfrtp_1_79/a_193_47# sky130_fd_sc_hd__dfrtp_1_79/a_27_47# VDPWR VDPWR sky130_fd_pr__pfet_01v8_hvt ad=0.1664 pd=1.8 as=0 ps=0 w=0.64 l=0.15
X306 sky130_fd_sc_hd__dfrtp_1_79/a_1283_21# V3R300 VDPWR VDPWR sky130_fd_pr__pfet_01v8_hvt ad=0 pd=0 as=0 ps=0 w=0.42 l=0.15
X307 VDPWR sky130_fd_sc_hd__dfrtp_1_79/a_761_289# sky130_fd_sc_hd__dfrtp_1_79/a_651_413# VDPWR sky130_fd_pr__pfet_01v8_hvt ad=0 pd=0 as=0 ps=0 w=0.42 l=0.15
X308 V3R037 sky130_fd_sc_hd__dfrtp_1_79/a_1283_21# VGND VGND sky130_fd_pr__nfet_01v8 ad=0.169 pd=1.82 as=0 ps=0 w=0.65 l=0.15
X309 sky130_fd_sc_hd__dfrtp_1_79/a_639_47# sky130_fd_sc_hd__dfrtp_1_79/a_193_47# sky130_fd_sc_hd__dfrtp_1_79/a_543_47# VGND sky130_fd_pr__special_nfet_01v8 ad=0 pd=0 as=0 ps=0 w=0.36 l=0.15
X310 VGND sky130_fd_sc_hd__dfrtp_1_79/a_1283_21# sky130_fd_sc_hd__dfrtp_1_79/a_1217_47# VGND sky130_fd_pr__nfet_01v8 ad=0 pd=0 as=0 ps=0 w=0.42 l=0.15
X311 sky130_fd_sc_hd__dfrtp_1_79/a_651_413# V3R300 VDPWR VDPWR sky130_fd_pr__pfet_01v8_hvt ad=0 pd=0 as=0 ps=0 w=0.42 l=0.15
X312 VGND V3R081 sky130_fd_sc_hd__dfrtp_1_79/a_27_47# VGND sky130_fd_pr__nfet_01v8 ad=0 pd=0 as=0.1092 ps=1.36 w=0.42 l=0.15
X313 sky130_fd_sc_hd__dfrtp_1_79/a_761_289# sky130_fd_sc_hd__dfrtp_1_79/a_543_47# VDPWR VDPWR sky130_fd_pr__pfet_01v8_hvt ad=0 pd=0 as=0 ps=0 w=0.84 l=0.15
X314 sky130_fd_sc_hd__dfrtp_1_57/a_805_47# sky130_fd_sc_hd__dfrtp_1_57/a_761_289# sky130_fd_sc_hd__dfrtp_1_57/a_639_47# VGND sky130_fd_pr__nfet_01v8 ad=0.0882 pd=1.26 as=0.2802 ps=2.2 w=0.42 l=0.15
X315 sky130_fd_sc_hd__dfrtp_1_57/a_1217_47# sky130_fd_sc_hd__dfrtp_1_57/a_27_47# sky130_fd_sc_hd__dfrtp_1_57/a_1108_47# VGND sky130_fd_pr__special_nfet_01v8 ad=0.1338 pd=1.5 as=0.1422 ps=1.51 w=0.36 l=0.15
X316 sky130_fd_sc_hd__dfrtp_1_57/a_1283_21# sky130_fd_sc_hd__dfrtp_1_57/a_1108_47# sky130_fd_sc_hd__dfrtp_1_57/a_1462_47# VGND sky130_fd_pr__nfet_01v8 ad=0.1092 pd=1.36 as=0.1281 ps=1.45 w=0.42 l=0.15
X317 sky130_fd_sc_hd__dfrtp_1_57/a_651_413# sky130_fd_sc_hd__dfrtp_1_57/a_27_47# sky130_fd_sc_hd__dfrtp_1_57/a_543_47# VDPWR sky130_fd_pr__pfet_01v8_hvt ad=0.3402 pd=3.3 as=0.1449 ps=1.53 w=0.42 l=0.15
X318 sky130_fd_sc_hd__dfrtp_1_57/a_1108_47# sky130_fd_sc_hd__dfrtp_1_57/a_193_47# sky130_fd_sc_hd__dfrtp_1_57/a_761_289# VGND sky130_fd_pr__special_nfet_01v8 ad=0 pd=0 as=0.1998 ps=1.97 w=0.36 l=0.15
X319 VGND V3R300 sky130_fd_sc_hd__dfrtp_1_57/a_805_47# VGND sky130_fd_pr__nfet_01v8 ad=0 pd=0 as=0 ps=0 w=0.42 l=0.15
X320 V3R016 sky130_fd_sc_hd__dfrtp_1_57/a_1283_21# VDPWR VDPWR sky130_fd_pr__pfet_01v8_hvt ad=0.26 pd=2.52 as=0 ps=0 w=1 l=0.15
X321 VDPWR V3R081 sky130_fd_sc_hd__dfrtp_1_57/a_27_47# VDPWR sky130_fd_pr__pfet_01v8_hvt ad=0 pd=0 as=0.1664 ps=1.8 w=0.64 l=0.15
X322 sky130_fd_sc_hd__dfrtp_1_57/a_448_47# V3R132 VDPWR VDPWR sky130_fd_pr__pfet_01v8_hvt ad=0.1302 pd=1.46 as=0 ps=0 w=0.42 l=0.15
X323 sky130_fd_sc_hd__dfrtp_1_57/a_761_289# sky130_fd_sc_hd__dfrtp_1_57/a_543_47# VGND VGND sky130_fd_pr__nfet_01v8 ad=0 pd=0 as=0 ps=0 w=0.64 l=0.15
X324 sky130_fd_sc_hd__dfrtp_1_57/a_193_47# sky130_fd_sc_hd__dfrtp_1_57/a_27_47# VGND VGND sky130_fd_pr__nfet_01v8 ad=0.1092 pd=1.36 as=0 ps=0 w=0.42 l=0.15
X325 sky130_fd_sc_hd__dfrtp_1_57/a_1108_47# sky130_fd_sc_hd__dfrtp_1_57/a_27_47# sky130_fd_sc_hd__dfrtp_1_57/a_761_289# VDPWR sky130_fd_pr__pfet_01v8_hvt ad=0.1176 pd=1.4 as=0.2583 ps=2.37 w=0.42 l=0.15
X326 sky130_fd_sc_hd__dfrtp_1_57/a_1462_47# V3R300 VGND VGND sky130_fd_pr__nfet_01v8 ad=0 pd=0 as=0 ps=0 w=0.42 l=0.15
X327 sky130_fd_sc_hd__dfrtp_1_57/a_543_47# sky130_fd_sc_hd__dfrtp_1_57/a_27_47# sky130_fd_sc_hd__dfrtp_1_57/a_448_47# VGND sky130_fd_pr__special_nfet_01v8 ad=0.1188 pd=1.38 as=0.132 ps=1.49 w=0.36 l=0.15
X328 sky130_fd_sc_hd__dfrtp_1_57/a_543_47# sky130_fd_sc_hd__dfrtp_1_57/a_193_47# sky130_fd_sc_hd__dfrtp_1_57/a_448_47# VDPWR sky130_fd_pr__pfet_01v8_hvt ad=0 pd=0 as=0 ps=0 w=0.42 l=0.15
X329 sky130_fd_sc_hd__dfrtp_1_57/a_448_47# V3R132 VGND VGND sky130_fd_pr__nfet_01v8 ad=0 pd=0 as=0 ps=0 w=0.42 l=0.15
X330 VDPWR sky130_fd_sc_hd__dfrtp_1_57/a_1283_21# sky130_fd_sc_hd__dfrtp_1_57/a_1270_413# VDPWR sky130_fd_pr__pfet_01v8_hvt ad=0 pd=0 as=0.1134 ps=1.38 w=0.42 l=0.15
X331 VDPWR sky130_fd_sc_hd__dfrtp_1_57/a_1108_47# sky130_fd_sc_hd__dfrtp_1_57/a_1283_21# VDPWR sky130_fd_pr__pfet_01v8_hvt ad=0 pd=0 as=0.1134 ps=1.38 w=0.42 l=0.15
X332 sky130_fd_sc_hd__dfrtp_1_57/a_1270_413# sky130_fd_sc_hd__dfrtp_1_57/a_193_47# sky130_fd_sc_hd__dfrtp_1_57/a_1108_47# VDPWR sky130_fd_pr__pfet_01v8_hvt ad=0 pd=0 as=0 ps=0 w=0.42 l=0.15
X333 sky130_fd_sc_hd__dfrtp_1_57/a_193_47# sky130_fd_sc_hd__dfrtp_1_57/a_27_47# VDPWR VDPWR sky130_fd_pr__pfet_01v8_hvt ad=0.1664 pd=1.8 as=0 ps=0 w=0.64 l=0.15
X334 sky130_fd_sc_hd__dfrtp_1_57/a_1283_21# V3R300 VDPWR VDPWR sky130_fd_pr__pfet_01v8_hvt ad=0 pd=0 as=0 ps=0 w=0.42 l=0.15
X335 VDPWR sky130_fd_sc_hd__dfrtp_1_57/a_761_289# sky130_fd_sc_hd__dfrtp_1_57/a_651_413# VDPWR sky130_fd_pr__pfet_01v8_hvt ad=0 pd=0 as=0 ps=0 w=0.42 l=0.15
X336 V3R016 sky130_fd_sc_hd__dfrtp_1_57/a_1283_21# VGND VGND sky130_fd_pr__nfet_01v8 ad=0.169 pd=1.82 as=0 ps=0 w=0.65 l=0.15
X337 sky130_fd_sc_hd__dfrtp_1_57/a_639_47# sky130_fd_sc_hd__dfrtp_1_57/a_193_47# sky130_fd_sc_hd__dfrtp_1_57/a_543_47# VGND sky130_fd_pr__special_nfet_01v8 ad=0 pd=0 as=0 ps=0 w=0.36 l=0.15
X338 VGND sky130_fd_sc_hd__dfrtp_1_57/a_1283_21# sky130_fd_sc_hd__dfrtp_1_57/a_1217_47# VGND sky130_fd_pr__nfet_01v8 ad=0 pd=0 as=0 ps=0 w=0.42 l=0.15
X339 sky130_fd_sc_hd__dfrtp_1_57/a_651_413# V3R300 VDPWR VDPWR sky130_fd_pr__pfet_01v8_hvt ad=0 pd=0 as=0 ps=0 w=0.42 l=0.15
X340 VGND V3R081 sky130_fd_sc_hd__dfrtp_1_57/a_27_47# VGND sky130_fd_pr__nfet_01v8 ad=0 pd=0 as=0.1092 ps=1.36 w=0.42 l=0.15
X341 sky130_fd_sc_hd__dfrtp_1_57/a_761_289# sky130_fd_sc_hd__dfrtp_1_57/a_543_47# VDPWR VDPWR sky130_fd_pr__pfet_01v8_hvt ad=0 pd=0 as=0 ps=0 w=0.84 l=0.15
X342 sky130_fd_sc_hd__dfrtp_1_46/a_805_47# sky130_fd_sc_hd__dfrtp_1_46/a_761_289# sky130_fd_sc_hd__dfrtp_1_46/a_639_47# VGND sky130_fd_pr__nfet_01v8 ad=0.0882 pd=1.26 as=0.2802 ps=2.2 w=0.42 l=0.15
X343 sky130_fd_sc_hd__dfrtp_1_46/a_1217_47# sky130_fd_sc_hd__dfrtp_1_46/a_27_47# sky130_fd_sc_hd__dfrtp_1_46/a_1108_47# VGND sky130_fd_pr__special_nfet_01v8 ad=0.1338 pd=1.5 as=0.1422 ps=1.51 w=0.36 l=0.15
X344 sky130_fd_sc_hd__dfrtp_1_46/a_1283_21# sky130_fd_sc_hd__dfrtp_1_46/a_1108_47# sky130_fd_sc_hd__dfrtp_1_46/a_1462_47# VGND sky130_fd_pr__nfet_01v8 ad=0.1092 pd=1.36 as=0.1281 ps=1.45 w=0.42 l=0.15
X345 sky130_fd_sc_hd__dfrtp_1_46/a_651_413# sky130_fd_sc_hd__dfrtp_1_46/a_27_47# sky130_fd_sc_hd__dfrtp_1_46/a_543_47# VDPWR sky130_fd_pr__pfet_01v8_hvt ad=0.3402 pd=3.3 as=0.1449 ps=1.53 w=0.42 l=0.15
X346 sky130_fd_sc_hd__dfrtp_1_46/a_1108_47# sky130_fd_sc_hd__dfrtp_1_46/a_193_47# sky130_fd_sc_hd__dfrtp_1_46/a_761_289# VGND sky130_fd_pr__special_nfet_01v8 ad=0 pd=0 as=0.1998 ps=1.97 w=0.36 l=0.15
X347 VGND V3R302 sky130_fd_sc_hd__dfrtp_1_46/a_805_47# VGND sky130_fd_pr__nfet_01v8 ad=0 pd=0 as=0 ps=0 w=0.42 l=0.15
X348 V3R066 sky130_fd_sc_hd__dfrtp_1_46/a_1283_21# VDPWR VDPWR sky130_fd_pr__pfet_01v8_hvt ad=0.26 pd=2.52 as=0 ps=0 w=1 l=0.15
X349 VDPWR V3R083 sky130_fd_sc_hd__dfrtp_1_46/a_27_47# VDPWR sky130_fd_pr__pfet_01v8_hvt ad=0 pd=0 as=0.1664 ps=1.8 w=0.64 l=0.15
X350 sky130_fd_sc_hd__dfrtp_1_46/a_448_47# V3R191 VDPWR VDPWR sky130_fd_pr__pfet_01v8_hvt ad=0.1302 pd=1.46 as=0 ps=0 w=0.42 l=0.15
X351 sky130_fd_sc_hd__dfrtp_1_46/a_761_289# sky130_fd_sc_hd__dfrtp_1_46/a_543_47# VGND VGND sky130_fd_pr__nfet_01v8 ad=0 pd=0 as=0 ps=0 w=0.64 l=0.15
X352 sky130_fd_sc_hd__dfrtp_1_46/a_193_47# sky130_fd_sc_hd__dfrtp_1_46/a_27_47# VGND VGND sky130_fd_pr__nfet_01v8 ad=0.1092 pd=1.36 as=0 ps=0 w=0.42 l=0.15
X353 sky130_fd_sc_hd__dfrtp_1_46/a_1108_47# sky130_fd_sc_hd__dfrtp_1_46/a_27_47# sky130_fd_sc_hd__dfrtp_1_46/a_761_289# VDPWR sky130_fd_pr__pfet_01v8_hvt ad=0.1176 pd=1.4 as=0.2583 ps=2.37 w=0.42 l=0.15
X354 sky130_fd_sc_hd__dfrtp_1_46/a_1462_47# V3R302 VGND VGND sky130_fd_pr__nfet_01v8 ad=0 pd=0 as=0 ps=0 w=0.42 l=0.15
X355 sky130_fd_sc_hd__dfrtp_1_46/a_543_47# sky130_fd_sc_hd__dfrtp_1_46/a_27_47# sky130_fd_sc_hd__dfrtp_1_46/a_448_47# VGND sky130_fd_pr__special_nfet_01v8 ad=0.1188 pd=1.38 as=0.132 ps=1.49 w=0.36 l=0.15
X356 sky130_fd_sc_hd__dfrtp_1_46/a_543_47# sky130_fd_sc_hd__dfrtp_1_46/a_193_47# sky130_fd_sc_hd__dfrtp_1_46/a_448_47# VDPWR sky130_fd_pr__pfet_01v8_hvt ad=0 pd=0 as=0 ps=0 w=0.42 l=0.15
X357 sky130_fd_sc_hd__dfrtp_1_46/a_448_47# V3R191 VGND VGND sky130_fd_pr__nfet_01v8 ad=0 pd=0 as=0 ps=0 w=0.42 l=0.15
X358 VDPWR sky130_fd_sc_hd__dfrtp_1_46/a_1283_21# sky130_fd_sc_hd__dfrtp_1_46/a_1270_413# VDPWR sky130_fd_pr__pfet_01v8_hvt ad=0 pd=0 as=0.1134 ps=1.38 w=0.42 l=0.15
X359 VDPWR sky130_fd_sc_hd__dfrtp_1_46/a_1108_47# sky130_fd_sc_hd__dfrtp_1_46/a_1283_21# VDPWR sky130_fd_pr__pfet_01v8_hvt ad=0 pd=0 as=0.1134 ps=1.38 w=0.42 l=0.15
X360 sky130_fd_sc_hd__dfrtp_1_46/a_1270_413# sky130_fd_sc_hd__dfrtp_1_46/a_193_47# sky130_fd_sc_hd__dfrtp_1_46/a_1108_47# VDPWR sky130_fd_pr__pfet_01v8_hvt ad=0 pd=0 as=0 ps=0 w=0.42 l=0.15
X361 sky130_fd_sc_hd__dfrtp_1_46/a_193_47# sky130_fd_sc_hd__dfrtp_1_46/a_27_47# VDPWR VDPWR sky130_fd_pr__pfet_01v8_hvt ad=0.1664 pd=1.8 as=0 ps=0 w=0.64 l=0.15
X362 sky130_fd_sc_hd__dfrtp_1_46/a_1283_21# V3R302 VDPWR VDPWR sky130_fd_pr__pfet_01v8_hvt ad=0 pd=0 as=0 ps=0 w=0.42 l=0.15
X363 VDPWR sky130_fd_sc_hd__dfrtp_1_46/a_761_289# sky130_fd_sc_hd__dfrtp_1_46/a_651_413# VDPWR sky130_fd_pr__pfet_01v8_hvt ad=0 pd=0 as=0 ps=0 w=0.42 l=0.15
X364 V3R066 sky130_fd_sc_hd__dfrtp_1_46/a_1283_21# VGND VGND sky130_fd_pr__nfet_01v8 ad=0.169 pd=1.82 as=0 ps=0 w=0.65 l=0.15
X365 sky130_fd_sc_hd__dfrtp_1_46/a_639_47# sky130_fd_sc_hd__dfrtp_1_46/a_193_47# sky130_fd_sc_hd__dfrtp_1_46/a_543_47# VGND sky130_fd_pr__special_nfet_01v8 ad=0 pd=0 as=0 ps=0 w=0.36 l=0.15
X366 VGND sky130_fd_sc_hd__dfrtp_1_46/a_1283_21# sky130_fd_sc_hd__dfrtp_1_46/a_1217_47# VGND sky130_fd_pr__nfet_01v8 ad=0 pd=0 as=0 ps=0 w=0.42 l=0.15
X367 sky130_fd_sc_hd__dfrtp_1_46/a_651_413# V3R302 VDPWR VDPWR sky130_fd_pr__pfet_01v8_hvt ad=0 pd=0 as=0 ps=0 w=0.42 l=0.15
X368 VGND V3R083 sky130_fd_sc_hd__dfrtp_1_46/a_27_47# VGND sky130_fd_pr__nfet_01v8 ad=0 pd=0 as=0.1092 ps=1.36 w=0.42 l=0.15
X369 sky130_fd_sc_hd__dfrtp_1_46/a_761_289# sky130_fd_sc_hd__dfrtp_1_46/a_543_47# VDPWR VDPWR sky130_fd_pr__pfet_01v8_hvt ad=0 pd=0 as=0 ps=0 w=0.84 l=0.15
X370 sky130_fd_sc_hd__dfrtp_1_35/a_805_47# sky130_fd_sc_hd__dfrtp_1_35/a_761_289# sky130_fd_sc_hd__dfrtp_1_35/a_639_47# VGND sky130_fd_pr__nfet_01v8 ad=0.0882 pd=1.26 as=0.2802 ps=2.2 w=0.42 l=0.15
X371 sky130_fd_sc_hd__dfrtp_1_35/a_1217_47# sky130_fd_sc_hd__dfrtp_1_35/a_27_47# sky130_fd_sc_hd__dfrtp_1_35/a_1108_47# VGND sky130_fd_pr__special_nfet_01v8 ad=0.1338 pd=1.5 as=0.1422 ps=1.51 w=0.36 l=0.15
X372 sky130_fd_sc_hd__dfrtp_1_35/a_1283_21# sky130_fd_sc_hd__dfrtp_1_35/a_1108_47# sky130_fd_sc_hd__dfrtp_1_35/a_1462_47# VGND sky130_fd_pr__nfet_01v8 ad=0.1092 pd=1.36 as=0.1281 ps=1.45 w=0.42 l=0.15
X373 sky130_fd_sc_hd__dfrtp_1_35/a_651_413# sky130_fd_sc_hd__dfrtp_1_35/a_27_47# sky130_fd_sc_hd__dfrtp_1_35/a_543_47# VDPWR sky130_fd_pr__pfet_01v8_hvt ad=0.3402 pd=3.3 as=0.1449 ps=1.53 w=0.42 l=0.15
X374 sky130_fd_sc_hd__dfrtp_1_35/a_1108_47# sky130_fd_sc_hd__dfrtp_1_35/a_193_47# sky130_fd_sc_hd__dfrtp_1_35/a_761_289# VGND sky130_fd_pr__special_nfet_01v8 ad=0 pd=0 as=0.1998 ps=1.97 w=0.36 l=0.15
X375 VGND V3R303 sky130_fd_sc_hd__dfrtp_1_35/a_805_47# VGND sky130_fd_pr__nfet_01v8 ad=0 pd=0 as=0 ps=0 w=0.42 l=0.15
X376 V3R078 sky130_fd_sc_hd__dfrtp_1_35/a_1283_21# VDPWR VDPWR sky130_fd_pr__pfet_01v8_hvt ad=0.26 pd=2.52 as=0 ps=0 w=1 l=0.15
X377 VDPWR V3R084 sky130_fd_sc_hd__dfrtp_1_35/a_27_47# VDPWR sky130_fd_pr__pfet_01v8_hvt ad=0 pd=0 as=0.1664 ps=1.8 w=0.64 l=0.15
X378 sky130_fd_sc_hd__dfrtp_1_35/a_448_47# V3R201 VDPWR VDPWR sky130_fd_pr__pfet_01v8_hvt ad=0.1302 pd=1.46 as=0 ps=0 w=0.42 l=0.15
X379 sky130_fd_sc_hd__dfrtp_1_35/a_761_289# sky130_fd_sc_hd__dfrtp_1_35/a_543_47# VGND VGND sky130_fd_pr__nfet_01v8 ad=0 pd=0 as=0 ps=0 w=0.64 l=0.15
X380 sky130_fd_sc_hd__dfrtp_1_35/a_193_47# sky130_fd_sc_hd__dfrtp_1_35/a_27_47# VGND VGND sky130_fd_pr__nfet_01v8 ad=0.1092 pd=1.36 as=0 ps=0 w=0.42 l=0.15
X381 sky130_fd_sc_hd__dfrtp_1_35/a_1108_47# sky130_fd_sc_hd__dfrtp_1_35/a_27_47# sky130_fd_sc_hd__dfrtp_1_35/a_761_289# VDPWR sky130_fd_pr__pfet_01v8_hvt ad=0.1176 pd=1.4 as=0.2583 ps=2.37 w=0.42 l=0.15
X382 sky130_fd_sc_hd__dfrtp_1_35/a_1462_47# V3R303 VGND VGND sky130_fd_pr__nfet_01v8 ad=0 pd=0 as=0 ps=0 w=0.42 l=0.15
X383 sky130_fd_sc_hd__dfrtp_1_35/a_543_47# sky130_fd_sc_hd__dfrtp_1_35/a_27_47# sky130_fd_sc_hd__dfrtp_1_35/a_448_47# VGND sky130_fd_pr__special_nfet_01v8 ad=0.1188 pd=1.38 as=0.132 ps=1.49 w=0.36 l=0.15
X384 sky130_fd_sc_hd__dfrtp_1_35/a_543_47# sky130_fd_sc_hd__dfrtp_1_35/a_193_47# sky130_fd_sc_hd__dfrtp_1_35/a_448_47# VDPWR sky130_fd_pr__pfet_01v8_hvt ad=0 pd=0 as=0 ps=0 w=0.42 l=0.15
X385 sky130_fd_sc_hd__dfrtp_1_35/a_448_47# V3R201 VGND VGND sky130_fd_pr__nfet_01v8 ad=0 pd=0 as=0 ps=0 w=0.42 l=0.15
X386 VDPWR sky130_fd_sc_hd__dfrtp_1_35/a_1283_21# sky130_fd_sc_hd__dfrtp_1_35/a_1270_413# VDPWR sky130_fd_pr__pfet_01v8_hvt ad=0 pd=0 as=0.1134 ps=1.38 w=0.42 l=0.15
X387 VDPWR sky130_fd_sc_hd__dfrtp_1_35/a_1108_47# sky130_fd_sc_hd__dfrtp_1_35/a_1283_21# VDPWR sky130_fd_pr__pfet_01v8_hvt ad=0 pd=0 as=0.1134 ps=1.38 w=0.42 l=0.15
X388 sky130_fd_sc_hd__dfrtp_1_35/a_1270_413# sky130_fd_sc_hd__dfrtp_1_35/a_193_47# sky130_fd_sc_hd__dfrtp_1_35/a_1108_47# VDPWR sky130_fd_pr__pfet_01v8_hvt ad=0 pd=0 as=0 ps=0 w=0.42 l=0.15
X389 sky130_fd_sc_hd__dfrtp_1_35/a_193_47# sky130_fd_sc_hd__dfrtp_1_35/a_27_47# VDPWR VDPWR sky130_fd_pr__pfet_01v8_hvt ad=0.1664 pd=1.8 as=0 ps=0 w=0.64 l=0.15
X390 sky130_fd_sc_hd__dfrtp_1_35/a_1283_21# V3R303 VDPWR VDPWR sky130_fd_pr__pfet_01v8_hvt ad=0 pd=0 as=0 ps=0 w=0.42 l=0.15
X391 VDPWR sky130_fd_sc_hd__dfrtp_1_35/a_761_289# sky130_fd_sc_hd__dfrtp_1_35/a_651_413# VDPWR sky130_fd_pr__pfet_01v8_hvt ad=0 pd=0 as=0 ps=0 w=0.42 l=0.15
X392 V3R078 sky130_fd_sc_hd__dfrtp_1_35/a_1283_21# VGND VGND sky130_fd_pr__nfet_01v8 ad=0.169 pd=1.82 as=0 ps=0 w=0.65 l=0.15
X393 sky130_fd_sc_hd__dfrtp_1_35/a_639_47# sky130_fd_sc_hd__dfrtp_1_35/a_193_47# sky130_fd_sc_hd__dfrtp_1_35/a_543_47# VGND sky130_fd_pr__special_nfet_01v8 ad=0 pd=0 as=0 ps=0 w=0.36 l=0.15
X394 VGND sky130_fd_sc_hd__dfrtp_1_35/a_1283_21# sky130_fd_sc_hd__dfrtp_1_35/a_1217_47# VGND sky130_fd_pr__nfet_01v8 ad=0 pd=0 as=0 ps=0 w=0.42 l=0.15
X395 sky130_fd_sc_hd__dfrtp_1_35/a_651_413# V3R303 VDPWR VDPWR sky130_fd_pr__pfet_01v8_hvt ad=0 pd=0 as=0 ps=0 w=0.42 l=0.15
X396 VGND V3R084 sky130_fd_sc_hd__dfrtp_1_35/a_27_47# VGND sky130_fd_pr__nfet_01v8 ad=0 pd=0 as=0.1092 ps=1.36 w=0.42 l=0.15
X397 sky130_fd_sc_hd__dfrtp_1_35/a_761_289# sky130_fd_sc_hd__dfrtp_1_35/a_543_47# VDPWR VDPWR sky130_fd_pr__pfet_01v8_hvt ad=0 pd=0 as=0 ps=0 w=0.84 l=0.15
X398 sky130_fd_sc_hd__dfrtp_1_24/a_805_47# sky130_fd_sc_hd__dfrtp_1_24/a_761_289# sky130_fd_sc_hd__dfrtp_1_24/a_639_47# VGND sky130_fd_pr__nfet_01v8 ad=0.0882 pd=1.26 as=0.2802 ps=2.2 w=0.42 l=0.15
X399 sky130_fd_sc_hd__dfrtp_1_24/a_1217_47# sky130_fd_sc_hd__dfrtp_1_24/a_27_47# sky130_fd_sc_hd__dfrtp_1_24/a_1108_47# VGND sky130_fd_pr__special_nfet_01v8 ad=0.1338 pd=1.5 as=0.1422 ps=1.51 w=0.36 l=0.15
X400 sky130_fd_sc_hd__dfrtp_1_24/a_1283_21# sky130_fd_sc_hd__dfrtp_1_24/a_1108_47# sky130_fd_sc_hd__dfrtp_1_24/a_1462_47# VGND sky130_fd_pr__nfet_01v8 ad=0.1092 pd=1.36 as=0.1281 ps=1.45 w=0.42 l=0.15
X401 sky130_fd_sc_hd__dfrtp_1_24/a_651_413# sky130_fd_sc_hd__dfrtp_1_24/a_27_47# sky130_fd_sc_hd__dfrtp_1_24/a_543_47# VDPWR sky130_fd_pr__pfet_01v8_hvt ad=0.3402 pd=3.3 as=0.1449 ps=1.53 w=0.42 l=0.15
X402 sky130_fd_sc_hd__dfrtp_1_24/a_1108_47# sky130_fd_sc_hd__dfrtp_1_24/a_193_47# sky130_fd_sc_hd__dfrtp_1_24/a_761_289# VGND sky130_fd_pr__special_nfet_01v8 ad=0 pd=0 as=0.1998 ps=1.97 w=0.36 l=0.15
X403 VGND V3R301 sky130_fd_sc_hd__dfrtp_1_24/a_805_47# VGND sky130_fd_pr__nfet_01v8 ad=0 pd=0 as=0 ps=0 w=0.42 l=0.15
X404 V3R027 sky130_fd_sc_hd__dfrtp_1_24/a_1283_21# VDPWR VDPWR sky130_fd_pr__pfet_01v8_hvt ad=0.26 pd=2.52 as=0 ps=0 w=1 l=0.15
X405 VDPWR V3R082 sky130_fd_sc_hd__dfrtp_1_24/a_27_47# VDPWR sky130_fd_pr__pfet_01v8_hvt ad=0 pd=0 as=0.1664 ps=1.8 w=0.64 l=0.15
X406 sky130_fd_sc_hd__dfrtp_1_24/a_448_47# V3R142 VDPWR VDPWR sky130_fd_pr__pfet_01v8_hvt ad=0.1302 pd=1.46 as=0 ps=0 w=0.42 l=0.15
X407 sky130_fd_sc_hd__dfrtp_1_24/a_761_289# sky130_fd_sc_hd__dfrtp_1_24/a_543_47# VGND VGND sky130_fd_pr__nfet_01v8 ad=0 pd=0 as=0 ps=0 w=0.64 l=0.15
X408 sky130_fd_sc_hd__dfrtp_1_24/a_193_47# sky130_fd_sc_hd__dfrtp_1_24/a_27_47# VGND VGND sky130_fd_pr__nfet_01v8 ad=0.1092 pd=1.36 as=0 ps=0 w=0.42 l=0.15
X409 sky130_fd_sc_hd__dfrtp_1_24/a_1108_47# sky130_fd_sc_hd__dfrtp_1_24/a_27_47# sky130_fd_sc_hd__dfrtp_1_24/a_761_289# VDPWR sky130_fd_pr__pfet_01v8_hvt ad=0.1176 pd=1.4 as=0.2583 ps=2.37 w=0.42 l=0.15
X410 sky130_fd_sc_hd__dfrtp_1_24/a_1462_47# V3R301 VGND VGND sky130_fd_pr__nfet_01v8 ad=0 pd=0 as=0 ps=0 w=0.42 l=0.15
X411 sky130_fd_sc_hd__dfrtp_1_24/a_543_47# sky130_fd_sc_hd__dfrtp_1_24/a_27_47# sky130_fd_sc_hd__dfrtp_1_24/a_448_47# VGND sky130_fd_pr__special_nfet_01v8 ad=0.1188 pd=1.38 as=0.132 ps=1.49 w=0.36 l=0.15
X412 sky130_fd_sc_hd__dfrtp_1_24/a_543_47# sky130_fd_sc_hd__dfrtp_1_24/a_193_47# sky130_fd_sc_hd__dfrtp_1_24/a_448_47# VDPWR sky130_fd_pr__pfet_01v8_hvt ad=0 pd=0 as=0 ps=0 w=0.42 l=0.15
X413 sky130_fd_sc_hd__dfrtp_1_24/a_448_47# V3R142 VGND VGND sky130_fd_pr__nfet_01v8 ad=0 pd=0 as=0 ps=0 w=0.42 l=0.15
X414 VDPWR sky130_fd_sc_hd__dfrtp_1_24/a_1283_21# sky130_fd_sc_hd__dfrtp_1_24/a_1270_413# VDPWR sky130_fd_pr__pfet_01v8_hvt ad=0 pd=0 as=0.1134 ps=1.38 w=0.42 l=0.15
X415 VDPWR sky130_fd_sc_hd__dfrtp_1_24/a_1108_47# sky130_fd_sc_hd__dfrtp_1_24/a_1283_21# VDPWR sky130_fd_pr__pfet_01v8_hvt ad=0 pd=0 as=0.1134 ps=1.38 w=0.42 l=0.15
X416 sky130_fd_sc_hd__dfrtp_1_24/a_1270_413# sky130_fd_sc_hd__dfrtp_1_24/a_193_47# sky130_fd_sc_hd__dfrtp_1_24/a_1108_47# VDPWR sky130_fd_pr__pfet_01v8_hvt ad=0 pd=0 as=0 ps=0 w=0.42 l=0.15
X417 sky130_fd_sc_hd__dfrtp_1_24/a_193_47# sky130_fd_sc_hd__dfrtp_1_24/a_27_47# VDPWR VDPWR sky130_fd_pr__pfet_01v8_hvt ad=0.1664 pd=1.8 as=0 ps=0 w=0.64 l=0.15
X418 sky130_fd_sc_hd__dfrtp_1_24/a_1283_21# V3R301 VDPWR VDPWR sky130_fd_pr__pfet_01v8_hvt ad=0 pd=0 as=0 ps=0 w=0.42 l=0.15
X419 VDPWR sky130_fd_sc_hd__dfrtp_1_24/a_761_289# sky130_fd_sc_hd__dfrtp_1_24/a_651_413# VDPWR sky130_fd_pr__pfet_01v8_hvt ad=0 pd=0 as=0 ps=0 w=0.42 l=0.15
X420 V3R027 sky130_fd_sc_hd__dfrtp_1_24/a_1283_21# VGND VGND sky130_fd_pr__nfet_01v8 ad=0.169 pd=1.82 as=0 ps=0 w=0.65 l=0.15
X421 sky130_fd_sc_hd__dfrtp_1_24/a_639_47# sky130_fd_sc_hd__dfrtp_1_24/a_193_47# sky130_fd_sc_hd__dfrtp_1_24/a_543_47# VGND sky130_fd_pr__special_nfet_01v8 ad=0 pd=0 as=0 ps=0 w=0.36 l=0.15
X422 VGND sky130_fd_sc_hd__dfrtp_1_24/a_1283_21# sky130_fd_sc_hd__dfrtp_1_24/a_1217_47# VGND sky130_fd_pr__nfet_01v8 ad=0 pd=0 as=0 ps=0 w=0.42 l=0.15
X423 sky130_fd_sc_hd__dfrtp_1_24/a_651_413# V3R301 VDPWR VDPWR sky130_fd_pr__pfet_01v8_hvt ad=0 pd=0 as=0 ps=0 w=0.42 l=0.15
X424 VGND V3R082 sky130_fd_sc_hd__dfrtp_1_24/a_27_47# VGND sky130_fd_pr__nfet_01v8 ad=0 pd=0 as=0.1092 ps=1.36 w=0.42 l=0.15
X425 sky130_fd_sc_hd__dfrtp_1_24/a_761_289# sky130_fd_sc_hd__dfrtp_1_24/a_543_47# VDPWR VDPWR sky130_fd_pr__pfet_01v8_hvt ad=0 pd=0 as=0 ps=0 w=0.84 l=0.15
X426 sky130_fd_sc_hd__dfrtp_1_68/a_805_47# sky130_fd_sc_hd__dfrtp_1_68/a_761_289# sky130_fd_sc_hd__dfrtp_1_68/a_639_47# VGND sky130_fd_pr__nfet_01v8 ad=0.0882 pd=1.26 as=0.2802 ps=2.2 w=0.42 l=0.15
X427 sky130_fd_sc_hd__dfrtp_1_68/a_1217_47# sky130_fd_sc_hd__dfrtp_1_68/a_27_47# sky130_fd_sc_hd__dfrtp_1_68/a_1108_47# VGND sky130_fd_pr__special_nfet_01v8 ad=0.1338 pd=1.5 as=0.1422 ps=1.51 w=0.36 l=0.15
X428 sky130_fd_sc_hd__dfrtp_1_68/a_1283_21# sky130_fd_sc_hd__dfrtp_1_68/a_1108_47# sky130_fd_sc_hd__dfrtp_1_68/a_1462_47# VGND sky130_fd_pr__nfet_01v8 ad=0.1092 pd=1.36 as=0.1281 ps=1.45 w=0.42 l=0.15
X429 sky130_fd_sc_hd__dfrtp_1_68/a_651_413# sky130_fd_sc_hd__dfrtp_1_68/a_27_47# sky130_fd_sc_hd__dfrtp_1_68/a_543_47# VDPWR sky130_fd_pr__pfet_01v8_hvt ad=0.3402 pd=3.3 as=0.1449 ps=1.53 w=0.42 l=0.15
X430 sky130_fd_sc_hd__dfrtp_1_68/a_1108_47# sky130_fd_sc_hd__dfrtp_1_68/a_193_47# sky130_fd_sc_hd__dfrtp_1_68/a_761_289# VGND sky130_fd_pr__special_nfet_01v8 ad=0 pd=0 as=0.1998 ps=1.97 w=0.36 l=0.15
X431 VGND V3R298 sky130_fd_sc_hd__dfrtp_1_68/a_805_47# VGND sky130_fd_pr__nfet_01v8 ad=0 pd=0 as=0 ps=0 w=0.42 l=0.15
X432 V3R180 sky130_fd_sc_hd__dfrtp_1_68/a_1283_21# VDPWR VDPWR sky130_fd_pr__pfet_01v8_hvt ad=0.26 pd=2.52 as=0 ps=0 w=1 l=0.15
X433 VDPWR V3R055 sky130_fd_sc_hd__dfrtp_1_68/a_27_47# VDPWR sky130_fd_pr__pfet_01v8_hvt ad=0 pd=0 as=0.1664 ps=1.8 w=0.64 l=0.15
X434 sky130_fd_sc_hd__dfrtp_1_68/a_448_47# V3R094 VDPWR VDPWR sky130_fd_pr__pfet_01v8_hvt ad=0.1302 pd=1.46 as=0 ps=0 w=0.42 l=0.15
X435 sky130_fd_sc_hd__dfrtp_1_68/a_761_289# sky130_fd_sc_hd__dfrtp_1_68/a_543_47# VGND VGND sky130_fd_pr__nfet_01v8 ad=0 pd=0 as=0 ps=0 w=0.64 l=0.15
X436 sky130_fd_sc_hd__dfrtp_1_68/a_193_47# sky130_fd_sc_hd__dfrtp_1_68/a_27_47# VGND VGND sky130_fd_pr__nfet_01v8 ad=0.1092 pd=1.36 as=0 ps=0 w=0.42 l=0.15
X437 sky130_fd_sc_hd__dfrtp_1_68/a_1108_47# sky130_fd_sc_hd__dfrtp_1_68/a_27_47# sky130_fd_sc_hd__dfrtp_1_68/a_761_289# VDPWR sky130_fd_pr__pfet_01v8_hvt ad=0.1176 pd=1.4 as=0.2583 ps=2.37 w=0.42 l=0.15
X438 sky130_fd_sc_hd__dfrtp_1_68/a_1462_47# V3R298 VGND VGND sky130_fd_pr__nfet_01v8 ad=0 pd=0 as=0 ps=0 w=0.42 l=0.15
X439 sky130_fd_sc_hd__dfrtp_1_68/a_543_47# sky130_fd_sc_hd__dfrtp_1_68/a_27_47# sky130_fd_sc_hd__dfrtp_1_68/a_448_47# VGND sky130_fd_pr__special_nfet_01v8 ad=0.1188 pd=1.38 as=0.132 ps=1.49 w=0.36 l=0.15
X440 sky130_fd_sc_hd__dfrtp_1_68/a_543_47# sky130_fd_sc_hd__dfrtp_1_68/a_193_47# sky130_fd_sc_hd__dfrtp_1_68/a_448_47# VDPWR sky130_fd_pr__pfet_01v8_hvt ad=0 pd=0 as=0 ps=0 w=0.42 l=0.15
X441 sky130_fd_sc_hd__dfrtp_1_68/a_448_47# V3R094 VGND VGND sky130_fd_pr__nfet_01v8 ad=0 pd=0 as=0 ps=0 w=0.42 l=0.15
X442 VDPWR sky130_fd_sc_hd__dfrtp_1_68/a_1283_21# sky130_fd_sc_hd__dfrtp_1_68/a_1270_413# VDPWR sky130_fd_pr__pfet_01v8_hvt ad=0 pd=0 as=0.1134 ps=1.38 w=0.42 l=0.15
X443 VDPWR sky130_fd_sc_hd__dfrtp_1_68/a_1108_47# sky130_fd_sc_hd__dfrtp_1_68/a_1283_21# VDPWR sky130_fd_pr__pfet_01v8_hvt ad=0 pd=0 as=0.1134 ps=1.38 w=0.42 l=0.15
X444 sky130_fd_sc_hd__dfrtp_1_68/a_1270_413# sky130_fd_sc_hd__dfrtp_1_68/a_193_47# sky130_fd_sc_hd__dfrtp_1_68/a_1108_47# VDPWR sky130_fd_pr__pfet_01v8_hvt ad=0 pd=0 as=0 ps=0 w=0.42 l=0.15
X445 sky130_fd_sc_hd__dfrtp_1_68/a_193_47# sky130_fd_sc_hd__dfrtp_1_68/a_27_47# VDPWR VDPWR sky130_fd_pr__pfet_01v8_hvt ad=0.1664 pd=1.8 as=0 ps=0 w=0.64 l=0.15
X446 sky130_fd_sc_hd__dfrtp_1_68/a_1283_21# V3R298 VDPWR VDPWR sky130_fd_pr__pfet_01v8_hvt ad=0 pd=0 as=0 ps=0 w=0.42 l=0.15
X447 VDPWR sky130_fd_sc_hd__dfrtp_1_68/a_761_289# sky130_fd_sc_hd__dfrtp_1_68/a_651_413# VDPWR sky130_fd_pr__pfet_01v8_hvt ad=0 pd=0 as=0 ps=0 w=0.42 l=0.15
X448 V3R180 sky130_fd_sc_hd__dfrtp_1_68/a_1283_21# VGND VGND sky130_fd_pr__nfet_01v8 ad=0.169 pd=1.82 as=0 ps=0 w=0.65 l=0.15
X449 sky130_fd_sc_hd__dfrtp_1_68/a_639_47# sky130_fd_sc_hd__dfrtp_1_68/a_193_47# sky130_fd_sc_hd__dfrtp_1_68/a_543_47# VGND sky130_fd_pr__special_nfet_01v8 ad=0 pd=0 as=0 ps=0 w=0.36 l=0.15
X450 VGND sky130_fd_sc_hd__dfrtp_1_68/a_1283_21# sky130_fd_sc_hd__dfrtp_1_68/a_1217_47# VGND sky130_fd_pr__nfet_01v8 ad=0 pd=0 as=0 ps=0 w=0.42 l=0.15
X451 sky130_fd_sc_hd__dfrtp_1_68/a_651_413# V3R298 VDPWR VDPWR sky130_fd_pr__pfet_01v8_hvt ad=0 pd=0 as=0 ps=0 w=0.42 l=0.15
X452 VGND V3R055 sky130_fd_sc_hd__dfrtp_1_68/a_27_47# VGND sky130_fd_pr__nfet_01v8 ad=0 pd=0 as=0.1092 ps=1.36 w=0.42 l=0.15
X453 sky130_fd_sc_hd__dfrtp_1_68/a_761_289# sky130_fd_sc_hd__dfrtp_1_68/a_543_47# VDPWR VDPWR sky130_fd_pr__pfet_01v8_hvt ad=0 pd=0 as=0 ps=0 w=0.84 l=0.15
X454 V3R278 sky130_fd_sc_hd__xor2_1_4/a_35_297# sky130_fd_sc_hd__xor2_1_4/a_285_297# VDPWR sky130_fd_pr__pfet_01v8_hvt ad=0.3 pd=2.6 as=0.53 ps=5.06 w=1 l=0.15
X455 V3R278 V3R077 sky130_fd_sc_hd__xor2_1_4/a_285_47# VGND sky130_fd_pr__nfet_01v8 ad=0.5005 pd=2.84 as=0.1755 ps=1.84 w=0.65 l=0.15
X456 sky130_fd_sc_hd__xor2_1_4/a_35_297# V3R077 VGND VGND sky130_fd_pr__nfet_01v8 ad=0.1755 pd=1.84 as=0 ps=0 w=0.65 l=0.15
X457 sky130_fd_sc_hd__xor2_1_4/a_117_297# V3R077 sky130_fd_sc_hd__xor2_1_4/a_35_297# VDPWR sky130_fd_pr__pfet_01v8_hvt ad=0.27 pd=2.54 as=0.26 ps=2.52 w=1 l=0.15
X458 VDPWR V3R077 sky130_fd_sc_hd__xor2_1_4/a_285_297# VDPWR sky130_fd_pr__pfet_01v8_hvt ad=0 pd=0 as=0 ps=0 w=1 l=0.15
X459 VGND V3R004 sky130_fd_sc_hd__xor2_1_4/a_35_297# VGND sky130_fd_pr__nfet_01v8 ad=0 pd=0 as=0 ps=0 w=0.65 l=0.15
X460 VGND sky130_fd_sc_hd__xor2_1_4/a_35_297# V3R278 VGND sky130_fd_pr__nfet_01v8 ad=0 pd=0 as=0 ps=0 w=0.65 l=0.15
X461 sky130_fd_sc_hd__xor2_1_4/a_285_297# V3R004 VDPWR VDPWR sky130_fd_pr__pfet_01v8_hvt ad=0 pd=0 as=0 ps=0 w=1 l=0.15
X462 VDPWR V3R004 sky130_fd_sc_hd__xor2_1_4/a_117_297# VDPWR sky130_fd_pr__pfet_01v8_hvt ad=0 pd=0 as=0 ps=0 w=1 l=0.15
X463 sky130_fd_sc_hd__xor2_1_4/a_285_47# V3R004 VGND VGND sky130_fd_pr__nfet_01v8 ad=0 pd=0 as=0 ps=0 w=0.65 l=0.15
X464 VDPWR sky130_fd_sc_hd__mux2_1_5/a_505_21# sky130_fd_sc_hd__mux2_1_5/a_535_374# VDPWR sky130_fd_pr__pfet_01v8_hvt ad=0 pd=0 as=0.0882 ps=1.26 w=0.42 l=0.15
X465 sky130_fd_sc_hd__mux2_1_5/a_505_21# V3R009 VDPWR VDPWR sky130_fd_pr__pfet_01v8_hvt ad=0.1176 pd=1.4 as=0 ps=0 w=0.42 l=0.15
X466 sky130_fd_sc_hd__mux2_1_5/a_218_374# V3R009 VDPWR VDPWR sky130_fd_pr__pfet_01v8_hvt ad=0.1533 pd=1.57 as=0 ps=0 w=0.42 l=0.15
X467 VGND sky130_fd_sc_hd__mux2_1_5/a_505_21# sky130_fd_sc_hd__mux2_1_5/a_439_47# VGND sky130_fd_pr__nfet_01v8 ad=0 pd=0 as=0.1386 ps=1.5 w=0.42 l=0.15
X468 sky130_fd_sc_hd__mux2_1_5/a_76_199# V3R001 sky130_fd_sc_hd__mux2_1_5/a_218_374# VDPWR sky130_fd_pr__pfet_01v8_hvt ad=0.3864 pd=2.68 as=0 ps=0 w=0.42 l=0.15
X469 sky130_fd_sc_hd__mux2_1_5/a_505_21# V3R009 VGND VGND sky130_fd_pr__nfet_01v8 ad=0.1092 pd=1.36 as=0 ps=0 w=0.42 l=0.15
X470 sky130_fd_sc_hd__mux2_1_5/a_439_47# V3R001 sky130_fd_sc_hd__mux2_1_5/a_76_199# VGND sky130_fd_pr__nfet_01v8 ad=0 pd=0 as=0.1995 ps=1.79 w=0.42 l=0.15
X471 sky130_fd_sc_hd__mux2_1_5/a_535_374# V3R034 sky130_fd_sc_hd__mux2_1_5/a_76_199# VDPWR sky130_fd_pr__pfet_01v8_hvt ad=0 pd=0 as=0 ps=0 w=0.42 l=0.15
X472 sky130_fd_sc_hd__mux2_1_5/a_76_199# V3R034 sky130_fd_sc_hd__mux2_1_5/a_218_47# VGND sky130_fd_pr__nfet_01v8 ad=0 pd=0 as=0.1386 ps=1.5 w=0.42 l=0.15
X473 sky130_fd_sc_hd__mux2_1_5/a_218_47# V3R009 VGND VGND sky130_fd_pr__nfet_01v8 ad=0 pd=0 as=0 ps=0 w=0.42 l=0.15
X474 VDPWR sky130_fd_sc_hd__mux2_1_5/a_76_199# V3R229 VDPWR sky130_fd_pr__pfet_01v8_hvt ad=0 pd=0 as=0.26 ps=2.52 w=1 l=0.15
X475 VGND sky130_fd_sc_hd__mux2_1_5/a_76_199# V3R229 VGND sky130_fd_pr__nfet_01v8 ad=0 pd=0 as=0.169 ps=1.82 w=0.65 l=0.15
X476 VDPWR V3R011 sky130_fd_sc_hd__and2_1_12/a_59_75# VDPWR sky130_fd_pr__pfet_01v8_hvt ad=0 pd=0 as=0.1134 ps=1.38 w=0.42 l=0.15
X477 V3R206 sky130_fd_sc_hd__and2_1_12/a_59_75# VDPWR VDPWR sky130_fd_pr__pfet_01v8_hvt ad=0.475 pd=2.95 as=0 ps=0 w=1 l=0.15
X478 VGND V3R011 sky130_fd_sc_hd__and2_1_12/a_145_75# VGND sky130_fd_pr__nfet_01v8 ad=0 pd=0 as=0.1134 ps=1.38 w=0.42 l=0.15
X479 sky130_fd_sc_hd__and2_1_12/a_59_75# V3R008 VDPWR VDPWR sky130_fd_pr__pfet_01v8_hvt ad=0 pd=0 as=0 ps=0 w=0.42 l=0.15
X480 V3R206 sky130_fd_sc_hd__and2_1_12/a_59_75# VGND VGND sky130_fd_pr__nfet_01v8 ad=0.182 pd=1.86 as=0 ps=0 w=0.65 l=0.15
X481 sky130_fd_sc_hd__and2_1_12/a_145_75# V3R008 sky130_fd_sc_hd__and2_1_12/a_59_75# VGND sky130_fd_pr__nfet_01v8 ad=0 pd=0 as=0.1176 ps=1.4 w=0.42 l=0.15
X482 VDPWR V3R003 sky130_fd_sc_hd__and2b_1_13/a_207_413# VDPWR sky130_fd_pr__pfet_01v8_hvt ad=0 pd=0 as=0.1218 ps=1.42 w=0.42 l=0.15
X483 V3R068 sky130_fd_sc_hd__and2b_1_13/a_207_413# VDPWR VDPWR sky130_fd_pr__pfet_01v8_hvt ad=0.26 pd=2.52 as=0 ps=0 w=1 l=0.15
X484 sky130_fd_sc_hd__and2b_1_13/a_297_47# sky130_fd_sc_hd__and2b_1_13/a_27_413# sky130_fd_sc_hd__and2b_1_13/a_207_413# VGND sky130_fd_pr__nfet_01v8 ad=0.1008 pd=1.32 as=0.1092 ps=1.36 w=0.42 l=0.15
X485 V3R068 sky130_fd_sc_hd__and2b_1_13/a_207_413# VGND VGND sky130_fd_pr__nfet_01v8 ad=0.169 pd=1.82 as=0 ps=0 w=0.65 l=0.15
X486 sky130_fd_sc_hd__and2b_1_13/a_207_413# sky130_fd_sc_hd__and2b_1_13/a_27_413# VDPWR VDPWR sky130_fd_pr__pfet_01v8_hvt ad=0 pd=0 as=0 ps=0 w=0.42 l=0.15
X487 VDPWR V3R238 sky130_fd_sc_hd__and2b_1_13/a_27_413# VDPWR sky130_fd_pr__pfet_01v8_hvt ad=0 pd=0 as=0.1092 ps=1.36 w=0.42 l=0.15
X488 VGND V3R003 sky130_fd_sc_hd__and2b_1_13/a_297_47# VGND sky130_fd_pr__nfet_01v8 ad=0 pd=0 as=0 ps=0 w=0.42 l=0.15
X489 sky130_fd_sc_hd__and2b_1_13/a_27_413# V3R238 VGND VGND sky130_fd_pr__nfet_01v8 ad=0.1092 pd=1.36 as=0 ps=0 w=0.42 l=0.15
X490 sky130_fd_sc_hd__dfrtp_1_14/a_805_47# sky130_fd_sc_hd__dfrtp_1_14/a_761_289# sky130_fd_sc_hd__dfrtp_1_14/a_639_47# VGND sky130_fd_pr__nfet_01v8 ad=0.0882 pd=1.26 as=0.2802 ps=2.2 w=0.42 l=0.15
X491 sky130_fd_sc_hd__dfrtp_1_14/a_1217_47# sky130_fd_sc_hd__dfrtp_1_14/a_27_47# sky130_fd_sc_hd__dfrtp_1_14/a_1108_47# VGND sky130_fd_pr__special_nfet_01v8 ad=0.1338 pd=1.5 as=0.1422 ps=1.51 w=0.36 l=0.15
X492 sky130_fd_sc_hd__dfrtp_1_14/a_1283_21# sky130_fd_sc_hd__dfrtp_1_14/a_1108_47# sky130_fd_sc_hd__dfrtp_1_14/a_1462_47# VGND sky130_fd_pr__nfet_01v8 ad=0.1092 pd=1.36 as=0.1281 ps=1.45 w=0.42 l=0.15
X493 sky130_fd_sc_hd__dfrtp_1_14/a_651_413# sky130_fd_sc_hd__dfrtp_1_14/a_27_47# sky130_fd_sc_hd__dfrtp_1_14/a_543_47# VDPWR sky130_fd_pr__pfet_01v8_hvt ad=0.3402 pd=3.3 as=0.1449 ps=1.53 w=0.42 l=0.15
X494 sky130_fd_sc_hd__dfrtp_1_14/a_1108_47# sky130_fd_sc_hd__dfrtp_1_14/a_193_47# sky130_fd_sc_hd__dfrtp_1_14/a_761_289# VGND sky130_fd_pr__special_nfet_01v8 ad=0 pd=0 as=0.1998 ps=1.97 w=0.36 l=0.15
X495 VGND V3R301 sky130_fd_sc_hd__dfrtp_1_14/a_805_47# VGND sky130_fd_pr__nfet_01v8 ad=0 pd=0 as=0 ps=0 w=0.42 l=0.15
X496 V3R032 sky130_fd_sc_hd__dfrtp_1_14/a_1283_21# VDPWR VDPWR sky130_fd_pr__pfet_01v8_hvt ad=0.26 pd=2.52 as=0 ps=0 w=1 l=0.15
X497 VDPWR V3R082 sky130_fd_sc_hd__dfrtp_1_14/a_27_47# VDPWR sky130_fd_pr__pfet_01v8_hvt ad=0 pd=0 as=0.1664 ps=1.8 w=0.64 l=0.15
X498 sky130_fd_sc_hd__dfrtp_1_14/a_448_47# V3R147 VDPWR VDPWR sky130_fd_pr__pfet_01v8_hvt ad=0.1302 pd=1.46 as=0 ps=0 w=0.42 l=0.15
X499 sky130_fd_sc_hd__dfrtp_1_14/a_761_289# sky130_fd_sc_hd__dfrtp_1_14/a_543_47# VGND VGND sky130_fd_pr__nfet_01v8 ad=0 pd=0 as=0 ps=0 w=0.64 l=0.15
X500 sky130_fd_sc_hd__dfrtp_1_14/a_193_47# sky130_fd_sc_hd__dfrtp_1_14/a_27_47# VGND VGND sky130_fd_pr__nfet_01v8 ad=0.1092 pd=1.36 as=0 ps=0 w=0.42 l=0.15
X501 sky130_fd_sc_hd__dfrtp_1_14/a_1108_47# sky130_fd_sc_hd__dfrtp_1_14/a_27_47# sky130_fd_sc_hd__dfrtp_1_14/a_761_289# VDPWR sky130_fd_pr__pfet_01v8_hvt ad=0.1176 pd=1.4 as=0.2583 ps=2.37 w=0.42 l=0.15
X502 sky130_fd_sc_hd__dfrtp_1_14/a_1462_47# V3R301 VGND VGND sky130_fd_pr__nfet_01v8 ad=0 pd=0 as=0 ps=0 w=0.42 l=0.15
X503 sky130_fd_sc_hd__dfrtp_1_14/a_543_47# sky130_fd_sc_hd__dfrtp_1_14/a_27_47# sky130_fd_sc_hd__dfrtp_1_14/a_448_47# VGND sky130_fd_pr__special_nfet_01v8 ad=0.1188 pd=1.38 as=0.132 ps=1.49 w=0.36 l=0.15
X504 sky130_fd_sc_hd__dfrtp_1_14/a_543_47# sky130_fd_sc_hd__dfrtp_1_14/a_193_47# sky130_fd_sc_hd__dfrtp_1_14/a_448_47# VDPWR sky130_fd_pr__pfet_01v8_hvt ad=0 pd=0 as=0 ps=0 w=0.42 l=0.15
X505 sky130_fd_sc_hd__dfrtp_1_14/a_448_47# V3R147 VGND VGND sky130_fd_pr__nfet_01v8 ad=0 pd=0 as=0 ps=0 w=0.42 l=0.15
X506 VDPWR sky130_fd_sc_hd__dfrtp_1_14/a_1283_21# sky130_fd_sc_hd__dfrtp_1_14/a_1270_413# VDPWR sky130_fd_pr__pfet_01v8_hvt ad=0 pd=0 as=0.1134 ps=1.38 w=0.42 l=0.15
X507 VDPWR sky130_fd_sc_hd__dfrtp_1_14/a_1108_47# sky130_fd_sc_hd__dfrtp_1_14/a_1283_21# VDPWR sky130_fd_pr__pfet_01v8_hvt ad=0 pd=0 as=0.1134 ps=1.38 w=0.42 l=0.15
X508 sky130_fd_sc_hd__dfrtp_1_14/a_1270_413# sky130_fd_sc_hd__dfrtp_1_14/a_193_47# sky130_fd_sc_hd__dfrtp_1_14/a_1108_47# VDPWR sky130_fd_pr__pfet_01v8_hvt ad=0 pd=0 as=0 ps=0 w=0.42 l=0.15
X509 sky130_fd_sc_hd__dfrtp_1_14/a_193_47# sky130_fd_sc_hd__dfrtp_1_14/a_27_47# VDPWR VDPWR sky130_fd_pr__pfet_01v8_hvt ad=0.1664 pd=1.8 as=0 ps=0 w=0.64 l=0.15
X510 sky130_fd_sc_hd__dfrtp_1_14/a_1283_21# V3R301 VDPWR VDPWR sky130_fd_pr__pfet_01v8_hvt ad=0 pd=0 as=0 ps=0 w=0.42 l=0.15
X511 VDPWR sky130_fd_sc_hd__dfrtp_1_14/a_761_289# sky130_fd_sc_hd__dfrtp_1_14/a_651_413# VDPWR sky130_fd_pr__pfet_01v8_hvt ad=0 pd=0 as=0 ps=0 w=0.42 l=0.15
X512 V3R032 sky130_fd_sc_hd__dfrtp_1_14/a_1283_21# VGND VGND sky130_fd_pr__nfet_01v8 ad=0.169 pd=1.82 as=0 ps=0 w=0.65 l=0.15
X513 sky130_fd_sc_hd__dfrtp_1_14/a_639_47# sky130_fd_sc_hd__dfrtp_1_14/a_193_47# sky130_fd_sc_hd__dfrtp_1_14/a_543_47# VGND sky130_fd_pr__special_nfet_01v8 ad=0 pd=0 as=0 ps=0 w=0.36 l=0.15
X514 VGND sky130_fd_sc_hd__dfrtp_1_14/a_1283_21# sky130_fd_sc_hd__dfrtp_1_14/a_1217_47# VGND sky130_fd_pr__nfet_01v8 ad=0 pd=0 as=0 ps=0 w=0.42 l=0.15
X515 sky130_fd_sc_hd__dfrtp_1_14/a_651_413# V3R301 VDPWR VDPWR sky130_fd_pr__pfet_01v8_hvt ad=0 pd=0 as=0 ps=0 w=0.42 l=0.15
X516 VGND V3R082 sky130_fd_sc_hd__dfrtp_1_14/a_27_47# VGND sky130_fd_pr__nfet_01v8 ad=0 pd=0 as=0.1092 ps=1.36 w=0.42 l=0.15
X517 sky130_fd_sc_hd__dfrtp_1_14/a_761_289# sky130_fd_sc_hd__dfrtp_1_14/a_543_47# VDPWR VDPWR sky130_fd_pr__pfet_01v8_hvt ad=0 pd=0 as=0 ps=0 w=0.84 l=0.15
X518 sky130_fd_sc_hd__dfrtp_1_69/a_805_47# sky130_fd_sc_hd__dfrtp_1_69/a_761_289# sky130_fd_sc_hd__dfrtp_1_69/a_639_47# VGND sky130_fd_pr__nfet_01v8 ad=0.0882 pd=1.26 as=0.2802 ps=2.2 w=0.42 l=0.15
X519 sky130_fd_sc_hd__dfrtp_1_69/a_1217_47# sky130_fd_sc_hd__dfrtp_1_69/a_27_47# sky130_fd_sc_hd__dfrtp_1_69/a_1108_47# VGND sky130_fd_pr__special_nfet_01v8 ad=0.1338 pd=1.5 as=0.1422 ps=1.51 w=0.36 l=0.15
X520 sky130_fd_sc_hd__dfrtp_1_69/a_1283_21# sky130_fd_sc_hd__dfrtp_1_69/a_1108_47# sky130_fd_sc_hd__dfrtp_1_69/a_1462_47# VGND sky130_fd_pr__nfet_01v8 ad=0.1092 pd=1.36 as=0.1281 ps=1.45 w=0.42 l=0.15
X521 sky130_fd_sc_hd__dfrtp_1_69/a_651_413# sky130_fd_sc_hd__dfrtp_1_69/a_27_47# sky130_fd_sc_hd__dfrtp_1_69/a_543_47# VDPWR sky130_fd_pr__pfet_01v8_hvt ad=0.3402 pd=3.3 as=0.1449 ps=1.53 w=0.42 l=0.15
X522 sky130_fd_sc_hd__dfrtp_1_69/a_1108_47# sky130_fd_sc_hd__dfrtp_1_69/a_193_47# sky130_fd_sc_hd__dfrtp_1_69/a_761_289# VGND sky130_fd_pr__special_nfet_01v8 ad=0 pd=0 as=0.1998 ps=1.97 w=0.36 l=0.15
X523 VGND V3R300 sky130_fd_sc_hd__dfrtp_1_69/a_805_47# VGND sky130_fd_pr__nfet_01v8 ad=0 pd=0 as=0 ps=0 w=0.42 l=0.15
X524 V3R041 sky130_fd_sc_hd__dfrtp_1_69/a_1283_21# VDPWR VDPWR sky130_fd_pr__pfet_01v8_hvt ad=0.26 pd=2.52 as=0 ps=0 w=1 l=0.15
X525 VDPWR V3R081 sky130_fd_sc_hd__dfrtp_1_69/a_27_47# VDPWR sky130_fd_pr__pfet_01v8_hvt ad=0 pd=0 as=0.1664 ps=1.8 w=0.64 l=0.15
X526 sky130_fd_sc_hd__dfrtp_1_69/a_448_47# V3R126 VDPWR VDPWR sky130_fd_pr__pfet_01v8_hvt ad=0.1302 pd=1.46 as=0 ps=0 w=0.42 l=0.15
X527 sky130_fd_sc_hd__dfrtp_1_69/a_761_289# sky130_fd_sc_hd__dfrtp_1_69/a_543_47# VGND VGND sky130_fd_pr__nfet_01v8 ad=0 pd=0 as=0 ps=0 w=0.64 l=0.15
X528 sky130_fd_sc_hd__dfrtp_1_69/a_193_47# sky130_fd_sc_hd__dfrtp_1_69/a_27_47# VGND VGND sky130_fd_pr__nfet_01v8 ad=0.1092 pd=1.36 as=0 ps=0 w=0.42 l=0.15
X529 sky130_fd_sc_hd__dfrtp_1_69/a_1108_47# sky130_fd_sc_hd__dfrtp_1_69/a_27_47# sky130_fd_sc_hd__dfrtp_1_69/a_761_289# VDPWR sky130_fd_pr__pfet_01v8_hvt ad=0.1176 pd=1.4 as=0.2583 ps=2.37 w=0.42 l=0.15
X530 sky130_fd_sc_hd__dfrtp_1_69/a_1462_47# V3R300 VGND VGND sky130_fd_pr__nfet_01v8 ad=0 pd=0 as=0 ps=0 w=0.42 l=0.15
X531 sky130_fd_sc_hd__dfrtp_1_69/a_543_47# sky130_fd_sc_hd__dfrtp_1_69/a_27_47# sky130_fd_sc_hd__dfrtp_1_69/a_448_47# VGND sky130_fd_pr__special_nfet_01v8 ad=0.1188 pd=1.38 as=0.132 ps=1.49 w=0.36 l=0.15
X532 sky130_fd_sc_hd__dfrtp_1_69/a_543_47# sky130_fd_sc_hd__dfrtp_1_69/a_193_47# sky130_fd_sc_hd__dfrtp_1_69/a_448_47# VDPWR sky130_fd_pr__pfet_01v8_hvt ad=0 pd=0 as=0 ps=0 w=0.42 l=0.15
X533 sky130_fd_sc_hd__dfrtp_1_69/a_448_47# V3R126 VGND VGND sky130_fd_pr__nfet_01v8 ad=0 pd=0 as=0 ps=0 w=0.42 l=0.15
X534 VDPWR sky130_fd_sc_hd__dfrtp_1_69/a_1283_21# sky130_fd_sc_hd__dfrtp_1_69/a_1270_413# VDPWR sky130_fd_pr__pfet_01v8_hvt ad=0 pd=0 as=0.1134 ps=1.38 w=0.42 l=0.15
X535 VDPWR sky130_fd_sc_hd__dfrtp_1_69/a_1108_47# sky130_fd_sc_hd__dfrtp_1_69/a_1283_21# VDPWR sky130_fd_pr__pfet_01v8_hvt ad=0 pd=0 as=0.1134 ps=1.38 w=0.42 l=0.15
X536 sky130_fd_sc_hd__dfrtp_1_69/a_1270_413# sky130_fd_sc_hd__dfrtp_1_69/a_193_47# sky130_fd_sc_hd__dfrtp_1_69/a_1108_47# VDPWR sky130_fd_pr__pfet_01v8_hvt ad=0 pd=0 as=0 ps=0 w=0.42 l=0.15
X537 sky130_fd_sc_hd__dfrtp_1_69/a_193_47# sky130_fd_sc_hd__dfrtp_1_69/a_27_47# VDPWR VDPWR sky130_fd_pr__pfet_01v8_hvt ad=0.1664 pd=1.8 as=0 ps=0 w=0.64 l=0.15
X538 sky130_fd_sc_hd__dfrtp_1_69/a_1283_21# V3R300 VDPWR VDPWR sky130_fd_pr__pfet_01v8_hvt ad=0 pd=0 as=0 ps=0 w=0.42 l=0.15
X539 VDPWR sky130_fd_sc_hd__dfrtp_1_69/a_761_289# sky130_fd_sc_hd__dfrtp_1_69/a_651_413# VDPWR sky130_fd_pr__pfet_01v8_hvt ad=0 pd=0 as=0 ps=0 w=0.42 l=0.15
X540 V3R041 sky130_fd_sc_hd__dfrtp_1_69/a_1283_21# VGND VGND sky130_fd_pr__nfet_01v8 ad=0.169 pd=1.82 as=0 ps=0 w=0.65 l=0.15
X541 sky130_fd_sc_hd__dfrtp_1_69/a_639_47# sky130_fd_sc_hd__dfrtp_1_69/a_193_47# sky130_fd_sc_hd__dfrtp_1_69/a_543_47# VGND sky130_fd_pr__special_nfet_01v8 ad=0 pd=0 as=0 ps=0 w=0.36 l=0.15
X542 VGND sky130_fd_sc_hd__dfrtp_1_69/a_1283_21# sky130_fd_sc_hd__dfrtp_1_69/a_1217_47# VGND sky130_fd_pr__nfet_01v8 ad=0 pd=0 as=0 ps=0 w=0.42 l=0.15
X543 sky130_fd_sc_hd__dfrtp_1_69/a_651_413# V3R300 VDPWR VDPWR sky130_fd_pr__pfet_01v8_hvt ad=0 pd=0 as=0 ps=0 w=0.42 l=0.15
X544 VGND V3R081 sky130_fd_sc_hd__dfrtp_1_69/a_27_47# VGND sky130_fd_pr__nfet_01v8 ad=0 pd=0 as=0.1092 ps=1.36 w=0.42 l=0.15
X545 sky130_fd_sc_hd__dfrtp_1_69/a_761_289# sky130_fd_sc_hd__dfrtp_1_69/a_543_47# VDPWR VDPWR sky130_fd_pr__pfet_01v8_hvt ad=0 pd=0 as=0 ps=0 w=0.84 l=0.15
X546 sky130_fd_sc_hd__dfrtp_1_58/a_805_47# sky130_fd_sc_hd__dfrtp_1_58/a_761_289# sky130_fd_sc_hd__dfrtp_1_58/a_639_47# VGND sky130_fd_pr__nfet_01v8 ad=0.0882 pd=1.26 as=0.2802 ps=2.2 w=0.42 l=0.15
X547 sky130_fd_sc_hd__dfrtp_1_58/a_1217_47# sky130_fd_sc_hd__dfrtp_1_58/a_27_47# sky130_fd_sc_hd__dfrtp_1_58/a_1108_47# VGND sky130_fd_pr__special_nfet_01v8 ad=0.1338 pd=1.5 as=0.1422 ps=1.51 w=0.36 l=0.15
X548 sky130_fd_sc_hd__dfrtp_1_58/a_1283_21# sky130_fd_sc_hd__dfrtp_1_58/a_1108_47# sky130_fd_sc_hd__dfrtp_1_58/a_1462_47# VGND sky130_fd_pr__nfet_01v8 ad=0.1092 pd=1.36 as=0.1281 ps=1.45 w=0.42 l=0.15
X549 sky130_fd_sc_hd__dfrtp_1_58/a_651_413# sky130_fd_sc_hd__dfrtp_1_58/a_27_47# sky130_fd_sc_hd__dfrtp_1_58/a_543_47# VDPWR sky130_fd_pr__pfet_01v8_hvt ad=0.3402 pd=3.3 as=0.1449 ps=1.53 w=0.42 l=0.15
X550 sky130_fd_sc_hd__dfrtp_1_58/a_1108_47# sky130_fd_sc_hd__dfrtp_1_58/a_193_47# sky130_fd_sc_hd__dfrtp_1_58/a_761_289# VGND sky130_fd_pr__special_nfet_01v8 ad=0 pd=0 as=0.1998 ps=1.97 w=0.36 l=0.15
X551 VGND V3R302 sky130_fd_sc_hd__dfrtp_1_58/a_805_47# VGND sky130_fd_pr__nfet_01v8 ad=0 pd=0 as=0 ps=0 w=0.42 l=0.15
X552 V3R064 sky130_fd_sc_hd__dfrtp_1_58/a_1283_21# VDPWR VDPWR sky130_fd_pr__pfet_01v8_hvt ad=0.26 pd=2.52 as=0 ps=0 w=1 l=0.15
X553 VDPWR V3R083 sky130_fd_sc_hd__dfrtp_1_58/a_27_47# VDPWR sky130_fd_pr__pfet_01v8_hvt ad=0 pd=0 as=0.1664 ps=1.8 w=0.64 l=0.15
X554 sky130_fd_sc_hd__dfrtp_1_58/a_448_47# V3R192 VDPWR VDPWR sky130_fd_pr__pfet_01v8_hvt ad=0.1302 pd=1.46 as=0 ps=0 w=0.42 l=0.15
X555 sky130_fd_sc_hd__dfrtp_1_58/a_761_289# sky130_fd_sc_hd__dfrtp_1_58/a_543_47# VGND VGND sky130_fd_pr__nfet_01v8 ad=0 pd=0 as=0 ps=0 w=0.64 l=0.15
X556 sky130_fd_sc_hd__dfrtp_1_58/a_193_47# sky130_fd_sc_hd__dfrtp_1_58/a_27_47# VGND VGND sky130_fd_pr__nfet_01v8 ad=0.1092 pd=1.36 as=0 ps=0 w=0.42 l=0.15
X557 sky130_fd_sc_hd__dfrtp_1_58/a_1108_47# sky130_fd_sc_hd__dfrtp_1_58/a_27_47# sky130_fd_sc_hd__dfrtp_1_58/a_761_289# VDPWR sky130_fd_pr__pfet_01v8_hvt ad=0.1176 pd=1.4 as=0.2583 ps=2.37 w=0.42 l=0.15
X558 sky130_fd_sc_hd__dfrtp_1_58/a_1462_47# V3R302 VGND VGND sky130_fd_pr__nfet_01v8 ad=0 pd=0 as=0 ps=0 w=0.42 l=0.15
X559 sky130_fd_sc_hd__dfrtp_1_58/a_543_47# sky130_fd_sc_hd__dfrtp_1_58/a_27_47# sky130_fd_sc_hd__dfrtp_1_58/a_448_47# VGND sky130_fd_pr__special_nfet_01v8 ad=0.1188 pd=1.38 as=0.132 ps=1.49 w=0.36 l=0.15
X560 sky130_fd_sc_hd__dfrtp_1_58/a_543_47# sky130_fd_sc_hd__dfrtp_1_58/a_193_47# sky130_fd_sc_hd__dfrtp_1_58/a_448_47# VDPWR sky130_fd_pr__pfet_01v8_hvt ad=0 pd=0 as=0 ps=0 w=0.42 l=0.15
X561 sky130_fd_sc_hd__dfrtp_1_58/a_448_47# V3R192 VGND VGND sky130_fd_pr__nfet_01v8 ad=0 pd=0 as=0 ps=0 w=0.42 l=0.15
X562 VDPWR sky130_fd_sc_hd__dfrtp_1_58/a_1283_21# sky130_fd_sc_hd__dfrtp_1_58/a_1270_413# VDPWR sky130_fd_pr__pfet_01v8_hvt ad=0 pd=0 as=0.1134 ps=1.38 w=0.42 l=0.15
X563 VDPWR sky130_fd_sc_hd__dfrtp_1_58/a_1108_47# sky130_fd_sc_hd__dfrtp_1_58/a_1283_21# VDPWR sky130_fd_pr__pfet_01v8_hvt ad=0 pd=0 as=0.1134 ps=1.38 w=0.42 l=0.15
X564 sky130_fd_sc_hd__dfrtp_1_58/a_1270_413# sky130_fd_sc_hd__dfrtp_1_58/a_193_47# sky130_fd_sc_hd__dfrtp_1_58/a_1108_47# VDPWR sky130_fd_pr__pfet_01v8_hvt ad=0 pd=0 as=0 ps=0 w=0.42 l=0.15
X565 sky130_fd_sc_hd__dfrtp_1_58/a_193_47# sky130_fd_sc_hd__dfrtp_1_58/a_27_47# VDPWR VDPWR sky130_fd_pr__pfet_01v8_hvt ad=0.1664 pd=1.8 as=0 ps=0 w=0.64 l=0.15
X566 sky130_fd_sc_hd__dfrtp_1_58/a_1283_21# V3R302 VDPWR VDPWR sky130_fd_pr__pfet_01v8_hvt ad=0 pd=0 as=0 ps=0 w=0.42 l=0.15
X567 VDPWR sky130_fd_sc_hd__dfrtp_1_58/a_761_289# sky130_fd_sc_hd__dfrtp_1_58/a_651_413# VDPWR sky130_fd_pr__pfet_01v8_hvt ad=0 pd=0 as=0 ps=0 w=0.42 l=0.15
X568 V3R064 sky130_fd_sc_hd__dfrtp_1_58/a_1283_21# VGND VGND sky130_fd_pr__nfet_01v8 ad=0.169 pd=1.82 as=0 ps=0 w=0.65 l=0.15
X569 sky130_fd_sc_hd__dfrtp_1_58/a_639_47# sky130_fd_sc_hd__dfrtp_1_58/a_193_47# sky130_fd_sc_hd__dfrtp_1_58/a_543_47# VGND sky130_fd_pr__special_nfet_01v8 ad=0 pd=0 as=0 ps=0 w=0.36 l=0.15
X570 VGND sky130_fd_sc_hd__dfrtp_1_58/a_1283_21# sky130_fd_sc_hd__dfrtp_1_58/a_1217_47# VGND sky130_fd_pr__nfet_01v8 ad=0 pd=0 as=0 ps=0 w=0.42 l=0.15
X571 sky130_fd_sc_hd__dfrtp_1_58/a_651_413# V3R302 VDPWR VDPWR sky130_fd_pr__pfet_01v8_hvt ad=0 pd=0 as=0 ps=0 w=0.42 l=0.15
X572 VGND V3R083 sky130_fd_sc_hd__dfrtp_1_58/a_27_47# VGND sky130_fd_pr__nfet_01v8 ad=0 pd=0 as=0.1092 ps=1.36 w=0.42 l=0.15
X573 sky130_fd_sc_hd__dfrtp_1_58/a_761_289# sky130_fd_sc_hd__dfrtp_1_58/a_543_47# VDPWR VDPWR sky130_fd_pr__pfet_01v8_hvt ad=0 pd=0 as=0 ps=0 w=0.84 l=0.15
X574 sky130_fd_sc_hd__dfrtp_1_47/a_805_47# sky130_fd_sc_hd__dfrtp_1_47/a_761_289# sky130_fd_sc_hd__dfrtp_1_47/a_639_47# VGND sky130_fd_pr__nfet_01v8 ad=0.0882 pd=1.26 as=0.2802 ps=2.2 w=0.42 l=0.15
X575 sky130_fd_sc_hd__dfrtp_1_47/a_1217_47# sky130_fd_sc_hd__dfrtp_1_47/a_27_47# sky130_fd_sc_hd__dfrtp_1_47/a_1108_47# VGND sky130_fd_pr__special_nfet_01v8 ad=0.1338 pd=1.5 as=0.1422 ps=1.51 w=0.36 l=0.15
X576 sky130_fd_sc_hd__dfrtp_1_47/a_1283_21# sky130_fd_sc_hd__dfrtp_1_47/a_1108_47# sky130_fd_sc_hd__dfrtp_1_47/a_1462_47# VGND sky130_fd_pr__nfet_01v8 ad=0.1092 pd=1.36 as=0.1281 ps=1.45 w=0.42 l=0.15
X577 sky130_fd_sc_hd__dfrtp_1_47/a_651_413# sky130_fd_sc_hd__dfrtp_1_47/a_27_47# sky130_fd_sc_hd__dfrtp_1_47/a_543_47# VDPWR sky130_fd_pr__pfet_01v8_hvt ad=0.3402 pd=3.3 as=0.1449 ps=1.53 w=0.42 l=0.15
X578 sky130_fd_sc_hd__dfrtp_1_47/a_1108_47# sky130_fd_sc_hd__dfrtp_1_47/a_193_47# sky130_fd_sc_hd__dfrtp_1_47/a_761_289# VGND sky130_fd_pr__special_nfet_01v8 ad=0 pd=0 as=0.1998 ps=1.97 w=0.36 l=0.15
X579 VGND V3R302 sky130_fd_sc_hd__dfrtp_1_47/a_805_47# VGND sky130_fd_pr__nfet_01v8 ad=0 pd=0 as=0 ps=0 w=0.42 l=0.15
X580 V3R007 sky130_fd_sc_hd__dfrtp_1_47/a_1283_21# VDPWR VDPWR sky130_fd_pr__pfet_01v8_hvt ad=0.26 pd=2.52 as=0 ps=0 w=1 l=0.15
X581 VDPWR V3R083 sky130_fd_sc_hd__dfrtp_1_47/a_27_47# VDPWR sky130_fd_pr__pfet_01v8_hvt ad=0 pd=0 as=0.1664 ps=1.8 w=0.64 l=0.15
X582 sky130_fd_sc_hd__dfrtp_1_47/a_448_47# V3R186 VDPWR VDPWR sky130_fd_pr__pfet_01v8_hvt ad=0.1302 pd=1.46 as=0 ps=0 w=0.42 l=0.15
X583 sky130_fd_sc_hd__dfrtp_1_47/a_761_289# sky130_fd_sc_hd__dfrtp_1_47/a_543_47# VGND VGND sky130_fd_pr__nfet_01v8 ad=0 pd=0 as=0 ps=0 w=0.64 l=0.15
X584 sky130_fd_sc_hd__dfrtp_1_47/a_193_47# sky130_fd_sc_hd__dfrtp_1_47/a_27_47# VGND VGND sky130_fd_pr__nfet_01v8 ad=0.1092 pd=1.36 as=0 ps=0 w=0.42 l=0.15
X585 sky130_fd_sc_hd__dfrtp_1_47/a_1108_47# sky130_fd_sc_hd__dfrtp_1_47/a_27_47# sky130_fd_sc_hd__dfrtp_1_47/a_761_289# VDPWR sky130_fd_pr__pfet_01v8_hvt ad=0.1176 pd=1.4 as=0.2583 ps=2.37 w=0.42 l=0.15
X586 sky130_fd_sc_hd__dfrtp_1_47/a_1462_47# V3R302 VGND VGND sky130_fd_pr__nfet_01v8 ad=0 pd=0 as=0 ps=0 w=0.42 l=0.15
X587 sky130_fd_sc_hd__dfrtp_1_47/a_543_47# sky130_fd_sc_hd__dfrtp_1_47/a_27_47# sky130_fd_sc_hd__dfrtp_1_47/a_448_47# VGND sky130_fd_pr__special_nfet_01v8 ad=0.1188 pd=1.38 as=0.132 ps=1.49 w=0.36 l=0.15
X588 sky130_fd_sc_hd__dfrtp_1_47/a_543_47# sky130_fd_sc_hd__dfrtp_1_47/a_193_47# sky130_fd_sc_hd__dfrtp_1_47/a_448_47# VDPWR sky130_fd_pr__pfet_01v8_hvt ad=0 pd=0 as=0 ps=0 w=0.42 l=0.15
X589 sky130_fd_sc_hd__dfrtp_1_47/a_448_47# V3R186 VGND VGND sky130_fd_pr__nfet_01v8 ad=0 pd=0 as=0 ps=0 w=0.42 l=0.15
X590 VDPWR sky130_fd_sc_hd__dfrtp_1_47/a_1283_21# sky130_fd_sc_hd__dfrtp_1_47/a_1270_413# VDPWR sky130_fd_pr__pfet_01v8_hvt ad=0 pd=0 as=0.1134 ps=1.38 w=0.42 l=0.15
X591 VDPWR sky130_fd_sc_hd__dfrtp_1_47/a_1108_47# sky130_fd_sc_hd__dfrtp_1_47/a_1283_21# VDPWR sky130_fd_pr__pfet_01v8_hvt ad=0 pd=0 as=0.1134 ps=1.38 w=0.42 l=0.15
X592 sky130_fd_sc_hd__dfrtp_1_47/a_1270_413# sky130_fd_sc_hd__dfrtp_1_47/a_193_47# sky130_fd_sc_hd__dfrtp_1_47/a_1108_47# VDPWR sky130_fd_pr__pfet_01v8_hvt ad=0 pd=0 as=0 ps=0 w=0.42 l=0.15
X593 sky130_fd_sc_hd__dfrtp_1_47/a_193_47# sky130_fd_sc_hd__dfrtp_1_47/a_27_47# VDPWR VDPWR sky130_fd_pr__pfet_01v8_hvt ad=0.1664 pd=1.8 as=0 ps=0 w=0.64 l=0.15
X594 sky130_fd_sc_hd__dfrtp_1_47/a_1283_21# V3R302 VDPWR VDPWR sky130_fd_pr__pfet_01v8_hvt ad=0 pd=0 as=0 ps=0 w=0.42 l=0.15
X595 VDPWR sky130_fd_sc_hd__dfrtp_1_47/a_761_289# sky130_fd_sc_hd__dfrtp_1_47/a_651_413# VDPWR sky130_fd_pr__pfet_01v8_hvt ad=0 pd=0 as=0 ps=0 w=0.42 l=0.15
X596 V3R007 sky130_fd_sc_hd__dfrtp_1_47/a_1283_21# VGND VGND sky130_fd_pr__nfet_01v8 ad=0.169 pd=1.82 as=0 ps=0 w=0.65 l=0.15
X597 sky130_fd_sc_hd__dfrtp_1_47/a_639_47# sky130_fd_sc_hd__dfrtp_1_47/a_193_47# sky130_fd_sc_hd__dfrtp_1_47/a_543_47# VGND sky130_fd_pr__special_nfet_01v8 ad=0 pd=0 as=0 ps=0 w=0.36 l=0.15
X598 VGND sky130_fd_sc_hd__dfrtp_1_47/a_1283_21# sky130_fd_sc_hd__dfrtp_1_47/a_1217_47# VGND sky130_fd_pr__nfet_01v8 ad=0 pd=0 as=0 ps=0 w=0.42 l=0.15
X599 sky130_fd_sc_hd__dfrtp_1_47/a_651_413# V3R302 VDPWR VDPWR sky130_fd_pr__pfet_01v8_hvt ad=0 pd=0 as=0 ps=0 w=0.42 l=0.15
X600 VGND V3R083 sky130_fd_sc_hd__dfrtp_1_47/a_27_47# VGND sky130_fd_pr__nfet_01v8 ad=0 pd=0 as=0.1092 ps=1.36 w=0.42 l=0.15
X601 sky130_fd_sc_hd__dfrtp_1_47/a_761_289# sky130_fd_sc_hd__dfrtp_1_47/a_543_47# VDPWR VDPWR sky130_fd_pr__pfet_01v8_hvt ad=0 pd=0 as=0 ps=0 w=0.84 l=0.15
X602 sky130_fd_sc_hd__dfrtp_1_36/a_805_47# sky130_fd_sc_hd__dfrtp_1_36/a_761_289# sky130_fd_sc_hd__dfrtp_1_36/a_639_47# VGND sky130_fd_pr__nfet_01v8 ad=0.0882 pd=1.26 as=0.2802 ps=2.2 w=0.42 l=0.15
X603 sky130_fd_sc_hd__dfrtp_1_36/a_1217_47# sky130_fd_sc_hd__dfrtp_1_36/a_27_47# sky130_fd_sc_hd__dfrtp_1_36/a_1108_47# VGND sky130_fd_pr__special_nfet_01v8 ad=0.1338 pd=1.5 as=0.1422 ps=1.51 w=0.36 l=0.15
X604 sky130_fd_sc_hd__dfrtp_1_36/a_1283_21# sky130_fd_sc_hd__dfrtp_1_36/a_1108_47# sky130_fd_sc_hd__dfrtp_1_36/a_1462_47# VGND sky130_fd_pr__nfet_01v8 ad=0.1092 pd=1.36 as=0.1281 ps=1.45 w=0.42 l=0.15
X605 sky130_fd_sc_hd__dfrtp_1_36/a_651_413# sky130_fd_sc_hd__dfrtp_1_36/a_27_47# sky130_fd_sc_hd__dfrtp_1_36/a_543_47# VDPWR sky130_fd_pr__pfet_01v8_hvt ad=0.3402 pd=3.3 as=0.1449 ps=1.53 w=0.42 l=0.15
X606 sky130_fd_sc_hd__dfrtp_1_36/a_1108_47# sky130_fd_sc_hd__dfrtp_1_36/a_193_47# sky130_fd_sc_hd__dfrtp_1_36/a_761_289# VGND sky130_fd_pr__special_nfet_01v8 ad=0 pd=0 as=0.1998 ps=1.97 w=0.36 l=0.15
X607 VGND V3R303 sky130_fd_sc_hd__dfrtp_1_36/a_805_47# VGND sky130_fd_pr__nfet_01v8 ad=0 pd=0 as=0 ps=0 w=0.42 l=0.15
X608 V3R077 sky130_fd_sc_hd__dfrtp_1_36/a_1283_21# VDPWR VDPWR sky130_fd_pr__pfet_01v8_hvt ad=0.26 pd=2.52 as=0 ps=0 w=1 l=0.15
X609 VDPWR V3R084 sky130_fd_sc_hd__dfrtp_1_36/a_27_47# VDPWR sky130_fd_pr__pfet_01v8_hvt ad=0 pd=0 as=0.1664 ps=1.8 w=0.64 l=0.15
X610 sky130_fd_sc_hd__dfrtp_1_36/a_448_47# V3R200 VDPWR VDPWR sky130_fd_pr__pfet_01v8_hvt ad=0.1302 pd=1.46 as=0 ps=0 w=0.42 l=0.15
X611 sky130_fd_sc_hd__dfrtp_1_36/a_761_289# sky130_fd_sc_hd__dfrtp_1_36/a_543_47# VGND VGND sky130_fd_pr__nfet_01v8 ad=0 pd=0 as=0 ps=0 w=0.64 l=0.15
X612 sky130_fd_sc_hd__dfrtp_1_36/a_193_47# sky130_fd_sc_hd__dfrtp_1_36/a_27_47# VGND VGND sky130_fd_pr__nfet_01v8 ad=0.1092 pd=1.36 as=0 ps=0 w=0.42 l=0.15
X613 sky130_fd_sc_hd__dfrtp_1_36/a_1108_47# sky130_fd_sc_hd__dfrtp_1_36/a_27_47# sky130_fd_sc_hd__dfrtp_1_36/a_761_289# VDPWR sky130_fd_pr__pfet_01v8_hvt ad=0.1176 pd=1.4 as=0.2583 ps=2.37 w=0.42 l=0.15
X614 sky130_fd_sc_hd__dfrtp_1_36/a_1462_47# V3R303 VGND VGND sky130_fd_pr__nfet_01v8 ad=0 pd=0 as=0 ps=0 w=0.42 l=0.15
X615 sky130_fd_sc_hd__dfrtp_1_36/a_543_47# sky130_fd_sc_hd__dfrtp_1_36/a_27_47# sky130_fd_sc_hd__dfrtp_1_36/a_448_47# VGND sky130_fd_pr__special_nfet_01v8 ad=0.1188 pd=1.38 as=0.132 ps=1.49 w=0.36 l=0.15
X616 sky130_fd_sc_hd__dfrtp_1_36/a_543_47# sky130_fd_sc_hd__dfrtp_1_36/a_193_47# sky130_fd_sc_hd__dfrtp_1_36/a_448_47# VDPWR sky130_fd_pr__pfet_01v8_hvt ad=0 pd=0 as=0 ps=0 w=0.42 l=0.15
X617 sky130_fd_sc_hd__dfrtp_1_36/a_448_47# V3R200 VGND VGND sky130_fd_pr__nfet_01v8 ad=0 pd=0 as=0 ps=0 w=0.42 l=0.15
X618 VDPWR sky130_fd_sc_hd__dfrtp_1_36/a_1283_21# sky130_fd_sc_hd__dfrtp_1_36/a_1270_413# VDPWR sky130_fd_pr__pfet_01v8_hvt ad=0 pd=0 as=0.1134 ps=1.38 w=0.42 l=0.15
X619 VDPWR sky130_fd_sc_hd__dfrtp_1_36/a_1108_47# sky130_fd_sc_hd__dfrtp_1_36/a_1283_21# VDPWR sky130_fd_pr__pfet_01v8_hvt ad=0 pd=0 as=0.1134 ps=1.38 w=0.42 l=0.15
X620 sky130_fd_sc_hd__dfrtp_1_36/a_1270_413# sky130_fd_sc_hd__dfrtp_1_36/a_193_47# sky130_fd_sc_hd__dfrtp_1_36/a_1108_47# VDPWR sky130_fd_pr__pfet_01v8_hvt ad=0 pd=0 as=0 ps=0 w=0.42 l=0.15
X621 sky130_fd_sc_hd__dfrtp_1_36/a_193_47# sky130_fd_sc_hd__dfrtp_1_36/a_27_47# VDPWR VDPWR sky130_fd_pr__pfet_01v8_hvt ad=0.1664 pd=1.8 as=0 ps=0 w=0.64 l=0.15
X622 sky130_fd_sc_hd__dfrtp_1_36/a_1283_21# V3R303 VDPWR VDPWR sky130_fd_pr__pfet_01v8_hvt ad=0 pd=0 as=0 ps=0 w=0.42 l=0.15
X623 VDPWR sky130_fd_sc_hd__dfrtp_1_36/a_761_289# sky130_fd_sc_hd__dfrtp_1_36/a_651_413# VDPWR sky130_fd_pr__pfet_01v8_hvt ad=0 pd=0 as=0 ps=0 w=0.42 l=0.15
X624 V3R077 sky130_fd_sc_hd__dfrtp_1_36/a_1283_21# VGND VGND sky130_fd_pr__nfet_01v8 ad=0.169 pd=1.82 as=0 ps=0 w=0.65 l=0.15
X625 sky130_fd_sc_hd__dfrtp_1_36/a_639_47# sky130_fd_sc_hd__dfrtp_1_36/a_193_47# sky130_fd_sc_hd__dfrtp_1_36/a_543_47# VGND sky130_fd_pr__special_nfet_01v8 ad=0 pd=0 as=0 ps=0 w=0.36 l=0.15
X626 VGND sky130_fd_sc_hd__dfrtp_1_36/a_1283_21# sky130_fd_sc_hd__dfrtp_1_36/a_1217_47# VGND sky130_fd_pr__nfet_01v8 ad=0 pd=0 as=0 ps=0 w=0.42 l=0.15
X627 sky130_fd_sc_hd__dfrtp_1_36/a_651_413# V3R303 VDPWR VDPWR sky130_fd_pr__pfet_01v8_hvt ad=0 pd=0 as=0 ps=0 w=0.42 l=0.15
X628 VGND V3R084 sky130_fd_sc_hd__dfrtp_1_36/a_27_47# VGND sky130_fd_pr__nfet_01v8 ad=0 pd=0 as=0.1092 ps=1.36 w=0.42 l=0.15
X629 sky130_fd_sc_hd__dfrtp_1_36/a_761_289# sky130_fd_sc_hd__dfrtp_1_36/a_543_47# VDPWR VDPWR sky130_fd_pr__pfet_01v8_hvt ad=0 pd=0 as=0 ps=0 w=0.84 l=0.15
X630 sky130_fd_sc_hd__dfrtp_1_25/a_805_47# sky130_fd_sc_hd__dfrtp_1_25/a_761_289# sky130_fd_sc_hd__dfrtp_1_25/a_639_47# VGND sky130_fd_pr__nfet_01v8 ad=0.0882 pd=1.26 as=0.2802 ps=2.2 w=0.42 l=0.15
X631 sky130_fd_sc_hd__dfrtp_1_25/a_1217_47# sky130_fd_sc_hd__dfrtp_1_25/a_27_47# sky130_fd_sc_hd__dfrtp_1_25/a_1108_47# VGND sky130_fd_pr__special_nfet_01v8 ad=0.1338 pd=1.5 as=0.1422 ps=1.51 w=0.36 l=0.15
X632 sky130_fd_sc_hd__dfrtp_1_25/a_1283_21# sky130_fd_sc_hd__dfrtp_1_25/a_1108_47# sky130_fd_sc_hd__dfrtp_1_25/a_1462_47# VGND sky130_fd_pr__nfet_01v8 ad=0.1092 pd=1.36 as=0.1281 ps=1.45 w=0.42 l=0.15
X633 sky130_fd_sc_hd__dfrtp_1_25/a_651_413# sky130_fd_sc_hd__dfrtp_1_25/a_27_47# sky130_fd_sc_hd__dfrtp_1_25/a_543_47# VDPWR sky130_fd_pr__pfet_01v8_hvt ad=0.3402 pd=3.3 as=0.1449 ps=1.53 w=0.42 l=0.15
X634 sky130_fd_sc_hd__dfrtp_1_25/a_1108_47# sky130_fd_sc_hd__dfrtp_1_25/a_193_47# sky130_fd_sc_hd__dfrtp_1_25/a_761_289# VGND sky130_fd_pr__special_nfet_01v8 ad=0 pd=0 as=0.1998 ps=1.97 w=0.36 l=0.15
X635 VGND V3R299 sky130_fd_sc_hd__dfrtp_1_25/a_805_47# VGND sky130_fd_pr__nfet_01v8 ad=0 pd=0 as=0 ps=0 w=0.42 l=0.15
X636 V3R167 sky130_fd_sc_hd__dfrtp_1_25/a_1283_21# VDPWR VDPWR sky130_fd_pr__pfet_01v8_hvt ad=0.26 pd=2.52 as=0 ps=0 w=1 l=0.15
X637 VDPWR V3R056 sky130_fd_sc_hd__dfrtp_1_25/a_27_47# VDPWR sky130_fd_pr__pfet_01v8_hvt ad=0 pd=0 as=0.1664 ps=1.8 w=0.64 l=0.15
X638 sky130_fd_sc_hd__dfrtp_1_25/a_448_47# V3R111 VDPWR VDPWR sky130_fd_pr__pfet_01v8_hvt ad=0.1302 pd=1.46 as=0 ps=0 w=0.42 l=0.15
X639 sky130_fd_sc_hd__dfrtp_1_25/a_761_289# sky130_fd_sc_hd__dfrtp_1_25/a_543_47# VGND VGND sky130_fd_pr__nfet_01v8 ad=0 pd=0 as=0 ps=0 w=0.64 l=0.15
X640 sky130_fd_sc_hd__dfrtp_1_25/a_193_47# sky130_fd_sc_hd__dfrtp_1_25/a_27_47# VGND VGND sky130_fd_pr__nfet_01v8 ad=0.1092 pd=1.36 as=0 ps=0 w=0.42 l=0.15
X641 sky130_fd_sc_hd__dfrtp_1_25/a_1108_47# sky130_fd_sc_hd__dfrtp_1_25/a_27_47# sky130_fd_sc_hd__dfrtp_1_25/a_761_289# VDPWR sky130_fd_pr__pfet_01v8_hvt ad=0.1176 pd=1.4 as=0.2583 ps=2.37 w=0.42 l=0.15
X642 sky130_fd_sc_hd__dfrtp_1_25/a_1462_47# V3R299 VGND VGND sky130_fd_pr__nfet_01v8 ad=0 pd=0 as=0 ps=0 w=0.42 l=0.15
X643 sky130_fd_sc_hd__dfrtp_1_25/a_543_47# sky130_fd_sc_hd__dfrtp_1_25/a_27_47# sky130_fd_sc_hd__dfrtp_1_25/a_448_47# VGND sky130_fd_pr__special_nfet_01v8 ad=0.1188 pd=1.38 as=0.132 ps=1.49 w=0.36 l=0.15
X644 sky130_fd_sc_hd__dfrtp_1_25/a_543_47# sky130_fd_sc_hd__dfrtp_1_25/a_193_47# sky130_fd_sc_hd__dfrtp_1_25/a_448_47# VDPWR sky130_fd_pr__pfet_01v8_hvt ad=0 pd=0 as=0 ps=0 w=0.42 l=0.15
X645 sky130_fd_sc_hd__dfrtp_1_25/a_448_47# V3R111 VGND VGND sky130_fd_pr__nfet_01v8 ad=0 pd=0 as=0 ps=0 w=0.42 l=0.15
X646 VDPWR sky130_fd_sc_hd__dfrtp_1_25/a_1283_21# sky130_fd_sc_hd__dfrtp_1_25/a_1270_413# VDPWR sky130_fd_pr__pfet_01v8_hvt ad=0 pd=0 as=0.1134 ps=1.38 w=0.42 l=0.15
X647 VDPWR sky130_fd_sc_hd__dfrtp_1_25/a_1108_47# sky130_fd_sc_hd__dfrtp_1_25/a_1283_21# VDPWR sky130_fd_pr__pfet_01v8_hvt ad=0 pd=0 as=0.1134 ps=1.38 w=0.42 l=0.15
X648 sky130_fd_sc_hd__dfrtp_1_25/a_1270_413# sky130_fd_sc_hd__dfrtp_1_25/a_193_47# sky130_fd_sc_hd__dfrtp_1_25/a_1108_47# VDPWR sky130_fd_pr__pfet_01v8_hvt ad=0 pd=0 as=0 ps=0 w=0.42 l=0.15
X649 sky130_fd_sc_hd__dfrtp_1_25/a_193_47# sky130_fd_sc_hd__dfrtp_1_25/a_27_47# VDPWR VDPWR sky130_fd_pr__pfet_01v8_hvt ad=0.1664 pd=1.8 as=0 ps=0 w=0.64 l=0.15
X650 sky130_fd_sc_hd__dfrtp_1_25/a_1283_21# V3R299 VDPWR VDPWR sky130_fd_pr__pfet_01v8_hvt ad=0 pd=0 as=0 ps=0 w=0.42 l=0.15
X651 VDPWR sky130_fd_sc_hd__dfrtp_1_25/a_761_289# sky130_fd_sc_hd__dfrtp_1_25/a_651_413# VDPWR sky130_fd_pr__pfet_01v8_hvt ad=0 pd=0 as=0 ps=0 w=0.42 l=0.15
X652 V3R167 sky130_fd_sc_hd__dfrtp_1_25/a_1283_21# VGND VGND sky130_fd_pr__nfet_01v8 ad=0.169 pd=1.82 as=0 ps=0 w=0.65 l=0.15
X653 sky130_fd_sc_hd__dfrtp_1_25/a_639_47# sky130_fd_sc_hd__dfrtp_1_25/a_193_47# sky130_fd_sc_hd__dfrtp_1_25/a_543_47# VGND sky130_fd_pr__special_nfet_01v8 ad=0 pd=0 as=0 ps=0 w=0.36 l=0.15
X654 VGND sky130_fd_sc_hd__dfrtp_1_25/a_1283_21# sky130_fd_sc_hd__dfrtp_1_25/a_1217_47# VGND sky130_fd_pr__nfet_01v8 ad=0 pd=0 as=0 ps=0 w=0.42 l=0.15
X655 sky130_fd_sc_hd__dfrtp_1_25/a_651_413# V3R299 VDPWR VDPWR sky130_fd_pr__pfet_01v8_hvt ad=0 pd=0 as=0 ps=0 w=0.42 l=0.15
X656 VGND V3R056 sky130_fd_sc_hd__dfrtp_1_25/a_27_47# VGND sky130_fd_pr__nfet_01v8 ad=0 pd=0 as=0.1092 ps=1.36 w=0.42 l=0.15
X657 sky130_fd_sc_hd__dfrtp_1_25/a_761_289# sky130_fd_sc_hd__dfrtp_1_25/a_543_47# VDPWR VDPWR sky130_fd_pr__pfet_01v8_hvt ad=0 pd=0 as=0 ps=0 w=0.84 l=0.15
X658 VGND sky130_fd_sc_hd__dfstp_1_0/a_652_21# sky130_fd_sc_hd__dfstp_1_0/a_586_47# VGND sky130_fd_pr__nfet_01v8 ad=0.0882 pd=0.84 as=0.06705 ps=0.75 w=0.42 l=0.15
X659 sky130_fd_sc_hd__dfstp_1_0/a_956_413# sky130_fd_sc_hd__dfstp_1_0/a_476_47# VDPWR VDPWR sky130_fd_pr__pfet_01v8_hvt ad=0.0483 pd=0.65 as=0.0567 ps=0.69 w=0.42 l=0.15
X660 VDPWR sky130_fd_sc_hd__dfstp_1_0/a_476_47# sky130_fd_sc_hd__dfstp_1_0/a_652_21# VDPWR sky130_fd_pr__pfet_01v8_hvt ad=0.0567 pd=0.69 as=0.0567 ps=0.69 w=0.42 l=0.15
X661 VDPWR V3R056 sky130_fd_sc_hd__dfstp_1_0/a_27_47# VDPWR sky130_fd_pr__pfet_01v8_hvt ad=0.0864 pd=0.91 as=0.1664 ps=1.8 w=0.64 l=0.15
X662 sky130_fd_sc_hd__dfstp_1_0/a_586_47# sky130_fd_sc_hd__dfstp_1_0/a_193_47# sky130_fd_sc_hd__dfstp_1_0/a_476_47# VGND sky130_fd_pr__special_nfet_01v8 ad=0.06705 pd=0.75 as=0.072 ps=0.76 w=0.36 l=0.15
X663 sky130_fd_sc_hd__dfstp_1_0/a_1056_47# sky130_fd_sc_hd__dfstp_1_0/a_476_47# VGND VGND sky130_fd_pr__nfet_01v8 ad=0.0441 pd=0.63 as=0.1092 ps=1.36 w=0.42 l=0.15
X664 sky130_fd_sc_hd__dfstp_1_0/a_476_47# sky130_fd_sc_hd__dfstp_1_0/a_27_47# sky130_fd_sc_hd__dfstp_1_0/a_381_47# VGND sky130_fd_pr__special_nfet_01v8 ad=0.072 pd=0.76 as=0.0935 ps=0.965 w=0.36 l=0.15
X665 sky130_fd_sc_hd__dfstp_1_0/a_381_47# V3R113 VDPWR VDPWR sky130_fd_pr__pfet_01v8_hvt ad=0.12495 pd=1.175 as=0.2184 ps=2.2 w=0.84 l=0.15
X666 sky130_fd_sc_hd__dfstp_1_0/a_652_21# V3R299 VDPWR VDPWR sky130_fd_pr__pfet_01v8_hvt ad=0.0567 pd=0.69 as=0.0798 ps=0.8 w=0.42 l=0.15
X667 sky130_fd_sc_hd__dfstp_1_0/a_1224_47# sky130_fd_sc_hd__dfstp_1_0/a_27_47# sky130_fd_sc_hd__dfstp_1_0/a_1032_413# VGND sky130_fd_pr__nfet_01v8 ad=0.0441 pd=0.63 as=0.0693 ps=0.75 w=0.42 l=0.15
X668 sky130_fd_sc_hd__dfstp_1_0/a_562_413# sky130_fd_sc_hd__dfstp_1_0/a_27_47# sky130_fd_sc_hd__dfstp_1_0/a_476_47# VDPWR sky130_fd_pr__pfet_01v8_hvt ad=0.0945 pd=0.87 as=0.0567 ps=0.69 w=0.42 l=0.15
X669 VGND sky130_fd_sc_hd__dfstp_1_0/a_1032_413# sky130_fd_sc_hd__dfstp_1_0/a_1602_47# VGND sky130_fd_pr__nfet_01v8 ad=0.097 pd=0.975 as=0.1092 ps=1.36 w=0.42 l=0.15
X670 VDPWR sky130_fd_sc_hd__dfstp_1_0/a_1182_261# sky130_fd_sc_hd__dfstp_1_0/a_1140_413# VDPWR sky130_fd_pr__pfet_01v8_hvt ad=0.1092 pd=1.36 as=0.0441 ps=0.63 w=0.42 l=0.15
X671 V3R169 sky130_fd_sc_hd__dfstp_1_0/a_1602_47# VDPWR VDPWR sky130_fd_pr__pfet_01v8_hvt ad=0.26 pd=2.52 as=0.149 ps=1.325 w=1 l=0.15
X672 sky130_fd_sc_hd__dfstp_1_0/a_1032_413# sky130_fd_sc_hd__dfstp_1_0/a_193_47# sky130_fd_sc_hd__dfstp_1_0/a_1056_47# VGND sky130_fd_pr__nfet_01v8 ad=0.0693 pd=0.75 as=0.0441 ps=0.63 w=0.42 l=0.15
X673 sky130_fd_sc_hd__dfstp_1_0/a_476_47# sky130_fd_sc_hd__dfstp_1_0/a_193_47# sky130_fd_sc_hd__dfstp_1_0/a_381_47# VDPWR sky130_fd_pr__pfet_01v8_hvt ad=0.0567 pd=0.69 as=0.12495 ps=1.175 w=0.42 l=0.15
X674 sky130_fd_sc_hd__dfstp_1_0/a_1296_47# sky130_fd_sc_hd__dfstp_1_0/a_1182_261# sky130_fd_sc_hd__dfstp_1_0/a_1224_47# VGND sky130_fd_pr__nfet_01v8 ad=0.0483 pd=0.65 as=0.0441 ps=0.63 w=0.42 l=0.15
X675 sky130_fd_sc_hd__dfstp_1_0/a_193_47# sky130_fd_sc_hd__dfstp_1_0/a_27_47# VGND VGND sky130_fd_pr__nfet_01v8 ad=0.1092 pd=1.36 as=0.0567 ps=0.69 w=0.42 l=0.15
X676 VDPWR sky130_fd_sc_hd__dfstp_1_0/a_652_21# sky130_fd_sc_hd__dfstp_1_0/a_562_413# VDPWR sky130_fd_pr__pfet_01v8_hvt ad=0.0798 pd=0.8 as=0.0945 ps=0.87 w=0.42 l=0.15
X677 VDPWR V3R299 sky130_fd_sc_hd__dfstp_1_0/a_1032_413# VDPWR sky130_fd_pr__pfet_01v8_hvt ad=0.12285 pd=1.17 as=0.1092 ps=1.36 w=0.42 l=0.15
X678 sky130_fd_sc_hd__dfstp_1_0/a_1032_413# sky130_fd_sc_hd__dfstp_1_0/a_27_47# sky130_fd_sc_hd__dfstp_1_0/a_956_413# VDPWR sky130_fd_pr__pfet_01v8_hvt ad=0.0819 pd=0.81 as=0.0483 ps=0.65 w=0.42 l=0.15
X679 sky130_fd_sc_hd__dfstp_1_0/a_1182_261# sky130_fd_sc_hd__dfstp_1_0/a_1032_413# VDPWR VDPWR sky130_fd_pr__pfet_01v8_hvt ad=0.2184 pd=2.2 as=0.12285 ps=1.17 w=0.84 l=0.15
X680 V3R169 sky130_fd_sc_hd__dfstp_1_0/a_1602_47# VGND VGND sky130_fd_pr__nfet_01v8 ad=0.169 pd=1.82 as=0.097 ps=0.975 w=0.65 l=0.15
X681 sky130_fd_sc_hd__dfstp_1_0/a_193_47# sky130_fd_sc_hd__dfstp_1_0/a_27_47# VDPWR VDPWR sky130_fd_pr__pfet_01v8_hvt ad=0.1664 pd=1.8 as=0.0864 ps=0.91 w=0.64 l=0.15
X682 sky130_fd_sc_hd__dfstp_1_0/a_1140_413# sky130_fd_sc_hd__dfstp_1_0/a_193_47# sky130_fd_sc_hd__dfstp_1_0/a_1032_413# VDPWR sky130_fd_pr__pfet_01v8_hvt ad=0.0441 pd=0.63 as=0.0819 ps=0.81 w=0.42 l=0.15
X683 VDPWR sky130_fd_sc_hd__dfstp_1_0/a_1032_413# sky130_fd_sc_hd__dfstp_1_0/a_1602_47# VDPWR sky130_fd_pr__pfet_01v8_hvt ad=0.149 pd=1.325 as=0.1664 ps=1.8 w=0.64 l=0.15
X684 sky130_fd_sc_hd__dfstp_1_0/a_796_47# V3R299 VGND VGND sky130_fd_pr__nfet_01v8 ad=0.0441 pd=0.63 as=0.0882 ps=0.84 w=0.42 l=0.15
X685 sky130_fd_sc_hd__dfstp_1_0/a_381_47# V3R113 VGND VGND sky130_fd_pr__nfet_01v8 ad=0.0935 pd=0.965 as=0.1664 ps=1.8 w=0.64 l=0.15
X686 sky130_fd_sc_hd__dfstp_1_0/a_1182_261# sky130_fd_sc_hd__dfstp_1_0/a_1032_413# VGND VGND sky130_fd_pr__nfet_01v8 ad=0.1404 pd=1.6 as=0.1137 ps=1.01 w=0.54 l=0.15
X687 sky130_fd_sc_hd__dfstp_1_0/a_652_21# sky130_fd_sc_hd__dfstp_1_0/a_476_47# sky130_fd_sc_hd__dfstp_1_0/a_796_47# VGND sky130_fd_pr__nfet_01v8 ad=0.1092 pd=1.36 as=0.0441 ps=0.63 w=0.42 l=0.15
X688 VGND V3R056 sky130_fd_sc_hd__dfstp_1_0/a_27_47# VGND sky130_fd_pr__nfet_01v8 ad=0.0567 pd=0.69 as=0.1092 ps=1.36 w=0.42 l=0.15
X689 VGND V3R299 sky130_fd_sc_hd__dfstp_1_0/a_1296_47# VGND sky130_fd_pr__nfet_01v8 ad=0.1137 pd=1.01 as=0.0483 ps=0.65 w=0.42 l=0.15
X690 V3R281 sky130_fd_sc_hd__xor2_1_5/a_35_297# sky130_fd_sc_hd__xor2_1_5/a_285_297# VDPWR sky130_fd_pr__pfet_01v8_hvt ad=0.3 pd=2.6 as=0.53 ps=5.06 w=1 l=0.15
X691 V3R281 V3R079 sky130_fd_sc_hd__xor2_1_5/a_285_47# VGND sky130_fd_pr__nfet_01v8 ad=0.5005 pd=2.84 as=0.1755 ps=1.84 w=0.65 l=0.15
X692 sky130_fd_sc_hd__xor2_1_5/a_35_297# V3R079 VGND VGND sky130_fd_pr__nfet_01v8 ad=0.1755 pd=1.84 as=0 ps=0 w=0.65 l=0.15
X693 sky130_fd_sc_hd__xor2_1_5/a_117_297# V3R079 sky130_fd_sc_hd__xor2_1_5/a_35_297# VDPWR sky130_fd_pr__pfet_01v8_hvt ad=0.27 pd=2.54 as=0.26 ps=2.52 w=1 l=0.15
X694 VDPWR V3R079 sky130_fd_sc_hd__xor2_1_5/a_285_297# VDPWR sky130_fd_pr__pfet_01v8_hvt ad=0 pd=0 as=0 ps=0 w=1 l=0.15
X695 VGND V3R006 sky130_fd_sc_hd__xor2_1_5/a_35_297# VGND sky130_fd_pr__nfet_01v8 ad=0 pd=0 as=0 ps=0 w=0.65 l=0.15
X696 VGND sky130_fd_sc_hd__xor2_1_5/a_35_297# V3R281 VGND sky130_fd_pr__nfet_01v8 ad=0 pd=0 as=0 ps=0 w=0.65 l=0.15
X697 sky130_fd_sc_hd__xor2_1_5/a_285_297# V3R006 VDPWR VDPWR sky130_fd_pr__pfet_01v8_hvt ad=0 pd=0 as=0 ps=0 w=1 l=0.15
X698 VDPWR V3R006 sky130_fd_sc_hd__xor2_1_5/a_117_297# VDPWR sky130_fd_pr__pfet_01v8_hvt ad=0 pd=0 as=0 ps=0 w=1 l=0.15
X699 sky130_fd_sc_hd__xor2_1_5/a_285_47# V3R006 VGND VGND sky130_fd_pr__nfet_01v8 ad=0 pd=0 as=0 ps=0 w=0.65 l=0.15
X700 VDPWR sky130_fd_sc_hd__mux2_1_6/a_505_21# sky130_fd_sc_hd__mux2_1_6/a_535_374# VDPWR sky130_fd_pr__pfet_01v8_hvt ad=0 pd=0 as=0.0882 ps=1.26 w=0.42 l=0.15
X701 sky130_fd_sc_hd__mux2_1_6/a_505_21# V3R063 VDPWR VDPWR sky130_fd_pr__pfet_01v8_hvt ad=0.1176 pd=1.4 as=0 ps=0 w=0.42 l=0.15
X702 sky130_fd_sc_hd__mux2_1_6/a_218_374# V3R063 VDPWR VDPWR sky130_fd_pr__pfet_01v8_hvt ad=0.1533 pd=1.57 as=0 ps=0 w=0.42 l=0.15
X703 VGND sky130_fd_sc_hd__mux2_1_6/a_505_21# sky130_fd_sc_hd__mux2_1_6/a_439_47# VGND sky130_fd_pr__nfet_01v8 ad=0 pd=0 as=0.1386 ps=1.5 w=0.42 l=0.15
X704 sky130_fd_sc_hd__mux2_1_6/a_76_199# V3R058 sky130_fd_sc_hd__mux2_1_6/a_218_374# VDPWR sky130_fd_pr__pfet_01v8_hvt ad=0.3864 pd=2.68 as=0 ps=0 w=0.42 l=0.15
X705 sky130_fd_sc_hd__mux2_1_6/a_505_21# V3R063 VGND VGND sky130_fd_pr__nfet_01v8 ad=0.1092 pd=1.36 as=0 ps=0 w=0.42 l=0.15
X706 sky130_fd_sc_hd__mux2_1_6/a_439_47# V3R058 sky130_fd_sc_hd__mux2_1_6/a_76_199# VGND sky130_fd_pr__nfet_01v8 ad=0 pd=0 as=0.1995 ps=1.79 w=0.42 l=0.15
X707 sky130_fd_sc_hd__mux2_1_6/a_535_374# V3R267 sky130_fd_sc_hd__mux2_1_6/a_76_199# VDPWR sky130_fd_pr__pfet_01v8_hvt ad=0 pd=0 as=0 ps=0 w=0.42 l=0.15
X708 sky130_fd_sc_hd__mux2_1_6/a_76_199# V3R267 sky130_fd_sc_hd__mux2_1_6/a_218_47# VGND sky130_fd_pr__nfet_01v8 ad=0 pd=0 as=0.1386 ps=1.5 w=0.42 l=0.15
X709 sky130_fd_sc_hd__mux2_1_6/a_218_47# V3R063 VGND VGND sky130_fd_pr__nfet_01v8 ad=0 pd=0 as=0 ps=0 w=0.42 l=0.15
X710 VDPWR sky130_fd_sc_hd__mux2_1_6/a_76_199# V3R193 VDPWR sky130_fd_pr__pfet_01v8_hvt ad=0 pd=0 as=0.26 ps=2.52 w=1 l=0.15
X711 VGND sky130_fd_sc_hd__mux2_1_6/a_76_199# V3R193 VGND sky130_fd_pr__nfet_01v8 ad=0 pd=0 as=0.169 ps=1.82 w=0.65 l=0.15
X712 sky130_fd_sc_hd__dfrtp_1_15/a_805_47# sky130_fd_sc_hd__dfrtp_1_15/a_761_289# sky130_fd_sc_hd__dfrtp_1_15/a_639_47# VGND sky130_fd_pr__nfet_01v8 ad=0.0882 pd=1.26 as=0.2802 ps=2.2 w=0.42 l=0.15
X713 sky130_fd_sc_hd__dfrtp_1_15/a_1217_47# sky130_fd_sc_hd__dfrtp_1_15/a_27_47# sky130_fd_sc_hd__dfrtp_1_15/a_1108_47# VGND sky130_fd_pr__special_nfet_01v8 ad=0.1338 pd=1.5 as=0.1422 ps=1.51 w=0.36 l=0.15
X714 sky130_fd_sc_hd__dfrtp_1_15/a_1283_21# sky130_fd_sc_hd__dfrtp_1_15/a_1108_47# sky130_fd_sc_hd__dfrtp_1_15/a_1462_47# VGND sky130_fd_pr__nfet_01v8 ad=0.1092 pd=1.36 as=0.1281 ps=1.45 w=0.42 l=0.15
X715 sky130_fd_sc_hd__dfrtp_1_15/a_651_413# sky130_fd_sc_hd__dfrtp_1_15/a_27_47# sky130_fd_sc_hd__dfrtp_1_15/a_543_47# VDPWR sky130_fd_pr__pfet_01v8_hvt ad=0.3402 pd=3.3 as=0.1449 ps=1.53 w=0.42 l=0.15
X716 sky130_fd_sc_hd__dfrtp_1_15/a_1108_47# sky130_fd_sc_hd__dfrtp_1_15/a_193_47# sky130_fd_sc_hd__dfrtp_1_15/a_761_289# VGND sky130_fd_pr__special_nfet_01v8 ad=0 pd=0 as=0.1998 ps=1.97 w=0.36 l=0.15
X717 VGND V3R303 sky130_fd_sc_hd__dfrtp_1_15/a_805_47# VGND sky130_fd_pr__nfet_01v8 ad=0 pd=0 as=0 ps=0 w=0.42 l=0.15
X718 V3R199 sky130_fd_sc_hd__dfrtp_1_15/a_1283_21# VDPWR VDPWR sky130_fd_pr__pfet_01v8_hvt ad=0.26 pd=2.52 as=0 ps=0 w=1 l=0.15
X719 VDPWR V3R084 sky130_fd_sc_hd__dfrtp_1_15/a_27_47# VDPWR sky130_fd_pr__pfet_01v8_hvt ad=0 pd=0 as=0.1664 ps=1.8 w=0.64 l=0.15
X720 sky130_fd_sc_hd__dfrtp_1_15/a_448_47# V3R072 VDPWR VDPWR sky130_fd_pr__pfet_01v8_hvt ad=0.1302 pd=1.46 as=0 ps=0 w=0.42 l=0.15
X721 sky130_fd_sc_hd__dfrtp_1_15/a_761_289# sky130_fd_sc_hd__dfrtp_1_15/a_543_47# VGND VGND sky130_fd_pr__nfet_01v8 ad=0 pd=0 as=0 ps=0 w=0.64 l=0.15
X722 sky130_fd_sc_hd__dfrtp_1_15/a_193_47# sky130_fd_sc_hd__dfrtp_1_15/a_27_47# VGND VGND sky130_fd_pr__nfet_01v8 ad=0.1092 pd=1.36 as=0 ps=0 w=0.42 l=0.15
X723 sky130_fd_sc_hd__dfrtp_1_15/a_1108_47# sky130_fd_sc_hd__dfrtp_1_15/a_27_47# sky130_fd_sc_hd__dfrtp_1_15/a_761_289# VDPWR sky130_fd_pr__pfet_01v8_hvt ad=0.1176 pd=1.4 as=0.2583 ps=2.37 w=0.42 l=0.15
X724 sky130_fd_sc_hd__dfrtp_1_15/a_1462_47# V3R303 VGND VGND sky130_fd_pr__nfet_01v8 ad=0 pd=0 as=0 ps=0 w=0.42 l=0.15
X725 sky130_fd_sc_hd__dfrtp_1_15/a_543_47# sky130_fd_sc_hd__dfrtp_1_15/a_27_47# sky130_fd_sc_hd__dfrtp_1_15/a_448_47# VGND sky130_fd_pr__special_nfet_01v8 ad=0.1188 pd=1.38 as=0.132 ps=1.49 w=0.36 l=0.15
X726 sky130_fd_sc_hd__dfrtp_1_15/a_543_47# sky130_fd_sc_hd__dfrtp_1_15/a_193_47# sky130_fd_sc_hd__dfrtp_1_15/a_448_47# VDPWR sky130_fd_pr__pfet_01v8_hvt ad=0 pd=0 as=0 ps=0 w=0.42 l=0.15
X727 sky130_fd_sc_hd__dfrtp_1_15/a_448_47# V3R072 VGND VGND sky130_fd_pr__nfet_01v8 ad=0 pd=0 as=0 ps=0 w=0.42 l=0.15
X728 VDPWR sky130_fd_sc_hd__dfrtp_1_15/a_1283_21# sky130_fd_sc_hd__dfrtp_1_15/a_1270_413# VDPWR sky130_fd_pr__pfet_01v8_hvt ad=0 pd=0 as=0.1134 ps=1.38 w=0.42 l=0.15
X729 VDPWR sky130_fd_sc_hd__dfrtp_1_15/a_1108_47# sky130_fd_sc_hd__dfrtp_1_15/a_1283_21# VDPWR sky130_fd_pr__pfet_01v8_hvt ad=0 pd=0 as=0.1134 ps=1.38 w=0.42 l=0.15
X730 sky130_fd_sc_hd__dfrtp_1_15/a_1270_413# sky130_fd_sc_hd__dfrtp_1_15/a_193_47# sky130_fd_sc_hd__dfrtp_1_15/a_1108_47# VDPWR sky130_fd_pr__pfet_01v8_hvt ad=0 pd=0 as=0 ps=0 w=0.42 l=0.15
X731 sky130_fd_sc_hd__dfrtp_1_15/a_193_47# sky130_fd_sc_hd__dfrtp_1_15/a_27_47# VDPWR VDPWR sky130_fd_pr__pfet_01v8_hvt ad=0.1664 pd=1.8 as=0 ps=0 w=0.64 l=0.15
X732 sky130_fd_sc_hd__dfrtp_1_15/a_1283_21# V3R303 VDPWR VDPWR sky130_fd_pr__pfet_01v8_hvt ad=0 pd=0 as=0 ps=0 w=0.42 l=0.15
X733 VDPWR sky130_fd_sc_hd__dfrtp_1_15/a_761_289# sky130_fd_sc_hd__dfrtp_1_15/a_651_413# VDPWR sky130_fd_pr__pfet_01v8_hvt ad=0 pd=0 as=0 ps=0 w=0.42 l=0.15
X734 V3R199 sky130_fd_sc_hd__dfrtp_1_15/a_1283_21# VGND VGND sky130_fd_pr__nfet_01v8 ad=0.169 pd=1.82 as=0 ps=0 w=0.65 l=0.15
X735 sky130_fd_sc_hd__dfrtp_1_15/a_639_47# sky130_fd_sc_hd__dfrtp_1_15/a_193_47# sky130_fd_sc_hd__dfrtp_1_15/a_543_47# VGND sky130_fd_pr__special_nfet_01v8 ad=0 pd=0 as=0 ps=0 w=0.36 l=0.15
X736 VGND sky130_fd_sc_hd__dfrtp_1_15/a_1283_21# sky130_fd_sc_hd__dfrtp_1_15/a_1217_47# VGND sky130_fd_pr__nfet_01v8 ad=0 pd=0 as=0 ps=0 w=0.42 l=0.15
X737 sky130_fd_sc_hd__dfrtp_1_15/a_651_413# V3R303 VDPWR VDPWR sky130_fd_pr__pfet_01v8_hvt ad=0 pd=0 as=0 ps=0 w=0.42 l=0.15
X738 VGND V3R084 sky130_fd_sc_hd__dfrtp_1_15/a_27_47# VGND sky130_fd_pr__nfet_01v8 ad=0 pd=0 as=0.1092 ps=1.36 w=0.42 l=0.15
X739 sky130_fd_sc_hd__dfrtp_1_15/a_761_289# sky130_fd_sc_hd__dfrtp_1_15/a_543_47# VDPWR VDPWR sky130_fd_pr__pfet_01v8_hvt ad=0 pd=0 as=0 ps=0 w=0.84 l=0.15
X740 sky130_fd_sc_hd__dfrtp_1_26/a_805_47# sky130_fd_sc_hd__dfrtp_1_26/a_761_289# sky130_fd_sc_hd__dfrtp_1_26/a_639_47# VGND sky130_fd_pr__nfet_01v8 ad=0.0882 pd=1.26 as=0.2802 ps=2.2 w=0.42 l=0.15
X741 sky130_fd_sc_hd__dfrtp_1_26/a_1217_47# sky130_fd_sc_hd__dfrtp_1_26/a_27_47# sky130_fd_sc_hd__dfrtp_1_26/a_1108_47# VGND sky130_fd_pr__special_nfet_01v8 ad=0.1338 pd=1.5 as=0.1422 ps=1.51 w=0.36 l=0.15
X742 sky130_fd_sc_hd__dfrtp_1_26/a_1283_21# sky130_fd_sc_hd__dfrtp_1_26/a_1108_47# sky130_fd_sc_hd__dfrtp_1_26/a_1462_47# VGND sky130_fd_pr__nfet_01v8 ad=0.1092 pd=1.36 as=0.1281 ps=1.45 w=0.42 l=0.15
X743 sky130_fd_sc_hd__dfrtp_1_26/a_651_413# sky130_fd_sc_hd__dfrtp_1_26/a_27_47# sky130_fd_sc_hd__dfrtp_1_26/a_543_47# VDPWR sky130_fd_pr__pfet_01v8_hvt ad=0.3402 pd=3.3 as=0.1449 ps=1.53 w=0.42 l=0.15
X744 sky130_fd_sc_hd__dfrtp_1_26/a_1108_47# sky130_fd_sc_hd__dfrtp_1_26/a_193_47# sky130_fd_sc_hd__dfrtp_1_26/a_761_289# VGND sky130_fd_pr__special_nfet_01v8 ad=0 pd=0 as=0.1998 ps=1.97 w=0.36 l=0.15
X745 VGND V3R301 sky130_fd_sc_hd__dfrtp_1_26/a_805_47# VGND sky130_fd_pr__nfet_01v8 ad=0 pd=0 as=0 ps=0 w=0.42 l=0.15
X746 V3R028 sky130_fd_sc_hd__dfrtp_1_26/a_1283_21# VDPWR VDPWR sky130_fd_pr__pfet_01v8_hvt ad=0.26 pd=2.52 as=0 ps=0 w=1 l=0.15
X747 VDPWR V3R082 sky130_fd_sc_hd__dfrtp_1_26/a_27_47# VDPWR sky130_fd_pr__pfet_01v8_hvt ad=0 pd=0 as=0.1664 ps=1.8 w=0.64 l=0.15
X748 sky130_fd_sc_hd__dfrtp_1_26/a_448_47# V3R143 VDPWR VDPWR sky130_fd_pr__pfet_01v8_hvt ad=0.1302 pd=1.46 as=0 ps=0 w=0.42 l=0.15
X749 sky130_fd_sc_hd__dfrtp_1_26/a_761_289# sky130_fd_sc_hd__dfrtp_1_26/a_543_47# VGND VGND sky130_fd_pr__nfet_01v8 ad=0 pd=0 as=0 ps=0 w=0.64 l=0.15
X750 sky130_fd_sc_hd__dfrtp_1_26/a_193_47# sky130_fd_sc_hd__dfrtp_1_26/a_27_47# VGND VGND sky130_fd_pr__nfet_01v8 ad=0.1092 pd=1.36 as=0 ps=0 w=0.42 l=0.15
X751 sky130_fd_sc_hd__dfrtp_1_26/a_1108_47# sky130_fd_sc_hd__dfrtp_1_26/a_27_47# sky130_fd_sc_hd__dfrtp_1_26/a_761_289# VDPWR sky130_fd_pr__pfet_01v8_hvt ad=0.1176 pd=1.4 as=0.2583 ps=2.37 w=0.42 l=0.15
X752 sky130_fd_sc_hd__dfrtp_1_26/a_1462_47# V3R301 VGND VGND sky130_fd_pr__nfet_01v8 ad=0 pd=0 as=0 ps=0 w=0.42 l=0.15
X753 sky130_fd_sc_hd__dfrtp_1_26/a_543_47# sky130_fd_sc_hd__dfrtp_1_26/a_27_47# sky130_fd_sc_hd__dfrtp_1_26/a_448_47# VGND sky130_fd_pr__special_nfet_01v8 ad=0.1188 pd=1.38 as=0.132 ps=1.49 w=0.36 l=0.15
X754 sky130_fd_sc_hd__dfrtp_1_26/a_543_47# sky130_fd_sc_hd__dfrtp_1_26/a_193_47# sky130_fd_sc_hd__dfrtp_1_26/a_448_47# VDPWR sky130_fd_pr__pfet_01v8_hvt ad=0 pd=0 as=0 ps=0 w=0.42 l=0.15
X755 sky130_fd_sc_hd__dfrtp_1_26/a_448_47# V3R143 VGND VGND sky130_fd_pr__nfet_01v8 ad=0 pd=0 as=0 ps=0 w=0.42 l=0.15
X756 VDPWR sky130_fd_sc_hd__dfrtp_1_26/a_1283_21# sky130_fd_sc_hd__dfrtp_1_26/a_1270_413# VDPWR sky130_fd_pr__pfet_01v8_hvt ad=0 pd=0 as=0.1134 ps=1.38 w=0.42 l=0.15
X757 VDPWR sky130_fd_sc_hd__dfrtp_1_26/a_1108_47# sky130_fd_sc_hd__dfrtp_1_26/a_1283_21# VDPWR sky130_fd_pr__pfet_01v8_hvt ad=0 pd=0 as=0.1134 ps=1.38 w=0.42 l=0.15
X758 sky130_fd_sc_hd__dfrtp_1_26/a_1270_413# sky130_fd_sc_hd__dfrtp_1_26/a_193_47# sky130_fd_sc_hd__dfrtp_1_26/a_1108_47# VDPWR sky130_fd_pr__pfet_01v8_hvt ad=0 pd=0 as=0 ps=0 w=0.42 l=0.15
X759 sky130_fd_sc_hd__dfrtp_1_26/a_193_47# sky130_fd_sc_hd__dfrtp_1_26/a_27_47# VDPWR VDPWR sky130_fd_pr__pfet_01v8_hvt ad=0.1664 pd=1.8 as=0 ps=0 w=0.64 l=0.15
X760 sky130_fd_sc_hd__dfrtp_1_26/a_1283_21# V3R301 VDPWR VDPWR sky130_fd_pr__pfet_01v8_hvt ad=0 pd=0 as=0 ps=0 w=0.42 l=0.15
X761 VDPWR sky130_fd_sc_hd__dfrtp_1_26/a_761_289# sky130_fd_sc_hd__dfrtp_1_26/a_651_413# VDPWR sky130_fd_pr__pfet_01v8_hvt ad=0 pd=0 as=0 ps=0 w=0.42 l=0.15
X762 V3R028 sky130_fd_sc_hd__dfrtp_1_26/a_1283_21# VGND VGND sky130_fd_pr__nfet_01v8 ad=0.169 pd=1.82 as=0 ps=0 w=0.65 l=0.15
X763 sky130_fd_sc_hd__dfrtp_1_26/a_639_47# sky130_fd_sc_hd__dfrtp_1_26/a_193_47# sky130_fd_sc_hd__dfrtp_1_26/a_543_47# VGND sky130_fd_pr__special_nfet_01v8 ad=0 pd=0 as=0 ps=0 w=0.36 l=0.15
X764 VGND sky130_fd_sc_hd__dfrtp_1_26/a_1283_21# sky130_fd_sc_hd__dfrtp_1_26/a_1217_47# VGND sky130_fd_pr__nfet_01v8 ad=0 pd=0 as=0 ps=0 w=0.42 l=0.15
X765 sky130_fd_sc_hd__dfrtp_1_26/a_651_413# V3R301 VDPWR VDPWR sky130_fd_pr__pfet_01v8_hvt ad=0 pd=0 as=0 ps=0 w=0.42 l=0.15
X766 VGND V3R082 sky130_fd_sc_hd__dfrtp_1_26/a_27_47# VGND sky130_fd_pr__nfet_01v8 ad=0 pd=0 as=0.1092 ps=1.36 w=0.42 l=0.15
X767 sky130_fd_sc_hd__dfrtp_1_26/a_761_289# sky130_fd_sc_hd__dfrtp_1_26/a_543_47# VDPWR VDPWR sky130_fd_pr__pfet_01v8_hvt ad=0 pd=0 as=0 ps=0 w=0.84 l=0.15
X768 sky130_fd_sc_hd__dfrtp_1_37/a_805_47# sky130_fd_sc_hd__dfrtp_1_37/a_761_289# sky130_fd_sc_hd__dfrtp_1_37/a_639_47# VGND sky130_fd_pr__nfet_01v8 ad=0.0882 pd=1.26 as=0.2802 ps=2.2 w=0.42 l=0.15
X769 sky130_fd_sc_hd__dfrtp_1_37/a_1217_47# sky130_fd_sc_hd__dfrtp_1_37/a_27_47# sky130_fd_sc_hd__dfrtp_1_37/a_1108_47# VGND sky130_fd_pr__special_nfet_01v8 ad=0.1338 pd=1.5 as=0.1422 ps=1.51 w=0.36 l=0.15
X770 sky130_fd_sc_hd__dfrtp_1_37/a_1283_21# sky130_fd_sc_hd__dfrtp_1_37/a_1108_47# sky130_fd_sc_hd__dfrtp_1_37/a_1462_47# VGND sky130_fd_pr__nfet_01v8 ad=0.1092 pd=1.36 as=0.1281 ps=1.45 w=0.42 l=0.15
X771 sky130_fd_sc_hd__dfrtp_1_37/a_651_413# sky130_fd_sc_hd__dfrtp_1_37/a_27_47# sky130_fd_sc_hd__dfrtp_1_37/a_543_47# VDPWR sky130_fd_pr__pfet_01v8_hvt ad=0.3402 pd=3.3 as=0.1449 ps=1.53 w=0.42 l=0.15
X772 sky130_fd_sc_hd__dfrtp_1_37/a_1108_47# sky130_fd_sc_hd__dfrtp_1_37/a_193_47# sky130_fd_sc_hd__dfrtp_1_37/a_761_289# VGND sky130_fd_pr__special_nfet_01v8 ad=0 pd=0 as=0.1998 ps=1.97 w=0.36 l=0.15
X773 VGND V3R299 sky130_fd_sc_hd__dfrtp_1_37/a_805_47# VGND sky130_fd_pr__nfet_01v8 ad=0 pd=0 as=0 ps=0 w=0.42 l=0.15
X774 V3R162 sky130_fd_sc_hd__dfrtp_1_37/a_1283_21# VDPWR VDPWR sky130_fd_pr__pfet_01v8_hvt ad=0.26 pd=2.52 as=0 ps=0 w=1 l=0.15
X775 VDPWR V3R056 sky130_fd_sc_hd__dfrtp_1_37/a_27_47# VDPWR sky130_fd_pr__pfet_01v8_hvt ad=0 pd=0 as=0.1664 ps=1.8 w=0.64 l=0.15
X776 sky130_fd_sc_hd__dfrtp_1_37/a_448_47# V3R106 VDPWR VDPWR sky130_fd_pr__pfet_01v8_hvt ad=0.1302 pd=1.46 as=0 ps=0 w=0.42 l=0.15
X777 sky130_fd_sc_hd__dfrtp_1_37/a_761_289# sky130_fd_sc_hd__dfrtp_1_37/a_543_47# VGND VGND sky130_fd_pr__nfet_01v8 ad=0 pd=0 as=0 ps=0 w=0.64 l=0.15
X778 sky130_fd_sc_hd__dfrtp_1_37/a_193_47# sky130_fd_sc_hd__dfrtp_1_37/a_27_47# VGND VGND sky130_fd_pr__nfet_01v8 ad=0.1092 pd=1.36 as=0 ps=0 w=0.42 l=0.15
X779 sky130_fd_sc_hd__dfrtp_1_37/a_1108_47# sky130_fd_sc_hd__dfrtp_1_37/a_27_47# sky130_fd_sc_hd__dfrtp_1_37/a_761_289# VDPWR sky130_fd_pr__pfet_01v8_hvt ad=0.1176 pd=1.4 as=0.2583 ps=2.37 w=0.42 l=0.15
X780 sky130_fd_sc_hd__dfrtp_1_37/a_1462_47# V3R299 VGND VGND sky130_fd_pr__nfet_01v8 ad=0 pd=0 as=0 ps=0 w=0.42 l=0.15
X781 sky130_fd_sc_hd__dfrtp_1_37/a_543_47# sky130_fd_sc_hd__dfrtp_1_37/a_27_47# sky130_fd_sc_hd__dfrtp_1_37/a_448_47# VGND sky130_fd_pr__special_nfet_01v8 ad=0.1188 pd=1.38 as=0.132 ps=1.49 w=0.36 l=0.15
X782 sky130_fd_sc_hd__dfrtp_1_37/a_543_47# sky130_fd_sc_hd__dfrtp_1_37/a_193_47# sky130_fd_sc_hd__dfrtp_1_37/a_448_47# VDPWR sky130_fd_pr__pfet_01v8_hvt ad=0 pd=0 as=0 ps=0 w=0.42 l=0.15
X783 sky130_fd_sc_hd__dfrtp_1_37/a_448_47# V3R106 VGND VGND sky130_fd_pr__nfet_01v8 ad=0 pd=0 as=0 ps=0 w=0.42 l=0.15
X784 VDPWR sky130_fd_sc_hd__dfrtp_1_37/a_1283_21# sky130_fd_sc_hd__dfrtp_1_37/a_1270_413# VDPWR sky130_fd_pr__pfet_01v8_hvt ad=0 pd=0 as=0.1134 ps=1.38 w=0.42 l=0.15
X785 VDPWR sky130_fd_sc_hd__dfrtp_1_37/a_1108_47# sky130_fd_sc_hd__dfrtp_1_37/a_1283_21# VDPWR sky130_fd_pr__pfet_01v8_hvt ad=0 pd=0 as=0.1134 ps=1.38 w=0.42 l=0.15
X786 sky130_fd_sc_hd__dfrtp_1_37/a_1270_413# sky130_fd_sc_hd__dfrtp_1_37/a_193_47# sky130_fd_sc_hd__dfrtp_1_37/a_1108_47# VDPWR sky130_fd_pr__pfet_01v8_hvt ad=0 pd=0 as=0 ps=0 w=0.42 l=0.15
X787 sky130_fd_sc_hd__dfrtp_1_37/a_193_47# sky130_fd_sc_hd__dfrtp_1_37/a_27_47# VDPWR VDPWR sky130_fd_pr__pfet_01v8_hvt ad=0.1664 pd=1.8 as=0 ps=0 w=0.64 l=0.15
X788 sky130_fd_sc_hd__dfrtp_1_37/a_1283_21# V3R299 VDPWR VDPWR sky130_fd_pr__pfet_01v8_hvt ad=0 pd=0 as=0 ps=0 w=0.42 l=0.15
X789 VDPWR sky130_fd_sc_hd__dfrtp_1_37/a_761_289# sky130_fd_sc_hd__dfrtp_1_37/a_651_413# VDPWR sky130_fd_pr__pfet_01v8_hvt ad=0 pd=0 as=0 ps=0 w=0.42 l=0.15
X790 V3R162 sky130_fd_sc_hd__dfrtp_1_37/a_1283_21# VGND VGND sky130_fd_pr__nfet_01v8 ad=0.169 pd=1.82 as=0 ps=0 w=0.65 l=0.15
X791 sky130_fd_sc_hd__dfrtp_1_37/a_639_47# sky130_fd_sc_hd__dfrtp_1_37/a_193_47# sky130_fd_sc_hd__dfrtp_1_37/a_543_47# VGND sky130_fd_pr__special_nfet_01v8 ad=0 pd=0 as=0 ps=0 w=0.36 l=0.15
X792 VGND sky130_fd_sc_hd__dfrtp_1_37/a_1283_21# sky130_fd_sc_hd__dfrtp_1_37/a_1217_47# VGND sky130_fd_pr__nfet_01v8 ad=0 pd=0 as=0 ps=0 w=0.42 l=0.15
X793 sky130_fd_sc_hd__dfrtp_1_37/a_651_413# V3R299 VDPWR VDPWR sky130_fd_pr__pfet_01v8_hvt ad=0 pd=0 as=0 ps=0 w=0.42 l=0.15
X794 VGND V3R056 sky130_fd_sc_hd__dfrtp_1_37/a_27_47# VGND sky130_fd_pr__nfet_01v8 ad=0 pd=0 as=0.1092 ps=1.36 w=0.42 l=0.15
X795 sky130_fd_sc_hd__dfrtp_1_37/a_761_289# sky130_fd_sc_hd__dfrtp_1_37/a_543_47# VDPWR VDPWR sky130_fd_pr__pfet_01v8_hvt ad=0 pd=0 as=0 ps=0 w=0.84 l=0.15
X796 sky130_fd_sc_hd__dfrtp_1_59/a_805_47# sky130_fd_sc_hd__dfrtp_1_59/a_761_289# sky130_fd_sc_hd__dfrtp_1_59/a_639_47# VGND sky130_fd_pr__nfet_01v8 ad=0.0882 pd=1.26 as=0.2802 ps=2.2 w=0.42 l=0.15
X797 sky130_fd_sc_hd__dfrtp_1_59/a_1217_47# sky130_fd_sc_hd__dfrtp_1_59/a_27_47# sky130_fd_sc_hd__dfrtp_1_59/a_1108_47# VGND sky130_fd_pr__special_nfet_01v8 ad=0.1338 pd=1.5 as=0.1422 ps=1.51 w=0.36 l=0.15
X798 sky130_fd_sc_hd__dfrtp_1_59/a_1283_21# sky130_fd_sc_hd__dfrtp_1_59/a_1108_47# sky130_fd_sc_hd__dfrtp_1_59/a_1462_47# VGND sky130_fd_pr__nfet_01v8 ad=0.1092 pd=1.36 as=0.1281 ps=1.45 w=0.42 l=0.15
X799 sky130_fd_sc_hd__dfrtp_1_59/a_651_413# sky130_fd_sc_hd__dfrtp_1_59/a_27_47# sky130_fd_sc_hd__dfrtp_1_59/a_543_47# VDPWR sky130_fd_pr__pfet_01v8_hvt ad=0.3402 pd=3.3 as=0.1449 ps=1.53 w=0.42 l=0.15
X800 sky130_fd_sc_hd__dfrtp_1_59/a_1108_47# sky130_fd_sc_hd__dfrtp_1_59/a_193_47# sky130_fd_sc_hd__dfrtp_1_59/a_761_289# VGND sky130_fd_pr__special_nfet_01v8 ad=0 pd=0 as=0.1998 ps=1.97 w=0.36 l=0.15
X801 VGND V3R302 sky130_fd_sc_hd__dfrtp_1_59/a_805_47# VGND sky130_fd_pr__nfet_01v8 ad=0 pd=0 as=0 ps=0 w=0.42 l=0.15
X802 V3R000 sky130_fd_sc_hd__dfrtp_1_59/a_1283_21# VDPWR VDPWR sky130_fd_pr__pfet_01v8_hvt ad=0.26 pd=2.52 as=0 ps=0 w=1 l=0.15
X803 VDPWR V3R083 sky130_fd_sc_hd__dfrtp_1_59/a_27_47# VDPWR sky130_fd_pr__pfet_01v8_hvt ad=0 pd=0 as=0.1664 ps=1.8 w=0.64 l=0.15
X804 sky130_fd_sc_hd__dfrtp_1_59/a_448_47# V3R183 VDPWR VDPWR sky130_fd_pr__pfet_01v8_hvt ad=0.1302 pd=1.46 as=0 ps=0 w=0.42 l=0.15
X805 sky130_fd_sc_hd__dfrtp_1_59/a_761_289# sky130_fd_sc_hd__dfrtp_1_59/a_543_47# VGND VGND sky130_fd_pr__nfet_01v8 ad=0 pd=0 as=0 ps=0 w=0.64 l=0.15
X806 sky130_fd_sc_hd__dfrtp_1_59/a_193_47# sky130_fd_sc_hd__dfrtp_1_59/a_27_47# VGND VGND sky130_fd_pr__nfet_01v8 ad=0.1092 pd=1.36 as=0 ps=0 w=0.42 l=0.15
X807 sky130_fd_sc_hd__dfrtp_1_59/a_1108_47# sky130_fd_sc_hd__dfrtp_1_59/a_27_47# sky130_fd_sc_hd__dfrtp_1_59/a_761_289# VDPWR sky130_fd_pr__pfet_01v8_hvt ad=0.1176 pd=1.4 as=0.2583 ps=2.37 w=0.42 l=0.15
X808 sky130_fd_sc_hd__dfrtp_1_59/a_1462_47# V3R302 VGND VGND sky130_fd_pr__nfet_01v8 ad=0 pd=0 as=0 ps=0 w=0.42 l=0.15
X809 sky130_fd_sc_hd__dfrtp_1_59/a_543_47# sky130_fd_sc_hd__dfrtp_1_59/a_27_47# sky130_fd_sc_hd__dfrtp_1_59/a_448_47# VGND sky130_fd_pr__special_nfet_01v8 ad=0.1188 pd=1.38 as=0.132 ps=1.49 w=0.36 l=0.15
X810 sky130_fd_sc_hd__dfrtp_1_59/a_543_47# sky130_fd_sc_hd__dfrtp_1_59/a_193_47# sky130_fd_sc_hd__dfrtp_1_59/a_448_47# VDPWR sky130_fd_pr__pfet_01v8_hvt ad=0 pd=0 as=0 ps=0 w=0.42 l=0.15
X811 sky130_fd_sc_hd__dfrtp_1_59/a_448_47# V3R183 VGND VGND sky130_fd_pr__nfet_01v8 ad=0 pd=0 as=0 ps=0 w=0.42 l=0.15
X812 VDPWR sky130_fd_sc_hd__dfrtp_1_59/a_1283_21# sky130_fd_sc_hd__dfrtp_1_59/a_1270_413# VDPWR sky130_fd_pr__pfet_01v8_hvt ad=0 pd=0 as=0.1134 ps=1.38 w=0.42 l=0.15
X813 VDPWR sky130_fd_sc_hd__dfrtp_1_59/a_1108_47# sky130_fd_sc_hd__dfrtp_1_59/a_1283_21# VDPWR sky130_fd_pr__pfet_01v8_hvt ad=0 pd=0 as=0.1134 ps=1.38 w=0.42 l=0.15
X814 sky130_fd_sc_hd__dfrtp_1_59/a_1270_413# sky130_fd_sc_hd__dfrtp_1_59/a_193_47# sky130_fd_sc_hd__dfrtp_1_59/a_1108_47# VDPWR sky130_fd_pr__pfet_01v8_hvt ad=0 pd=0 as=0 ps=0 w=0.42 l=0.15
X815 sky130_fd_sc_hd__dfrtp_1_59/a_193_47# sky130_fd_sc_hd__dfrtp_1_59/a_27_47# VDPWR VDPWR sky130_fd_pr__pfet_01v8_hvt ad=0.1664 pd=1.8 as=0 ps=0 w=0.64 l=0.15
X816 sky130_fd_sc_hd__dfrtp_1_59/a_1283_21# V3R302 VDPWR VDPWR sky130_fd_pr__pfet_01v8_hvt ad=0 pd=0 as=0 ps=0 w=0.42 l=0.15
X817 VDPWR sky130_fd_sc_hd__dfrtp_1_59/a_761_289# sky130_fd_sc_hd__dfrtp_1_59/a_651_413# VDPWR sky130_fd_pr__pfet_01v8_hvt ad=0 pd=0 as=0 ps=0 w=0.42 l=0.15
X818 V3R000 sky130_fd_sc_hd__dfrtp_1_59/a_1283_21# VGND VGND sky130_fd_pr__nfet_01v8 ad=0.169 pd=1.82 as=0 ps=0 w=0.65 l=0.15
X819 sky130_fd_sc_hd__dfrtp_1_59/a_639_47# sky130_fd_sc_hd__dfrtp_1_59/a_193_47# sky130_fd_sc_hd__dfrtp_1_59/a_543_47# VGND sky130_fd_pr__special_nfet_01v8 ad=0 pd=0 as=0 ps=0 w=0.36 l=0.15
X820 VGND sky130_fd_sc_hd__dfrtp_1_59/a_1283_21# sky130_fd_sc_hd__dfrtp_1_59/a_1217_47# VGND sky130_fd_pr__nfet_01v8 ad=0 pd=0 as=0 ps=0 w=0.42 l=0.15
X821 sky130_fd_sc_hd__dfrtp_1_59/a_651_413# V3R302 VDPWR VDPWR sky130_fd_pr__pfet_01v8_hvt ad=0 pd=0 as=0 ps=0 w=0.42 l=0.15
X822 VGND V3R083 sky130_fd_sc_hd__dfrtp_1_59/a_27_47# VGND sky130_fd_pr__nfet_01v8 ad=0 pd=0 as=0.1092 ps=1.36 w=0.42 l=0.15
X823 sky130_fd_sc_hd__dfrtp_1_59/a_761_289# sky130_fd_sc_hd__dfrtp_1_59/a_543_47# VDPWR VDPWR sky130_fd_pr__pfet_01v8_hvt ad=0 pd=0 as=0 ps=0 w=0.84 l=0.15
X824 sky130_fd_sc_hd__dfrtp_1_48/a_805_47# sky130_fd_sc_hd__dfrtp_1_48/a_761_289# sky130_fd_sc_hd__dfrtp_1_48/a_639_47# VGND sky130_fd_pr__nfet_01v8 ad=0.0882 pd=1.26 as=0.2802 ps=2.2 w=0.42 l=0.15
X825 sky130_fd_sc_hd__dfrtp_1_48/a_1217_47# sky130_fd_sc_hd__dfrtp_1_48/a_27_47# sky130_fd_sc_hd__dfrtp_1_48/a_1108_47# VGND sky130_fd_pr__special_nfet_01v8 ad=0.1338 pd=1.5 as=0.1422 ps=1.51 w=0.36 l=0.15
X826 sky130_fd_sc_hd__dfrtp_1_48/a_1283_21# sky130_fd_sc_hd__dfrtp_1_48/a_1108_47# sky130_fd_sc_hd__dfrtp_1_48/a_1462_47# VGND sky130_fd_pr__nfet_01v8 ad=0.1092 pd=1.36 as=0.1281 ps=1.45 w=0.42 l=0.15
X827 sky130_fd_sc_hd__dfrtp_1_48/a_651_413# sky130_fd_sc_hd__dfrtp_1_48/a_27_47# sky130_fd_sc_hd__dfrtp_1_48/a_543_47# VDPWR sky130_fd_pr__pfet_01v8_hvt ad=0.3402 pd=3.3 as=0.1449 ps=1.53 w=0.42 l=0.15
X828 sky130_fd_sc_hd__dfrtp_1_48/a_1108_47# sky130_fd_sc_hd__dfrtp_1_48/a_193_47# sky130_fd_sc_hd__dfrtp_1_48/a_761_289# VGND sky130_fd_pr__special_nfet_01v8 ad=0 pd=0 as=0.1998 ps=1.97 w=0.36 l=0.15
X829 VGND V3R304 sky130_fd_sc_hd__dfrtp_1_48/a_805_47# VGND sky130_fd_pr__nfet_01v8 ad=0 pd=0 as=0 ps=0 w=0.42 l=0.15
X830 V3R292 sky130_fd_sc_hd__dfrtp_1_48/a_1283_21# VDPWR VDPWR sky130_fd_pr__pfet_01v8_hvt ad=0.26 pd=2.52 as=0 ps=0 w=1 l=0.15
X831 VDPWR V3R085 sky130_fd_sc_hd__dfrtp_1_48/a_27_47# VDPWR sky130_fd_pr__pfet_01v8_hvt ad=0 pd=0 as=0.1664 ps=1.8 w=0.64 l=0.15
X832 sky130_fd_sc_hd__dfrtp_1_48/a_448_47# V3R294 VDPWR VDPWR sky130_fd_pr__pfet_01v8_hvt ad=0.1302 pd=1.46 as=0 ps=0 w=0.42 l=0.15
X833 sky130_fd_sc_hd__dfrtp_1_48/a_761_289# sky130_fd_sc_hd__dfrtp_1_48/a_543_47# VGND VGND sky130_fd_pr__nfet_01v8 ad=0 pd=0 as=0 ps=0 w=0.64 l=0.15
X834 sky130_fd_sc_hd__dfrtp_1_48/a_193_47# sky130_fd_sc_hd__dfrtp_1_48/a_27_47# VGND VGND sky130_fd_pr__nfet_01v8 ad=0.1092 pd=1.36 as=0 ps=0 w=0.42 l=0.15
X835 sky130_fd_sc_hd__dfrtp_1_48/a_1108_47# sky130_fd_sc_hd__dfrtp_1_48/a_27_47# sky130_fd_sc_hd__dfrtp_1_48/a_761_289# VDPWR sky130_fd_pr__pfet_01v8_hvt ad=0.1176 pd=1.4 as=0.2583 ps=2.37 w=0.42 l=0.15
X836 sky130_fd_sc_hd__dfrtp_1_48/a_1462_47# V3R304 VGND VGND sky130_fd_pr__nfet_01v8 ad=0 pd=0 as=0 ps=0 w=0.42 l=0.15
X837 sky130_fd_sc_hd__dfrtp_1_48/a_543_47# sky130_fd_sc_hd__dfrtp_1_48/a_27_47# sky130_fd_sc_hd__dfrtp_1_48/a_448_47# VGND sky130_fd_pr__special_nfet_01v8 ad=0.1188 pd=1.38 as=0.132 ps=1.49 w=0.36 l=0.15
X838 sky130_fd_sc_hd__dfrtp_1_48/a_543_47# sky130_fd_sc_hd__dfrtp_1_48/a_193_47# sky130_fd_sc_hd__dfrtp_1_48/a_448_47# VDPWR sky130_fd_pr__pfet_01v8_hvt ad=0 pd=0 as=0 ps=0 w=0.42 l=0.15
X839 sky130_fd_sc_hd__dfrtp_1_48/a_448_47# V3R294 VGND VGND sky130_fd_pr__nfet_01v8 ad=0 pd=0 as=0 ps=0 w=0.42 l=0.15
X840 VDPWR sky130_fd_sc_hd__dfrtp_1_48/a_1283_21# sky130_fd_sc_hd__dfrtp_1_48/a_1270_413# VDPWR sky130_fd_pr__pfet_01v8_hvt ad=0 pd=0 as=0.1134 ps=1.38 w=0.42 l=0.15
X841 VDPWR sky130_fd_sc_hd__dfrtp_1_48/a_1108_47# sky130_fd_sc_hd__dfrtp_1_48/a_1283_21# VDPWR sky130_fd_pr__pfet_01v8_hvt ad=0 pd=0 as=0.1134 ps=1.38 w=0.42 l=0.15
X842 sky130_fd_sc_hd__dfrtp_1_48/a_1270_413# sky130_fd_sc_hd__dfrtp_1_48/a_193_47# sky130_fd_sc_hd__dfrtp_1_48/a_1108_47# VDPWR sky130_fd_pr__pfet_01v8_hvt ad=0 pd=0 as=0 ps=0 w=0.42 l=0.15
X843 sky130_fd_sc_hd__dfrtp_1_48/a_193_47# sky130_fd_sc_hd__dfrtp_1_48/a_27_47# VDPWR VDPWR sky130_fd_pr__pfet_01v8_hvt ad=0.1664 pd=1.8 as=0 ps=0 w=0.64 l=0.15
X844 sky130_fd_sc_hd__dfrtp_1_48/a_1283_21# V3R304 VDPWR VDPWR sky130_fd_pr__pfet_01v8_hvt ad=0 pd=0 as=0 ps=0 w=0.42 l=0.15
X845 VDPWR sky130_fd_sc_hd__dfrtp_1_48/a_761_289# sky130_fd_sc_hd__dfrtp_1_48/a_651_413# VDPWR sky130_fd_pr__pfet_01v8_hvt ad=0 pd=0 as=0 ps=0 w=0.42 l=0.15
X846 V3R292 sky130_fd_sc_hd__dfrtp_1_48/a_1283_21# VGND VGND sky130_fd_pr__nfet_01v8 ad=0.169 pd=1.82 as=0 ps=0 w=0.65 l=0.15
X847 sky130_fd_sc_hd__dfrtp_1_48/a_639_47# sky130_fd_sc_hd__dfrtp_1_48/a_193_47# sky130_fd_sc_hd__dfrtp_1_48/a_543_47# VGND sky130_fd_pr__special_nfet_01v8 ad=0 pd=0 as=0 ps=0 w=0.36 l=0.15
X848 VGND sky130_fd_sc_hd__dfrtp_1_48/a_1283_21# sky130_fd_sc_hd__dfrtp_1_48/a_1217_47# VGND sky130_fd_pr__nfet_01v8 ad=0 pd=0 as=0 ps=0 w=0.42 l=0.15
X849 sky130_fd_sc_hd__dfrtp_1_48/a_651_413# V3R304 VDPWR VDPWR sky130_fd_pr__pfet_01v8_hvt ad=0 pd=0 as=0 ps=0 w=0.42 l=0.15
X850 VGND V3R085 sky130_fd_sc_hd__dfrtp_1_48/a_27_47# VGND sky130_fd_pr__nfet_01v8 ad=0 pd=0 as=0.1092 ps=1.36 w=0.42 l=0.15
X851 sky130_fd_sc_hd__dfrtp_1_48/a_761_289# sky130_fd_sc_hd__dfrtp_1_48/a_543_47# VDPWR VDPWR sky130_fd_pr__pfet_01v8_hvt ad=0 pd=0 as=0 ps=0 w=0.84 l=0.15
X852 VGND sky130_fd_sc_hd__dfstp_1_1/a_652_21# sky130_fd_sc_hd__dfstp_1_1/a_586_47# VGND sky130_fd_pr__nfet_01v8 ad=0 pd=0 as=0.1341 ps=1.5 w=0.42 l=0.15
X853 sky130_fd_sc_hd__dfstp_1_1/a_956_413# sky130_fd_sc_hd__dfstp_1_1/a_476_47# VDPWR VDPWR sky130_fd_pr__pfet_01v8_hvt ad=0.0966 pd=1.3 as=0 ps=0 w=0.42 l=0.15
X854 VDPWR sky130_fd_sc_hd__dfstp_1_1/a_476_47# sky130_fd_sc_hd__dfstp_1_1/a_652_21# VDPWR sky130_fd_pr__pfet_01v8_hvt ad=0 pd=0 as=0.1134 ps=1.38 w=0.42 l=0.15
X855 VDPWR V3R082 sky130_fd_sc_hd__dfstp_1_1/a_27_47# VDPWR sky130_fd_pr__pfet_01v8_hvt ad=0 pd=0 as=0.1664 ps=1.8 w=0.64 l=0.15
X856 sky130_fd_sc_hd__dfstp_1_1/a_586_47# sky130_fd_sc_hd__dfstp_1_1/a_193_47# sky130_fd_sc_hd__dfstp_1_1/a_476_47# VGND sky130_fd_pr__special_nfet_01v8 ad=0 pd=0 as=0.144 ps=1.52 w=0.36 l=0.15
X857 sky130_fd_sc_hd__dfstp_1_1/a_1056_47# sky130_fd_sc_hd__dfstp_1_1/a_476_47# VGND VGND sky130_fd_pr__nfet_01v8 ad=0.0882 pd=1.26 as=0 ps=0 w=0.42 l=0.15
X858 sky130_fd_sc_hd__dfstp_1_1/a_476_47# sky130_fd_sc_hd__dfstp_1_1/a_27_47# sky130_fd_sc_hd__dfstp_1_1/a_381_47# VGND sky130_fd_pr__special_nfet_01v8 ad=0 pd=0 as=0.187 ps=1.93 w=0.36 l=0.15
X859 sky130_fd_sc_hd__dfstp_1_1/a_381_47# V3R145 VDPWR VDPWR sky130_fd_pr__pfet_01v8_hvt ad=0.2499 pd=2.35 as=0 ps=0 w=0.84 l=0.15
X860 sky130_fd_sc_hd__dfstp_1_1/a_652_21# V3R301 VDPWR VDPWR sky130_fd_pr__pfet_01v8_hvt ad=0 pd=0 as=0 ps=0 w=0.42 l=0.15
X861 sky130_fd_sc_hd__dfstp_1_1/a_1224_47# sky130_fd_sc_hd__dfstp_1_1/a_27_47# sky130_fd_sc_hd__dfstp_1_1/a_1032_413# VGND sky130_fd_pr__nfet_01v8 ad=0.0882 pd=1.26 as=0.1386 ps=1.5 w=0.42 l=0.15
X862 sky130_fd_sc_hd__dfstp_1_1/a_562_413# sky130_fd_sc_hd__dfstp_1_1/a_27_47# sky130_fd_sc_hd__dfstp_1_1/a_476_47# VDPWR sky130_fd_pr__pfet_01v8_hvt ad=0.189 pd=1.74 as=0.1134 ps=1.38 w=0.42 l=0.15
X863 VGND sky130_fd_sc_hd__dfstp_1_1/a_1032_413# sky130_fd_sc_hd__dfstp_1_1/a_1602_47# VGND sky130_fd_pr__nfet_01v8 ad=0 pd=0 as=0.1092 ps=1.36 w=0.42 l=0.15
X864 VDPWR sky130_fd_sc_hd__dfstp_1_1/a_1182_261# sky130_fd_sc_hd__dfstp_1_1/a_1140_413# VDPWR sky130_fd_pr__pfet_01v8_hvt ad=0 pd=0 as=0.0882 ps=1.26 w=0.42 l=0.15
X865 V3R030 sky130_fd_sc_hd__dfstp_1_1/a_1602_47# VDPWR VDPWR sky130_fd_pr__pfet_01v8_hvt ad=0.26 pd=2.52 as=0 ps=0 w=1 l=0.15
X866 sky130_fd_sc_hd__dfstp_1_1/a_1032_413# sky130_fd_sc_hd__dfstp_1_1/a_193_47# sky130_fd_sc_hd__dfstp_1_1/a_1056_47# VGND sky130_fd_pr__nfet_01v8 ad=0 pd=0 as=0 ps=0 w=0.42 l=0.15
X867 sky130_fd_sc_hd__dfstp_1_1/a_476_47# sky130_fd_sc_hd__dfstp_1_1/a_193_47# sky130_fd_sc_hd__dfstp_1_1/a_381_47# VDPWR sky130_fd_pr__pfet_01v8_hvt ad=0 pd=0 as=0 ps=0 w=0.42 l=0.15
X868 sky130_fd_sc_hd__dfstp_1_1/a_1296_47# sky130_fd_sc_hd__dfstp_1_1/a_1182_261# sky130_fd_sc_hd__dfstp_1_1/a_1224_47# VGND sky130_fd_pr__nfet_01v8 ad=0.0966 pd=1.3 as=0 ps=0 w=0.42 l=0.15
X869 sky130_fd_sc_hd__dfstp_1_1/a_193_47# sky130_fd_sc_hd__dfstp_1_1/a_27_47# VGND VGND sky130_fd_pr__nfet_01v8 ad=0.1092 pd=1.36 as=0 ps=0 w=0.42 l=0.15
X870 VDPWR sky130_fd_sc_hd__dfstp_1_1/a_652_21# sky130_fd_sc_hd__dfstp_1_1/a_562_413# VDPWR sky130_fd_pr__pfet_01v8_hvt ad=0 pd=0 as=0 ps=0 w=0.42 l=0.15
X871 VDPWR V3R301 sky130_fd_sc_hd__dfstp_1_1/a_1032_413# VDPWR sky130_fd_pr__pfet_01v8_hvt ad=0 pd=0 as=0.273 ps=2.98 w=0.42 l=0.15
X872 sky130_fd_sc_hd__dfstp_1_1/a_1032_413# sky130_fd_sc_hd__dfstp_1_1/a_27_47# sky130_fd_sc_hd__dfstp_1_1/a_956_413# VDPWR sky130_fd_pr__pfet_01v8_hvt ad=0 pd=0 as=0 ps=0 w=0.42 l=0.15
X873 sky130_fd_sc_hd__dfstp_1_1/a_1182_261# sky130_fd_sc_hd__dfstp_1_1/a_1032_413# VDPWR VDPWR sky130_fd_pr__pfet_01v8_hvt ad=0.2184 pd=2.2 as=0 ps=0 w=0.84 l=0.15
X874 V3R030 sky130_fd_sc_hd__dfstp_1_1/a_1602_47# VGND VGND sky130_fd_pr__nfet_01v8 ad=0.169 pd=1.82 as=0 ps=0 w=0.65 l=0.15
X875 sky130_fd_sc_hd__dfstp_1_1/a_193_47# sky130_fd_sc_hd__dfstp_1_1/a_27_47# VDPWR VDPWR sky130_fd_pr__pfet_01v8_hvt ad=0.1664 pd=1.8 as=0 ps=0 w=0.64 l=0.15
X876 sky130_fd_sc_hd__dfstp_1_1/a_1140_413# sky130_fd_sc_hd__dfstp_1_1/a_193_47# sky130_fd_sc_hd__dfstp_1_1/a_1032_413# VDPWR sky130_fd_pr__pfet_01v8_hvt ad=0 pd=0 as=0 ps=0 w=0.42 l=0.15
X877 VDPWR sky130_fd_sc_hd__dfstp_1_1/a_1032_413# sky130_fd_sc_hd__dfstp_1_1/a_1602_47# VDPWR sky130_fd_pr__pfet_01v8_hvt ad=0 pd=0 as=0.1664 ps=1.8 w=0.64 l=0.15
X878 sky130_fd_sc_hd__dfstp_1_1/a_796_47# V3R301 VGND VGND sky130_fd_pr__nfet_01v8 ad=0.0882 pd=1.26 as=0 ps=0 w=0.42 l=0.15
X879 sky130_fd_sc_hd__dfstp_1_1/a_381_47# V3R145 VGND VGND sky130_fd_pr__nfet_01v8 ad=0 pd=0 as=0 ps=0 w=0.64 l=0.15
X880 sky130_fd_sc_hd__dfstp_1_1/a_1182_261# sky130_fd_sc_hd__dfstp_1_1/a_1032_413# VGND VGND sky130_fd_pr__nfet_01v8 ad=0.1404 pd=1.6 as=0 ps=0 w=0.54 l=0.15
X881 sky130_fd_sc_hd__dfstp_1_1/a_652_21# sky130_fd_sc_hd__dfstp_1_1/a_476_47# sky130_fd_sc_hd__dfstp_1_1/a_796_47# VGND sky130_fd_pr__nfet_01v8 ad=0.1092 pd=1.36 as=0 ps=0 w=0.42 l=0.15
X882 VGND V3R082 sky130_fd_sc_hd__dfstp_1_1/a_27_47# VGND sky130_fd_pr__nfet_01v8 ad=0 pd=0 as=0.1092 ps=1.36 w=0.42 l=0.15
X883 VGND V3R301 sky130_fd_sc_hd__dfstp_1_1/a_1296_47# VGND sky130_fd_pr__nfet_01v8 ad=0 pd=0 as=0 ps=0 w=0.42 l=0.15
X884 V3R273 sky130_fd_sc_hd__xor2_1_6/a_35_297# sky130_fd_sc_hd__xor2_1_6/a_285_297# VDPWR sky130_fd_pr__pfet_01v8_hvt ad=0.3 pd=2.6 as=0.53 ps=5.06 w=1 l=0.15
X885 V3R273 V3R002 sky130_fd_sc_hd__xor2_1_6/a_285_47# VGND sky130_fd_pr__nfet_01v8 ad=0.5005 pd=2.84 as=0.1755 ps=1.84 w=0.65 l=0.15
X886 sky130_fd_sc_hd__xor2_1_6/a_35_297# V3R002 VGND VGND sky130_fd_pr__nfet_01v8 ad=0.1755 pd=1.84 as=0 ps=0 w=0.65 l=0.15
X887 sky130_fd_sc_hd__xor2_1_6/a_117_297# V3R002 sky130_fd_sc_hd__xor2_1_6/a_35_297# VDPWR sky130_fd_pr__pfet_01v8_hvt ad=0.27 pd=2.54 as=0.26 ps=2.52 w=1 l=0.15
X888 VDPWR V3R002 sky130_fd_sc_hd__xor2_1_6/a_285_297# VDPWR sky130_fd_pr__pfet_01v8_hvt ad=0 pd=0 as=0 ps=0 w=1 l=0.15
X889 VGND V3R052 sky130_fd_sc_hd__xor2_1_6/a_35_297# VGND sky130_fd_pr__nfet_01v8 ad=0 pd=0 as=0 ps=0 w=0.65 l=0.15
X890 VGND sky130_fd_sc_hd__xor2_1_6/a_35_297# V3R273 VGND sky130_fd_pr__nfet_01v8 ad=0 pd=0 as=0 ps=0 w=0.65 l=0.15
X891 sky130_fd_sc_hd__xor2_1_6/a_285_297# V3R052 VDPWR VDPWR sky130_fd_pr__pfet_01v8_hvt ad=0 pd=0 as=0 ps=0 w=1 l=0.15
X892 VDPWR V3R052 sky130_fd_sc_hd__xor2_1_6/a_117_297# VDPWR sky130_fd_pr__pfet_01v8_hvt ad=0 pd=0 as=0 ps=0 w=1 l=0.15
X893 sky130_fd_sc_hd__xor2_1_6/a_285_47# V3R052 VGND VGND sky130_fd_pr__nfet_01v8 ad=0 pd=0 as=0 ps=0 w=0.65 l=0.15
X894 VDPWR sky130_fd_sc_hd__mux2_1_7/a_505_21# sky130_fd_sc_hd__mux2_1_7/a_535_374# VDPWR sky130_fd_pr__pfet_01v8_hvt ad=0 pd=0 as=0.0882 ps=1.26 w=0.42 l=0.15
X895 sky130_fd_sc_hd__mux2_1_7/a_505_21# V3R062 VDPWR VDPWR sky130_fd_pr__pfet_01v8_hvt ad=0.1176 pd=1.4 as=0 ps=0 w=0.42 l=0.15
X896 sky130_fd_sc_hd__mux2_1_7/a_218_374# V3R062 VDPWR VDPWR sky130_fd_pr__pfet_01v8_hvt ad=0.1533 pd=1.57 as=0 ps=0 w=0.42 l=0.15
X897 VGND sky130_fd_sc_hd__mux2_1_7/a_505_21# sky130_fd_sc_hd__mux2_1_7/a_439_47# VGND sky130_fd_pr__nfet_01v8 ad=0 pd=0 as=0.1386 ps=1.5 w=0.42 l=0.15
X898 sky130_fd_sc_hd__mux2_1_7/a_76_199# V3R171 sky130_fd_sc_hd__mux2_1_7/a_218_374# VDPWR sky130_fd_pr__pfet_01v8_hvt ad=0.3864 pd=2.68 as=0 ps=0 w=0.42 l=0.15
X899 sky130_fd_sc_hd__mux2_1_7/a_505_21# V3R062 VGND VGND sky130_fd_pr__nfet_01v8 ad=0.1092 pd=1.36 as=0 ps=0 w=0.42 l=0.15
X900 sky130_fd_sc_hd__mux2_1_7/a_439_47# V3R171 sky130_fd_sc_hd__mux2_1_7/a_76_199# VGND sky130_fd_pr__nfet_01v8 ad=0 pd=0 as=0.1995 ps=1.79 w=0.42 l=0.15
X901 sky130_fd_sc_hd__mux2_1_7/a_535_374# V3R170 sky130_fd_sc_hd__mux2_1_7/a_76_199# VDPWR sky130_fd_pr__pfet_01v8_hvt ad=0 pd=0 as=0 ps=0 w=0.42 l=0.15
X902 sky130_fd_sc_hd__mux2_1_7/a_76_199# V3R170 sky130_fd_sc_hd__mux2_1_7/a_218_47# VGND sky130_fd_pr__nfet_01v8 ad=0 pd=0 as=0.1386 ps=1.5 w=0.42 l=0.15
X903 sky130_fd_sc_hd__mux2_1_7/a_218_47# V3R062 VGND VGND sky130_fd_pr__nfet_01v8 ad=0 pd=0 as=0 ps=0 w=0.42 l=0.15
X904 VDPWR sky130_fd_sc_hd__mux2_1_7/a_76_199# V3R114 VDPWR sky130_fd_pr__pfet_01v8_hvt ad=0 pd=0 as=0.26 ps=2.52 w=1 l=0.15
X905 VGND sky130_fd_sc_hd__mux2_1_7/a_76_199# V3R114 VGND sky130_fd_pr__nfet_01v8 ad=0 pd=0 as=0.169 ps=1.82 w=0.65 l=0.15
X906 sky130_fd_sc_hd__dfrtp_1_0/a_805_47# sky130_fd_sc_hd__dfrtp_1_0/a_761_289# sky130_fd_sc_hd__dfrtp_1_0/a_639_47# VGND sky130_fd_pr__nfet_01v8 ad=0.0882 pd=1.26 as=0.2802 ps=2.2 w=0.42 l=0.15
X907 sky130_fd_sc_hd__dfrtp_1_0/a_1217_47# sky130_fd_sc_hd__dfrtp_1_0/a_27_47# sky130_fd_sc_hd__dfrtp_1_0/a_1108_47# VGND sky130_fd_pr__special_nfet_01v8 ad=0.1338 pd=1.5 as=0.1422 ps=1.51 w=0.36 l=0.15
X908 sky130_fd_sc_hd__dfrtp_1_0/a_1283_21# sky130_fd_sc_hd__dfrtp_1_0/a_1108_47# sky130_fd_sc_hd__dfrtp_1_0/a_1462_47# VGND sky130_fd_pr__nfet_01v8 ad=0.1092 pd=1.36 as=0.1281 ps=1.45 w=0.42 l=0.15
X909 sky130_fd_sc_hd__dfrtp_1_0/a_651_413# sky130_fd_sc_hd__dfrtp_1_0/a_27_47# sky130_fd_sc_hd__dfrtp_1_0/a_543_47# VDPWR sky130_fd_pr__pfet_01v8_hvt ad=0.3402 pd=3.3 as=0.1449 ps=1.53 w=0.42 l=0.15
X910 sky130_fd_sc_hd__dfrtp_1_0/a_1108_47# sky130_fd_sc_hd__dfrtp_1_0/a_193_47# sky130_fd_sc_hd__dfrtp_1_0/a_761_289# VGND sky130_fd_pr__special_nfet_01v8 ad=0 pd=0 as=0.1998 ps=1.97 w=0.36 l=0.15
X911 VGND V3R302 sky130_fd_sc_hd__dfrtp_1_0/a_805_47# VGND sky130_fd_pr__nfet_01v8 ad=0 pd=0 as=0 ps=0 w=0.42 l=0.15
X912 V3R196 sky130_fd_sc_hd__dfrtp_1_0/a_1283_21# VDPWR VDPWR sky130_fd_pr__pfet_01v8_hvt ad=0.26 pd=2.52 as=0 ps=0 w=1 l=0.15
X913 VDPWR V3R083 sky130_fd_sc_hd__dfrtp_1_0/a_27_47# VDPWR sky130_fd_pr__pfet_01v8_hvt ad=0 pd=0 as=0.1664 ps=1.8 w=0.64 l=0.15
X914 sky130_fd_sc_hd__dfrtp_1_0/a_448_47# V3R048 VDPWR VDPWR sky130_fd_pr__pfet_01v8_hvt ad=0.1302 pd=1.46 as=0 ps=0 w=0.42 l=0.15
X915 sky130_fd_sc_hd__dfrtp_1_0/a_761_289# sky130_fd_sc_hd__dfrtp_1_0/a_543_47# VGND VGND sky130_fd_pr__nfet_01v8 ad=0 pd=0 as=0 ps=0 w=0.64 l=0.15
X916 sky130_fd_sc_hd__dfrtp_1_0/a_193_47# sky130_fd_sc_hd__dfrtp_1_0/a_27_47# VGND VGND sky130_fd_pr__nfet_01v8 ad=0.1092 pd=1.36 as=0 ps=0 w=0.42 l=0.15
X917 sky130_fd_sc_hd__dfrtp_1_0/a_1108_47# sky130_fd_sc_hd__dfrtp_1_0/a_27_47# sky130_fd_sc_hd__dfrtp_1_0/a_761_289# VDPWR sky130_fd_pr__pfet_01v8_hvt ad=0.1176 pd=1.4 as=0.2583 ps=2.37 w=0.42 l=0.15
X918 sky130_fd_sc_hd__dfrtp_1_0/a_1462_47# V3R302 VGND VGND sky130_fd_pr__nfet_01v8 ad=0 pd=0 as=0 ps=0 w=0.42 l=0.15
X919 sky130_fd_sc_hd__dfrtp_1_0/a_543_47# sky130_fd_sc_hd__dfrtp_1_0/a_27_47# sky130_fd_sc_hd__dfrtp_1_0/a_448_47# VGND sky130_fd_pr__special_nfet_01v8 ad=0.1188 pd=1.38 as=0.132 ps=1.49 w=0.36 l=0.15
X920 sky130_fd_sc_hd__dfrtp_1_0/a_543_47# sky130_fd_sc_hd__dfrtp_1_0/a_193_47# sky130_fd_sc_hd__dfrtp_1_0/a_448_47# VDPWR sky130_fd_pr__pfet_01v8_hvt ad=0 pd=0 as=0 ps=0 w=0.42 l=0.15
X921 sky130_fd_sc_hd__dfrtp_1_0/a_448_47# V3R048 VGND VGND sky130_fd_pr__nfet_01v8 ad=0 pd=0 as=0 ps=0 w=0.42 l=0.15
X922 VDPWR sky130_fd_sc_hd__dfrtp_1_0/a_1283_21# sky130_fd_sc_hd__dfrtp_1_0/a_1270_413# VDPWR sky130_fd_pr__pfet_01v8_hvt ad=0 pd=0 as=0.1134 ps=1.38 w=0.42 l=0.15
X923 VDPWR sky130_fd_sc_hd__dfrtp_1_0/a_1108_47# sky130_fd_sc_hd__dfrtp_1_0/a_1283_21# VDPWR sky130_fd_pr__pfet_01v8_hvt ad=0 pd=0 as=0.1134 ps=1.38 w=0.42 l=0.15
X924 sky130_fd_sc_hd__dfrtp_1_0/a_1270_413# sky130_fd_sc_hd__dfrtp_1_0/a_193_47# sky130_fd_sc_hd__dfrtp_1_0/a_1108_47# VDPWR sky130_fd_pr__pfet_01v8_hvt ad=0 pd=0 as=0 ps=0 w=0.42 l=0.15
X925 sky130_fd_sc_hd__dfrtp_1_0/a_193_47# sky130_fd_sc_hd__dfrtp_1_0/a_27_47# VDPWR VDPWR sky130_fd_pr__pfet_01v8_hvt ad=0.1664 pd=1.8 as=0 ps=0 w=0.64 l=0.15
X926 sky130_fd_sc_hd__dfrtp_1_0/a_1283_21# V3R302 VDPWR VDPWR sky130_fd_pr__pfet_01v8_hvt ad=0 pd=0 as=0 ps=0 w=0.42 l=0.15
X927 VDPWR sky130_fd_sc_hd__dfrtp_1_0/a_761_289# sky130_fd_sc_hd__dfrtp_1_0/a_651_413# VDPWR sky130_fd_pr__pfet_01v8_hvt ad=0 pd=0 as=0 ps=0 w=0.42 l=0.15
X928 V3R196 sky130_fd_sc_hd__dfrtp_1_0/a_1283_21# VGND VGND sky130_fd_pr__nfet_01v8 ad=0.169 pd=1.82 as=0 ps=0 w=0.65 l=0.15
X929 sky130_fd_sc_hd__dfrtp_1_0/a_639_47# sky130_fd_sc_hd__dfrtp_1_0/a_193_47# sky130_fd_sc_hd__dfrtp_1_0/a_543_47# VGND sky130_fd_pr__special_nfet_01v8 ad=0 pd=0 as=0 ps=0 w=0.36 l=0.15
X930 VGND sky130_fd_sc_hd__dfrtp_1_0/a_1283_21# sky130_fd_sc_hd__dfrtp_1_0/a_1217_47# VGND sky130_fd_pr__nfet_01v8 ad=0 pd=0 as=0 ps=0 w=0.42 l=0.15
X931 sky130_fd_sc_hd__dfrtp_1_0/a_651_413# V3R302 VDPWR VDPWR sky130_fd_pr__pfet_01v8_hvt ad=0 pd=0 as=0 ps=0 w=0.42 l=0.15
X932 VGND V3R083 sky130_fd_sc_hd__dfrtp_1_0/a_27_47# VGND sky130_fd_pr__nfet_01v8 ad=0 pd=0 as=0.1092 ps=1.36 w=0.42 l=0.15
X933 sky130_fd_sc_hd__dfrtp_1_0/a_761_289# sky130_fd_sc_hd__dfrtp_1_0/a_543_47# VDPWR VDPWR sky130_fd_pr__pfet_01v8_hvt ad=0 pd=0 as=0 ps=0 w=0.84 l=0.15
X934 sky130_fd_sc_hd__dfrtp_1_16/a_805_47# sky130_fd_sc_hd__dfrtp_1_16/a_761_289# sky130_fd_sc_hd__dfrtp_1_16/a_639_47# VGND sky130_fd_pr__nfet_01v8 ad=0.0882 pd=1.26 as=0.2802 ps=2.2 w=0.42 l=0.15
X935 sky130_fd_sc_hd__dfrtp_1_16/a_1217_47# sky130_fd_sc_hd__dfrtp_1_16/a_27_47# sky130_fd_sc_hd__dfrtp_1_16/a_1108_47# VGND sky130_fd_pr__special_nfet_01v8 ad=0.1338 pd=1.5 as=0.1422 ps=1.51 w=0.36 l=0.15
X936 sky130_fd_sc_hd__dfrtp_1_16/a_1283_21# sky130_fd_sc_hd__dfrtp_1_16/a_1108_47# sky130_fd_sc_hd__dfrtp_1_16/a_1462_47# VGND sky130_fd_pr__nfet_01v8 ad=0.1092 pd=1.36 as=0.1281 ps=1.45 w=0.42 l=0.15
X937 sky130_fd_sc_hd__dfrtp_1_16/a_651_413# sky130_fd_sc_hd__dfrtp_1_16/a_27_47# sky130_fd_sc_hd__dfrtp_1_16/a_543_47# VDPWR sky130_fd_pr__pfet_01v8_hvt ad=0.3402 pd=3.3 as=0.1449 ps=1.53 w=0.42 l=0.15
X938 sky130_fd_sc_hd__dfrtp_1_16/a_1108_47# sky130_fd_sc_hd__dfrtp_1_16/a_193_47# sky130_fd_sc_hd__dfrtp_1_16/a_761_289# VGND sky130_fd_pr__special_nfet_01v8 ad=0 pd=0 as=0.1998 ps=1.97 w=0.36 l=0.15
X939 VGND V3R303 sky130_fd_sc_hd__dfrtp_1_16/a_805_47# VGND sky130_fd_pr__nfet_01v8 ad=0 pd=0 as=0 ps=0 w=0.42 l=0.15
X940 V3R198 sky130_fd_sc_hd__dfrtp_1_16/a_1283_21# VDPWR VDPWR sky130_fd_pr__pfet_01v8_hvt ad=0.26 pd=2.52 as=0 ps=0 w=1 l=0.15
X941 VDPWR V3R084 sky130_fd_sc_hd__dfrtp_1_16/a_27_47# VDPWR sky130_fd_pr__pfet_01v8_hvt ad=0 pd=0 as=0.1664 ps=1.8 w=0.64 l=0.15
X942 sky130_fd_sc_hd__dfrtp_1_16/a_448_47# V3R296 VDPWR VDPWR sky130_fd_pr__pfet_01v8_hvt ad=0.1302 pd=1.46 as=0 ps=0 w=0.42 l=0.15
X943 sky130_fd_sc_hd__dfrtp_1_16/a_761_289# sky130_fd_sc_hd__dfrtp_1_16/a_543_47# VGND VGND sky130_fd_pr__nfet_01v8 ad=0 pd=0 as=0 ps=0 w=0.64 l=0.15
X944 sky130_fd_sc_hd__dfrtp_1_16/a_193_47# sky130_fd_sc_hd__dfrtp_1_16/a_27_47# VGND VGND sky130_fd_pr__nfet_01v8 ad=0.1092 pd=1.36 as=0 ps=0 w=0.42 l=0.15
X945 sky130_fd_sc_hd__dfrtp_1_16/a_1108_47# sky130_fd_sc_hd__dfrtp_1_16/a_27_47# sky130_fd_sc_hd__dfrtp_1_16/a_761_289# VDPWR sky130_fd_pr__pfet_01v8_hvt ad=0.1176 pd=1.4 as=0.2583 ps=2.37 w=0.42 l=0.15
X946 sky130_fd_sc_hd__dfrtp_1_16/a_1462_47# V3R303 VGND VGND sky130_fd_pr__nfet_01v8 ad=0 pd=0 as=0 ps=0 w=0.42 l=0.15
X947 sky130_fd_sc_hd__dfrtp_1_16/a_543_47# sky130_fd_sc_hd__dfrtp_1_16/a_27_47# sky130_fd_sc_hd__dfrtp_1_16/a_448_47# VGND sky130_fd_pr__special_nfet_01v8 ad=0.1188 pd=1.38 as=0.132 ps=1.49 w=0.36 l=0.15
X948 sky130_fd_sc_hd__dfrtp_1_16/a_543_47# sky130_fd_sc_hd__dfrtp_1_16/a_193_47# sky130_fd_sc_hd__dfrtp_1_16/a_448_47# VDPWR sky130_fd_pr__pfet_01v8_hvt ad=0 pd=0 as=0 ps=0 w=0.42 l=0.15
X949 sky130_fd_sc_hd__dfrtp_1_16/a_448_47# V3R296 VGND VGND sky130_fd_pr__nfet_01v8 ad=0 pd=0 as=0 ps=0 w=0.42 l=0.15
X950 VDPWR sky130_fd_sc_hd__dfrtp_1_16/a_1283_21# sky130_fd_sc_hd__dfrtp_1_16/a_1270_413# VDPWR sky130_fd_pr__pfet_01v8_hvt ad=0 pd=0 as=0.1134 ps=1.38 w=0.42 l=0.15
X951 VDPWR sky130_fd_sc_hd__dfrtp_1_16/a_1108_47# sky130_fd_sc_hd__dfrtp_1_16/a_1283_21# VDPWR sky130_fd_pr__pfet_01v8_hvt ad=0 pd=0 as=0.1134 ps=1.38 w=0.42 l=0.15
X952 sky130_fd_sc_hd__dfrtp_1_16/a_1270_413# sky130_fd_sc_hd__dfrtp_1_16/a_193_47# sky130_fd_sc_hd__dfrtp_1_16/a_1108_47# VDPWR sky130_fd_pr__pfet_01v8_hvt ad=0 pd=0 as=0 ps=0 w=0.42 l=0.15
X953 sky130_fd_sc_hd__dfrtp_1_16/a_193_47# sky130_fd_sc_hd__dfrtp_1_16/a_27_47# VDPWR VDPWR sky130_fd_pr__pfet_01v8_hvt ad=0.1664 pd=1.8 as=0 ps=0 w=0.64 l=0.15
X954 sky130_fd_sc_hd__dfrtp_1_16/a_1283_21# V3R303 VDPWR VDPWR sky130_fd_pr__pfet_01v8_hvt ad=0 pd=0 as=0 ps=0 w=0.42 l=0.15
X955 VDPWR sky130_fd_sc_hd__dfrtp_1_16/a_761_289# sky130_fd_sc_hd__dfrtp_1_16/a_651_413# VDPWR sky130_fd_pr__pfet_01v8_hvt ad=0 pd=0 as=0 ps=0 w=0.42 l=0.15
X956 V3R198 sky130_fd_sc_hd__dfrtp_1_16/a_1283_21# VGND VGND sky130_fd_pr__nfet_01v8 ad=0.169 pd=1.82 as=0 ps=0 w=0.65 l=0.15
X957 sky130_fd_sc_hd__dfrtp_1_16/a_639_47# sky130_fd_sc_hd__dfrtp_1_16/a_193_47# sky130_fd_sc_hd__dfrtp_1_16/a_543_47# VGND sky130_fd_pr__special_nfet_01v8 ad=0 pd=0 as=0 ps=0 w=0.36 l=0.15
X958 VGND sky130_fd_sc_hd__dfrtp_1_16/a_1283_21# sky130_fd_sc_hd__dfrtp_1_16/a_1217_47# VGND sky130_fd_pr__nfet_01v8 ad=0 pd=0 as=0 ps=0 w=0.42 l=0.15
X959 sky130_fd_sc_hd__dfrtp_1_16/a_651_413# V3R303 VDPWR VDPWR sky130_fd_pr__pfet_01v8_hvt ad=0 pd=0 as=0 ps=0 w=0.42 l=0.15
X960 VGND V3R084 sky130_fd_sc_hd__dfrtp_1_16/a_27_47# VGND sky130_fd_pr__nfet_01v8 ad=0 pd=0 as=0.1092 ps=1.36 w=0.42 l=0.15
X961 sky130_fd_sc_hd__dfrtp_1_16/a_761_289# sky130_fd_sc_hd__dfrtp_1_16/a_543_47# VDPWR VDPWR sky130_fd_pr__pfet_01v8_hvt ad=0 pd=0 as=0 ps=0 w=0.84 l=0.15
X962 sky130_fd_sc_hd__dfrtp_1_38/a_805_47# sky130_fd_sc_hd__dfrtp_1_38/a_761_289# sky130_fd_sc_hd__dfrtp_1_38/a_639_47# VGND sky130_fd_pr__nfet_01v8 ad=0.0882 pd=1.26 as=0.2802 ps=2.2 w=0.42 l=0.15
X963 sky130_fd_sc_hd__dfrtp_1_38/a_1217_47# sky130_fd_sc_hd__dfrtp_1_38/a_27_47# sky130_fd_sc_hd__dfrtp_1_38/a_1108_47# VGND sky130_fd_pr__special_nfet_01v8 ad=0.1338 pd=1.5 as=0.1422 ps=1.51 w=0.36 l=0.15
X964 sky130_fd_sc_hd__dfrtp_1_38/a_1283_21# sky130_fd_sc_hd__dfrtp_1_38/a_1108_47# sky130_fd_sc_hd__dfrtp_1_38/a_1462_47# VGND sky130_fd_pr__nfet_01v8 ad=0.1092 pd=1.36 as=0.1281 ps=1.45 w=0.42 l=0.15
X965 sky130_fd_sc_hd__dfrtp_1_38/a_651_413# sky130_fd_sc_hd__dfrtp_1_38/a_27_47# sky130_fd_sc_hd__dfrtp_1_38/a_543_47# VDPWR sky130_fd_pr__pfet_01v8_hvt ad=0.3402 pd=3.3 as=0.1449 ps=1.53 w=0.42 l=0.15
X966 sky130_fd_sc_hd__dfrtp_1_38/a_1108_47# sky130_fd_sc_hd__dfrtp_1_38/a_193_47# sky130_fd_sc_hd__dfrtp_1_38/a_761_289# VGND sky130_fd_pr__special_nfet_01v8 ad=0 pd=0 as=0.1998 ps=1.97 w=0.36 l=0.15
X967 VGND V3R301 sky130_fd_sc_hd__dfrtp_1_38/a_805_47# VGND sky130_fd_pr__nfet_01v8 ad=0 pd=0 as=0 ps=0 w=0.42 l=0.15
X968 V3R023 sky130_fd_sc_hd__dfrtp_1_38/a_1283_21# VDPWR VDPWR sky130_fd_pr__pfet_01v8_hvt ad=0.26 pd=2.52 as=0 ps=0 w=1 l=0.15
X969 VDPWR V3R082 sky130_fd_sc_hd__dfrtp_1_38/a_27_47# VDPWR sky130_fd_pr__pfet_01v8_hvt ad=0 pd=0 as=0.1664 ps=1.8 w=0.64 l=0.15
X970 sky130_fd_sc_hd__dfrtp_1_38/a_448_47# V3R138 VDPWR VDPWR sky130_fd_pr__pfet_01v8_hvt ad=0.1302 pd=1.46 as=0 ps=0 w=0.42 l=0.15
X971 sky130_fd_sc_hd__dfrtp_1_38/a_761_289# sky130_fd_sc_hd__dfrtp_1_38/a_543_47# VGND VGND sky130_fd_pr__nfet_01v8 ad=0 pd=0 as=0 ps=0 w=0.64 l=0.15
X972 sky130_fd_sc_hd__dfrtp_1_38/a_193_47# sky130_fd_sc_hd__dfrtp_1_38/a_27_47# VGND VGND sky130_fd_pr__nfet_01v8 ad=0.1092 pd=1.36 as=0 ps=0 w=0.42 l=0.15
X973 sky130_fd_sc_hd__dfrtp_1_38/a_1108_47# sky130_fd_sc_hd__dfrtp_1_38/a_27_47# sky130_fd_sc_hd__dfrtp_1_38/a_761_289# VDPWR sky130_fd_pr__pfet_01v8_hvt ad=0.1176 pd=1.4 as=0.2583 ps=2.37 w=0.42 l=0.15
X974 sky130_fd_sc_hd__dfrtp_1_38/a_1462_47# V3R301 VGND VGND sky130_fd_pr__nfet_01v8 ad=0 pd=0 as=0 ps=0 w=0.42 l=0.15
X975 sky130_fd_sc_hd__dfrtp_1_38/a_543_47# sky130_fd_sc_hd__dfrtp_1_38/a_27_47# sky130_fd_sc_hd__dfrtp_1_38/a_448_47# VGND sky130_fd_pr__special_nfet_01v8 ad=0.1188 pd=1.38 as=0.132 ps=1.49 w=0.36 l=0.15
X976 sky130_fd_sc_hd__dfrtp_1_38/a_543_47# sky130_fd_sc_hd__dfrtp_1_38/a_193_47# sky130_fd_sc_hd__dfrtp_1_38/a_448_47# VDPWR sky130_fd_pr__pfet_01v8_hvt ad=0 pd=0 as=0 ps=0 w=0.42 l=0.15
X977 sky130_fd_sc_hd__dfrtp_1_38/a_448_47# V3R138 VGND VGND sky130_fd_pr__nfet_01v8 ad=0 pd=0 as=0 ps=0 w=0.42 l=0.15
X978 VDPWR sky130_fd_sc_hd__dfrtp_1_38/a_1283_21# sky130_fd_sc_hd__dfrtp_1_38/a_1270_413# VDPWR sky130_fd_pr__pfet_01v8_hvt ad=0 pd=0 as=0.1134 ps=1.38 w=0.42 l=0.15
X979 VDPWR sky130_fd_sc_hd__dfrtp_1_38/a_1108_47# sky130_fd_sc_hd__dfrtp_1_38/a_1283_21# VDPWR sky130_fd_pr__pfet_01v8_hvt ad=0 pd=0 as=0.1134 ps=1.38 w=0.42 l=0.15
X980 sky130_fd_sc_hd__dfrtp_1_38/a_1270_413# sky130_fd_sc_hd__dfrtp_1_38/a_193_47# sky130_fd_sc_hd__dfrtp_1_38/a_1108_47# VDPWR sky130_fd_pr__pfet_01v8_hvt ad=0 pd=0 as=0 ps=0 w=0.42 l=0.15
X981 sky130_fd_sc_hd__dfrtp_1_38/a_193_47# sky130_fd_sc_hd__dfrtp_1_38/a_27_47# VDPWR VDPWR sky130_fd_pr__pfet_01v8_hvt ad=0.1664 pd=1.8 as=0 ps=0 w=0.64 l=0.15
X982 sky130_fd_sc_hd__dfrtp_1_38/a_1283_21# V3R301 VDPWR VDPWR sky130_fd_pr__pfet_01v8_hvt ad=0 pd=0 as=0 ps=0 w=0.42 l=0.15
X983 VDPWR sky130_fd_sc_hd__dfrtp_1_38/a_761_289# sky130_fd_sc_hd__dfrtp_1_38/a_651_413# VDPWR sky130_fd_pr__pfet_01v8_hvt ad=0 pd=0 as=0 ps=0 w=0.42 l=0.15
X984 V3R023 sky130_fd_sc_hd__dfrtp_1_38/a_1283_21# VGND VGND sky130_fd_pr__nfet_01v8 ad=0.169 pd=1.82 as=0 ps=0 w=0.65 l=0.15
X985 sky130_fd_sc_hd__dfrtp_1_38/a_639_47# sky130_fd_sc_hd__dfrtp_1_38/a_193_47# sky130_fd_sc_hd__dfrtp_1_38/a_543_47# VGND sky130_fd_pr__special_nfet_01v8 ad=0 pd=0 as=0 ps=0 w=0.36 l=0.15
X986 VGND sky130_fd_sc_hd__dfrtp_1_38/a_1283_21# sky130_fd_sc_hd__dfrtp_1_38/a_1217_47# VGND sky130_fd_pr__nfet_01v8 ad=0 pd=0 as=0 ps=0 w=0.42 l=0.15
X987 sky130_fd_sc_hd__dfrtp_1_38/a_651_413# V3R301 VDPWR VDPWR sky130_fd_pr__pfet_01v8_hvt ad=0 pd=0 as=0 ps=0 w=0.42 l=0.15
X988 VGND V3R082 sky130_fd_sc_hd__dfrtp_1_38/a_27_47# VGND sky130_fd_pr__nfet_01v8 ad=0 pd=0 as=0.1092 ps=1.36 w=0.42 l=0.15
X989 sky130_fd_sc_hd__dfrtp_1_38/a_761_289# sky130_fd_sc_hd__dfrtp_1_38/a_543_47# VDPWR VDPWR sky130_fd_pr__pfet_01v8_hvt ad=0 pd=0 as=0 ps=0 w=0.84 l=0.15
X990 sky130_fd_sc_hd__dfrtp_1_27/a_805_47# sky130_fd_sc_hd__dfrtp_1_27/a_761_289# sky130_fd_sc_hd__dfrtp_1_27/a_639_47# VGND sky130_fd_pr__nfet_01v8 ad=0.0882 pd=1.26 as=0.2802 ps=2.2 w=0.42 l=0.15
X991 sky130_fd_sc_hd__dfrtp_1_27/a_1217_47# sky130_fd_sc_hd__dfrtp_1_27/a_27_47# sky130_fd_sc_hd__dfrtp_1_27/a_1108_47# VGND sky130_fd_pr__special_nfet_01v8 ad=0.1338 pd=1.5 as=0.1422 ps=1.51 w=0.36 l=0.15
X992 sky130_fd_sc_hd__dfrtp_1_27/a_1283_21# sky130_fd_sc_hd__dfrtp_1_27/a_1108_47# sky130_fd_sc_hd__dfrtp_1_27/a_1462_47# VGND sky130_fd_pr__nfet_01v8 ad=0.1092 pd=1.36 as=0.1281 ps=1.45 w=0.42 l=0.15
X993 sky130_fd_sc_hd__dfrtp_1_27/a_651_413# sky130_fd_sc_hd__dfrtp_1_27/a_27_47# sky130_fd_sc_hd__dfrtp_1_27/a_543_47# VDPWR sky130_fd_pr__pfet_01v8_hvt ad=0.3402 pd=3.3 as=0.1449 ps=1.53 w=0.42 l=0.15
X994 sky130_fd_sc_hd__dfrtp_1_27/a_1108_47# sky130_fd_sc_hd__dfrtp_1_27/a_193_47# sky130_fd_sc_hd__dfrtp_1_27/a_761_289# VGND sky130_fd_pr__special_nfet_01v8 ad=0 pd=0 as=0.1998 ps=1.97 w=0.36 l=0.15
X995 VGND V3R303 sky130_fd_sc_hd__dfrtp_1_27/a_805_47# VGND sky130_fd_pr__nfet_01v8 ad=0 pd=0 as=0 ps=0 w=0.42 l=0.15
X996 V3R202 sky130_fd_sc_hd__dfrtp_1_27/a_1283_21# VDPWR VDPWR sky130_fd_pr__pfet_01v8_hvt ad=0.26 pd=2.52 as=0 ps=0 w=1 l=0.15
X997 VDPWR V3R084 sky130_fd_sc_hd__dfrtp_1_27/a_27_47# VDPWR sky130_fd_pr__pfet_01v8_hvt ad=0 pd=0 as=0.1664 ps=1.8 w=0.64 l=0.15
X998 sky130_fd_sc_hd__dfrtp_1_27/a_448_47# V3R075 VDPWR VDPWR sky130_fd_pr__pfet_01v8_hvt ad=0.1302 pd=1.46 as=0 ps=0 w=0.42 l=0.15
X999 sky130_fd_sc_hd__dfrtp_1_27/a_761_289# sky130_fd_sc_hd__dfrtp_1_27/a_543_47# VGND VGND sky130_fd_pr__nfet_01v8 ad=0 pd=0 as=0 ps=0 w=0.64 l=0.15
X1000 sky130_fd_sc_hd__dfrtp_1_27/a_193_47# sky130_fd_sc_hd__dfrtp_1_27/a_27_47# VGND VGND sky130_fd_pr__nfet_01v8 ad=0.1092 pd=1.36 as=0 ps=0 w=0.42 l=0.15
X1001 sky130_fd_sc_hd__dfrtp_1_27/a_1108_47# sky130_fd_sc_hd__dfrtp_1_27/a_27_47# sky130_fd_sc_hd__dfrtp_1_27/a_761_289# VDPWR sky130_fd_pr__pfet_01v8_hvt ad=0.1176 pd=1.4 as=0.2583 ps=2.37 w=0.42 l=0.15
X1002 sky130_fd_sc_hd__dfrtp_1_27/a_1462_47# V3R303 VGND VGND sky130_fd_pr__nfet_01v8 ad=0 pd=0 as=0 ps=0 w=0.42 l=0.15
X1003 sky130_fd_sc_hd__dfrtp_1_27/a_543_47# sky130_fd_sc_hd__dfrtp_1_27/a_27_47# sky130_fd_sc_hd__dfrtp_1_27/a_448_47# VGND sky130_fd_pr__special_nfet_01v8 ad=0.1188 pd=1.38 as=0.132 ps=1.49 w=0.36 l=0.15
X1004 sky130_fd_sc_hd__dfrtp_1_27/a_543_47# sky130_fd_sc_hd__dfrtp_1_27/a_193_47# sky130_fd_sc_hd__dfrtp_1_27/a_448_47# VDPWR sky130_fd_pr__pfet_01v8_hvt ad=0 pd=0 as=0 ps=0 w=0.42 l=0.15
X1005 sky130_fd_sc_hd__dfrtp_1_27/a_448_47# V3R075 VGND VGND sky130_fd_pr__nfet_01v8 ad=0 pd=0 as=0 ps=0 w=0.42 l=0.15
X1006 VDPWR sky130_fd_sc_hd__dfrtp_1_27/a_1283_21# sky130_fd_sc_hd__dfrtp_1_27/a_1270_413# VDPWR sky130_fd_pr__pfet_01v8_hvt ad=0 pd=0 as=0.1134 ps=1.38 w=0.42 l=0.15
X1007 VDPWR sky130_fd_sc_hd__dfrtp_1_27/a_1108_47# sky130_fd_sc_hd__dfrtp_1_27/a_1283_21# VDPWR sky130_fd_pr__pfet_01v8_hvt ad=0 pd=0 as=0.1134 ps=1.38 w=0.42 l=0.15
X1008 sky130_fd_sc_hd__dfrtp_1_27/a_1270_413# sky130_fd_sc_hd__dfrtp_1_27/a_193_47# sky130_fd_sc_hd__dfrtp_1_27/a_1108_47# VDPWR sky130_fd_pr__pfet_01v8_hvt ad=0 pd=0 as=0 ps=0 w=0.42 l=0.15
X1009 sky130_fd_sc_hd__dfrtp_1_27/a_193_47# sky130_fd_sc_hd__dfrtp_1_27/a_27_47# VDPWR VDPWR sky130_fd_pr__pfet_01v8_hvt ad=0.1664 pd=1.8 as=0 ps=0 w=0.64 l=0.15
X1010 sky130_fd_sc_hd__dfrtp_1_27/a_1283_21# V3R303 VDPWR VDPWR sky130_fd_pr__pfet_01v8_hvt ad=0 pd=0 as=0 ps=0 w=0.42 l=0.15
X1011 VDPWR sky130_fd_sc_hd__dfrtp_1_27/a_761_289# sky130_fd_sc_hd__dfrtp_1_27/a_651_413# VDPWR sky130_fd_pr__pfet_01v8_hvt ad=0 pd=0 as=0 ps=0 w=0.42 l=0.15
X1012 V3R202 sky130_fd_sc_hd__dfrtp_1_27/a_1283_21# VGND VGND sky130_fd_pr__nfet_01v8 ad=0.169 pd=1.82 as=0 ps=0 w=0.65 l=0.15
X1013 sky130_fd_sc_hd__dfrtp_1_27/a_639_47# sky130_fd_sc_hd__dfrtp_1_27/a_193_47# sky130_fd_sc_hd__dfrtp_1_27/a_543_47# VGND sky130_fd_pr__special_nfet_01v8 ad=0 pd=0 as=0 ps=0 w=0.36 l=0.15
X1014 VGND sky130_fd_sc_hd__dfrtp_1_27/a_1283_21# sky130_fd_sc_hd__dfrtp_1_27/a_1217_47# VGND sky130_fd_pr__nfet_01v8 ad=0 pd=0 as=0 ps=0 w=0.42 l=0.15
X1015 sky130_fd_sc_hd__dfrtp_1_27/a_651_413# V3R303 VDPWR VDPWR sky130_fd_pr__pfet_01v8_hvt ad=0 pd=0 as=0 ps=0 w=0.42 l=0.15
X1016 VGND V3R084 sky130_fd_sc_hd__dfrtp_1_27/a_27_47# VGND sky130_fd_pr__nfet_01v8 ad=0 pd=0 as=0.1092 ps=1.36 w=0.42 l=0.15
X1017 sky130_fd_sc_hd__dfrtp_1_27/a_761_289# sky130_fd_sc_hd__dfrtp_1_27/a_543_47# VDPWR VDPWR sky130_fd_pr__pfet_01v8_hvt ad=0 pd=0 as=0 ps=0 w=0.84 l=0.15
X1018 sky130_fd_sc_hd__dfrtp_1_49/a_805_47# sky130_fd_sc_hd__dfrtp_1_49/a_761_289# sky130_fd_sc_hd__dfrtp_1_49/a_639_47# VGND sky130_fd_pr__nfet_01v8 ad=0.0882 pd=1.26 as=0.2802 ps=2.2 w=0.42 l=0.15
X1019 sky130_fd_sc_hd__dfrtp_1_49/a_1217_47# sky130_fd_sc_hd__dfrtp_1_49/a_27_47# sky130_fd_sc_hd__dfrtp_1_49/a_1108_47# VGND sky130_fd_pr__special_nfet_01v8 ad=0.1338 pd=1.5 as=0.1422 ps=1.51 w=0.36 l=0.15
X1020 sky130_fd_sc_hd__dfrtp_1_49/a_1283_21# sky130_fd_sc_hd__dfrtp_1_49/a_1108_47# sky130_fd_sc_hd__dfrtp_1_49/a_1462_47# VGND sky130_fd_pr__nfet_01v8 ad=0.1092 pd=1.36 as=0.1281 ps=1.45 w=0.42 l=0.15
X1021 sky130_fd_sc_hd__dfrtp_1_49/a_651_413# sky130_fd_sc_hd__dfrtp_1_49/a_27_47# sky130_fd_sc_hd__dfrtp_1_49/a_543_47# VDPWR sky130_fd_pr__pfet_01v8_hvt ad=0.3402 pd=3.3 as=0.1449 ps=1.53 w=0.42 l=0.15
X1022 sky130_fd_sc_hd__dfrtp_1_49/a_1108_47# sky130_fd_sc_hd__dfrtp_1_49/a_193_47# sky130_fd_sc_hd__dfrtp_1_49/a_761_289# VGND sky130_fd_pr__special_nfet_01v8 ad=0 pd=0 as=0.1998 ps=1.97 w=0.36 l=0.15
X1023 VGND V3R299 sky130_fd_sc_hd__dfrtp_1_49/a_805_47# VGND sky130_fd_pr__nfet_01v8 ad=0 pd=0 as=0 ps=0 w=0.42 l=0.15
X1024 V3R157 sky130_fd_sc_hd__dfrtp_1_49/a_1283_21# VDPWR VDPWR sky130_fd_pr__pfet_01v8_hvt ad=0.26 pd=2.52 as=0 ps=0 w=1 l=0.15
X1025 VDPWR V3R056 sky130_fd_sc_hd__dfrtp_1_49/a_27_47# VDPWR sky130_fd_pr__pfet_01v8_hvt ad=0 pd=0 as=0.1664 ps=1.8 w=0.64 l=0.15
X1026 sky130_fd_sc_hd__dfrtp_1_49/a_448_47# V3R102 VDPWR VDPWR sky130_fd_pr__pfet_01v8_hvt ad=0.1302 pd=1.46 as=0 ps=0 w=0.42 l=0.15
X1027 sky130_fd_sc_hd__dfrtp_1_49/a_761_289# sky130_fd_sc_hd__dfrtp_1_49/a_543_47# VGND VGND sky130_fd_pr__nfet_01v8 ad=0 pd=0 as=0 ps=0 w=0.64 l=0.15
X1028 sky130_fd_sc_hd__dfrtp_1_49/a_193_47# sky130_fd_sc_hd__dfrtp_1_49/a_27_47# VGND VGND sky130_fd_pr__nfet_01v8 ad=0.1092 pd=1.36 as=0 ps=0 w=0.42 l=0.15
X1029 sky130_fd_sc_hd__dfrtp_1_49/a_1108_47# sky130_fd_sc_hd__dfrtp_1_49/a_27_47# sky130_fd_sc_hd__dfrtp_1_49/a_761_289# VDPWR sky130_fd_pr__pfet_01v8_hvt ad=0.1176 pd=1.4 as=0.2583 ps=2.37 w=0.42 l=0.15
X1030 sky130_fd_sc_hd__dfrtp_1_49/a_1462_47# V3R299 VGND VGND sky130_fd_pr__nfet_01v8 ad=0 pd=0 as=0 ps=0 w=0.42 l=0.15
X1031 sky130_fd_sc_hd__dfrtp_1_49/a_543_47# sky130_fd_sc_hd__dfrtp_1_49/a_27_47# sky130_fd_sc_hd__dfrtp_1_49/a_448_47# VGND sky130_fd_pr__special_nfet_01v8 ad=0.1188 pd=1.38 as=0.132 ps=1.49 w=0.36 l=0.15
X1032 sky130_fd_sc_hd__dfrtp_1_49/a_543_47# sky130_fd_sc_hd__dfrtp_1_49/a_193_47# sky130_fd_sc_hd__dfrtp_1_49/a_448_47# VDPWR sky130_fd_pr__pfet_01v8_hvt ad=0 pd=0 as=0 ps=0 w=0.42 l=0.15
X1033 sky130_fd_sc_hd__dfrtp_1_49/a_448_47# V3R102 VGND VGND sky130_fd_pr__nfet_01v8 ad=0 pd=0 as=0 ps=0 w=0.42 l=0.15
X1034 VDPWR sky130_fd_sc_hd__dfrtp_1_49/a_1283_21# sky130_fd_sc_hd__dfrtp_1_49/a_1270_413# VDPWR sky130_fd_pr__pfet_01v8_hvt ad=0 pd=0 as=0.1134 ps=1.38 w=0.42 l=0.15
X1035 VDPWR sky130_fd_sc_hd__dfrtp_1_49/a_1108_47# sky130_fd_sc_hd__dfrtp_1_49/a_1283_21# VDPWR sky130_fd_pr__pfet_01v8_hvt ad=0 pd=0 as=0.1134 ps=1.38 w=0.42 l=0.15
X1036 sky130_fd_sc_hd__dfrtp_1_49/a_1270_413# sky130_fd_sc_hd__dfrtp_1_49/a_193_47# sky130_fd_sc_hd__dfrtp_1_49/a_1108_47# VDPWR sky130_fd_pr__pfet_01v8_hvt ad=0 pd=0 as=0 ps=0 w=0.42 l=0.15
X1037 sky130_fd_sc_hd__dfrtp_1_49/a_193_47# sky130_fd_sc_hd__dfrtp_1_49/a_27_47# VDPWR VDPWR sky130_fd_pr__pfet_01v8_hvt ad=0.1664 pd=1.8 as=0 ps=0 w=0.64 l=0.15
X1038 sky130_fd_sc_hd__dfrtp_1_49/a_1283_21# V3R299 VDPWR VDPWR sky130_fd_pr__pfet_01v8_hvt ad=0 pd=0 as=0 ps=0 w=0.42 l=0.15
X1039 VDPWR sky130_fd_sc_hd__dfrtp_1_49/a_761_289# sky130_fd_sc_hd__dfrtp_1_49/a_651_413# VDPWR sky130_fd_pr__pfet_01v8_hvt ad=0 pd=0 as=0 ps=0 w=0.42 l=0.15
X1040 V3R157 sky130_fd_sc_hd__dfrtp_1_49/a_1283_21# VGND VGND sky130_fd_pr__nfet_01v8 ad=0.169 pd=1.82 as=0 ps=0 w=0.65 l=0.15
X1041 sky130_fd_sc_hd__dfrtp_1_49/a_639_47# sky130_fd_sc_hd__dfrtp_1_49/a_193_47# sky130_fd_sc_hd__dfrtp_1_49/a_543_47# VGND sky130_fd_pr__special_nfet_01v8 ad=0 pd=0 as=0 ps=0 w=0.36 l=0.15
X1042 VGND sky130_fd_sc_hd__dfrtp_1_49/a_1283_21# sky130_fd_sc_hd__dfrtp_1_49/a_1217_47# VGND sky130_fd_pr__nfet_01v8 ad=0 pd=0 as=0 ps=0 w=0.42 l=0.15
X1043 sky130_fd_sc_hd__dfrtp_1_49/a_651_413# V3R299 VDPWR VDPWR sky130_fd_pr__pfet_01v8_hvt ad=0 pd=0 as=0 ps=0 w=0.42 l=0.15
X1044 VGND V3R056 sky130_fd_sc_hd__dfrtp_1_49/a_27_47# VGND sky130_fd_pr__nfet_01v8 ad=0 pd=0 as=0.1092 ps=1.36 w=0.42 l=0.15
X1045 sky130_fd_sc_hd__dfrtp_1_49/a_761_289# sky130_fd_sc_hd__dfrtp_1_49/a_543_47# VDPWR VDPWR sky130_fd_pr__pfet_01v8_hvt ad=0 pd=0 as=0 ps=0 w=0.84 l=0.15
X1046 VGND sky130_fd_sc_hd__dfstp_1_2/a_652_21# sky130_fd_sc_hd__dfstp_1_2/a_586_47# VGND sky130_fd_pr__nfet_01v8 ad=0 pd=0 as=0.1341 ps=1.5 w=0.42 l=0.15
X1047 sky130_fd_sc_hd__dfstp_1_2/a_956_413# sky130_fd_sc_hd__dfstp_1_2/a_476_47# VDPWR VDPWR sky130_fd_pr__pfet_01v8_hvt ad=0.0966 pd=1.3 as=0 ps=0 w=0.42 l=0.15
X1048 VDPWR sky130_fd_sc_hd__dfstp_1_2/a_476_47# sky130_fd_sc_hd__dfstp_1_2/a_652_21# VDPWR sky130_fd_pr__pfet_01v8_hvt ad=0 pd=0 as=0.1134 ps=1.38 w=0.42 l=0.15
X1049 VDPWR V3R056 sky130_fd_sc_hd__dfstp_1_2/a_27_47# VDPWR sky130_fd_pr__pfet_01v8_hvt ad=0 pd=0 as=0.1664 ps=1.8 w=0.64 l=0.15
X1050 sky130_fd_sc_hd__dfstp_1_2/a_586_47# sky130_fd_sc_hd__dfstp_1_2/a_193_47# sky130_fd_sc_hd__dfstp_1_2/a_476_47# VGND sky130_fd_pr__special_nfet_01v8 ad=0 pd=0 as=0.144 ps=1.52 w=0.36 l=0.15
X1051 sky130_fd_sc_hd__dfstp_1_2/a_1056_47# sky130_fd_sc_hd__dfstp_1_2/a_476_47# VGND VGND sky130_fd_pr__nfet_01v8 ad=0.0882 pd=1.26 as=0 ps=0 w=0.42 l=0.15
X1052 sky130_fd_sc_hd__dfstp_1_2/a_476_47# sky130_fd_sc_hd__dfstp_1_2/a_27_47# sky130_fd_sc_hd__dfstp_1_2/a_381_47# VGND sky130_fd_pr__special_nfet_01v8 ad=0 pd=0 as=0.187 ps=1.93 w=0.36 l=0.15
X1053 sky130_fd_sc_hd__dfstp_1_2/a_381_47# V3R105 VDPWR VDPWR sky130_fd_pr__pfet_01v8_hvt ad=0.2499 pd=2.35 as=0 ps=0 w=0.84 l=0.15
X1054 sky130_fd_sc_hd__dfstp_1_2/a_652_21# V3R299 VDPWR VDPWR sky130_fd_pr__pfet_01v8_hvt ad=0 pd=0 as=0 ps=0 w=0.42 l=0.15
X1055 sky130_fd_sc_hd__dfstp_1_2/a_1224_47# sky130_fd_sc_hd__dfstp_1_2/a_27_47# sky130_fd_sc_hd__dfstp_1_2/a_1032_413# VGND sky130_fd_pr__nfet_01v8 ad=0.0882 pd=1.26 as=0.1386 ps=1.5 w=0.42 l=0.15
X1056 sky130_fd_sc_hd__dfstp_1_2/a_562_413# sky130_fd_sc_hd__dfstp_1_2/a_27_47# sky130_fd_sc_hd__dfstp_1_2/a_476_47# VDPWR sky130_fd_pr__pfet_01v8_hvt ad=0.189 pd=1.74 as=0.1134 ps=1.38 w=0.42 l=0.15
X1057 VGND sky130_fd_sc_hd__dfstp_1_2/a_1032_413# sky130_fd_sc_hd__dfstp_1_2/a_1602_47# VGND sky130_fd_pr__nfet_01v8 ad=0 pd=0 as=0.1092 ps=1.36 w=0.42 l=0.15
X1058 VDPWR sky130_fd_sc_hd__dfstp_1_2/a_1182_261# sky130_fd_sc_hd__dfstp_1_2/a_1140_413# VDPWR sky130_fd_pr__pfet_01v8_hvt ad=0 pd=0 as=0.0882 ps=1.26 w=0.42 l=0.15
X1059 V3R160 sky130_fd_sc_hd__dfstp_1_2/a_1602_47# VDPWR VDPWR sky130_fd_pr__pfet_01v8_hvt ad=0.26 pd=2.52 as=0 ps=0 w=1 l=0.15
X1060 sky130_fd_sc_hd__dfstp_1_2/a_1032_413# sky130_fd_sc_hd__dfstp_1_2/a_193_47# sky130_fd_sc_hd__dfstp_1_2/a_1056_47# VGND sky130_fd_pr__nfet_01v8 ad=0 pd=0 as=0 ps=0 w=0.42 l=0.15
X1061 sky130_fd_sc_hd__dfstp_1_2/a_476_47# sky130_fd_sc_hd__dfstp_1_2/a_193_47# sky130_fd_sc_hd__dfstp_1_2/a_381_47# VDPWR sky130_fd_pr__pfet_01v8_hvt ad=0 pd=0 as=0 ps=0 w=0.42 l=0.15
X1062 sky130_fd_sc_hd__dfstp_1_2/a_1296_47# sky130_fd_sc_hd__dfstp_1_2/a_1182_261# sky130_fd_sc_hd__dfstp_1_2/a_1224_47# VGND sky130_fd_pr__nfet_01v8 ad=0.0966 pd=1.3 as=0 ps=0 w=0.42 l=0.15
X1063 sky130_fd_sc_hd__dfstp_1_2/a_193_47# sky130_fd_sc_hd__dfstp_1_2/a_27_47# VGND VGND sky130_fd_pr__nfet_01v8 ad=0.1092 pd=1.36 as=0 ps=0 w=0.42 l=0.15
X1064 VDPWR sky130_fd_sc_hd__dfstp_1_2/a_652_21# sky130_fd_sc_hd__dfstp_1_2/a_562_413# VDPWR sky130_fd_pr__pfet_01v8_hvt ad=0 pd=0 as=0 ps=0 w=0.42 l=0.15
X1065 VDPWR V3R299 sky130_fd_sc_hd__dfstp_1_2/a_1032_413# VDPWR sky130_fd_pr__pfet_01v8_hvt ad=0 pd=0 as=0.273 ps=2.98 w=0.42 l=0.15
X1066 sky130_fd_sc_hd__dfstp_1_2/a_1032_413# sky130_fd_sc_hd__dfstp_1_2/a_27_47# sky130_fd_sc_hd__dfstp_1_2/a_956_413# VDPWR sky130_fd_pr__pfet_01v8_hvt ad=0 pd=0 as=0 ps=0 w=0.42 l=0.15
X1067 sky130_fd_sc_hd__dfstp_1_2/a_1182_261# sky130_fd_sc_hd__dfstp_1_2/a_1032_413# VDPWR VDPWR sky130_fd_pr__pfet_01v8_hvt ad=0.2184 pd=2.2 as=0 ps=0 w=0.84 l=0.15
X1068 V3R160 sky130_fd_sc_hd__dfstp_1_2/a_1602_47# VGND VGND sky130_fd_pr__nfet_01v8 ad=0.169 pd=1.82 as=0 ps=0 w=0.65 l=0.15
X1069 sky130_fd_sc_hd__dfstp_1_2/a_193_47# sky130_fd_sc_hd__dfstp_1_2/a_27_47# VDPWR VDPWR sky130_fd_pr__pfet_01v8_hvt ad=0.1664 pd=1.8 as=0 ps=0 w=0.64 l=0.15
X1070 sky130_fd_sc_hd__dfstp_1_2/a_1140_413# sky130_fd_sc_hd__dfstp_1_2/a_193_47# sky130_fd_sc_hd__dfstp_1_2/a_1032_413# VDPWR sky130_fd_pr__pfet_01v8_hvt ad=0 pd=0 as=0 ps=0 w=0.42 l=0.15
X1071 VDPWR sky130_fd_sc_hd__dfstp_1_2/a_1032_413# sky130_fd_sc_hd__dfstp_1_2/a_1602_47# VDPWR sky130_fd_pr__pfet_01v8_hvt ad=0 pd=0 as=0.1664 ps=1.8 w=0.64 l=0.15
X1072 sky130_fd_sc_hd__dfstp_1_2/a_796_47# V3R299 VGND VGND sky130_fd_pr__nfet_01v8 ad=0.0882 pd=1.26 as=0 ps=0 w=0.42 l=0.15
X1073 sky130_fd_sc_hd__dfstp_1_2/a_381_47# V3R105 VGND VGND sky130_fd_pr__nfet_01v8 ad=0 pd=0 as=0 ps=0 w=0.64 l=0.15
X1074 sky130_fd_sc_hd__dfstp_1_2/a_1182_261# sky130_fd_sc_hd__dfstp_1_2/a_1032_413# VGND VGND sky130_fd_pr__nfet_01v8 ad=0.1404 pd=1.6 as=0 ps=0 w=0.54 l=0.15
X1075 sky130_fd_sc_hd__dfstp_1_2/a_652_21# sky130_fd_sc_hd__dfstp_1_2/a_476_47# sky130_fd_sc_hd__dfstp_1_2/a_796_47# VGND sky130_fd_pr__nfet_01v8 ad=0.1092 pd=1.36 as=0 ps=0 w=0.42 l=0.15
X1076 VGND V3R056 sky130_fd_sc_hd__dfstp_1_2/a_27_47# VGND sky130_fd_pr__nfet_01v8 ad=0 pd=0 as=0.1092 ps=1.36 w=0.42 l=0.15
X1077 VGND V3R299 sky130_fd_sc_hd__dfstp_1_2/a_1296_47# VGND sky130_fd_pr__nfet_01v8 ad=0 pd=0 as=0 ps=0 w=0.42 l=0.15
X1078 V3R241 sky130_fd_sc_hd__xor2_1_7/a_35_297# sky130_fd_sc_hd__xor2_1_7/a_285_297# VDPWR sky130_fd_pr__pfet_01v8_hvt ad=0.3 pd=2.6 as=0.53 ps=5.06 w=1 l=0.15
X1079 V3R241 V3R067 sky130_fd_sc_hd__xor2_1_7/a_285_47# VGND sky130_fd_pr__nfet_01v8 ad=0.5005 pd=2.84 as=0.1755 ps=1.84 w=0.65 l=0.15
X1080 sky130_fd_sc_hd__xor2_1_7/a_35_297# V3R067 VGND VGND sky130_fd_pr__nfet_01v8 ad=0.1755 pd=1.84 as=0 ps=0 w=0.65 l=0.15
X1081 sky130_fd_sc_hd__xor2_1_7/a_117_297# V3R067 sky130_fd_sc_hd__xor2_1_7/a_35_297# VDPWR sky130_fd_pr__pfet_01v8_hvt ad=0.27 pd=2.54 as=0.26 ps=2.52 w=1 l=0.15
X1082 VDPWR V3R067 sky130_fd_sc_hd__xor2_1_7/a_285_297# VDPWR sky130_fd_pr__pfet_01v8_hvt ad=0 pd=0 as=0 ps=0 w=1 l=0.15
X1083 VGND V3R066 sky130_fd_sc_hd__xor2_1_7/a_35_297# VGND sky130_fd_pr__nfet_01v8 ad=0 pd=0 as=0 ps=0 w=0.65 l=0.15
X1084 VGND sky130_fd_sc_hd__xor2_1_7/a_35_297# V3R241 VGND sky130_fd_pr__nfet_01v8 ad=0 pd=0 as=0 ps=0 w=0.65 l=0.15
X1085 sky130_fd_sc_hd__xor2_1_7/a_285_297# V3R066 VDPWR VDPWR sky130_fd_pr__pfet_01v8_hvt ad=0 pd=0 as=0 ps=0 w=1 l=0.15
X1086 VDPWR V3R066 sky130_fd_sc_hd__xor2_1_7/a_117_297# VDPWR sky130_fd_pr__pfet_01v8_hvt ad=0 pd=0 as=0 ps=0 w=1 l=0.15
X1087 sky130_fd_sc_hd__xor2_1_7/a_285_47# V3R066 VGND VGND sky130_fd_pr__nfet_01v8 ad=0 pd=0 as=0 ps=0 w=0.65 l=0.15
X1088 VDPWR sky130_fd_sc_hd__mux2_1_8/a_505_21# sky130_fd_sc_hd__mux2_1_8/a_535_374# VDPWR sky130_fd_pr__pfet_01v8_hvt ad=0 pd=0 as=0.0882 ps=1.26 w=0.42 l=0.15
X1089 sky130_fd_sc_hd__mux2_1_8/a_505_21# V3R045 VDPWR VDPWR sky130_fd_pr__pfet_01v8_hvt ad=0.1176 pd=1.4 as=0 ps=0 w=0.42 l=0.15
X1090 sky130_fd_sc_hd__mux2_1_8/a_218_374# V3R045 VDPWR VDPWR sky130_fd_pr__pfet_01v8_hvt ad=0.1533 pd=1.57 as=0 ps=0 w=0.42 l=0.15
X1091 VGND sky130_fd_sc_hd__mux2_1_8/a_505_21# sky130_fd_sc_hd__mux2_1_8/a_439_47# VGND sky130_fd_pr__nfet_01v8 ad=0 pd=0 as=0.1386 ps=1.5 w=0.42 l=0.15
X1092 sky130_fd_sc_hd__mux2_1_8/a_76_199# V3R031 sky130_fd_sc_hd__mux2_1_8/a_218_374# VDPWR sky130_fd_pr__pfet_01v8_hvt ad=0.3864 pd=2.68 as=0 ps=0 w=0.42 l=0.15
X1093 sky130_fd_sc_hd__mux2_1_8/a_505_21# V3R045 VGND VGND sky130_fd_pr__nfet_01v8 ad=0.1092 pd=1.36 as=0 ps=0 w=0.42 l=0.15
X1094 sky130_fd_sc_hd__mux2_1_8/a_439_47# V3R031 sky130_fd_sc_hd__mux2_1_8/a_76_199# VGND sky130_fd_pr__nfet_01v8 ad=0 pd=0 as=0.1995 ps=1.79 w=0.42 l=0.15
X1095 sky130_fd_sc_hd__mux2_1_8/a_535_374# V3R170 sky130_fd_sc_hd__mux2_1_8/a_76_199# VDPWR sky130_fd_pr__pfet_01v8_hvt ad=0 pd=0 as=0 ps=0 w=0.42 l=0.15
X1096 sky130_fd_sc_hd__mux2_1_8/a_76_199# V3R170 sky130_fd_sc_hd__mux2_1_8/a_218_47# VGND sky130_fd_pr__nfet_01v8 ad=0 pd=0 as=0.1386 ps=1.5 w=0.42 l=0.15
X1097 sky130_fd_sc_hd__mux2_1_8/a_218_47# V3R045 VGND VGND sky130_fd_pr__nfet_01v8 ad=0 pd=0 as=0 ps=0 w=0.42 l=0.15
X1098 VDPWR sky130_fd_sc_hd__mux2_1_8/a_76_199# V3R146 VDPWR sky130_fd_pr__pfet_01v8_hvt ad=0 pd=0 as=0.26 ps=2.52 w=1 l=0.15
X1099 VGND sky130_fd_sc_hd__mux2_1_8/a_76_199# V3R146 VGND sky130_fd_pr__nfet_01v8 ad=0 pd=0 as=0.169 ps=1.82 w=0.65 l=0.15
X1100 sky130_fd_sc_hd__dfrtp_1_1/a_805_47# sky130_fd_sc_hd__dfrtp_1_1/a_761_289# sky130_fd_sc_hd__dfrtp_1_1/a_639_47# VGND sky130_fd_pr__nfet_01v8 ad=0.0882 pd=1.26 as=0.2802 ps=2.2 w=0.42 l=0.15
X1101 sky130_fd_sc_hd__dfrtp_1_1/a_1217_47# sky130_fd_sc_hd__dfrtp_1_1/a_27_47# sky130_fd_sc_hd__dfrtp_1_1/a_1108_47# VGND sky130_fd_pr__special_nfet_01v8 ad=0.1338 pd=1.5 as=0.1422 ps=1.51 w=0.36 l=0.15
X1102 sky130_fd_sc_hd__dfrtp_1_1/a_1283_21# sky130_fd_sc_hd__dfrtp_1_1/a_1108_47# sky130_fd_sc_hd__dfrtp_1_1/a_1462_47# VGND sky130_fd_pr__nfet_01v8 ad=0.1092 pd=1.36 as=0.1281 ps=1.45 w=0.42 l=0.15
X1103 sky130_fd_sc_hd__dfrtp_1_1/a_651_413# sky130_fd_sc_hd__dfrtp_1_1/a_27_47# sky130_fd_sc_hd__dfrtp_1_1/a_543_47# VDPWR sky130_fd_pr__pfet_01v8_hvt ad=0.3402 pd=3.3 as=0.1449 ps=1.53 w=0.42 l=0.15
X1104 sky130_fd_sc_hd__dfrtp_1_1/a_1108_47# sky130_fd_sc_hd__dfrtp_1_1/a_193_47# sky130_fd_sc_hd__dfrtp_1_1/a_761_289# VGND sky130_fd_pr__special_nfet_01v8 ad=0 pd=0 as=0.1998 ps=1.97 w=0.36 l=0.15
X1105 VGND V3R302 sky130_fd_sc_hd__dfrtp_1_1/a_805_47# VGND sky130_fd_pr__nfet_01v8 ad=0 pd=0 as=0 ps=0 w=0.42 l=0.15
X1106 V3R195 sky130_fd_sc_hd__dfrtp_1_1/a_1283_21# VDPWR VDPWR sky130_fd_pr__pfet_01v8_hvt ad=0.26 pd=2.52 as=0 ps=0 w=1 l=0.15
X1107 VDPWR V3R083 sky130_fd_sc_hd__dfrtp_1_1/a_27_47# VDPWR sky130_fd_pr__pfet_01v8_hvt ad=0 pd=0 as=0.1664 ps=1.8 w=0.64 l=0.15
X1108 sky130_fd_sc_hd__dfrtp_1_1/a_448_47# V3R047 VDPWR VDPWR sky130_fd_pr__pfet_01v8_hvt ad=0.1302 pd=1.46 as=0 ps=0 w=0.42 l=0.15
X1109 sky130_fd_sc_hd__dfrtp_1_1/a_761_289# sky130_fd_sc_hd__dfrtp_1_1/a_543_47# VGND VGND sky130_fd_pr__nfet_01v8 ad=0 pd=0 as=0 ps=0 w=0.64 l=0.15
X1110 sky130_fd_sc_hd__dfrtp_1_1/a_193_47# sky130_fd_sc_hd__dfrtp_1_1/a_27_47# VGND VGND sky130_fd_pr__nfet_01v8 ad=0.1092 pd=1.36 as=0 ps=0 w=0.42 l=0.15
X1111 sky130_fd_sc_hd__dfrtp_1_1/a_1108_47# sky130_fd_sc_hd__dfrtp_1_1/a_27_47# sky130_fd_sc_hd__dfrtp_1_1/a_761_289# VDPWR sky130_fd_pr__pfet_01v8_hvt ad=0.1176 pd=1.4 as=0.2583 ps=2.37 w=0.42 l=0.15
X1112 sky130_fd_sc_hd__dfrtp_1_1/a_1462_47# V3R302 VGND VGND sky130_fd_pr__nfet_01v8 ad=0 pd=0 as=0 ps=0 w=0.42 l=0.15
X1113 sky130_fd_sc_hd__dfrtp_1_1/a_543_47# sky130_fd_sc_hd__dfrtp_1_1/a_27_47# sky130_fd_sc_hd__dfrtp_1_1/a_448_47# VGND sky130_fd_pr__special_nfet_01v8 ad=0.1188 pd=1.38 as=0.132 ps=1.49 w=0.36 l=0.15
X1114 sky130_fd_sc_hd__dfrtp_1_1/a_543_47# sky130_fd_sc_hd__dfrtp_1_1/a_193_47# sky130_fd_sc_hd__dfrtp_1_1/a_448_47# VDPWR sky130_fd_pr__pfet_01v8_hvt ad=0 pd=0 as=0 ps=0 w=0.42 l=0.15
X1115 sky130_fd_sc_hd__dfrtp_1_1/a_448_47# V3R047 VGND VGND sky130_fd_pr__nfet_01v8 ad=0 pd=0 as=0 ps=0 w=0.42 l=0.15
X1116 VDPWR sky130_fd_sc_hd__dfrtp_1_1/a_1283_21# sky130_fd_sc_hd__dfrtp_1_1/a_1270_413# VDPWR sky130_fd_pr__pfet_01v8_hvt ad=0 pd=0 as=0.1134 ps=1.38 w=0.42 l=0.15
X1117 VDPWR sky130_fd_sc_hd__dfrtp_1_1/a_1108_47# sky130_fd_sc_hd__dfrtp_1_1/a_1283_21# VDPWR sky130_fd_pr__pfet_01v8_hvt ad=0 pd=0 as=0.1134 ps=1.38 w=0.42 l=0.15
X1118 sky130_fd_sc_hd__dfrtp_1_1/a_1270_413# sky130_fd_sc_hd__dfrtp_1_1/a_193_47# sky130_fd_sc_hd__dfrtp_1_1/a_1108_47# VDPWR sky130_fd_pr__pfet_01v8_hvt ad=0 pd=0 as=0 ps=0 w=0.42 l=0.15
X1119 sky130_fd_sc_hd__dfrtp_1_1/a_193_47# sky130_fd_sc_hd__dfrtp_1_1/a_27_47# VDPWR VDPWR sky130_fd_pr__pfet_01v8_hvt ad=0.1664 pd=1.8 as=0 ps=0 w=0.64 l=0.15
X1120 sky130_fd_sc_hd__dfrtp_1_1/a_1283_21# V3R302 VDPWR VDPWR sky130_fd_pr__pfet_01v8_hvt ad=0 pd=0 as=0 ps=0 w=0.42 l=0.15
X1121 VDPWR sky130_fd_sc_hd__dfrtp_1_1/a_761_289# sky130_fd_sc_hd__dfrtp_1_1/a_651_413# VDPWR sky130_fd_pr__pfet_01v8_hvt ad=0 pd=0 as=0 ps=0 w=0.42 l=0.15
X1122 V3R195 sky130_fd_sc_hd__dfrtp_1_1/a_1283_21# VGND VGND sky130_fd_pr__nfet_01v8 ad=0.169 pd=1.82 as=0 ps=0 w=0.65 l=0.15
X1123 sky130_fd_sc_hd__dfrtp_1_1/a_639_47# sky130_fd_sc_hd__dfrtp_1_1/a_193_47# sky130_fd_sc_hd__dfrtp_1_1/a_543_47# VGND sky130_fd_pr__special_nfet_01v8 ad=0 pd=0 as=0 ps=0 w=0.36 l=0.15
X1124 VGND sky130_fd_sc_hd__dfrtp_1_1/a_1283_21# sky130_fd_sc_hd__dfrtp_1_1/a_1217_47# VGND sky130_fd_pr__nfet_01v8 ad=0 pd=0 as=0 ps=0 w=0.42 l=0.15
X1125 sky130_fd_sc_hd__dfrtp_1_1/a_651_413# V3R302 VDPWR VDPWR sky130_fd_pr__pfet_01v8_hvt ad=0 pd=0 as=0 ps=0 w=0.42 l=0.15
X1126 VGND V3R083 sky130_fd_sc_hd__dfrtp_1_1/a_27_47# VGND sky130_fd_pr__nfet_01v8 ad=0 pd=0 as=0.1092 ps=1.36 w=0.42 l=0.15
X1127 sky130_fd_sc_hd__dfrtp_1_1/a_761_289# sky130_fd_sc_hd__dfrtp_1_1/a_543_47# VDPWR VDPWR sky130_fd_pr__pfet_01v8_hvt ad=0 pd=0 as=0 ps=0 w=0.84 l=0.15
X1128 sky130_fd_sc_hd__dfrtp_1_17/a_805_47# sky130_fd_sc_hd__dfrtp_1_17/a_761_289# sky130_fd_sc_hd__dfrtp_1_17/a_639_47# VGND sky130_fd_pr__nfet_01v8 ad=0.0882 pd=1.26 as=0.2802 ps=2.2 w=0.42 l=0.15
X1129 sky130_fd_sc_hd__dfrtp_1_17/a_1217_47# sky130_fd_sc_hd__dfrtp_1_17/a_27_47# sky130_fd_sc_hd__dfrtp_1_17/a_1108_47# VGND sky130_fd_pr__special_nfet_01v8 ad=0.1338 pd=1.5 as=0.1422 ps=1.51 w=0.36 l=0.15
X1130 sky130_fd_sc_hd__dfrtp_1_17/a_1283_21# sky130_fd_sc_hd__dfrtp_1_17/a_1108_47# sky130_fd_sc_hd__dfrtp_1_17/a_1462_47# VGND sky130_fd_pr__nfet_01v8 ad=0.1092 pd=1.36 as=0.1281 ps=1.45 w=0.42 l=0.15
X1131 sky130_fd_sc_hd__dfrtp_1_17/a_651_413# sky130_fd_sc_hd__dfrtp_1_17/a_27_47# sky130_fd_sc_hd__dfrtp_1_17/a_543_47# VDPWR sky130_fd_pr__pfet_01v8_hvt ad=0.3402 pd=3.3 as=0.1449 ps=1.53 w=0.42 l=0.15
X1132 sky130_fd_sc_hd__dfrtp_1_17/a_1108_47# sky130_fd_sc_hd__dfrtp_1_17/a_193_47# sky130_fd_sc_hd__dfrtp_1_17/a_761_289# VGND sky130_fd_pr__special_nfet_01v8 ad=0 pd=0 as=0.1998 ps=1.97 w=0.36 l=0.15
X1133 VGND V3R303 sky130_fd_sc_hd__dfrtp_1_17/a_805_47# VGND sky130_fd_pr__nfet_01v8 ad=0 pd=0 as=0 ps=0 w=0.42 l=0.15
X1134 V3R197 sky130_fd_sc_hd__dfrtp_1_17/a_1283_21# VDPWR VDPWR sky130_fd_pr__pfet_01v8_hvt ad=0.26 pd=2.52 as=0 ps=0 w=1 l=0.15
X1135 VDPWR V3R084 sky130_fd_sc_hd__dfrtp_1_17/a_27_47# VDPWR sky130_fd_pr__pfet_01v8_hvt ad=0 pd=0 as=0.1664 ps=1.8 w=0.64 l=0.15
X1136 sky130_fd_sc_hd__dfrtp_1_17/a_448_47# V3R049 VDPWR VDPWR sky130_fd_pr__pfet_01v8_hvt ad=0.1302 pd=1.46 as=0 ps=0 w=0.42 l=0.15
X1137 sky130_fd_sc_hd__dfrtp_1_17/a_761_289# sky130_fd_sc_hd__dfrtp_1_17/a_543_47# VGND VGND sky130_fd_pr__nfet_01v8 ad=0 pd=0 as=0 ps=0 w=0.64 l=0.15
X1138 sky130_fd_sc_hd__dfrtp_1_17/a_193_47# sky130_fd_sc_hd__dfrtp_1_17/a_27_47# VGND VGND sky130_fd_pr__nfet_01v8 ad=0.1092 pd=1.36 as=0 ps=0 w=0.42 l=0.15
X1139 sky130_fd_sc_hd__dfrtp_1_17/a_1108_47# sky130_fd_sc_hd__dfrtp_1_17/a_27_47# sky130_fd_sc_hd__dfrtp_1_17/a_761_289# VDPWR sky130_fd_pr__pfet_01v8_hvt ad=0.1176 pd=1.4 as=0.2583 ps=2.37 w=0.42 l=0.15
X1140 sky130_fd_sc_hd__dfrtp_1_17/a_1462_47# V3R303 VGND VGND sky130_fd_pr__nfet_01v8 ad=0 pd=0 as=0 ps=0 w=0.42 l=0.15
X1141 sky130_fd_sc_hd__dfrtp_1_17/a_543_47# sky130_fd_sc_hd__dfrtp_1_17/a_27_47# sky130_fd_sc_hd__dfrtp_1_17/a_448_47# VGND sky130_fd_pr__special_nfet_01v8 ad=0.1188 pd=1.38 as=0.132 ps=1.49 w=0.36 l=0.15
X1142 sky130_fd_sc_hd__dfrtp_1_17/a_543_47# sky130_fd_sc_hd__dfrtp_1_17/a_193_47# sky130_fd_sc_hd__dfrtp_1_17/a_448_47# VDPWR sky130_fd_pr__pfet_01v8_hvt ad=0 pd=0 as=0 ps=0 w=0.42 l=0.15
X1143 sky130_fd_sc_hd__dfrtp_1_17/a_448_47# V3R049 VGND VGND sky130_fd_pr__nfet_01v8 ad=0 pd=0 as=0 ps=0 w=0.42 l=0.15
X1144 VDPWR sky130_fd_sc_hd__dfrtp_1_17/a_1283_21# sky130_fd_sc_hd__dfrtp_1_17/a_1270_413# VDPWR sky130_fd_pr__pfet_01v8_hvt ad=0 pd=0 as=0.1134 ps=1.38 w=0.42 l=0.15
X1145 VDPWR sky130_fd_sc_hd__dfrtp_1_17/a_1108_47# sky130_fd_sc_hd__dfrtp_1_17/a_1283_21# VDPWR sky130_fd_pr__pfet_01v8_hvt ad=0 pd=0 as=0.1134 ps=1.38 w=0.42 l=0.15
X1146 sky130_fd_sc_hd__dfrtp_1_17/a_1270_413# sky130_fd_sc_hd__dfrtp_1_17/a_193_47# sky130_fd_sc_hd__dfrtp_1_17/a_1108_47# VDPWR sky130_fd_pr__pfet_01v8_hvt ad=0 pd=0 as=0 ps=0 w=0.42 l=0.15
X1147 sky130_fd_sc_hd__dfrtp_1_17/a_193_47# sky130_fd_sc_hd__dfrtp_1_17/a_27_47# VDPWR VDPWR sky130_fd_pr__pfet_01v8_hvt ad=0.1664 pd=1.8 as=0 ps=0 w=0.64 l=0.15
X1148 sky130_fd_sc_hd__dfrtp_1_17/a_1283_21# V3R303 VDPWR VDPWR sky130_fd_pr__pfet_01v8_hvt ad=0 pd=0 as=0 ps=0 w=0.42 l=0.15
X1149 VDPWR sky130_fd_sc_hd__dfrtp_1_17/a_761_289# sky130_fd_sc_hd__dfrtp_1_17/a_651_413# VDPWR sky130_fd_pr__pfet_01v8_hvt ad=0 pd=0 as=0 ps=0 w=0.42 l=0.15
X1150 V3R197 sky130_fd_sc_hd__dfrtp_1_17/a_1283_21# VGND VGND sky130_fd_pr__nfet_01v8 ad=0.169 pd=1.82 as=0 ps=0 w=0.65 l=0.15
X1151 sky130_fd_sc_hd__dfrtp_1_17/a_639_47# sky130_fd_sc_hd__dfrtp_1_17/a_193_47# sky130_fd_sc_hd__dfrtp_1_17/a_543_47# VGND sky130_fd_pr__special_nfet_01v8 ad=0 pd=0 as=0 ps=0 w=0.36 l=0.15
X1152 VGND sky130_fd_sc_hd__dfrtp_1_17/a_1283_21# sky130_fd_sc_hd__dfrtp_1_17/a_1217_47# VGND sky130_fd_pr__nfet_01v8 ad=0 pd=0 as=0 ps=0 w=0.42 l=0.15
X1153 sky130_fd_sc_hd__dfrtp_1_17/a_651_413# V3R303 VDPWR VDPWR sky130_fd_pr__pfet_01v8_hvt ad=0 pd=0 as=0 ps=0 w=0.42 l=0.15
X1154 VGND V3R084 sky130_fd_sc_hd__dfrtp_1_17/a_27_47# VGND sky130_fd_pr__nfet_01v8 ad=0 pd=0 as=0.1092 ps=1.36 w=0.42 l=0.15
X1155 sky130_fd_sc_hd__dfrtp_1_17/a_761_289# sky130_fd_sc_hd__dfrtp_1_17/a_543_47# VDPWR VDPWR sky130_fd_pr__pfet_01v8_hvt ad=0 pd=0 as=0 ps=0 w=0.84 l=0.15
X1156 sky130_fd_sc_hd__dfrtp_1_39/a_805_47# sky130_fd_sc_hd__dfrtp_1_39/a_761_289# sky130_fd_sc_hd__dfrtp_1_39/a_639_47# VGND sky130_fd_pr__nfet_01v8 ad=0.0882 pd=1.26 as=0.2802 ps=2.2 w=0.42 l=0.15
X1157 sky130_fd_sc_hd__dfrtp_1_39/a_1217_47# sky130_fd_sc_hd__dfrtp_1_39/a_27_47# sky130_fd_sc_hd__dfrtp_1_39/a_1108_47# VGND sky130_fd_pr__special_nfet_01v8 ad=0.1338 pd=1.5 as=0.1422 ps=1.51 w=0.36 l=0.15
X1158 sky130_fd_sc_hd__dfrtp_1_39/a_1283_21# sky130_fd_sc_hd__dfrtp_1_39/a_1108_47# sky130_fd_sc_hd__dfrtp_1_39/a_1462_47# VGND sky130_fd_pr__nfet_01v8 ad=0.1092 pd=1.36 as=0.1281 ps=1.45 w=0.42 l=0.15
X1159 sky130_fd_sc_hd__dfrtp_1_39/a_651_413# sky130_fd_sc_hd__dfrtp_1_39/a_27_47# sky130_fd_sc_hd__dfrtp_1_39/a_543_47# VDPWR sky130_fd_pr__pfet_01v8_hvt ad=0.3402 pd=3.3 as=0.1449 ps=1.53 w=0.42 l=0.15
X1160 sky130_fd_sc_hd__dfrtp_1_39/a_1108_47# sky130_fd_sc_hd__dfrtp_1_39/a_193_47# sky130_fd_sc_hd__dfrtp_1_39/a_761_289# VGND sky130_fd_pr__special_nfet_01v8 ad=0 pd=0 as=0.1998 ps=1.97 w=0.36 l=0.15
X1161 VGND V3R299 sky130_fd_sc_hd__dfrtp_1_39/a_805_47# VGND sky130_fd_pr__nfet_01v8 ad=0 pd=0 as=0 ps=0 w=0.42 l=0.15
X1162 V3R163 sky130_fd_sc_hd__dfrtp_1_39/a_1283_21# VDPWR VDPWR sky130_fd_pr__pfet_01v8_hvt ad=0.26 pd=2.52 as=0 ps=0 w=1 l=0.15
X1163 VDPWR V3R056 sky130_fd_sc_hd__dfrtp_1_39/a_27_47# VDPWR sky130_fd_pr__pfet_01v8_hvt ad=0 pd=0 as=0.1664 ps=1.8 w=0.64 l=0.15
X1164 sky130_fd_sc_hd__dfrtp_1_39/a_448_47# V3R107 VDPWR VDPWR sky130_fd_pr__pfet_01v8_hvt ad=0.1302 pd=1.46 as=0 ps=0 w=0.42 l=0.15
X1165 sky130_fd_sc_hd__dfrtp_1_39/a_761_289# sky130_fd_sc_hd__dfrtp_1_39/a_543_47# VGND VGND sky130_fd_pr__nfet_01v8 ad=0 pd=0 as=0 ps=0 w=0.64 l=0.15
X1166 sky130_fd_sc_hd__dfrtp_1_39/a_193_47# sky130_fd_sc_hd__dfrtp_1_39/a_27_47# VGND VGND sky130_fd_pr__nfet_01v8 ad=0.1092 pd=1.36 as=0 ps=0 w=0.42 l=0.15
X1167 sky130_fd_sc_hd__dfrtp_1_39/a_1108_47# sky130_fd_sc_hd__dfrtp_1_39/a_27_47# sky130_fd_sc_hd__dfrtp_1_39/a_761_289# VDPWR sky130_fd_pr__pfet_01v8_hvt ad=0.1176 pd=1.4 as=0.2583 ps=2.37 w=0.42 l=0.15
X1168 sky130_fd_sc_hd__dfrtp_1_39/a_1462_47# V3R299 VGND VGND sky130_fd_pr__nfet_01v8 ad=0 pd=0 as=0 ps=0 w=0.42 l=0.15
X1169 sky130_fd_sc_hd__dfrtp_1_39/a_543_47# sky130_fd_sc_hd__dfrtp_1_39/a_27_47# sky130_fd_sc_hd__dfrtp_1_39/a_448_47# VGND sky130_fd_pr__special_nfet_01v8 ad=0.1188 pd=1.38 as=0.132 ps=1.49 w=0.36 l=0.15
X1170 sky130_fd_sc_hd__dfrtp_1_39/a_543_47# sky130_fd_sc_hd__dfrtp_1_39/a_193_47# sky130_fd_sc_hd__dfrtp_1_39/a_448_47# VDPWR sky130_fd_pr__pfet_01v8_hvt ad=0 pd=0 as=0 ps=0 w=0.42 l=0.15
X1171 sky130_fd_sc_hd__dfrtp_1_39/a_448_47# V3R107 VGND VGND sky130_fd_pr__nfet_01v8 ad=0 pd=0 as=0 ps=0 w=0.42 l=0.15
X1172 VDPWR sky130_fd_sc_hd__dfrtp_1_39/a_1283_21# sky130_fd_sc_hd__dfrtp_1_39/a_1270_413# VDPWR sky130_fd_pr__pfet_01v8_hvt ad=0 pd=0 as=0.1134 ps=1.38 w=0.42 l=0.15
X1173 VDPWR sky130_fd_sc_hd__dfrtp_1_39/a_1108_47# sky130_fd_sc_hd__dfrtp_1_39/a_1283_21# VDPWR sky130_fd_pr__pfet_01v8_hvt ad=0 pd=0 as=0.1134 ps=1.38 w=0.42 l=0.15
X1174 sky130_fd_sc_hd__dfrtp_1_39/a_1270_413# sky130_fd_sc_hd__dfrtp_1_39/a_193_47# sky130_fd_sc_hd__dfrtp_1_39/a_1108_47# VDPWR sky130_fd_pr__pfet_01v8_hvt ad=0 pd=0 as=0 ps=0 w=0.42 l=0.15
X1175 sky130_fd_sc_hd__dfrtp_1_39/a_193_47# sky130_fd_sc_hd__dfrtp_1_39/a_27_47# VDPWR VDPWR sky130_fd_pr__pfet_01v8_hvt ad=0.1664 pd=1.8 as=0 ps=0 w=0.64 l=0.15
X1176 sky130_fd_sc_hd__dfrtp_1_39/a_1283_21# V3R299 VDPWR VDPWR sky130_fd_pr__pfet_01v8_hvt ad=0 pd=0 as=0 ps=0 w=0.42 l=0.15
X1177 VDPWR sky130_fd_sc_hd__dfrtp_1_39/a_761_289# sky130_fd_sc_hd__dfrtp_1_39/a_651_413# VDPWR sky130_fd_pr__pfet_01v8_hvt ad=0 pd=0 as=0 ps=0 w=0.42 l=0.15
X1178 V3R163 sky130_fd_sc_hd__dfrtp_1_39/a_1283_21# VGND VGND sky130_fd_pr__nfet_01v8 ad=0.169 pd=1.82 as=0 ps=0 w=0.65 l=0.15
X1179 sky130_fd_sc_hd__dfrtp_1_39/a_639_47# sky130_fd_sc_hd__dfrtp_1_39/a_193_47# sky130_fd_sc_hd__dfrtp_1_39/a_543_47# VGND sky130_fd_pr__special_nfet_01v8 ad=0 pd=0 as=0 ps=0 w=0.36 l=0.15
X1180 VGND sky130_fd_sc_hd__dfrtp_1_39/a_1283_21# sky130_fd_sc_hd__dfrtp_1_39/a_1217_47# VGND sky130_fd_pr__nfet_01v8 ad=0 pd=0 as=0 ps=0 w=0.42 l=0.15
X1181 sky130_fd_sc_hd__dfrtp_1_39/a_651_413# V3R299 VDPWR VDPWR sky130_fd_pr__pfet_01v8_hvt ad=0 pd=0 as=0 ps=0 w=0.42 l=0.15
X1182 VGND V3R056 sky130_fd_sc_hd__dfrtp_1_39/a_27_47# VGND sky130_fd_pr__nfet_01v8 ad=0 pd=0 as=0.1092 ps=1.36 w=0.42 l=0.15
X1183 sky130_fd_sc_hd__dfrtp_1_39/a_761_289# sky130_fd_sc_hd__dfrtp_1_39/a_543_47# VDPWR VDPWR sky130_fd_pr__pfet_01v8_hvt ad=0 pd=0 as=0 ps=0 w=0.84 l=0.15
X1184 sky130_fd_sc_hd__dfrtp_1_28/a_805_47# sky130_fd_sc_hd__dfrtp_1_28/a_761_289# sky130_fd_sc_hd__dfrtp_1_28/a_639_47# VGND sky130_fd_pr__nfet_01v8 ad=0.0882 pd=1.26 as=0.2802 ps=2.2 w=0.42 l=0.15
X1185 sky130_fd_sc_hd__dfrtp_1_28/a_1217_47# sky130_fd_sc_hd__dfrtp_1_28/a_27_47# sky130_fd_sc_hd__dfrtp_1_28/a_1108_47# VGND sky130_fd_pr__special_nfet_01v8 ad=0.1338 pd=1.5 as=0.1422 ps=1.51 w=0.36 l=0.15
X1186 sky130_fd_sc_hd__dfrtp_1_28/a_1283_21# sky130_fd_sc_hd__dfrtp_1_28/a_1108_47# sky130_fd_sc_hd__dfrtp_1_28/a_1462_47# VGND sky130_fd_pr__nfet_01v8 ad=0.1092 pd=1.36 as=0.1281 ps=1.45 w=0.42 l=0.15
X1187 sky130_fd_sc_hd__dfrtp_1_28/a_651_413# sky130_fd_sc_hd__dfrtp_1_28/a_27_47# sky130_fd_sc_hd__dfrtp_1_28/a_543_47# VDPWR sky130_fd_pr__pfet_01v8_hvt ad=0.3402 pd=3.3 as=0.1449 ps=1.53 w=0.42 l=0.15
X1188 sky130_fd_sc_hd__dfrtp_1_28/a_1108_47# sky130_fd_sc_hd__dfrtp_1_28/a_193_47# sky130_fd_sc_hd__dfrtp_1_28/a_761_289# VGND sky130_fd_pr__special_nfet_01v8 ad=0 pd=0 as=0.1998 ps=1.97 w=0.36 l=0.15
X1189 VGND V3R303 sky130_fd_sc_hd__dfrtp_1_28/a_805_47# VGND sky130_fd_pr__nfet_01v8 ad=0 pd=0 as=0 ps=0 w=0.42 l=0.15
X1190 V3R201 sky130_fd_sc_hd__dfrtp_1_28/a_1283_21# VDPWR VDPWR sky130_fd_pr__pfet_01v8_hvt ad=0.26 pd=2.52 as=0 ps=0 w=1 l=0.15
X1191 VDPWR V3R084 sky130_fd_sc_hd__dfrtp_1_28/a_27_47# VDPWR sky130_fd_pr__pfet_01v8_hvt ad=0 pd=0 as=0.1664 ps=1.8 w=0.64 l=0.15
X1192 sky130_fd_sc_hd__dfrtp_1_28/a_448_47# V3R074 VDPWR VDPWR sky130_fd_pr__pfet_01v8_hvt ad=0.1302 pd=1.46 as=0 ps=0 w=0.42 l=0.15
X1193 sky130_fd_sc_hd__dfrtp_1_28/a_761_289# sky130_fd_sc_hd__dfrtp_1_28/a_543_47# VGND VGND sky130_fd_pr__nfet_01v8 ad=0 pd=0 as=0 ps=0 w=0.64 l=0.15
X1194 sky130_fd_sc_hd__dfrtp_1_28/a_193_47# sky130_fd_sc_hd__dfrtp_1_28/a_27_47# VGND VGND sky130_fd_pr__nfet_01v8 ad=0.1092 pd=1.36 as=0 ps=0 w=0.42 l=0.15
X1195 sky130_fd_sc_hd__dfrtp_1_28/a_1108_47# sky130_fd_sc_hd__dfrtp_1_28/a_27_47# sky130_fd_sc_hd__dfrtp_1_28/a_761_289# VDPWR sky130_fd_pr__pfet_01v8_hvt ad=0.1176 pd=1.4 as=0.2583 ps=2.37 w=0.42 l=0.15
X1196 sky130_fd_sc_hd__dfrtp_1_28/a_1462_47# V3R303 VGND VGND sky130_fd_pr__nfet_01v8 ad=0 pd=0 as=0 ps=0 w=0.42 l=0.15
X1197 sky130_fd_sc_hd__dfrtp_1_28/a_543_47# sky130_fd_sc_hd__dfrtp_1_28/a_27_47# sky130_fd_sc_hd__dfrtp_1_28/a_448_47# VGND sky130_fd_pr__special_nfet_01v8 ad=0.1188 pd=1.38 as=0.132 ps=1.49 w=0.36 l=0.15
X1198 sky130_fd_sc_hd__dfrtp_1_28/a_543_47# sky130_fd_sc_hd__dfrtp_1_28/a_193_47# sky130_fd_sc_hd__dfrtp_1_28/a_448_47# VDPWR sky130_fd_pr__pfet_01v8_hvt ad=0 pd=0 as=0 ps=0 w=0.42 l=0.15
X1199 sky130_fd_sc_hd__dfrtp_1_28/a_448_47# V3R074 VGND VGND sky130_fd_pr__nfet_01v8 ad=0 pd=0 as=0 ps=0 w=0.42 l=0.15
X1200 VDPWR sky130_fd_sc_hd__dfrtp_1_28/a_1283_21# sky130_fd_sc_hd__dfrtp_1_28/a_1270_413# VDPWR sky130_fd_pr__pfet_01v8_hvt ad=0 pd=0 as=0.1134 ps=1.38 w=0.42 l=0.15
X1201 VDPWR sky130_fd_sc_hd__dfrtp_1_28/a_1108_47# sky130_fd_sc_hd__dfrtp_1_28/a_1283_21# VDPWR sky130_fd_pr__pfet_01v8_hvt ad=0 pd=0 as=0.1134 ps=1.38 w=0.42 l=0.15
X1202 sky130_fd_sc_hd__dfrtp_1_28/a_1270_413# sky130_fd_sc_hd__dfrtp_1_28/a_193_47# sky130_fd_sc_hd__dfrtp_1_28/a_1108_47# VDPWR sky130_fd_pr__pfet_01v8_hvt ad=0 pd=0 as=0 ps=0 w=0.42 l=0.15
X1203 sky130_fd_sc_hd__dfrtp_1_28/a_193_47# sky130_fd_sc_hd__dfrtp_1_28/a_27_47# VDPWR VDPWR sky130_fd_pr__pfet_01v8_hvt ad=0.1664 pd=1.8 as=0 ps=0 w=0.64 l=0.15
X1204 sky130_fd_sc_hd__dfrtp_1_28/a_1283_21# V3R303 VDPWR VDPWR sky130_fd_pr__pfet_01v8_hvt ad=0 pd=0 as=0 ps=0 w=0.42 l=0.15
X1205 VDPWR sky130_fd_sc_hd__dfrtp_1_28/a_761_289# sky130_fd_sc_hd__dfrtp_1_28/a_651_413# VDPWR sky130_fd_pr__pfet_01v8_hvt ad=0 pd=0 as=0 ps=0 w=0.42 l=0.15
X1206 V3R201 sky130_fd_sc_hd__dfrtp_1_28/a_1283_21# VGND VGND sky130_fd_pr__nfet_01v8 ad=0.169 pd=1.82 as=0 ps=0 w=0.65 l=0.15
X1207 sky130_fd_sc_hd__dfrtp_1_28/a_639_47# sky130_fd_sc_hd__dfrtp_1_28/a_193_47# sky130_fd_sc_hd__dfrtp_1_28/a_543_47# VGND sky130_fd_pr__special_nfet_01v8 ad=0 pd=0 as=0 ps=0 w=0.36 l=0.15
X1208 VGND sky130_fd_sc_hd__dfrtp_1_28/a_1283_21# sky130_fd_sc_hd__dfrtp_1_28/a_1217_47# VGND sky130_fd_pr__nfet_01v8 ad=0 pd=0 as=0 ps=0 w=0.42 l=0.15
X1209 sky130_fd_sc_hd__dfrtp_1_28/a_651_413# V3R303 VDPWR VDPWR sky130_fd_pr__pfet_01v8_hvt ad=0 pd=0 as=0 ps=0 w=0.42 l=0.15
X1210 VGND V3R084 sky130_fd_sc_hd__dfrtp_1_28/a_27_47# VGND sky130_fd_pr__nfet_01v8 ad=0 pd=0 as=0.1092 ps=1.36 w=0.42 l=0.15
X1211 sky130_fd_sc_hd__dfrtp_1_28/a_761_289# sky130_fd_sc_hd__dfrtp_1_28/a_543_47# VDPWR VDPWR sky130_fd_pr__pfet_01v8_hvt ad=0 pd=0 as=0 ps=0 w=0.84 l=0.15
X1212 VDPWR V3R283 sky130_fd_sc_hd__nor2_1_0/a_109_297# VDPWR sky130_fd_pr__pfet_01v8_hvt ad=0.26 pd=2.52 as=0.105 ps=1.21 w=1 l=0.15
X1213 VGND V3R283 V3R284 VGND sky130_fd_pr__nfet_01v8 ad=0.169 pd=1.82 as=0.08775 ps=0.92 w=0.65 l=0.15
X1214 sky130_fd_sc_hd__nor2_1_0/a_109_297# V3R276 V3R284 VDPWR sky130_fd_pr__pfet_01v8_hvt ad=0.105 pd=1.21 as=0.26 ps=2.52 w=1 l=0.15
X1215 V3R284 V3R276 VGND VGND sky130_fd_pr__nfet_01v8 ad=0.08775 pd=0.92 as=0.169 ps=1.82 w=0.65 l=0.15
X1216 VGND sky130_fd_sc_hd__dfstp_1_3/a_652_21# sky130_fd_sc_hd__dfstp_1_3/a_586_47# VGND sky130_fd_pr__nfet_01v8 ad=0 pd=0 as=0.1341 ps=1.5 w=0.42 l=0.15
X1217 sky130_fd_sc_hd__dfstp_1_3/a_956_413# sky130_fd_sc_hd__dfstp_1_3/a_476_47# VDPWR VDPWR sky130_fd_pr__pfet_01v8_hvt ad=0.0966 pd=1.3 as=0 ps=0 w=0.42 l=0.15
X1218 VDPWR sky130_fd_sc_hd__dfstp_1_3/a_476_47# sky130_fd_sc_hd__dfstp_1_3/a_652_21# VDPWR sky130_fd_pr__pfet_01v8_hvt ad=0 pd=0 as=0.1134 ps=1.38 w=0.42 l=0.15
X1219 VDPWR V3R082 sky130_fd_sc_hd__dfstp_1_3/a_27_47# VDPWR sky130_fd_pr__pfet_01v8_hvt ad=0 pd=0 as=0.1664 ps=1.8 w=0.64 l=0.15
X1220 sky130_fd_sc_hd__dfstp_1_3/a_586_47# sky130_fd_sc_hd__dfstp_1_3/a_193_47# sky130_fd_sc_hd__dfstp_1_3/a_476_47# VGND sky130_fd_pr__special_nfet_01v8 ad=0 pd=0 as=0.144 ps=1.52 w=0.36 l=0.15
X1221 sky130_fd_sc_hd__dfstp_1_3/a_1056_47# sky130_fd_sc_hd__dfstp_1_3/a_476_47# VGND VGND sky130_fd_pr__nfet_01v8 ad=0.0882 pd=1.26 as=0 ps=0 w=0.42 l=0.15
X1222 sky130_fd_sc_hd__dfstp_1_3/a_476_47# sky130_fd_sc_hd__dfstp_1_3/a_27_47# sky130_fd_sc_hd__dfstp_1_3/a_381_47# VGND sky130_fd_pr__special_nfet_01v8 ad=0 pd=0 as=0.187 ps=1.93 w=0.36 l=0.15
X1223 sky130_fd_sc_hd__dfstp_1_3/a_381_47# V3R137 VDPWR VDPWR sky130_fd_pr__pfet_01v8_hvt ad=0.2499 pd=2.35 as=0 ps=0 w=0.84 l=0.15
X1224 sky130_fd_sc_hd__dfstp_1_3/a_652_21# V3R301 VDPWR VDPWR sky130_fd_pr__pfet_01v8_hvt ad=0 pd=0 as=0 ps=0 w=0.42 l=0.15
X1225 sky130_fd_sc_hd__dfstp_1_3/a_1224_47# sky130_fd_sc_hd__dfstp_1_3/a_27_47# sky130_fd_sc_hd__dfstp_1_3/a_1032_413# VGND sky130_fd_pr__nfet_01v8 ad=0.0882 pd=1.26 as=0.1386 ps=1.5 w=0.42 l=0.15
X1226 sky130_fd_sc_hd__dfstp_1_3/a_562_413# sky130_fd_sc_hd__dfstp_1_3/a_27_47# sky130_fd_sc_hd__dfstp_1_3/a_476_47# VDPWR sky130_fd_pr__pfet_01v8_hvt ad=0.189 pd=1.74 as=0.1134 ps=1.38 w=0.42 l=0.15
X1227 VGND sky130_fd_sc_hd__dfstp_1_3/a_1032_413# sky130_fd_sc_hd__dfstp_1_3/a_1602_47# VGND sky130_fd_pr__nfet_01v8 ad=0 pd=0 as=0.1092 ps=1.36 w=0.42 l=0.15
X1228 VDPWR sky130_fd_sc_hd__dfstp_1_3/a_1182_261# sky130_fd_sc_hd__dfstp_1_3/a_1140_413# VDPWR sky130_fd_pr__pfet_01v8_hvt ad=0 pd=0 as=0.0882 ps=1.26 w=0.42 l=0.15
X1229 V3R021 sky130_fd_sc_hd__dfstp_1_3/a_1602_47# VDPWR VDPWR sky130_fd_pr__pfet_01v8_hvt ad=0.26 pd=2.52 as=0 ps=0 w=1 l=0.15
X1230 sky130_fd_sc_hd__dfstp_1_3/a_1032_413# sky130_fd_sc_hd__dfstp_1_3/a_193_47# sky130_fd_sc_hd__dfstp_1_3/a_1056_47# VGND sky130_fd_pr__nfet_01v8 ad=0 pd=0 as=0 ps=0 w=0.42 l=0.15
X1231 sky130_fd_sc_hd__dfstp_1_3/a_476_47# sky130_fd_sc_hd__dfstp_1_3/a_193_47# sky130_fd_sc_hd__dfstp_1_3/a_381_47# VDPWR sky130_fd_pr__pfet_01v8_hvt ad=0 pd=0 as=0 ps=0 w=0.42 l=0.15
X1232 sky130_fd_sc_hd__dfstp_1_3/a_1296_47# sky130_fd_sc_hd__dfstp_1_3/a_1182_261# sky130_fd_sc_hd__dfstp_1_3/a_1224_47# VGND sky130_fd_pr__nfet_01v8 ad=0.0966 pd=1.3 as=0 ps=0 w=0.42 l=0.15
X1233 sky130_fd_sc_hd__dfstp_1_3/a_193_47# sky130_fd_sc_hd__dfstp_1_3/a_27_47# VGND VGND sky130_fd_pr__nfet_01v8 ad=0.1092 pd=1.36 as=0 ps=0 w=0.42 l=0.15
X1234 VDPWR sky130_fd_sc_hd__dfstp_1_3/a_652_21# sky130_fd_sc_hd__dfstp_1_3/a_562_413# VDPWR sky130_fd_pr__pfet_01v8_hvt ad=0 pd=0 as=0 ps=0 w=0.42 l=0.15
X1235 VDPWR V3R301 sky130_fd_sc_hd__dfstp_1_3/a_1032_413# VDPWR sky130_fd_pr__pfet_01v8_hvt ad=0 pd=0 as=0.273 ps=2.98 w=0.42 l=0.15
X1236 sky130_fd_sc_hd__dfstp_1_3/a_1032_413# sky130_fd_sc_hd__dfstp_1_3/a_27_47# sky130_fd_sc_hd__dfstp_1_3/a_956_413# VDPWR sky130_fd_pr__pfet_01v8_hvt ad=0 pd=0 as=0 ps=0 w=0.42 l=0.15
X1237 sky130_fd_sc_hd__dfstp_1_3/a_1182_261# sky130_fd_sc_hd__dfstp_1_3/a_1032_413# VDPWR VDPWR sky130_fd_pr__pfet_01v8_hvt ad=0.2184 pd=2.2 as=0 ps=0 w=0.84 l=0.15
X1238 V3R021 sky130_fd_sc_hd__dfstp_1_3/a_1602_47# VGND VGND sky130_fd_pr__nfet_01v8 ad=0.169 pd=1.82 as=0 ps=0 w=0.65 l=0.15
X1239 sky130_fd_sc_hd__dfstp_1_3/a_193_47# sky130_fd_sc_hd__dfstp_1_3/a_27_47# VDPWR VDPWR sky130_fd_pr__pfet_01v8_hvt ad=0.1664 pd=1.8 as=0 ps=0 w=0.64 l=0.15
X1240 sky130_fd_sc_hd__dfstp_1_3/a_1140_413# sky130_fd_sc_hd__dfstp_1_3/a_193_47# sky130_fd_sc_hd__dfstp_1_3/a_1032_413# VDPWR sky130_fd_pr__pfet_01v8_hvt ad=0 pd=0 as=0 ps=0 w=0.42 l=0.15
X1241 VDPWR sky130_fd_sc_hd__dfstp_1_3/a_1032_413# sky130_fd_sc_hd__dfstp_1_3/a_1602_47# VDPWR sky130_fd_pr__pfet_01v8_hvt ad=0 pd=0 as=0.1664 ps=1.8 w=0.64 l=0.15
X1242 sky130_fd_sc_hd__dfstp_1_3/a_796_47# V3R301 VGND VGND sky130_fd_pr__nfet_01v8 ad=0.0882 pd=1.26 as=0 ps=0 w=0.42 l=0.15
X1243 sky130_fd_sc_hd__dfstp_1_3/a_381_47# V3R137 VGND VGND sky130_fd_pr__nfet_01v8 ad=0 pd=0 as=0 ps=0 w=0.64 l=0.15
X1244 sky130_fd_sc_hd__dfstp_1_3/a_1182_261# sky130_fd_sc_hd__dfstp_1_3/a_1032_413# VGND VGND sky130_fd_pr__nfet_01v8 ad=0.1404 pd=1.6 as=0 ps=0 w=0.54 l=0.15
X1245 sky130_fd_sc_hd__dfstp_1_3/a_652_21# sky130_fd_sc_hd__dfstp_1_3/a_476_47# sky130_fd_sc_hd__dfstp_1_3/a_796_47# VGND sky130_fd_pr__nfet_01v8 ad=0.1092 pd=1.36 as=0 ps=0 w=0.42 l=0.15
X1246 VGND V3R082 sky130_fd_sc_hd__dfstp_1_3/a_27_47# VGND sky130_fd_pr__nfet_01v8 ad=0 pd=0 as=0.1092 ps=1.36 w=0.42 l=0.15
X1247 VGND V3R301 sky130_fd_sc_hd__dfstp_1_3/a_1296_47# VGND sky130_fd_pr__nfet_01v8 ad=0 pd=0 as=0 ps=0 w=0.42 l=0.15
X1248 V3R243 sky130_fd_sc_hd__xor2_1_8/a_35_297# sky130_fd_sc_hd__xor2_1_8/a_285_297# VDPWR sky130_fd_pr__pfet_01v8_hvt ad=0.3 pd=2.6 as=0.53 ps=5.06 w=1 l=0.15
X1249 V3R243 V3R001 sky130_fd_sc_hd__xor2_1_8/a_285_47# VGND sky130_fd_pr__nfet_01v8 ad=0.5005 pd=2.84 as=0.1755 ps=1.84 w=0.65 l=0.15
X1250 sky130_fd_sc_hd__xor2_1_8/a_35_297# V3R001 VGND VGND sky130_fd_pr__nfet_01v8 ad=0.1755 pd=1.84 as=0 ps=0 w=0.65 l=0.15
X1251 sky130_fd_sc_hd__xor2_1_8/a_117_297# V3R001 sky130_fd_sc_hd__xor2_1_8/a_35_297# VDPWR sky130_fd_pr__pfet_01v8_hvt ad=0.27 pd=2.54 as=0.26 ps=2.52 w=1 l=0.15
X1252 VDPWR V3R001 sky130_fd_sc_hd__xor2_1_8/a_285_297# VDPWR sky130_fd_pr__pfet_01v8_hvt ad=0 pd=0 as=0 ps=0 w=1 l=0.15
X1253 VGND V3R002 sky130_fd_sc_hd__xor2_1_8/a_35_297# VGND sky130_fd_pr__nfet_01v8 ad=0 pd=0 as=0 ps=0 w=0.65 l=0.15
X1254 VGND sky130_fd_sc_hd__xor2_1_8/a_35_297# V3R243 VGND sky130_fd_pr__nfet_01v8 ad=0 pd=0 as=0 ps=0 w=0.65 l=0.15
X1255 sky130_fd_sc_hd__xor2_1_8/a_285_297# V3R002 VDPWR VDPWR sky130_fd_pr__pfet_01v8_hvt ad=0 pd=0 as=0 ps=0 w=1 l=0.15
X1256 VDPWR V3R002 sky130_fd_sc_hd__xor2_1_8/a_117_297# VDPWR sky130_fd_pr__pfet_01v8_hvt ad=0 pd=0 as=0 ps=0 w=1 l=0.15
X1257 sky130_fd_sc_hd__xor2_1_8/a_285_47# V3R002 VGND VGND sky130_fd_pr__nfet_01v8 ad=0 pd=0 as=0 ps=0 w=0.65 l=0.15
X1258 VDPWR sky130_fd_sc_hd__mux2_1_9/a_505_21# sky130_fd_sc_hd__mux2_1_9/a_535_374# VDPWR sky130_fd_pr__pfet_01v8_hvt ad=0 pd=0 as=0.0882 ps=1.26 w=0.42 l=0.15
X1259 sky130_fd_sc_hd__mux2_1_9/a_505_21# V3R062 VDPWR VDPWR sky130_fd_pr__pfet_01v8_hvt ad=0.1176 pd=1.4 as=0 ps=0 w=0.42 l=0.15
X1260 sky130_fd_sc_hd__mux2_1_9/a_218_374# V3R062 VDPWR VDPWR sky130_fd_pr__pfet_01v8_hvt ad=0.1533 pd=1.57 as=0 ps=0 w=0.42 l=0.15
X1261 VGND sky130_fd_sc_hd__mux2_1_9/a_505_21# sky130_fd_sc_hd__mux2_1_9/a_439_47# VGND sky130_fd_pr__nfet_01v8 ad=0 pd=0 as=0.1386 ps=1.5 w=0.42 l=0.15
X1262 sky130_fd_sc_hd__mux2_1_9/a_76_199# V3R173 sky130_fd_sc_hd__mux2_1_9/a_218_374# VDPWR sky130_fd_pr__pfet_01v8_hvt ad=0.3864 pd=2.68 as=0 ps=0 w=0.42 l=0.15
X1263 sky130_fd_sc_hd__mux2_1_9/a_505_21# V3R062 VGND VGND sky130_fd_pr__nfet_01v8 ad=0.1092 pd=1.36 as=0 ps=0 w=0.42 l=0.15
X1264 sky130_fd_sc_hd__mux2_1_9/a_439_47# V3R173 sky130_fd_sc_hd__mux2_1_9/a_76_199# VGND sky130_fd_pr__nfet_01v8 ad=0 pd=0 as=0.1995 ps=1.79 w=0.42 l=0.15
X1265 sky130_fd_sc_hd__mux2_1_9/a_535_374# V3R171 sky130_fd_sc_hd__mux2_1_9/a_76_199# VDPWR sky130_fd_pr__pfet_01v8_hvt ad=0 pd=0 as=0 ps=0 w=0.42 l=0.15
X1266 sky130_fd_sc_hd__mux2_1_9/a_76_199# V3R171 sky130_fd_sc_hd__mux2_1_9/a_218_47# VGND sky130_fd_pr__nfet_01v8 ad=0 pd=0 as=0.1386 ps=1.5 w=0.42 l=0.15
X1267 sky130_fd_sc_hd__mux2_1_9/a_218_47# V3R062 VGND VGND sky130_fd_pr__nfet_01v8 ad=0 pd=0 as=0 ps=0 w=0.42 l=0.15
X1268 VDPWR sky130_fd_sc_hd__mux2_1_9/a_76_199# V3R115 VDPWR sky130_fd_pr__pfet_01v8_hvt ad=0 pd=0 as=0.26 ps=2.52 w=1 l=0.15
X1269 VGND sky130_fd_sc_hd__mux2_1_9/a_76_199# V3R115 VGND sky130_fd_pr__nfet_01v8 ad=0 pd=0 as=0.169 ps=1.82 w=0.65 l=0.15
X1270 sky130_fd_sc_hd__dfrtp_1_2/a_805_47# sky130_fd_sc_hd__dfrtp_1_2/a_761_289# sky130_fd_sc_hd__dfrtp_1_2/a_639_47# VGND sky130_fd_pr__nfet_01v8 ad=0.0882 pd=1.26 as=0.2802 ps=2.2 w=0.42 l=0.15
X1271 sky130_fd_sc_hd__dfrtp_1_2/a_1217_47# sky130_fd_sc_hd__dfrtp_1_2/a_27_47# sky130_fd_sc_hd__dfrtp_1_2/a_1108_47# VGND sky130_fd_pr__special_nfet_01v8 ad=0.1338 pd=1.5 as=0.1422 ps=1.51 w=0.36 l=0.15
X1272 sky130_fd_sc_hd__dfrtp_1_2/a_1283_21# sky130_fd_sc_hd__dfrtp_1_2/a_1108_47# sky130_fd_sc_hd__dfrtp_1_2/a_1462_47# VGND sky130_fd_pr__nfet_01v8 ad=0.1092 pd=1.36 as=0.1281 ps=1.45 w=0.42 l=0.15
X1273 sky130_fd_sc_hd__dfrtp_1_2/a_651_413# sky130_fd_sc_hd__dfrtp_1_2/a_27_47# sky130_fd_sc_hd__dfrtp_1_2/a_543_47# VDPWR sky130_fd_pr__pfet_01v8_hvt ad=0.3402 pd=3.3 as=0.1449 ps=1.53 w=0.42 l=0.15
X1274 sky130_fd_sc_hd__dfrtp_1_2/a_1108_47# sky130_fd_sc_hd__dfrtp_1_2/a_193_47# sky130_fd_sc_hd__dfrtp_1_2/a_761_289# VGND sky130_fd_pr__special_nfet_01v8 ad=0 pd=0 as=0.1998 ps=1.97 w=0.36 l=0.15
X1275 VGND V3R302 sky130_fd_sc_hd__dfrtp_1_2/a_805_47# VGND sky130_fd_pr__nfet_01v8 ad=0 pd=0 as=0 ps=0 w=0.42 l=0.15
X1276 V3R194 sky130_fd_sc_hd__dfrtp_1_2/a_1283_21# VDPWR VDPWR sky130_fd_pr__pfet_01v8_hvt ad=0.26 pd=2.52 as=0 ps=0 w=1 l=0.15
X1277 VDPWR V3R083 sky130_fd_sc_hd__dfrtp_1_2/a_27_47# VDPWR sky130_fd_pr__pfet_01v8_hvt ad=0 pd=0 as=0.1664 ps=1.8 w=0.64 l=0.15
X1278 sky130_fd_sc_hd__dfrtp_1_2/a_448_47# V3R205 VDPWR VDPWR sky130_fd_pr__pfet_01v8_hvt ad=0.1302 pd=1.46 as=0 ps=0 w=0.42 l=0.15
X1279 sky130_fd_sc_hd__dfrtp_1_2/a_761_289# sky130_fd_sc_hd__dfrtp_1_2/a_543_47# VGND VGND sky130_fd_pr__nfet_01v8 ad=0 pd=0 as=0 ps=0 w=0.64 l=0.15
X1280 sky130_fd_sc_hd__dfrtp_1_2/a_193_47# sky130_fd_sc_hd__dfrtp_1_2/a_27_47# VGND VGND sky130_fd_pr__nfet_01v8 ad=0.1092 pd=1.36 as=0 ps=0 w=0.42 l=0.15
X1281 sky130_fd_sc_hd__dfrtp_1_2/a_1108_47# sky130_fd_sc_hd__dfrtp_1_2/a_27_47# sky130_fd_sc_hd__dfrtp_1_2/a_761_289# VDPWR sky130_fd_pr__pfet_01v8_hvt ad=0.1176 pd=1.4 as=0.2583 ps=2.37 w=0.42 l=0.15
X1282 sky130_fd_sc_hd__dfrtp_1_2/a_1462_47# V3R302 VGND VGND sky130_fd_pr__nfet_01v8 ad=0 pd=0 as=0 ps=0 w=0.42 l=0.15
X1283 sky130_fd_sc_hd__dfrtp_1_2/a_543_47# sky130_fd_sc_hd__dfrtp_1_2/a_27_47# sky130_fd_sc_hd__dfrtp_1_2/a_448_47# VGND sky130_fd_pr__special_nfet_01v8 ad=0.1188 pd=1.38 as=0.132 ps=1.49 w=0.36 l=0.15
X1284 sky130_fd_sc_hd__dfrtp_1_2/a_543_47# sky130_fd_sc_hd__dfrtp_1_2/a_193_47# sky130_fd_sc_hd__dfrtp_1_2/a_448_47# VDPWR sky130_fd_pr__pfet_01v8_hvt ad=0 pd=0 as=0 ps=0 w=0.42 l=0.15
X1285 sky130_fd_sc_hd__dfrtp_1_2/a_448_47# V3R205 VGND VGND sky130_fd_pr__nfet_01v8 ad=0 pd=0 as=0 ps=0 w=0.42 l=0.15
X1286 VDPWR sky130_fd_sc_hd__dfrtp_1_2/a_1283_21# sky130_fd_sc_hd__dfrtp_1_2/a_1270_413# VDPWR sky130_fd_pr__pfet_01v8_hvt ad=0 pd=0 as=0.1134 ps=1.38 w=0.42 l=0.15
X1287 VDPWR sky130_fd_sc_hd__dfrtp_1_2/a_1108_47# sky130_fd_sc_hd__dfrtp_1_2/a_1283_21# VDPWR sky130_fd_pr__pfet_01v8_hvt ad=0 pd=0 as=0.1134 ps=1.38 w=0.42 l=0.15
X1288 sky130_fd_sc_hd__dfrtp_1_2/a_1270_413# sky130_fd_sc_hd__dfrtp_1_2/a_193_47# sky130_fd_sc_hd__dfrtp_1_2/a_1108_47# VDPWR sky130_fd_pr__pfet_01v8_hvt ad=0 pd=0 as=0 ps=0 w=0.42 l=0.15
X1289 sky130_fd_sc_hd__dfrtp_1_2/a_193_47# sky130_fd_sc_hd__dfrtp_1_2/a_27_47# VDPWR VDPWR sky130_fd_pr__pfet_01v8_hvt ad=0.1664 pd=1.8 as=0 ps=0 w=0.64 l=0.15
X1290 sky130_fd_sc_hd__dfrtp_1_2/a_1283_21# V3R302 VDPWR VDPWR sky130_fd_pr__pfet_01v8_hvt ad=0 pd=0 as=0 ps=0 w=0.42 l=0.15
X1291 VDPWR sky130_fd_sc_hd__dfrtp_1_2/a_761_289# sky130_fd_sc_hd__dfrtp_1_2/a_651_413# VDPWR sky130_fd_pr__pfet_01v8_hvt ad=0 pd=0 as=0 ps=0 w=0.42 l=0.15
X1292 V3R194 sky130_fd_sc_hd__dfrtp_1_2/a_1283_21# VGND VGND sky130_fd_pr__nfet_01v8 ad=0.169 pd=1.82 as=0 ps=0 w=0.65 l=0.15
X1293 sky130_fd_sc_hd__dfrtp_1_2/a_639_47# sky130_fd_sc_hd__dfrtp_1_2/a_193_47# sky130_fd_sc_hd__dfrtp_1_2/a_543_47# VGND sky130_fd_pr__special_nfet_01v8 ad=0 pd=0 as=0 ps=0 w=0.36 l=0.15
X1294 VGND sky130_fd_sc_hd__dfrtp_1_2/a_1283_21# sky130_fd_sc_hd__dfrtp_1_2/a_1217_47# VGND sky130_fd_pr__nfet_01v8 ad=0 pd=0 as=0 ps=0 w=0.42 l=0.15
X1295 sky130_fd_sc_hd__dfrtp_1_2/a_651_413# V3R302 VDPWR VDPWR sky130_fd_pr__pfet_01v8_hvt ad=0 pd=0 as=0 ps=0 w=0.42 l=0.15
X1296 VGND V3R083 sky130_fd_sc_hd__dfrtp_1_2/a_27_47# VGND sky130_fd_pr__nfet_01v8 ad=0 pd=0 as=0.1092 ps=1.36 w=0.42 l=0.15
X1297 sky130_fd_sc_hd__dfrtp_1_2/a_761_289# sky130_fd_sc_hd__dfrtp_1_2/a_543_47# VDPWR VDPWR sky130_fd_pr__pfet_01v8_hvt ad=0 pd=0 as=0 ps=0 w=0.84 l=0.15
X1298 v3_four_channel_output_load_integration_0/combined_p VGND sky130_fd_pr__cap_mim_m3_1 l=4.2 w=4.2
X1299 v3_four_channel_output_load_integration_0/v3_four_channel_shared_support_integration_0/v3_tail_bias_support_block_0/vbias v3_four_channel_output_load_integration_0/v3_four_channel_shared_support_integration_0/v3_tail_bias_support_block_0/vbias VGND VGND sky130_fd_pr__nfet_01v8 ad=1.16 pd=8.29 as=1.16 ps=8.29 w=8 l=1
X1300 v3_four_channel_output_load_integration_0/v3_four_channel_shared_support_integration_0/v3_tail_bias_support_block_0/vbias v3_four_channel_output_load_integration_0/v3_four_channel_shared_support_integration_0/v3_tail_bias_support_block_0/vbias VGND VGND sky130_fd_pr__nfet_01v8 ad=2.32 pd=16.58 as=1.16 ps=8.29 w=8 l=1
X1301 VGND v3_four_channel_output_load_integration_0/v3_four_channel_shared_support_integration_0/v3_tail_bias_support_block_0/vbias v3_four_channel_output_load_integration_0/v3_four_channel_shared_support_integration_0/v3_tail_bias_support_block_0/vbias VGND sky130_fd_pr__nfet_01v8 ad=1.16 pd=8.29 as=1.16 ps=8.29 w=8 l=1
X1302 v3_four_channel_output_load_integration_0/v3_four_channel_shared_support_integration_0/v3_tail_bias_support_block_0/vbias v3_four_channel_output_load_integration_0/v3_four_channel_shared_support_integration_0/v3_tail_bias_support_block_0/vbias VGND VGND sky130_fd_pr__nfet_01v8 ad=1.16 pd=8.29 as=1.16 ps=8.29 w=8 l=1
X1303 v3_four_channel_output_load_integration_0/v3_four_channel_shared_support_integration_0/v3_tail_bias_support_block_0/vbias VGND sky130_fd_pr__cap_mim_m3_1 l=22 w=22
X1304 VGND v3_four_channel_output_load_integration_0/v3_four_channel_shared_support_integration_0/v3_tail_bias_support_block_0/vbias v3_four_channel_output_load_integration_0/v3_four_channel_shared_support_integration_0/v3_tail_bias_support_block_0/vbias VGND sky130_fd_pr__nfet_01v8 ad=1.16 pd=8.29 as=2.32 ps=16.58 w=8 l=1
X1305 VDPWR v3_four_channel_output_load_integration_0/v3_four_channel_shared_support_integration_0/v3_tail_bias_support_block_0/vbias VGND sky130_fd_pr__res_high_po_1p41 l=44.98
X1306 VGND v3_four_channel_output_load_integration_0/v3_four_channel_shared_support_integration_0/v3_tail_bias_support_block_0/vbias v3_four_channel_output_load_integration_0/v3_four_channel_shared_support_integration_0/v3_tail_bias_support_block_0/vbias VGND sky130_fd_pr__nfet_01v8 ad=1.16 pd=8.29 as=1.16 ps=8.29 w=8 l=1
X1307 VGND v3_four_channel_output_load_integration_0/v3_four_channel_shared_support_integration_0/v3_tail_bias_support_block_0/vbias v3_four_channel_output_load_integration_0/v3_four_channel_shared_support_integration_0/v3_tail_bias_support_block_0/vbias VGND sky130_fd_pr__nfet_01v8 ad=1.16 pd=8.29 as=1.16 ps=8.29 w=8 l=1
X1308 v3_four_channel_output_load_integration_0/v3_four_channel_shared_support_integration_0/v3_tail_bias_support_block_0/vbias v3_four_channel_output_load_integration_0/v3_four_channel_shared_support_integration_0/v3_tail_bias_support_block_0/vbias VGND VGND sky130_fd_pr__nfet_01v8 ad=1.16 pd=8.29 as=1.16 ps=8.29 w=8 l=1
X1309 v3_four_channel_output_load_integration_0/v3_four_channel_shared_support_integration_0/v3_tail_bias_support_block_0/vbias VGND sky130_fd_pr__cap_mim_m3_1 l=22 w=22
X1310 v3_four_channel_output_load_integration_0/v3_four_channel_shared_support_integration_0/v3_vcm_support_block_0/a_4259_24172# v3_four_channel_output_load_integration_0/v3_four_channel_shared_support_integration_0/v3_vcm_support_block_0/ref VGND sky130_fd_pr__res_xhigh_po_1p41 l=5.88
X1311 v3_four_channel_output_load_integration_0/v3_four_channel_shared_support_integration_0/v3_vcm_support_block_0/a_4259_27772# v3_four_channel_output_load_integration_0/v3_four_channel_shared_support_integration_0/v3_vcm_support_block_0/a_4259_24172# VGND sky130_fd_pr__res_xhigh_po_1p41 l=5.88
X1312 v3_four_channel_output_load_integration_0/v3_four_channel_shared_support_integration_0/v3_vcm_support_block_0/ref VGND sky130_fd_pr__cap_mim_m3_1 l=22 w=22
X1313 v3_four_channel_output_load_integration_0/v3_four_channel_shared_support_integration_0/v3_vcm_support_block_0/ref VGND sky130_fd_pr__cap_mim_m3_1 l=22 w=22
X1314 v3_four_channel_output_load_integration_0/v3_four_channel_shared_support_integration_0/v3_vcm_support_block_0/ref VGND sky130_fd_pr__cap_mim_m3_1 l=22 w=22
X1315 v3_four_channel_output_load_integration_0/v3_four_channel_shared_support_integration_0/v3_vcm_support_block_0/a_8459_24172# VGND VGND sky130_fd_pr__res_xhigh_po_1p41 l=5.88
X1316 v3_four_channel_output_load_integration_0/v3_four_channel_shared_support_integration_0/v3_vcm_support_block_0/a_4259_27772# v3_four_channel_output_load_integration_0/v3_four_channel_shared_support_integration_0/v3_vcm_support_block_0/a_8459_24172# VGND sky130_fd_pr__res_xhigh_po_1p41 l=5.88
X1317 v3_four_channel_output_load_integration_0/v3_four_channel_shared_support_integration_0/v3_vcm_support_block_0/a_6359_24172# v3_four_channel_output_load_integration_0/v3_four_channel_shared_support_integration_0/v3_vcm_support_block_0/ref VGND sky130_fd_pr__res_xhigh_po_1p41 l=5.88
X1318 VDPWR v3_four_channel_output_load_integration_0/v3_four_channel_shared_support_integration_0/v3_vcm_support_block_0/a_6359_24172# VGND sky130_fd_pr__res_xhigh_po_1p41 l=5.88
X1319 v3_four_channel_output_load_integration_0/v3_four_channel_shared_support_integration_0/v3_four_channel_bias_reference_distribution_0/v3_four_channel_phase_distribution_0/v3_four_channel_output_collection_0/v3_four_channel_placement_0/v3_channel_selector_late_promotion_0/v3_channel_input_bias_late_promotion_0/a_4678_23422# v3_four_channel_output_load_integration_0/v3_four_channel_shared_support_integration_0/v3_four_channel_bias_reference_distribution_0/v3_four_channel_phase_distribution_0/v3_four_channel_output_collection_0/v3_four_channel_placement_0/v3_channel_selector_late_promotion_0/v3_selector_route_pilot_0/group3_lo_p v3_four_channel_output_load_integration_0/combined_n VGND sky130_fd_pr__nfet_01v8 ad=0.1885 pd=1.88 as=0.1885 ps=1.88 w=0.65 l=0.15
X1320 v3_four_channel_output_load_integration_0/combined_n v3_four_channel_output_load_integration_0/v3_four_channel_shared_support_integration_0/v3_four_channel_bias_reference_distribution_0/v3_four_channel_phase_distribution_0/v3_four_channel_output_collection_0/v3_four_channel_placement_0/v3_channel_selector_late_promotion_0/v3_selector_route_pilot_0/group3_lo_p v3_four_channel_output_load_integration_0/v3_four_channel_shared_support_integration_0/v3_four_channel_bias_reference_distribution_0/v3_four_channel_phase_distribution_0/v3_four_channel_output_collection_0/v3_four_channel_placement_0/v3_channel_selector_late_promotion_0/v3_channel_input_bias_late_promotion_0/a_4254_6978# VGND sky130_fd_pr__nfet_01v8 ad=0.1885 pd=1.88 as=0.1885 ps=1.88 w=0.65 l=0.15
X1321 v3_four_channel_output_load_integration_0/v3_four_channel_shared_support_integration_0/v3_four_channel_bias_reference_distribution_0/v3_four_channel_phase_distribution_0/v3_four_channel_output_collection_0/v3_four_channel_placement_0/v3_channel_selector_late_promotion_0/v3_channel_input_bias_late_promotion_0/a_4678_23422# v3_four_channel_output_load_integration_0/v3_four_channel_shared_support_integration_0/v3_vcm_support_block_0/ref v3_four_channel_output_load_integration_0/v3_four_channel_shared_support_integration_0/v3_four_channel_bias_reference_distribution_0/v3_four_channel_phase_distribution_0/v3_four_channel_output_collection_0/v3_four_channel_placement_0/v3_channel_selector_late_promotion_0/v3_channel_input_bias_late_promotion_0/a_4382_21688# VGND sky130_fd_pr__nfet_01v8 ad=0.2436 pd=2.26 as=0.2436 ps=2.26 w=0.84 l=0.6
X1322 v3_four_channel_output_load_integration_0/combined_n v3_four_channel_output_load_integration_0/v3_four_channel_shared_support_integration_0/v3_four_channel_bias_reference_distribution_0/v3_four_channel_phase_distribution_0/v3_four_channel_output_collection_0/v3_four_channel_placement_0/v3_channel_selector_late_promotion_0/v3_selector_route_pilot_0/group3_lo_n v3_four_channel_output_load_integration_0/v3_four_channel_shared_support_integration_0/v3_four_channel_bias_reference_distribution_0/v3_four_channel_phase_distribution_0/v3_four_channel_output_collection_0/v3_four_channel_placement_0/v3_channel_selector_late_promotion_0/v3_channel_input_bias_late_promotion_0/a_7038_22978# VGND sky130_fd_pr__nfet_01v8 ad=0.1885 pd=1.88 as=0.1885 ps=1.88 w=0.65 l=0.15
X1323 v3_four_channel_output_load_integration_0/combined_n v3_four_channel_output_load_integration_0/v3_four_channel_shared_support_integration_0/v3_four_channel_bias_reference_distribution_0/v3_four_channel_phase_distribution_0/v3_four_channel_output_collection_0/v3_four_channel_placement_0/v3_channel_selector_late_promotion_0/v3_selector_route_pilot_0/group3_lo_p v3_four_channel_output_load_integration_0/v3_four_channel_shared_support_integration_0/v3_four_channel_bias_reference_distribution_0/v3_four_channel_phase_distribution_0/v3_four_channel_output_collection_0/v3_four_channel_placement_0/v3_channel_selector_late_promotion_0/v3_channel_input_bias_late_promotion_0/a_7038_6978# VGND sky130_fd_pr__nfet_01v8 ad=0.1885 pd=1.88 as=0.1885 ps=1.88 w=0.65 l=0.15
X1324 v3_four_channel_output_load_integration_0/v3_four_channel_shared_support_integration_0/v3_four_channel_bias_reference_distribution_0/v3_four_channel_phase_distribution_0/v3_four_channel_output_collection_0/v3_four_channel_placement_0/v3_channel_selector_late_promotion_0/v3_channel_input_bias_late_promotion_0/a_7462_11422# V3I003 v3_four_channel_output_load_integration_0/v3_four_channel_shared_support_integration_0/v3_four_channel_bias_reference_distribution_0/v3_four_channel_phase_distribution_0/v3_four_channel_output_collection_0/v3_four_channel_placement_0/v3_channel_selector_late_promotion_0/v3_channel_input_bias_late_promotion_0/a_7216_10978# VGND sky130_fd_pr__nfet_01v8 ad=0.2436 pd=2.26 as=0.2436 ps=2.26 w=0.84 l=0.6
X1325 v3_four_channel_output_load_integration_0/v3_four_channel_shared_support_integration_0/v3_four_channel_bias_reference_distribution_0/v3_four_channel_phase_distribution_0/v3_four_channel_output_collection_0/v3_four_channel_placement_0/v3_channel_selector_late_promotion_0/v3_channel_input_bias_late_promotion_0/a_7462_11422# v3_four_channel_output_load_integration_0/v3_four_channel_shared_support_integration_0/v3_four_channel_bias_reference_distribution_0/v3_four_channel_phase_distribution_0/v3_four_channel_output_collection_0/v3_four_channel_placement_0/v3_channel_selector_late_promotion_0/v3_selector_route_pilot_0/group2_lo_n v3_four_channel_output_load_integration_0/combined_n VGND sky130_fd_pr__nfet_01v8 ad=0.1885 pd=1.88 as=0.1885 ps=1.88 w=0.65 l=0.15
X1326 v3_four_channel_output_load_integration_0/v3_four_channel_shared_support_integration_0/v3_four_channel_bias_reference_distribution_0/v3_four_channel_phase_distribution_0/v3_four_channel_output_collection_0/v3_four_channel_placement_0/v3_channel_selector_late_promotion_0/v3_channel_input_bias_late_promotion_0/a_5774_21688# V3I003 v3_four_channel_output_load_integration_0/v3_four_channel_shared_support_integration_0/v3_four_channel_bias_reference_distribution_0/v3_four_channel_phase_distribution_0/v3_four_channel_output_collection_0/v3_four_channel_placement_0/v3_channel_selector_late_promotion_0/v3_channel_input_bias_late_promotion_0/a_5646_22978# VGND sky130_fd_pr__nfet_01v8 ad=0.2436 pd=2.26 as=0.2436 ps=2.26 w=0.84 l=0.6
X1327 VGND v3_four_channel_output_load_integration_0/v3_four_channel_shared_support_integration_0/v3_tail_bias_support_block_0/vbias v3_four_channel_output_load_integration_0/v3_four_channel_shared_support_integration_0/v3_four_channel_bias_reference_distribution_0/v3_four_channel_phase_distribution_0/v3_four_channel_output_collection_0/v3_four_channel_placement_0/v3_channel_selector_late_promotion_0/v3_channel_input_bias_late_promotion_0/a_5774_17688# VGND sky130_fd_pr__nfet_01v8 ad=1.4703 pd=10.72 as=1.4703 ps=10.72 w=5.07 l=1
X1328 v3_four_channel_output_load_integration_0/v3_four_channel_shared_support_integration_0/v3_four_channel_bias_reference_distribution_0/v3_four_channel_phase_distribution_0/v3_four_channel_output_collection_0/v3_four_channel_placement_0/v3_channel_selector_late_promotion_0/v3_channel_input_bias_late_promotion_0/a_6070_7422# V3I003 v3_four_channel_output_load_integration_0/v3_four_channel_shared_support_integration_0/v3_four_channel_bias_reference_distribution_0/v3_four_channel_phase_distribution_0/v3_four_channel_output_collection_0/v3_four_channel_placement_0/v3_channel_selector_late_promotion_0/v3_channel_input_bias_late_promotion_0/a_5824_6978# VGND sky130_fd_pr__nfet_01v8 ad=0.2436 pd=2.26 as=0.2436 ps=2.26 w=0.84 l=0.6
X1329 v3_four_channel_output_load_integration_0/v3_four_channel_shared_support_integration_0/v3_four_channel_bias_reference_distribution_0/v3_four_channel_phase_distribution_0/v3_four_channel_output_collection_0/v3_four_channel_placement_0/v3_channel_selector_late_promotion_0/v3_channel_input_bias_late_promotion_0/a_6070_7422# v3_four_channel_output_load_integration_0/v3_four_channel_shared_support_integration_0/v3_four_channel_bias_reference_distribution_0/v3_four_channel_phase_distribution_0/v3_four_channel_output_collection_0/v3_four_channel_placement_0/v3_channel_selector_late_promotion_0/v3_selector_route_pilot_0/group3_lo_n v3_four_channel_output_load_integration_0/combined_n VGND sky130_fd_pr__nfet_01v8 ad=0.1885 pd=1.88 as=0.1885 ps=1.88 w=0.65 l=0.15
X1330 v3_four_channel_output_load_integration_0/v3_four_channel_shared_support_integration_0/v3_vcm_support_block_0/ref V3I003 VGND sky130_fd_pr__res_xhigh_po_0p35 l=17.36
X1331 v3_four_channel_output_load_integration_0/v3_four_channel_shared_support_integration_0/v3_four_channel_bias_reference_distribution_0/v3_four_channel_phase_distribution_0/v3_four_channel_output_collection_0/v3_four_channel_placement_0/v3_channel_selector_late_promotion_0/v3_channel_input_bias_late_promotion_0/a_7462_23422# v3_four_channel_output_load_integration_0/v3_four_channel_shared_support_integration_0/v3_vcm_support_block_0/ref v3_four_channel_output_load_integration_0/v3_four_channel_shared_support_integration_0/v3_four_channel_bias_reference_distribution_0/v3_four_channel_phase_distribution_0/v3_four_channel_output_collection_0/v3_four_channel_placement_0/v3_channel_selector_late_promotion_0/v3_channel_input_bias_late_promotion_0/a_7166_21688# VGND sky130_fd_pr__nfet_01v8 ad=0.2436 pd=2.26 as=0.2436 ps=2.26 w=0.84 l=0.6
X1332 v3_four_channel_output_load_integration_0/v3_four_channel_shared_support_integration_0/v3_four_channel_bias_reference_distribution_0/v3_four_channel_phase_distribution_0/v3_four_channel_output_collection_0/v3_four_channel_placement_0/v3_channel_selector_late_promotion_0/v3_channel_input_bias_late_promotion_0/a_7462_23422# v3_four_channel_output_load_integration_0/v3_four_channel_shared_support_integration_0/v3_four_channel_bias_reference_distribution_0/v3_four_channel_phase_distribution_0/v3_four_channel_output_collection_0/v3_four_channel_placement_0/v3_channel_selector_late_promotion_0/v3_selector_route_pilot_0/group3_lo_p v3_four_channel_output_load_integration_0/combined_n VGND sky130_fd_pr__nfet_01v8 ad=0.1885 pd=1.88 as=0.1885 ps=1.88 w=0.65 l=0.15
X1333 VGND v3_four_channel_output_load_integration_0/v3_four_channel_shared_support_integration_0/v3_tail_bias_support_block_0/vbias v3_four_channel_output_load_integration_0/v3_four_channel_shared_support_integration_0/v3_four_channel_bias_reference_distribution_0/v3_four_channel_phase_distribution_0/v3_four_channel_output_collection_0/v3_four_channel_placement_0/v3_channel_selector_late_promotion_0/v3_channel_input_bias_late_promotion_0/a_4382_21688# VGND sky130_fd_pr__nfet_01v8 ad=1.4703 pd=10.72 as=1.4703 ps=10.72 w=5.07 l=1
X1334 VGND v3_four_channel_output_load_integration_0/v3_four_channel_shared_support_integration_0/v3_tail_bias_support_block_0/vbias v3_four_channel_output_load_integration_0/v3_four_channel_shared_support_integration_0/v3_four_channel_bias_reference_distribution_0/v3_four_channel_phase_distribution_0/v3_four_channel_output_collection_0/v3_four_channel_placement_0/v3_channel_selector_late_promotion_0/v3_channel_input_bias_late_promotion_0/a_5774_13688# VGND sky130_fd_pr__nfet_01v8 ad=1.4703 pd=10.72 as=1.4703 ps=10.72 w=5.07 l=1
X1335 VGND v3_four_channel_output_load_integration_0/v3_four_channel_shared_support_integration_0/v3_tail_bias_support_block_0/vbias v3_four_channel_output_load_integration_0/v3_four_channel_shared_support_integration_0/v3_four_channel_bias_reference_distribution_0/v3_four_channel_phase_distribution_0/v3_four_channel_output_collection_0/v3_four_channel_placement_0/v3_channel_selector_late_promotion_0/v3_channel_input_bias_late_promotion_0/a_7166_17688# VGND sky130_fd_pr__nfet_01v8 ad=1.4703 pd=10.72 as=1.4703 ps=10.72 w=5.07 l=1
X1336 VGND VGND VGND VGND sky130_fd_pr__nfet_01v8 ad=0.1885 pd=1.88 as=0 ps=0 w=0.65 l=0.15
X1337 v3_four_channel_output_load_integration_0/combined_p v3_four_channel_output_load_integration_0/v3_four_channel_shared_support_integration_0/v3_four_channel_bias_reference_distribution_0/v3_four_channel_phase_distribution_0/v3_four_channel_output_collection_0/v3_four_channel_placement_0/v3_channel_selector_late_promotion_0/v3_selector_route_pilot_0/group3_lo_p v3_four_channel_output_load_integration_0/v3_four_channel_shared_support_integration_0/v3_four_channel_bias_reference_distribution_0/v3_four_channel_phase_distribution_0/v3_four_channel_output_collection_0/v3_four_channel_placement_0/v3_channel_selector_late_promotion_0/v3_channel_input_bias_late_promotion_0/a_5646_18978# VGND sky130_fd_pr__nfet_01v8 ad=0.1885 pd=1.88 as=0.1885 ps=1.88 w=0.65 l=0.15
X1338 VGND VGND VGND VGND sky130_fd_pr__nfet_01v8 ad=0.1885 pd=1.88 as=0 ps=0 w=0.65 l=0.15
X1339 v3_four_channel_output_load_integration_0/v3_four_channel_shared_support_integration_0/v3_four_channel_bias_reference_distribution_0/v3_four_channel_phase_distribution_0/v3_four_channel_output_collection_0/v3_four_channel_placement_0/v3_channel_selector_late_promotion_0/v3_channel_input_bias_late_promotion_0/a_6070_19422# v3_four_channel_output_load_integration_0/v3_four_channel_shared_support_integration_0/v3_four_channel_bias_reference_distribution_0/v3_four_channel_phase_distribution_0/v3_four_channel_output_collection_0/v3_four_channel_placement_0/v3_channel_selector_late_promotion_0/v3_selector_route_pilot_0/group3_lo_n v3_four_channel_output_load_integration_0/combined_p VGND sky130_fd_pr__nfet_01v8 ad=0.1885 pd=1.88 as=0.1885 ps=1.88 w=0.65 l=0.15
X1340 VGND VGND VGND VGND sky130_fd_pr__nfet_01v8 ad=0.1885 pd=1.88 as=0 ps=0 w=0.65 l=0.15
X1341 v3_four_channel_output_load_integration_0/combined_p v3_four_channel_output_load_integration_0/v3_four_channel_shared_support_integration_0/v3_four_channel_bias_reference_distribution_0/v3_four_channel_phase_distribution_0/v3_four_channel_output_collection_0/v3_four_channel_placement_0/v3_channel_selector_late_promotion_0/v3_selector_route_pilot_0/group2_lo_p v3_four_channel_output_load_integration_0/v3_four_channel_shared_support_integration_0/v3_four_channel_bias_reference_distribution_0/v3_four_channel_phase_distribution_0/v3_four_channel_output_collection_0/v3_four_channel_placement_0/v3_channel_selector_late_promotion_0/v3_channel_input_bias_late_promotion_0/a_4254_18978# VGND sky130_fd_pr__nfet_01v8 ad=0.1885 pd=1.88 as=0.1885 ps=1.88 w=0.65 l=0.15
X1342 v3_four_channel_output_load_integration_0/v3_four_channel_shared_support_integration_0/v3_four_channel_bias_reference_distribution_0/v3_four_channel_phase_distribution_0/v3_four_channel_output_collection_0/v3_four_channel_placement_0/v3_channel_selector_late_promotion_0/v3_channel_input_bias_late_promotion_0/a_7216_14978# v3_four_channel_output_load_integration_0/v3_four_channel_shared_support_integration_0/v3_tail_bias_support_block_0/vbias VGND VGND sky130_fd_pr__nfet_01v8 ad=1.4703 pd=10.72 as=1.4703 ps=10.72 w=5.07 l=1
X1343 VGND VGND VGND VGND sky130_fd_pr__nfet_01v8 ad=0.1885 pd=1.88 as=0 ps=0 w=0.65 l=0.15
X1344 VGND VGND VGND VGND sky130_fd_pr__nfet_01v8 ad=0.1885 pd=1.88 as=0 ps=0 w=0.65 l=0.15
X1345 v3_four_channel_output_load_integration_0/v3_four_channel_shared_support_integration_0/v3_four_channel_bias_reference_distribution_0/v3_four_channel_phase_distribution_0/v3_four_channel_output_collection_0/v3_four_channel_placement_0/v3_channel_selector_late_promotion_0/v3_channel_input_bias_late_promotion_0/a_4382_17688# V3I003 v3_four_channel_output_load_integration_0/v3_four_channel_shared_support_integration_0/v3_four_channel_bias_reference_distribution_0/v3_four_channel_phase_distribution_0/v3_four_channel_output_collection_0/v3_four_channel_placement_0/v3_channel_selector_late_promotion_0/v3_channel_input_bias_late_promotion_0/a_4254_18978# VGND sky130_fd_pr__nfet_01v8 ad=0.2436 pd=2.26 as=0.2436 ps=2.26 w=0.84 l=0.6
X1346 v3_four_channel_output_load_integration_0/v3_four_channel_shared_support_integration_0/v3_four_channel_bias_reference_distribution_0/v3_four_channel_phase_distribution_0/v3_four_channel_output_collection_0/v3_four_channel_placement_0/v3_channel_selector_late_promotion_0/v3_channel_input_bias_late_promotion_0/a_4678_19422# v3_four_channel_output_load_integration_0/v3_four_channel_shared_support_integration_0/v3_four_channel_bias_reference_distribution_0/v3_four_channel_phase_distribution_0/v3_four_channel_output_collection_0/v3_four_channel_placement_0/v3_channel_selector_late_promotion_0/v3_selector_route_pilot_0/group2_lo_n v3_four_channel_output_load_integration_0/combined_p VGND sky130_fd_pr__nfet_01v8 ad=0.1885 pd=1.88 as=0.1885 ps=1.88 w=0.65 l=0.15
X1347 v3_four_channel_output_load_integration_0/combined_p v3_four_channel_output_load_integration_0/v3_four_channel_shared_support_integration_0/v3_four_channel_bias_reference_distribution_0/v3_four_channel_phase_distribution_0/v3_four_channel_output_collection_0/v3_four_channel_placement_0/v3_channel_selector_late_promotion_0/v3_selector_route_pilot_0/group0_lo_p v3_four_channel_output_load_integration_0/v3_four_channel_shared_support_integration_0/v3_four_channel_bias_reference_distribution_0/v3_four_channel_phase_distribution_0/v3_four_channel_output_collection_0/v3_four_channel_placement_0/v3_channel_selector_late_promotion_0/v3_channel_input_bias_late_promotion_0/a_5646_14978# VGND sky130_fd_pr__nfet_01v8 ad=0.1885 pd=1.88 as=0.1885 ps=1.88 w=0.65 l=0.15
X1348 v3_four_channel_output_load_integration_0/combined_p v3_four_channel_output_load_integration_0/v3_four_channel_shared_support_integration_0/v3_four_channel_bias_reference_distribution_0/v3_four_channel_phase_distribution_0/v3_four_channel_output_collection_0/v3_four_channel_placement_0/v3_channel_selector_late_promotion_0/v3_selector_route_pilot_0/group2_lo_p v3_four_channel_output_load_integration_0/v3_four_channel_shared_support_integration_0/v3_four_channel_bias_reference_distribution_0/v3_four_channel_phase_distribution_0/v3_four_channel_output_collection_0/v3_four_channel_placement_0/v3_channel_selector_late_promotion_0/v3_channel_input_bias_late_promotion_0/a_7038_18978# VGND sky130_fd_pr__nfet_01v8 ad=0.1885 pd=1.88 as=0.1885 ps=1.88 w=0.65 l=0.15
X1349 VGND VGND VGND VGND sky130_fd_pr__nfet_01v8 ad=1.4703 pd=10.72 as=0 ps=0 w=5.07 l=1
X1350 v3_four_channel_output_load_integration_0/v3_four_channel_shared_support_integration_0/v3_four_channel_bias_reference_distribution_0/v3_four_channel_phase_distribution_0/v3_four_channel_output_collection_0/v3_four_channel_placement_0/v3_channel_selector_late_promotion_0/v3_channel_input_bias_late_promotion_0/a_6070_15422# v3_four_channel_output_load_integration_0/v3_four_channel_shared_support_integration_0/v3_four_channel_bias_reference_distribution_0/v3_four_channel_phase_distribution_0/v3_four_channel_output_collection_0/v3_four_channel_placement_0/v3_channel_selector_late_promotion_0/v3_selector_route_pilot_0/group0_lo_n v3_four_channel_output_load_integration_0/combined_p VGND sky130_fd_pr__nfet_01v8 ad=0.1885 pd=1.88 as=0.1885 ps=1.88 w=0.65 l=0.15
X1351 v3_four_channel_output_load_integration_0/v3_four_channel_shared_support_integration_0/v3_four_channel_bias_reference_distribution_0/v3_four_channel_phase_distribution_0/v3_four_channel_output_collection_0/v3_four_channel_placement_0/v3_channel_selector_late_promotion_0/v3_channel_input_bias_late_promotion_0/a_7166_17688# V3I003 v3_four_channel_output_load_integration_0/v3_four_channel_shared_support_integration_0/v3_four_channel_bias_reference_distribution_0/v3_four_channel_phase_distribution_0/v3_four_channel_output_collection_0/v3_four_channel_placement_0/v3_channel_selector_late_promotion_0/v3_channel_input_bias_late_promotion_0/a_7038_18978# VGND sky130_fd_pr__nfet_01v8 ad=0.2436 pd=2.26 as=0.2436 ps=2.26 w=0.84 l=0.6
X1352 v3_four_channel_output_load_integration_0/combined_n v3_four_channel_output_load_integration_0/v3_four_channel_shared_support_integration_0/v3_four_channel_bias_reference_distribution_0/v3_four_channel_phase_distribution_0/v3_four_channel_output_collection_0/v3_four_channel_placement_0/v3_channel_selector_late_promotion_0/v3_selector_route_pilot_0/group3_lo_n v3_four_channel_output_load_integration_0/v3_four_channel_shared_support_integration_0/v3_four_channel_bias_reference_distribution_0/v3_four_channel_phase_distribution_0/v3_four_channel_output_collection_0/v3_four_channel_placement_0/v3_channel_selector_late_promotion_0/v3_channel_input_bias_late_promotion_0/a_5646_18978# VGND sky130_fd_pr__nfet_01v8 ad=0.1885 pd=1.88 as=0.1885 ps=1.88 w=0.65 l=0.15
X1353 VGND v3_four_channel_output_load_integration_0/v3_four_channel_shared_support_integration_0/v3_tail_bias_support_block_0/vbias v3_four_channel_output_load_integration_0/v3_four_channel_shared_support_integration_0/v3_four_channel_bias_reference_distribution_0/v3_four_channel_phase_distribution_0/v3_four_channel_output_collection_0/v3_four_channel_placement_0/v3_channel_selector_late_promotion_0/v3_channel_input_bias_late_promotion_0/a_5774_21688# VGND sky130_fd_pr__nfet_01v8 ad=1.4703 pd=10.72 as=1.4703 ps=10.72 w=5.07 l=1
X1354 v3_four_channel_output_load_integration_0/v3_four_channel_shared_support_integration_0/v3_four_channel_bias_reference_distribution_0/v3_four_channel_phase_distribution_0/v3_four_channel_output_collection_0/v3_four_channel_placement_0/v3_channel_selector_late_promotion_0/v3_channel_input_bias_late_promotion_0/a_6070_19422# v3_four_channel_output_load_integration_0/v3_four_channel_shared_support_integration_0/v3_vcm_support_block_0/ref v3_four_channel_output_load_integration_0/v3_four_channel_shared_support_integration_0/v3_four_channel_bias_reference_distribution_0/v3_four_channel_phase_distribution_0/v3_four_channel_output_collection_0/v3_four_channel_placement_0/v3_channel_selector_late_promotion_0/v3_channel_input_bias_late_promotion_0/a_5774_17688# VGND sky130_fd_pr__nfet_01v8 ad=0.2436 pd=2.26 as=0.2436 ps=2.26 w=0.84 l=0.6
X1355 VGND VGND VGND VGND sky130_fd_pr__nfet_01v8 ad=1.4703 pd=10.72 as=0 ps=0 w=5.07 l=1
X1356 v3_four_channel_output_load_integration_0/combined_p v3_four_channel_output_load_integration_0/v3_four_channel_shared_support_integration_0/v3_four_channel_bias_reference_distribution_0/v3_four_channel_phase_distribution_0/v3_four_channel_output_collection_0/v3_four_channel_placement_0/v3_channel_selector_late_promotion_0/v3_selector_route_pilot_0/group1_lo_p v3_four_channel_output_load_integration_0/v3_four_channel_shared_support_integration_0/v3_four_channel_bias_reference_distribution_0/v3_four_channel_phase_distribution_0/v3_four_channel_output_collection_0/v3_four_channel_placement_0/v3_channel_selector_late_promotion_0/v3_channel_input_bias_late_promotion_0/a_4254_14978# VGND sky130_fd_pr__nfet_01v8 ad=0.1885 pd=1.88 as=0.1885 ps=1.88 w=0.65 l=0.15
X1357 v3_four_channel_output_load_integration_0/v3_four_channel_shared_support_integration_0/v3_four_channel_bias_reference_distribution_0/v3_four_channel_phase_distribution_0/v3_four_channel_output_collection_0/v3_four_channel_placement_0/v3_channel_selector_late_promotion_0/v3_channel_input_bias_late_promotion_0/a_6070_19422# v3_four_channel_output_load_integration_0/v3_four_channel_shared_support_integration_0/v3_four_channel_bias_reference_distribution_0/v3_four_channel_phase_distribution_0/v3_four_channel_output_collection_0/v3_four_channel_placement_0/v3_channel_selector_late_promotion_0/v3_selector_route_pilot_0/group3_lo_p v3_four_channel_output_load_integration_0/combined_n VGND sky130_fd_pr__nfet_01v8 ad=0.1885 pd=1.88 as=0.1885 ps=1.88 w=0.65 l=0.15
X1358 VGND VGND VGND VGND sky130_fd_pr__nfet_01v8 ad=0.1885 pd=1.88 as=0 ps=0 w=0.65 l=0.15
X1359 v3_four_channel_output_load_integration_0/v3_four_channel_shared_support_integration_0/v3_four_channel_bias_reference_distribution_0/v3_four_channel_phase_distribution_0/v3_four_channel_output_collection_0/v3_four_channel_placement_0/v3_channel_selector_late_promotion_0/v3_channel_input_bias_late_promotion_0/a_5824_10978# v3_four_channel_output_load_integration_0/v3_four_channel_shared_support_integration_0/v3_tail_bias_support_block_0/vbias VGND VGND sky130_fd_pr__nfet_01v8 ad=1.4703 pd=10.72 as=1.4703 ps=10.72 w=5.07 l=1
X1360 v3_four_channel_output_load_integration_0/v3_four_channel_shared_support_integration_0/v3_four_channel_bias_reference_distribution_0/v3_four_channel_phase_distribution_0/v3_four_channel_output_collection_0/v3_four_channel_placement_0/v3_channel_selector_late_promotion_0/v3_channel_input_bias_late_promotion_0/a_4382_13688# V3I003 v3_four_channel_output_load_integration_0/v3_four_channel_shared_support_integration_0/v3_four_channel_bias_reference_distribution_0/v3_four_channel_phase_distribution_0/v3_four_channel_output_collection_0/v3_four_channel_placement_0/v3_channel_selector_late_promotion_0/v3_channel_input_bias_late_promotion_0/a_4254_14978# VGND sky130_fd_pr__nfet_01v8 ad=0.2436 pd=2.26 as=0.2436 ps=2.26 w=0.84 l=0.6
X1361 v3_four_channel_output_load_integration_0/v3_four_channel_shared_support_integration_0/v3_four_channel_bias_reference_distribution_0/v3_four_channel_phase_distribution_0/v3_four_channel_output_collection_0/v3_four_channel_placement_0/v3_channel_selector_late_promotion_0/v3_channel_input_bias_late_promotion_0/a_4678_15422# v3_four_channel_output_load_integration_0/v3_four_channel_shared_support_integration_0/v3_four_channel_bias_reference_distribution_0/v3_four_channel_phase_distribution_0/v3_four_channel_output_collection_0/v3_four_channel_placement_0/v3_channel_selector_late_promotion_0/v3_selector_route_pilot_0/group1_lo_n v3_four_channel_output_load_integration_0/combined_p VGND sky130_fd_pr__nfet_01v8 ad=0.1885 pd=1.88 as=0.1885 ps=1.88 w=0.65 l=0.15
X1362 v3_four_channel_output_load_integration_0/combined_n v3_four_channel_output_load_integration_0/v3_four_channel_shared_support_integration_0/v3_four_channel_bias_reference_distribution_0/v3_four_channel_phase_distribution_0/v3_four_channel_output_collection_0/v3_four_channel_placement_0/v3_channel_selector_late_promotion_0/v3_selector_route_pilot_0/group2_lo_n v3_four_channel_output_load_integration_0/v3_four_channel_shared_support_integration_0/v3_four_channel_bias_reference_distribution_0/v3_four_channel_phase_distribution_0/v3_four_channel_output_collection_0/v3_four_channel_placement_0/v3_channel_selector_late_promotion_0/v3_channel_input_bias_late_promotion_0/a_4254_18978# VGND sky130_fd_pr__nfet_01v8 ad=0.1885 pd=1.88 as=0.1885 ps=1.88 w=0.65 l=0.15
X1363 v3_four_channel_output_load_integration_0/combined_p v3_four_channel_output_load_integration_0/v3_four_channel_shared_support_integration_0/v3_four_channel_bias_reference_distribution_0/v3_four_channel_phase_distribution_0/v3_four_channel_output_collection_0/v3_four_channel_placement_0/v3_channel_selector_late_promotion_0/v3_selector_route_pilot_0/group3_lo_n v3_four_channel_output_load_integration_0/v3_four_channel_shared_support_integration_0/v3_four_channel_bias_reference_distribution_0/v3_four_channel_phase_distribution_0/v3_four_channel_output_collection_0/v3_four_channel_placement_0/v3_channel_selector_late_promotion_0/v3_channel_input_bias_late_promotion_0/a_5646_10978# VGND sky130_fd_pr__nfet_01v8 ad=0.1885 pd=1.88 as=0.1885 ps=1.88 w=0.65 l=0.15
X1364 v3_four_channel_output_load_integration_0/combined_p v3_four_channel_output_load_integration_0/v3_four_channel_shared_support_integration_0/v3_four_channel_bias_reference_distribution_0/v3_four_channel_phase_distribution_0/v3_four_channel_output_collection_0/v3_four_channel_placement_0/v3_channel_selector_late_promotion_0/v3_selector_route_pilot_0/group1_lo_n v3_four_channel_output_load_integration_0/v3_four_channel_shared_support_integration_0/v3_four_channel_bias_reference_distribution_0/v3_four_channel_phase_distribution_0/v3_four_channel_output_collection_0/v3_four_channel_placement_0/v3_channel_selector_late_promotion_0/v3_channel_input_bias_late_promotion_0/a_7038_14978# VGND sky130_fd_pr__nfet_01v8 ad=0.1885 pd=1.88 as=0.1885 ps=1.88 w=0.65 l=0.15
X1365 v3_four_channel_output_load_integration_0/v3_four_channel_shared_support_integration_0/v3_four_channel_bias_reference_distribution_0/v3_four_channel_phase_distribution_0/v3_four_channel_output_collection_0/v3_four_channel_placement_0/v3_channel_selector_late_promotion_0/v3_channel_input_bias_late_promotion_0/a_7462_19422# v3_four_channel_output_load_integration_0/v3_four_channel_shared_support_integration_0/v3_four_channel_bias_reference_distribution_0/v3_four_channel_phase_distribution_0/v3_four_channel_output_collection_0/v3_four_channel_placement_0/v3_channel_selector_late_promotion_0/v3_selector_route_pilot_0/group2_lo_n v3_four_channel_output_load_integration_0/combined_p VGND sky130_fd_pr__nfet_01v8 ad=0.1885 pd=1.88 as=0.1885 ps=1.88 w=0.65 l=0.15
X1366 v3_four_channel_output_load_integration_0/v3_four_channel_shared_support_integration_0/v3_four_channel_bias_reference_distribution_0/v3_four_channel_phase_distribution_0/v3_four_channel_output_collection_0/v3_four_channel_placement_0/v3_channel_selector_late_promotion_0/v3_channel_input_bias_late_promotion_0/a_4678_7422# v3_four_channel_output_load_integration_0/v3_four_channel_shared_support_integration_0/v3_four_channel_bias_reference_distribution_0/v3_four_channel_phase_distribution_0/v3_four_channel_output_collection_0/v3_four_channel_placement_0/v3_channel_selector_late_promotion_0/v3_selector_route_pilot_0/group3_lo_p v3_four_channel_output_load_integration_0/combined_p VGND sky130_fd_pr__nfet_01v8 ad=0.1885 pd=1.88 as=0.1885 ps=1.88 w=0.65 l=0.15
X1367 v3_four_channel_output_load_integration_0/v3_four_channel_shared_support_integration_0/v3_four_channel_bias_reference_distribution_0/v3_four_channel_phase_distribution_0/v3_four_channel_output_collection_0/v3_four_channel_placement_0/v3_channel_selector_late_promotion_0/v3_channel_input_bias_late_promotion_0/a_6070_11422# v3_four_channel_output_load_integration_0/v3_four_channel_shared_support_integration_0/v3_four_channel_bias_reference_distribution_0/v3_four_channel_phase_distribution_0/v3_four_channel_output_collection_0/v3_four_channel_placement_0/v3_channel_selector_late_promotion_0/v3_selector_route_pilot_0/group3_lo_p v3_four_channel_output_load_integration_0/combined_p VGND sky130_fd_pr__nfet_01v8 ad=0.1885 pd=1.88 as=0.1885 ps=1.88 w=0.65 l=0.15
X1368 v3_four_channel_output_load_integration_0/v3_four_channel_shared_support_integration_0/v3_four_channel_bias_reference_distribution_0/v3_four_channel_phase_distribution_0/v3_four_channel_output_collection_0/v3_four_channel_placement_0/v3_channel_selector_late_promotion_0/v3_channel_input_bias_late_promotion_0/a_7216_10978# v3_four_channel_output_load_integration_0/v3_four_channel_shared_support_integration_0/v3_tail_bias_support_block_0/vbias VGND VGND sky130_fd_pr__nfet_01v8 ad=1.4703 pd=10.72 as=1.4703 ps=10.72 w=5.07 l=1
X1369 v3_four_channel_output_load_integration_0/v3_four_channel_shared_support_integration_0/v3_four_channel_bias_reference_distribution_0/v3_four_channel_phase_distribution_0/v3_four_channel_output_collection_0/v3_four_channel_placement_0/v3_channel_selector_late_promotion_0/v3_channel_input_bias_late_promotion_0/a_7216_14978# v3_four_channel_output_load_integration_0/v3_four_channel_shared_support_integration_0/v3_vcm_support_block_0/ref v3_four_channel_output_load_integration_0/v3_four_channel_shared_support_integration_0/v3_four_channel_bias_reference_distribution_0/v3_four_channel_phase_distribution_0/v3_four_channel_output_collection_0/v3_four_channel_placement_0/v3_channel_selector_late_promotion_0/v3_channel_input_bias_late_promotion_0/a_7038_14978# VGND sky130_fd_pr__nfet_01v8 ad=0.2436 pd=2.26 as=0.2436 ps=2.26 w=0.84 l=0.6
X1370 v3_four_channel_output_load_integration_0/v3_four_channel_shared_support_integration_0/v3_four_channel_bias_reference_distribution_0/v3_four_channel_phase_distribution_0/v3_four_channel_output_collection_0/v3_four_channel_placement_0/v3_channel_selector_late_promotion_0/v3_channel_input_bias_late_promotion_0/a_4678_19422# v3_four_channel_output_load_integration_0/v3_four_channel_shared_support_integration_0/v3_vcm_support_block_0/ref v3_four_channel_output_load_integration_0/v3_four_channel_shared_support_integration_0/v3_four_channel_bias_reference_distribution_0/v3_four_channel_phase_distribution_0/v3_four_channel_output_collection_0/v3_four_channel_placement_0/v3_channel_selector_late_promotion_0/v3_channel_input_bias_late_promotion_0/a_4382_17688# VGND sky130_fd_pr__nfet_01v8 ad=0.2436 pd=2.26 as=0.2436 ps=2.26 w=0.84 l=0.6
X1371 v3_four_channel_output_load_integration_0/v3_four_channel_shared_support_integration_0/v3_four_channel_bias_reference_distribution_0/v3_four_channel_phase_distribution_0/v3_four_channel_output_collection_0/v3_four_channel_placement_0/v3_channel_selector_late_promotion_0/v3_channel_input_bias_late_promotion_0/a_4678_19422# v3_four_channel_output_load_integration_0/v3_four_channel_shared_support_integration_0/v3_four_channel_bias_reference_distribution_0/v3_four_channel_phase_distribution_0/v3_four_channel_output_collection_0/v3_four_channel_placement_0/v3_channel_selector_late_promotion_0/v3_selector_route_pilot_0/group2_lo_p v3_four_channel_output_load_integration_0/combined_n VGND sky130_fd_pr__nfet_01v8 ad=0.1885 pd=1.88 as=0.1885 ps=1.88 w=0.65 l=0.15
X1372 v3_four_channel_output_load_integration_0/combined_n v3_four_channel_output_load_integration_0/v3_four_channel_shared_support_integration_0/v3_four_channel_bias_reference_distribution_0/v3_four_channel_phase_distribution_0/v3_four_channel_output_collection_0/v3_four_channel_placement_0/v3_channel_selector_late_promotion_0/v3_selector_route_pilot_0/group0_lo_n v3_four_channel_output_load_integration_0/v3_four_channel_shared_support_integration_0/v3_four_channel_bias_reference_distribution_0/v3_four_channel_phase_distribution_0/v3_four_channel_output_collection_0/v3_four_channel_placement_0/v3_channel_selector_late_promotion_0/v3_channel_input_bias_late_promotion_0/a_5646_14978# VGND sky130_fd_pr__nfet_01v8 ad=0.1885 pd=1.88 as=0.1885 ps=1.88 w=0.65 l=0.15
X1373 v3_four_channel_output_load_integration_0/combined_n v3_four_channel_output_load_integration_0/v3_four_channel_shared_support_integration_0/v3_four_channel_bias_reference_distribution_0/v3_four_channel_phase_distribution_0/v3_four_channel_output_collection_0/v3_four_channel_placement_0/v3_channel_selector_late_promotion_0/v3_selector_route_pilot_0/group2_lo_n v3_four_channel_output_load_integration_0/v3_four_channel_shared_support_integration_0/v3_four_channel_bias_reference_distribution_0/v3_four_channel_phase_distribution_0/v3_four_channel_output_collection_0/v3_four_channel_placement_0/v3_channel_selector_late_promotion_0/v3_channel_input_bias_late_promotion_0/a_7038_18978# VGND sky130_fd_pr__nfet_01v8 ad=0.1885 pd=1.88 as=0.1885 ps=1.88 w=0.65 l=0.15
X1374 v3_four_channel_output_load_integration_0/v3_four_channel_shared_support_integration_0/v3_four_channel_bias_reference_distribution_0/v3_four_channel_phase_distribution_0/v3_four_channel_output_collection_0/v3_four_channel_placement_0/v3_channel_selector_late_promotion_0/v3_channel_input_bias_late_promotion_0/a_7462_7422# v3_four_channel_output_load_integration_0/v3_four_channel_shared_support_integration_0/v3_four_channel_bias_reference_distribution_0/v3_four_channel_phase_distribution_0/v3_four_channel_output_collection_0/v3_four_channel_placement_0/v3_channel_selector_late_promotion_0/v3_selector_route_pilot_0/group3_lo_p v3_four_channel_output_load_integration_0/combined_p VGND sky130_fd_pr__nfet_01v8 ad=0.1885 pd=1.88 as=0.1885 ps=1.88 w=0.65 l=0.15
X1375 VGND v3_four_channel_output_load_integration_0/v3_four_channel_shared_support_integration_0/v3_tail_bias_support_block_0/vbias v3_four_channel_output_load_integration_0/v3_four_channel_shared_support_integration_0/v3_four_channel_bias_reference_distribution_0/v3_four_channel_phase_distribution_0/v3_four_channel_output_collection_0/v3_four_channel_placement_0/v3_channel_selector_late_promotion_0/v3_channel_input_bias_late_promotion_0/a_7166_21688# VGND sky130_fd_pr__nfet_01v8 ad=1.4703 pd=10.72 as=1.4703 ps=10.72 w=5.07 l=1
X1376 v3_four_channel_output_load_integration_0/v3_four_channel_shared_support_integration_0/v3_four_channel_bias_reference_distribution_0/v3_four_channel_phase_distribution_0/v3_four_channel_output_collection_0/v3_four_channel_placement_0/v3_channel_selector_late_promotion_0/v3_channel_input_bias_late_promotion_0/a_6070_15422# v3_four_channel_output_load_integration_0/v3_four_channel_shared_support_integration_0/v3_vcm_support_block_0/ref v3_four_channel_output_load_integration_0/v3_four_channel_shared_support_integration_0/v3_four_channel_bias_reference_distribution_0/v3_four_channel_phase_distribution_0/v3_four_channel_output_collection_0/v3_four_channel_placement_0/v3_channel_selector_late_promotion_0/v3_channel_input_bias_late_promotion_0/a_5774_13688# VGND sky130_fd_pr__nfet_01v8 ad=0.2436 pd=2.26 as=0.2436 ps=2.26 w=0.84 l=0.6
X1377 v3_four_channel_output_load_integration_0/combined_p v3_four_channel_output_load_integration_0/v3_four_channel_shared_support_integration_0/v3_four_channel_bias_reference_distribution_0/v3_four_channel_phase_distribution_0/v3_four_channel_output_collection_0/v3_four_channel_placement_0/v3_channel_selector_late_promotion_0/v3_selector_route_pilot_0/group2_lo_n v3_four_channel_output_load_integration_0/v3_four_channel_shared_support_integration_0/v3_four_channel_bias_reference_distribution_0/v3_four_channel_phase_distribution_0/v3_four_channel_output_collection_0/v3_four_channel_placement_0/v3_channel_selector_late_promotion_0/v3_channel_input_bias_late_promotion_0/a_4254_10978# VGND sky130_fd_pr__nfet_01v8 ad=0.1885 pd=1.88 as=0.1885 ps=1.88 w=0.65 l=0.15
X1378 v3_four_channel_output_load_integration_0/v3_four_channel_shared_support_integration_0/v3_four_channel_bias_reference_distribution_0/v3_four_channel_phase_distribution_0/v3_four_channel_output_collection_0/v3_four_channel_placement_0/v3_channel_selector_late_promotion_0/v3_channel_input_bias_late_promotion_0/a_6070_15422# v3_four_channel_output_load_integration_0/v3_four_channel_shared_support_integration_0/v3_four_channel_bias_reference_distribution_0/v3_four_channel_phase_distribution_0/v3_four_channel_output_collection_0/v3_four_channel_placement_0/v3_channel_selector_late_promotion_0/v3_selector_route_pilot_0/group0_lo_p v3_four_channel_output_load_integration_0/combined_n VGND sky130_fd_pr__nfet_01v8 ad=0.1885 pd=1.88 as=0.1885 ps=1.88 w=0.65 l=0.15
X1379 v3_four_channel_output_load_integration_0/v3_four_channel_shared_support_integration_0/v3_four_channel_bias_reference_distribution_0/v3_four_channel_phase_distribution_0/v3_four_channel_output_collection_0/v3_four_channel_placement_0/v3_channel_selector_late_promotion_0/v3_channel_input_bias_late_promotion_0/a_5824_6978# v3_four_channel_output_load_integration_0/v3_four_channel_shared_support_integration_0/v3_vcm_support_block_0/ref v3_four_channel_output_load_integration_0/v3_four_channel_shared_support_integration_0/v3_four_channel_bias_reference_distribution_0/v3_four_channel_phase_distribution_0/v3_four_channel_output_collection_0/v3_four_channel_placement_0/v3_channel_selector_late_promotion_0/v3_channel_input_bias_late_promotion_0/a_5646_6978# VGND sky130_fd_pr__nfet_01v8 ad=0.2436 pd=2.26 as=0.2436 ps=2.26 w=0.84 l=0.6
X1380 v3_four_channel_output_load_integration_0/v3_four_channel_shared_support_integration_0/v3_four_channel_bias_reference_distribution_0/v3_four_channel_phase_distribution_0/v3_four_channel_output_collection_0/v3_four_channel_placement_0/v3_channel_selector_late_promotion_0/v3_channel_input_bias_late_promotion_0/a_5774_17688# V3I003 v3_four_channel_output_load_integration_0/v3_four_channel_shared_support_integration_0/v3_four_channel_bias_reference_distribution_0/v3_four_channel_phase_distribution_0/v3_four_channel_output_collection_0/v3_four_channel_placement_0/v3_channel_selector_late_promotion_0/v3_channel_input_bias_late_promotion_0/a_5646_18978# VGND sky130_fd_pr__nfet_01v8 ad=0.2436 pd=2.26 as=0.2436 ps=2.26 w=0.84 l=0.6
X1381 v3_four_channel_output_load_integration_0/combined_p v3_four_channel_output_load_integration_0/v3_four_channel_shared_support_integration_0/v3_four_channel_bias_reference_distribution_0/v3_four_channel_phase_distribution_0/v3_four_channel_output_collection_0/v3_four_channel_placement_0/v3_channel_selector_late_promotion_0/v3_selector_route_pilot_0/group3_lo_p v3_four_channel_output_load_integration_0/v3_four_channel_shared_support_integration_0/v3_four_channel_bias_reference_distribution_0/v3_four_channel_phase_distribution_0/v3_four_channel_output_collection_0/v3_four_channel_placement_0/v3_channel_selector_late_promotion_0/v3_channel_input_bias_late_promotion_0/a_5646_22978# VGND sky130_fd_pr__nfet_01v8 ad=0.1885 pd=1.88 as=0.1885 ps=1.88 w=0.65 l=0.15
X1382 v3_four_channel_output_load_integration_0/v3_four_channel_shared_support_integration_0/v3_four_channel_bias_reference_distribution_0/v3_four_channel_phase_distribution_0/v3_four_channel_output_collection_0/v3_four_channel_placement_0/v3_channel_selector_late_promotion_0/v3_channel_input_bias_late_promotion_0/a_5824_6978# v3_four_channel_output_load_integration_0/v3_four_channel_shared_support_integration_0/v3_tail_bias_support_block_0/vbias VGND VGND sky130_fd_pr__nfet_01v8 ad=1.4703 pd=10.72 as=1.4703 ps=10.72 w=5.07 l=1
X1383 v3_four_channel_output_load_integration_0/v3_four_channel_shared_support_integration_0/v3_four_channel_bias_reference_distribution_0/v3_four_channel_phase_distribution_0/v3_four_channel_output_collection_0/v3_four_channel_placement_0/v3_channel_selector_late_promotion_0/v3_channel_input_bias_late_promotion_0/a_4432_10978# v3_four_channel_output_load_integration_0/v3_four_channel_shared_support_integration_0/v3_vcm_support_block_0/ref v3_four_channel_output_load_integration_0/v3_four_channel_shared_support_integration_0/v3_four_channel_bias_reference_distribution_0/v3_four_channel_phase_distribution_0/v3_four_channel_output_collection_0/v3_four_channel_placement_0/v3_channel_selector_late_promotion_0/v3_channel_input_bias_late_promotion_0/a_4254_10978# VGND sky130_fd_pr__nfet_01v8 ad=0.2436 pd=2.26 as=0.2436 ps=2.26 w=0.84 l=0.6
X1384 v3_four_channel_output_load_integration_0/v3_four_channel_shared_support_integration_0/v3_four_channel_bias_reference_distribution_0/v3_four_channel_phase_distribution_0/v3_four_channel_output_collection_0/v3_four_channel_placement_0/v3_channel_selector_late_promotion_0/v3_channel_input_bias_late_promotion_0/a_4678_11422# v3_four_channel_output_load_integration_0/v3_four_channel_shared_support_integration_0/v3_four_channel_bias_reference_distribution_0/v3_four_channel_phase_distribution_0/v3_four_channel_output_collection_0/v3_four_channel_placement_0/v3_channel_selector_late_promotion_0/v3_selector_route_pilot_0/group2_lo_p v3_four_channel_output_load_integration_0/combined_p VGND sky130_fd_pr__nfet_01v8 ad=0.1885 pd=1.88 as=0.1885 ps=1.88 w=0.65 l=0.15
X1385 v3_four_channel_output_load_integration_0/v3_four_channel_shared_support_integration_0/v3_four_channel_bias_reference_distribution_0/v3_four_channel_phase_distribution_0/v3_four_channel_output_collection_0/v3_four_channel_placement_0/v3_channel_selector_late_promotion_0/v3_channel_input_bias_late_promotion_0/a_6070_23422# v3_four_channel_output_load_integration_0/v3_four_channel_shared_support_integration_0/v3_four_channel_bias_reference_distribution_0/v3_four_channel_phase_distribution_0/v3_four_channel_output_collection_0/v3_four_channel_placement_0/v3_channel_selector_late_promotion_0/v3_selector_route_pilot_0/group3_lo_n v3_four_channel_output_load_integration_0/combined_p VGND sky130_fd_pr__nfet_01v8 ad=0.1885 pd=1.88 as=0.1885 ps=1.88 w=0.65 l=0.15
X1386 v3_four_channel_output_load_integration_0/combined_n v3_four_channel_output_load_integration_0/v3_four_channel_shared_support_integration_0/v3_four_channel_bias_reference_distribution_0/v3_four_channel_phase_distribution_0/v3_four_channel_output_collection_0/v3_four_channel_placement_0/v3_channel_selector_late_promotion_0/v3_selector_route_pilot_0/group1_lo_n v3_four_channel_output_load_integration_0/v3_four_channel_shared_support_integration_0/v3_four_channel_bias_reference_distribution_0/v3_four_channel_phase_distribution_0/v3_four_channel_output_collection_0/v3_four_channel_placement_0/v3_channel_selector_late_promotion_0/v3_channel_input_bias_late_promotion_0/a_4254_14978# VGND sky130_fd_pr__nfet_01v8 ad=0.1885 pd=1.88 as=0.1885 ps=1.88 w=0.65 l=0.15
X1387 v3_four_channel_output_load_integration_0/combined_p v3_four_channel_output_load_integration_0/v3_four_channel_shared_support_integration_0/v3_four_channel_bias_reference_distribution_0/v3_four_channel_phase_distribution_0/v3_four_channel_output_collection_0/v3_four_channel_placement_0/v3_channel_selector_late_promotion_0/v3_selector_route_pilot_0/group2_lo_n v3_four_channel_output_load_integration_0/v3_four_channel_shared_support_integration_0/v3_four_channel_bias_reference_distribution_0/v3_four_channel_phase_distribution_0/v3_four_channel_output_collection_0/v3_four_channel_placement_0/v3_channel_selector_late_promotion_0/v3_channel_input_bias_late_promotion_0/a_7038_10978# VGND sky130_fd_pr__nfet_01v8 ad=0.1885 pd=1.88 as=0.1885 ps=1.88 w=0.65 l=0.15
X1388 v3_four_channel_output_load_integration_0/v3_four_channel_shared_support_integration_0/v3_four_channel_bias_reference_distribution_0/v3_four_channel_phase_distribution_0/v3_four_channel_output_collection_0/v3_four_channel_placement_0/v3_channel_selector_late_promotion_0/v3_channel_input_bias_late_promotion_0/a_7462_15422# v3_four_channel_output_load_integration_0/v3_four_channel_shared_support_integration_0/v3_four_channel_bias_reference_distribution_0/v3_four_channel_phase_distribution_0/v3_four_channel_output_collection_0/v3_four_channel_placement_0/v3_channel_selector_late_promotion_0/v3_selector_route_pilot_0/group1_lo_p v3_four_channel_output_load_integration_0/combined_p VGND sky130_fd_pr__nfet_01v8 ad=0.1885 pd=1.88 as=0.1885 ps=1.88 w=0.65 l=0.15
X1389 VGND VGND VGND VGND sky130_fd_pr__nfet_01v8 ad=1.4703 pd=10.72 as=0 ps=0 w=5.07 l=1
X1390 v3_four_channel_output_load_integration_0/v3_four_channel_shared_support_integration_0/v3_four_channel_bias_reference_distribution_0/v3_four_channel_phase_distribution_0/v3_four_channel_output_collection_0/v3_four_channel_placement_0/v3_channel_selector_late_promotion_0/v3_channel_input_bias_late_promotion_0/a_7216_6978# v3_four_channel_output_load_integration_0/v3_four_channel_shared_support_integration_0/v3_tail_bias_support_block_0/vbias VGND VGND sky130_fd_pr__nfet_01v8 ad=1.4703 pd=10.72 as=1.4703 ps=10.72 w=5.07 l=1
X1391 v3_four_channel_output_load_integration_0/v3_four_channel_shared_support_integration_0/v3_four_channel_bias_reference_distribution_0/v3_four_channel_phase_distribution_0/v3_four_channel_output_collection_0/v3_four_channel_placement_0/v3_channel_selector_late_promotion_0/v3_channel_input_bias_late_promotion_0/a_7216_10978# v3_four_channel_output_load_integration_0/v3_four_channel_shared_support_integration_0/v3_vcm_support_block_0/ref v3_four_channel_output_load_integration_0/v3_four_channel_shared_support_integration_0/v3_four_channel_bias_reference_distribution_0/v3_four_channel_phase_distribution_0/v3_four_channel_output_collection_0/v3_four_channel_placement_0/v3_channel_selector_late_promotion_0/v3_channel_input_bias_late_promotion_0/a_7038_10978# VGND sky130_fd_pr__nfet_01v8 ad=0.2436 pd=2.26 as=0.2436 ps=2.26 w=0.84 l=0.6
X1392 v3_four_channel_output_load_integration_0/v3_four_channel_shared_support_integration_0/v3_four_channel_bias_reference_distribution_0/v3_four_channel_phase_distribution_0/v3_four_channel_output_collection_0/v3_four_channel_placement_0/v3_channel_selector_late_promotion_0/v3_channel_input_bias_late_promotion_0/a_4678_15422# v3_four_channel_output_load_integration_0/v3_four_channel_shared_support_integration_0/v3_vcm_support_block_0/ref v3_four_channel_output_load_integration_0/v3_four_channel_shared_support_integration_0/v3_four_channel_bias_reference_distribution_0/v3_four_channel_phase_distribution_0/v3_four_channel_output_collection_0/v3_four_channel_placement_0/v3_channel_selector_late_promotion_0/v3_channel_input_bias_late_promotion_0/a_4382_13688# VGND sky130_fd_pr__nfet_01v8 ad=0.2436 pd=2.26 as=0.2436 ps=2.26 w=0.84 l=0.6
X1393 v3_four_channel_output_load_integration_0/v3_four_channel_shared_support_integration_0/v3_four_channel_bias_reference_distribution_0/v3_four_channel_phase_distribution_0/v3_four_channel_output_collection_0/v3_four_channel_placement_0/v3_channel_selector_late_promotion_0/v3_channel_input_bias_late_promotion_0/a_4678_15422# v3_four_channel_output_load_integration_0/v3_four_channel_shared_support_integration_0/v3_four_channel_bias_reference_distribution_0/v3_four_channel_phase_distribution_0/v3_four_channel_output_collection_0/v3_four_channel_placement_0/v3_channel_selector_late_promotion_0/v3_selector_route_pilot_0/group1_lo_p v3_four_channel_output_load_integration_0/combined_n VGND sky130_fd_pr__nfet_01v8 ad=0.1885 pd=1.88 as=0.1885 ps=1.88 w=0.65 l=0.15
X1394 v3_four_channel_output_load_integration_0/combined_p v3_four_channel_output_load_integration_0/v3_four_channel_shared_support_integration_0/v3_four_channel_bias_reference_distribution_0/v3_four_channel_phase_distribution_0/v3_four_channel_output_collection_0/v3_four_channel_placement_0/v3_channel_selector_late_promotion_0/v3_selector_route_pilot_0/group3_lo_p v3_four_channel_output_load_integration_0/v3_four_channel_shared_support_integration_0/v3_four_channel_bias_reference_distribution_0/v3_four_channel_phase_distribution_0/v3_four_channel_output_collection_0/v3_four_channel_placement_0/v3_channel_selector_late_promotion_0/v3_channel_input_bias_late_promotion_0/a_4254_22978# VGND sky130_fd_pr__nfet_01v8 ad=0.1885 pd=1.88 as=0.1885 ps=1.88 w=0.65 l=0.15
X1395 v3_four_channel_output_load_integration_0/v3_four_channel_shared_support_integration_0/v3_four_channel_bias_reference_distribution_0/v3_four_channel_phase_distribution_0/v3_four_channel_output_collection_0/v3_four_channel_placement_0/v3_channel_selector_late_promotion_0/v3_channel_input_bias_late_promotion_0/a_7462_19422# v3_four_channel_output_load_integration_0/v3_four_channel_shared_support_integration_0/v3_vcm_support_block_0/ref v3_four_channel_output_load_integration_0/v3_four_channel_shared_support_integration_0/v3_four_channel_bias_reference_distribution_0/v3_four_channel_phase_distribution_0/v3_four_channel_output_collection_0/v3_four_channel_placement_0/v3_channel_selector_late_promotion_0/v3_channel_input_bias_late_promotion_0/a_7166_17688# VGND sky130_fd_pr__nfet_01v8 ad=0.2436 pd=2.26 as=0.2436 ps=2.26 w=0.84 l=0.6
X1396 v3_four_channel_output_load_integration_0/combined_n v3_four_channel_output_load_integration_0/v3_four_channel_shared_support_integration_0/v3_four_channel_bias_reference_distribution_0/v3_four_channel_phase_distribution_0/v3_four_channel_output_collection_0/v3_four_channel_placement_0/v3_channel_selector_late_promotion_0/v3_selector_route_pilot_0/group3_lo_p v3_four_channel_output_load_integration_0/v3_four_channel_shared_support_integration_0/v3_four_channel_bias_reference_distribution_0/v3_four_channel_phase_distribution_0/v3_four_channel_output_collection_0/v3_four_channel_placement_0/v3_channel_selector_late_promotion_0/v3_channel_input_bias_late_promotion_0/a_5646_10978# VGND sky130_fd_pr__nfet_01v8 ad=0.1885 pd=1.88 as=0.1885 ps=1.88 w=0.65 l=0.15
X1397 v3_four_channel_output_load_integration_0/combined_n v3_four_channel_output_load_integration_0/v3_four_channel_shared_support_integration_0/v3_four_channel_bias_reference_distribution_0/v3_four_channel_phase_distribution_0/v3_four_channel_output_collection_0/v3_four_channel_placement_0/v3_channel_selector_late_promotion_0/v3_selector_route_pilot_0/group1_lo_p v3_four_channel_output_load_integration_0/v3_four_channel_shared_support_integration_0/v3_four_channel_bias_reference_distribution_0/v3_four_channel_phase_distribution_0/v3_four_channel_output_collection_0/v3_four_channel_placement_0/v3_channel_selector_late_promotion_0/v3_channel_input_bias_late_promotion_0/a_7038_14978# VGND sky130_fd_pr__nfet_01v8 ad=0.1885 pd=1.88 as=0.1885 ps=1.88 w=0.65 l=0.15
X1398 v3_four_channel_output_load_integration_0/v3_four_channel_shared_support_integration_0/v3_four_channel_bias_reference_distribution_0/v3_four_channel_phase_distribution_0/v3_four_channel_output_collection_0/v3_four_channel_placement_0/v3_channel_selector_late_promotion_0/v3_channel_input_bias_late_promotion_0/a_7462_19422# v3_four_channel_output_load_integration_0/v3_four_channel_shared_support_integration_0/v3_four_channel_bias_reference_distribution_0/v3_four_channel_phase_distribution_0/v3_four_channel_output_collection_0/v3_four_channel_placement_0/v3_channel_selector_late_promotion_0/v3_selector_route_pilot_0/group2_lo_p v3_four_channel_output_load_integration_0/combined_n VGND sky130_fd_pr__nfet_01v8 ad=0.1885 pd=1.88 as=0.1885 ps=1.88 w=0.65 l=0.15
X1399 v3_four_channel_output_load_integration_0/v3_four_channel_shared_support_integration_0/v3_four_channel_bias_reference_distribution_0/v3_four_channel_phase_distribution_0/v3_four_channel_output_collection_0/v3_four_channel_placement_0/v3_channel_selector_late_promotion_0/v3_channel_input_bias_late_promotion_0/a_4678_7422# V3I003 v3_four_channel_output_load_integration_0/v3_four_channel_shared_support_integration_0/v3_four_channel_bias_reference_distribution_0/v3_four_channel_phase_distribution_0/v3_four_channel_output_collection_0/v3_four_channel_placement_0/v3_channel_selector_late_promotion_0/v3_channel_input_bias_late_promotion_0/a_4432_6978# VGND sky130_fd_pr__nfet_01v8 ad=0.2436 pd=2.26 as=0.2436 ps=2.26 w=0.84 l=0.6
X1400 v3_four_channel_output_load_integration_0/combined_p v3_four_channel_output_load_integration_0/v3_four_channel_shared_support_integration_0/v3_four_channel_bias_reference_distribution_0/v3_four_channel_phase_distribution_0/v3_four_channel_output_collection_0/v3_four_channel_placement_0/v3_channel_selector_late_promotion_0/v3_selector_route_pilot_0/group3_lo_n v3_four_channel_output_load_integration_0/v3_four_channel_shared_support_integration_0/v3_four_channel_bias_reference_distribution_0/v3_four_channel_phase_distribution_0/v3_four_channel_output_collection_0/v3_four_channel_placement_0/v3_channel_selector_late_promotion_0/v3_channel_input_bias_late_promotion_0/a_5646_6978# VGND sky130_fd_pr__nfet_01v8 ad=0.1885 pd=1.88 as=0.1885 ps=1.88 w=0.65 l=0.15
X1401 v3_four_channel_output_load_integration_0/v3_four_channel_shared_support_integration_0/v3_four_channel_bias_reference_distribution_0/v3_four_channel_phase_distribution_0/v3_four_channel_output_collection_0/v3_four_channel_placement_0/v3_channel_selector_late_promotion_0/v3_channel_input_bias_late_promotion_0/a_4678_7422# v3_four_channel_output_load_integration_0/v3_four_channel_shared_support_integration_0/v3_four_channel_bias_reference_distribution_0/v3_four_channel_phase_distribution_0/v3_four_channel_output_collection_0/v3_four_channel_placement_0/v3_channel_selector_late_promotion_0/v3_selector_route_pilot_0/group3_lo_n v3_four_channel_output_load_integration_0/combined_n VGND sky130_fd_pr__nfet_01v8 ad=0.1885 pd=1.88 as=0.1885 ps=1.88 w=0.65 l=0.15
X1402 v3_four_channel_output_load_integration_0/v3_four_channel_shared_support_integration_0/v3_four_channel_bias_reference_distribution_0/v3_four_channel_phase_distribution_0/v3_four_channel_output_collection_0/v3_four_channel_placement_0/v3_channel_selector_late_promotion_0/v3_channel_input_bias_late_promotion_0/a_6070_11422# V3I003 v3_four_channel_output_load_integration_0/v3_four_channel_shared_support_integration_0/v3_four_channel_bias_reference_distribution_0/v3_four_channel_phase_distribution_0/v3_four_channel_output_collection_0/v3_four_channel_placement_0/v3_channel_selector_late_promotion_0/v3_channel_input_bias_late_promotion_0/a_5824_10978# VGND sky130_fd_pr__nfet_01v8 ad=0.2436 pd=2.26 as=0.2436 ps=2.26 w=0.84 l=0.6
X1403 v3_four_channel_output_load_integration_0/v3_four_channel_shared_support_integration_0/v3_four_channel_bias_reference_distribution_0/v3_four_channel_phase_distribution_0/v3_four_channel_output_collection_0/v3_four_channel_placement_0/v3_channel_selector_late_promotion_0/v3_channel_input_bias_late_promotion_0/a_6070_11422# v3_four_channel_output_load_integration_0/v3_four_channel_shared_support_integration_0/v3_four_channel_bias_reference_distribution_0/v3_four_channel_phase_distribution_0/v3_four_channel_output_collection_0/v3_four_channel_placement_0/v3_channel_selector_late_promotion_0/v3_selector_route_pilot_0/group3_lo_n v3_four_channel_output_load_integration_0/combined_n VGND sky130_fd_pr__nfet_01v8 ad=0.1885 pd=1.88 as=0.1885 ps=1.88 w=0.65 l=0.15
X1404 v3_four_channel_output_load_integration_0/v3_four_channel_shared_support_integration_0/v3_four_channel_bias_reference_distribution_0/v3_four_channel_phase_distribution_0/v3_four_channel_output_collection_0/v3_four_channel_placement_0/v3_channel_selector_late_promotion_0/v3_channel_input_bias_late_promotion_0/a_4382_21688# V3I003 v3_four_channel_output_load_integration_0/v3_four_channel_shared_support_integration_0/v3_four_channel_bias_reference_distribution_0/v3_four_channel_phase_distribution_0/v3_four_channel_output_collection_0/v3_four_channel_placement_0/v3_channel_selector_late_promotion_0/v3_channel_input_bias_late_promotion_0/a_4254_22978# VGND sky130_fd_pr__nfet_01v8 ad=0.2436 pd=2.26 as=0.2436 ps=2.26 w=0.84 l=0.6
X1405 v3_four_channel_output_load_integration_0/v3_four_channel_shared_support_integration_0/v3_four_channel_bias_reference_distribution_0/v3_four_channel_phase_distribution_0/v3_four_channel_output_collection_0/v3_four_channel_placement_0/v3_channel_selector_late_promotion_0/v3_channel_input_bias_late_promotion_0/a_4678_23422# v3_four_channel_output_load_integration_0/v3_four_channel_shared_support_integration_0/v3_four_channel_bias_reference_distribution_0/v3_four_channel_phase_distribution_0/v3_four_channel_output_collection_0/v3_four_channel_placement_0/v3_channel_selector_late_promotion_0/v3_selector_route_pilot_0/group3_lo_n v3_four_channel_output_load_integration_0/combined_p VGND sky130_fd_pr__nfet_01v8 ad=0.1885 pd=1.88 as=0.1885 ps=1.88 w=0.65 l=0.15
X1406 v3_four_channel_output_load_integration_0/combined_p v3_four_channel_output_load_integration_0/v3_four_channel_shared_support_integration_0/v3_four_channel_bias_reference_distribution_0/v3_four_channel_phase_distribution_0/v3_four_channel_output_collection_0/v3_four_channel_placement_0/v3_channel_selector_late_promotion_0/v3_selector_route_pilot_0/group3_lo_n v3_four_channel_output_load_integration_0/v3_four_channel_shared_support_integration_0/v3_four_channel_bias_reference_distribution_0/v3_four_channel_phase_distribution_0/v3_four_channel_output_collection_0/v3_four_channel_placement_0/v3_channel_selector_late_promotion_0/v3_channel_input_bias_late_promotion_0/a_4254_6978# VGND sky130_fd_pr__nfet_01v8 ad=0.1885 pd=1.88 as=0.1885 ps=1.88 w=0.65 l=0.15
X1407 v3_four_channel_output_load_integration_0/v3_four_channel_shared_support_integration_0/v3_four_channel_bias_reference_distribution_0/v3_four_channel_phase_distribution_0/v3_four_channel_output_collection_0/v3_four_channel_placement_0/v3_channel_selector_late_promotion_0/v3_channel_input_bias_late_promotion_0/a_5774_13688# V3I003 v3_four_channel_output_load_integration_0/v3_four_channel_shared_support_integration_0/v3_four_channel_bias_reference_distribution_0/v3_four_channel_phase_distribution_0/v3_four_channel_output_collection_0/v3_four_channel_placement_0/v3_channel_selector_late_promotion_0/v3_channel_input_bias_late_promotion_0/a_5646_14978# VGND sky130_fd_pr__nfet_01v8 ad=0.2436 pd=2.26 as=0.2436 ps=2.26 w=0.84 l=0.6
X1408 v3_four_channel_output_load_integration_0/combined_p v3_four_channel_output_load_integration_0/v3_four_channel_shared_support_integration_0/v3_four_channel_bias_reference_distribution_0/v3_four_channel_phase_distribution_0/v3_four_channel_output_collection_0/v3_four_channel_placement_0/v3_channel_selector_late_promotion_0/v3_selector_route_pilot_0/group3_lo_p v3_four_channel_output_load_integration_0/v3_four_channel_shared_support_integration_0/v3_four_channel_bias_reference_distribution_0/v3_four_channel_phase_distribution_0/v3_four_channel_output_collection_0/v3_four_channel_placement_0/v3_channel_selector_late_promotion_0/v3_channel_input_bias_late_promotion_0/a_7038_22978# VGND sky130_fd_pr__nfet_01v8 ad=0.1885 pd=1.88 as=0.1885 ps=1.88 w=0.65 l=0.15
X1409 v3_four_channel_output_load_integration_0/v3_four_channel_shared_support_integration_0/v3_four_channel_bias_reference_distribution_0/v3_four_channel_phase_distribution_0/v3_four_channel_output_collection_0/v3_four_channel_placement_0/v3_channel_selector_late_promotion_0/v3_channel_input_bias_late_promotion_0/a_7462_7422# V3I003 v3_four_channel_output_load_integration_0/v3_four_channel_shared_support_integration_0/v3_four_channel_bias_reference_distribution_0/v3_four_channel_phase_distribution_0/v3_four_channel_output_collection_0/v3_four_channel_placement_0/v3_channel_selector_late_promotion_0/v3_channel_input_bias_late_promotion_0/a_7216_6978# VGND sky130_fd_pr__nfet_01v8 ad=0.2436 pd=2.26 as=0.2436 ps=2.26 w=0.84 l=0.6
X1410 v3_four_channel_output_load_integration_0/v3_four_channel_shared_support_integration_0/v3_four_channel_bias_reference_distribution_0/v3_four_channel_phase_distribution_0/v3_four_channel_output_collection_0/v3_four_channel_placement_0/v3_channel_selector_late_promotion_0/v3_channel_input_bias_late_promotion_0/a_4432_10978# v3_four_channel_output_load_integration_0/v3_four_channel_shared_support_integration_0/v3_tail_bias_support_block_0/vbias VGND VGND sky130_fd_pr__nfet_01v8 ad=1.4703 pd=10.72 as=1.4703 ps=10.72 w=5.07 l=1
X1411 v3_four_channel_output_load_integration_0/v3_four_channel_shared_support_integration_0/v3_four_channel_bias_reference_distribution_0/v3_four_channel_phase_distribution_0/v3_four_channel_output_collection_0/v3_four_channel_placement_0/v3_channel_selector_late_promotion_0/v3_channel_input_bias_late_promotion_0/a_7462_7422# v3_four_channel_output_load_integration_0/v3_four_channel_shared_support_integration_0/v3_four_channel_bias_reference_distribution_0/v3_four_channel_phase_distribution_0/v3_four_channel_output_collection_0/v3_four_channel_placement_0/v3_channel_selector_late_promotion_0/v3_selector_route_pilot_0/group3_lo_n v3_four_channel_output_load_integration_0/combined_n VGND sky130_fd_pr__nfet_01v8 ad=0.1885 pd=1.88 as=0.1885 ps=1.88 w=0.65 l=0.15
X1412 VGND v3_four_channel_output_load_integration_0/v3_four_channel_shared_support_integration_0/v3_tail_bias_support_block_0/vbias v3_four_channel_output_load_integration_0/v3_four_channel_shared_support_integration_0/v3_four_channel_bias_reference_distribution_0/v3_four_channel_phase_distribution_0/v3_four_channel_output_collection_0/v3_four_channel_placement_0/v3_channel_selector_late_promotion_0/v3_channel_input_bias_late_promotion_0/a_4382_17688# VGND sky130_fd_pr__nfet_01v8 ad=1.4703 pd=10.72 as=1.4703 ps=10.72 w=5.07 l=1
X1413 v3_four_channel_output_load_integration_0/combined_p v3_four_channel_output_load_integration_0/v3_four_channel_shared_support_integration_0/v3_four_channel_bias_reference_distribution_0/v3_four_channel_phase_distribution_0/v3_four_channel_output_collection_0/v3_four_channel_placement_0/v3_channel_selector_late_promotion_0/v3_selector_route_pilot_0/group3_lo_n v3_four_channel_output_load_integration_0/v3_four_channel_shared_support_integration_0/v3_four_channel_bias_reference_distribution_0/v3_four_channel_phase_distribution_0/v3_four_channel_output_collection_0/v3_four_channel_placement_0/v3_channel_selector_late_promotion_0/v3_channel_input_bias_late_promotion_0/a_7038_6978# VGND sky130_fd_pr__nfet_01v8 ad=0.1885 pd=1.88 as=0.1885 ps=1.88 w=0.65 l=0.15
X1414 v3_four_channel_output_load_integration_0/combined_n v3_four_channel_output_load_integration_0/v3_four_channel_shared_support_integration_0/v3_four_channel_bias_reference_distribution_0/v3_four_channel_phase_distribution_0/v3_four_channel_output_collection_0/v3_four_channel_placement_0/v3_channel_selector_late_promotion_0/v3_selector_route_pilot_0/group2_lo_p v3_four_channel_output_load_integration_0/v3_four_channel_shared_support_integration_0/v3_four_channel_bias_reference_distribution_0/v3_four_channel_phase_distribution_0/v3_four_channel_output_collection_0/v3_four_channel_placement_0/v3_channel_selector_late_promotion_0/v3_channel_input_bias_late_promotion_0/a_4254_10978# VGND sky130_fd_pr__nfet_01v8 ad=0.1885 pd=1.88 as=0.1885 ps=1.88 w=0.65 l=0.15
X1415 v3_four_channel_output_load_integration_0/v3_four_channel_shared_support_integration_0/v3_four_channel_bias_reference_distribution_0/v3_four_channel_phase_distribution_0/v3_four_channel_output_collection_0/v3_four_channel_placement_0/v3_channel_selector_late_promotion_0/v3_channel_input_bias_late_promotion_0/a_7462_11422# v3_four_channel_output_load_integration_0/v3_four_channel_shared_support_integration_0/v3_four_channel_bias_reference_distribution_0/v3_four_channel_phase_distribution_0/v3_four_channel_output_collection_0/v3_four_channel_placement_0/v3_channel_selector_late_promotion_0/v3_selector_route_pilot_0/group2_lo_p v3_four_channel_output_load_integration_0/combined_p VGND sky130_fd_pr__nfet_01v8 ad=0.1885 pd=1.88 as=0.1885 ps=1.88 w=0.65 l=0.15
X1416 v3_four_channel_output_load_integration_0/v3_four_channel_shared_support_integration_0/v3_four_channel_bias_reference_distribution_0/v3_four_channel_phase_distribution_0/v3_four_channel_output_collection_0/v3_four_channel_placement_0/v3_channel_selector_late_promotion_0/v3_channel_input_bias_late_promotion_0/a_7166_21688# V3I003 v3_four_channel_output_load_integration_0/v3_four_channel_shared_support_integration_0/v3_four_channel_bias_reference_distribution_0/v3_four_channel_phase_distribution_0/v3_four_channel_output_collection_0/v3_four_channel_placement_0/v3_channel_selector_late_promotion_0/v3_channel_input_bias_late_promotion_0/a_7038_22978# VGND sky130_fd_pr__nfet_01v8 ad=0.2436 pd=2.26 as=0.2436 ps=2.26 w=0.84 l=0.6
X1417 v3_four_channel_output_load_integration_0/combined_n v3_four_channel_output_load_integration_0/v3_four_channel_shared_support_integration_0/v3_four_channel_bias_reference_distribution_0/v3_four_channel_phase_distribution_0/v3_four_channel_output_collection_0/v3_four_channel_placement_0/v3_channel_selector_late_promotion_0/v3_selector_route_pilot_0/group3_lo_n v3_four_channel_output_load_integration_0/v3_four_channel_shared_support_integration_0/v3_four_channel_bias_reference_distribution_0/v3_four_channel_phase_distribution_0/v3_four_channel_output_collection_0/v3_four_channel_placement_0/v3_channel_selector_late_promotion_0/v3_channel_input_bias_late_promotion_0/a_5646_22978# VGND sky130_fd_pr__nfet_01v8 ad=0.1885 pd=1.88 as=0.1885 ps=1.88 w=0.65 l=0.15
X1418 v3_four_channel_output_load_integration_0/v3_four_channel_shared_support_integration_0/v3_four_channel_bias_reference_distribution_0/v3_four_channel_phase_distribution_0/v3_four_channel_output_collection_0/v3_four_channel_placement_0/v3_channel_selector_late_promotion_0/v3_channel_input_bias_late_promotion_0/a_4678_11422# V3I003 v3_four_channel_output_load_integration_0/v3_four_channel_shared_support_integration_0/v3_four_channel_bias_reference_distribution_0/v3_four_channel_phase_distribution_0/v3_four_channel_output_collection_0/v3_four_channel_placement_0/v3_channel_selector_late_promotion_0/v3_channel_input_bias_late_promotion_0/a_4432_10978# VGND sky130_fd_pr__nfet_01v8 ad=0.2436 pd=2.26 as=0.2436 ps=2.26 w=0.84 l=0.6
X1419 v3_four_channel_output_load_integration_0/v3_four_channel_shared_support_integration_0/v3_four_channel_bias_reference_distribution_0/v3_four_channel_phase_distribution_0/v3_four_channel_output_collection_0/v3_four_channel_placement_0/v3_channel_selector_late_promotion_0/v3_channel_input_bias_late_promotion_0/a_6070_23422# v3_four_channel_output_load_integration_0/v3_four_channel_shared_support_integration_0/v3_vcm_support_block_0/ref v3_four_channel_output_load_integration_0/v3_four_channel_shared_support_integration_0/v3_four_channel_bias_reference_distribution_0/v3_four_channel_phase_distribution_0/v3_four_channel_output_collection_0/v3_four_channel_placement_0/v3_channel_selector_late_promotion_0/v3_channel_input_bias_late_promotion_0/a_5774_21688# VGND sky130_fd_pr__nfet_01v8 ad=0.2436 pd=2.26 as=0.2436 ps=2.26 w=0.84 l=0.6
X1420 v3_four_channel_output_load_integration_0/v3_four_channel_shared_support_integration_0/v3_four_channel_bias_reference_distribution_0/v3_four_channel_phase_distribution_0/v3_four_channel_output_collection_0/v3_four_channel_placement_0/v3_channel_selector_late_promotion_0/v3_channel_input_bias_late_promotion_0/a_6070_23422# v3_four_channel_output_load_integration_0/v3_four_channel_shared_support_integration_0/v3_four_channel_bias_reference_distribution_0/v3_four_channel_phase_distribution_0/v3_four_channel_output_collection_0/v3_four_channel_placement_0/v3_channel_selector_late_promotion_0/v3_selector_route_pilot_0/group3_lo_p v3_four_channel_output_load_integration_0/combined_n VGND sky130_fd_pr__nfet_01v8 ad=0.1885 pd=1.88 as=0.1885 ps=1.88 w=0.65 l=0.15
X1421 v3_four_channel_output_load_integration_0/v3_four_channel_shared_support_integration_0/v3_four_channel_bias_reference_distribution_0/v3_four_channel_phase_distribution_0/v3_four_channel_output_collection_0/v3_four_channel_placement_0/v3_channel_selector_late_promotion_0/v3_channel_input_bias_late_promotion_0/a_4678_11422# v3_four_channel_output_load_integration_0/v3_four_channel_shared_support_integration_0/v3_four_channel_bias_reference_distribution_0/v3_four_channel_phase_distribution_0/v3_four_channel_output_collection_0/v3_four_channel_placement_0/v3_channel_selector_late_promotion_0/v3_selector_route_pilot_0/group2_lo_n v3_four_channel_output_load_integration_0/combined_n VGND sky130_fd_pr__nfet_01v8 ad=0.1885 pd=1.88 as=0.1885 ps=1.88 w=0.65 l=0.15
X1422 v3_four_channel_output_load_integration_0/v3_four_channel_shared_support_integration_0/v3_four_channel_bias_reference_distribution_0/v3_four_channel_phase_distribution_0/v3_four_channel_output_collection_0/v3_four_channel_placement_0/v3_channel_selector_late_promotion_0/v3_channel_input_bias_late_promotion_0/a_7462_15422# V3I003 v3_four_channel_output_load_integration_0/v3_four_channel_shared_support_integration_0/v3_four_channel_bias_reference_distribution_0/v3_four_channel_phase_distribution_0/v3_four_channel_output_collection_0/v3_four_channel_placement_0/v3_channel_selector_late_promotion_0/v3_channel_input_bias_late_promotion_0/a_7216_14978# VGND sky130_fd_pr__nfet_01v8 ad=0.2436 pd=2.26 as=0.2436 ps=2.26 w=0.84 l=0.6
X1423 v3_four_channel_output_load_integration_0/v3_four_channel_shared_support_integration_0/v3_four_channel_bias_reference_distribution_0/v3_four_channel_phase_distribution_0/v3_four_channel_output_collection_0/v3_four_channel_placement_0/v3_channel_selector_late_promotion_0/v3_channel_input_bias_late_promotion_0/a_6070_7422# v3_four_channel_output_load_integration_0/v3_four_channel_shared_support_integration_0/v3_four_channel_bias_reference_distribution_0/v3_four_channel_phase_distribution_0/v3_four_channel_output_collection_0/v3_four_channel_placement_0/v3_channel_selector_late_promotion_0/v3_selector_route_pilot_0/group3_lo_p v3_four_channel_output_load_integration_0/combined_p VGND sky130_fd_pr__nfet_01v8 ad=0.1885 pd=1.88 as=0.1885 ps=1.88 w=0.65 l=0.15
X1424 v3_four_channel_output_load_integration_0/combined_n v3_four_channel_output_load_integration_0/v3_four_channel_shared_support_integration_0/v3_four_channel_bias_reference_distribution_0/v3_four_channel_phase_distribution_0/v3_four_channel_output_collection_0/v3_four_channel_placement_0/v3_channel_selector_late_promotion_0/v3_selector_route_pilot_0/group2_lo_p v3_four_channel_output_load_integration_0/v3_four_channel_shared_support_integration_0/v3_four_channel_bias_reference_distribution_0/v3_four_channel_phase_distribution_0/v3_four_channel_output_collection_0/v3_four_channel_placement_0/v3_channel_selector_late_promotion_0/v3_channel_input_bias_late_promotion_0/a_7038_10978# VGND sky130_fd_pr__nfet_01v8 ad=0.1885 pd=1.88 as=0.1885 ps=1.88 w=0.65 l=0.15
X1425 v3_four_channel_output_load_integration_0/v3_four_channel_shared_support_integration_0/v3_four_channel_bias_reference_distribution_0/v3_four_channel_phase_distribution_0/v3_four_channel_output_collection_0/v3_four_channel_placement_0/v3_channel_selector_late_promotion_0/v3_channel_input_bias_late_promotion_0/a_7462_15422# v3_four_channel_output_load_integration_0/v3_four_channel_shared_support_integration_0/v3_four_channel_bias_reference_distribution_0/v3_four_channel_phase_distribution_0/v3_four_channel_output_collection_0/v3_four_channel_placement_0/v3_channel_selector_late_promotion_0/v3_selector_route_pilot_0/group1_lo_n v3_four_channel_output_load_integration_0/combined_n VGND sky130_fd_pr__nfet_01v8 ad=0.1885 pd=1.88 as=0.1885 ps=1.88 w=0.65 l=0.15
X1426 v3_four_channel_output_load_integration_0/v3_four_channel_shared_support_integration_0/v3_four_channel_bias_reference_distribution_0/v3_four_channel_phase_distribution_0/v3_four_channel_output_collection_0/v3_four_channel_placement_0/v3_channel_selector_late_promotion_0/v3_channel_input_bias_late_promotion_0/a_4432_6978# v3_four_channel_output_load_integration_0/v3_four_channel_shared_support_integration_0/v3_vcm_support_block_0/ref v3_four_channel_output_load_integration_0/v3_four_channel_shared_support_integration_0/v3_four_channel_bias_reference_distribution_0/v3_four_channel_phase_distribution_0/v3_four_channel_output_collection_0/v3_four_channel_placement_0/v3_channel_selector_late_promotion_0/v3_channel_input_bias_late_promotion_0/a_4254_6978# VGND sky130_fd_pr__nfet_01v8 ad=0.2436 pd=2.26 as=0.2436 ps=2.26 w=0.84 l=0.6
X1427 v3_four_channel_output_load_integration_0/v3_four_channel_shared_support_integration_0/v3_four_channel_bias_reference_distribution_0/v3_four_channel_phase_distribution_0/v3_four_channel_output_collection_0/v3_four_channel_placement_0/v3_channel_selector_late_promotion_0/v3_channel_input_bias_late_promotion_0/a_5824_10978# v3_four_channel_output_load_integration_0/v3_four_channel_shared_support_integration_0/v3_vcm_support_block_0/ref v3_four_channel_output_load_integration_0/v3_four_channel_shared_support_integration_0/v3_four_channel_bias_reference_distribution_0/v3_four_channel_phase_distribution_0/v3_four_channel_output_collection_0/v3_four_channel_placement_0/v3_channel_selector_late_promotion_0/v3_channel_input_bias_late_promotion_0/a_5646_10978# VGND sky130_fd_pr__nfet_01v8 ad=0.2436 pd=2.26 as=0.2436 ps=2.26 w=0.84 l=0.6
X1428 v3_four_channel_output_load_integration_0/combined_n v3_four_channel_output_load_integration_0/v3_four_channel_shared_support_integration_0/v3_four_channel_bias_reference_distribution_0/v3_four_channel_phase_distribution_0/v3_four_channel_output_collection_0/v3_four_channel_placement_0/v3_channel_selector_late_promotion_0/v3_selector_route_pilot_0/group3_lo_n v3_four_channel_output_load_integration_0/v3_four_channel_shared_support_integration_0/v3_four_channel_bias_reference_distribution_0/v3_four_channel_phase_distribution_0/v3_four_channel_output_collection_0/v3_four_channel_placement_0/v3_channel_selector_late_promotion_0/v3_channel_input_bias_late_promotion_0/a_4254_22978# VGND sky130_fd_pr__nfet_01v8 ad=0.1885 pd=1.88 as=0.1885 ps=1.88 w=0.65 l=0.15
X1429 v3_four_channel_output_load_integration_0/v3_four_channel_shared_support_integration_0/v3_four_channel_bias_reference_distribution_0/v3_four_channel_phase_distribution_0/v3_four_channel_output_collection_0/v3_four_channel_placement_0/v3_channel_selector_late_promotion_0/v3_channel_input_bias_late_promotion_0/a_7462_23422# v3_four_channel_output_load_integration_0/v3_four_channel_shared_support_integration_0/v3_four_channel_bias_reference_distribution_0/v3_four_channel_phase_distribution_0/v3_four_channel_output_collection_0/v3_four_channel_placement_0/v3_channel_selector_late_promotion_0/v3_selector_route_pilot_0/group3_lo_n v3_four_channel_output_load_integration_0/combined_p VGND sky130_fd_pr__nfet_01v8 ad=0.1885 pd=1.88 as=0.1885 ps=1.88 w=0.65 l=0.15
X1430 v3_four_channel_output_load_integration_0/v3_four_channel_shared_support_integration_0/v3_four_channel_bias_reference_distribution_0/v3_four_channel_phase_distribution_0/v3_four_channel_output_collection_0/v3_four_channel_placement_0/v3_channel_selector_late_promotion_0/v3_channel_input_bias_late_promotion_0/a_4432_6978# v3_four_channel_output_load_integration_0/v3_four_channel_shared_support_integration_0/v3_tail_bias_support_block_0/vbias VGND VGND sky130_fd_pr__nfet_01v8 ad=1.4703 pd=10.72 as=1.4703 ps=10.72 w=5.07 l=1
X1431 v3_four_channel_output_load_integration_0/v3_four_channel_shared_support_integration_0/v3_four_channel_bias_reference_distribution_0/v3_four_channel_phase_distribution_0/v3_four_channel_output_collection_0/v3_four_channel_placement_0/v3_channel_selector_late_promotion_0/v3_channel_input_bias_late_promotion_0/a_7216_6978# v3_four_channel_output_load_integration_0/v3_four_channel_shared_support_integration_0/v3_vcm_support_block_0/ref v3_four_channel_output_load_integration_0/v3_four_channel_shared_support_integration_0/v3_four_channel_bias_reference_distribution_0/v3_four_channel_phase_distribution_0/v3_four_channel_output_collection_0/v3_four_channel_placement_0/v3_channel_selector_late_promotion_0/v3_channel_input_bias_late_promotion_0/a_7038_6978# VGND sky130_fd_pr__nfet_01v8 ad=0.2436 pd=2.26 as=0.2436 ps=2.26 w=0.84 l=0.6
X1432 v3_four_channel_output_load_integration_0/combined_n v3_four_channel_output_load_integration_0/v3_four_channel_shared_support_integration_0/v3_four_channel_bias_reference_distribution_0/v3_four_channel_phase_distribution_0/v3_four_channel_output_collection_0/v3_four_channel_placement_0/v3_channel_selector_late_promotion_0/v3_selector_route_pilot_0/group3_lo_p v3_four_channel_output_load_integration_0/v3_four_channel_shared_support_integration_0/v3_four_channel_bias_reference_distribution_0/v3_four_channel_phase_distribution_0/v3_four_channel_output_collection_0/v3_four_channel_placement_0/v3_channel_selector_late_promotion_0/v3_channel_input_bias_late_promotion_0/a_5646_6978# VGND sky130_fd_pr__nfet_01v8 ad=0.1885 pd=1.88 as=0.1885 ps=1.88 w=0.65 l=0.15
X1433 VGND v3_four_channel_output_load_integration_0/v3_four_channel_shared_support_integration_0/v3_tail_bias_support_block_0/vbias v3_four_channel_output_load_integration_0/v3_four_channel_shared_support_integration_0/v3_four_channel_bias_reference_distribution_0/v3_four_channel_phase_distribution_0/v3_four_channel_output_collection_0/v3_four_channel_placement_0/v3_channel_selector_late_promotion_0/v3_channel_input_bias_late_promotion_0/a_4382_13688# VGND sky130_fd_pr__nfet_01v8 ad=1.4703 pd=10.72 as=1.4703 ps=10.72 w=5.07 l=1
X1434 VDPWR v3_four_channel_output_load_integration_0/v3_four_channel_shared_support_integration_0/v3_four_channel_bias_reference_distribution_0/v3_four_channel_phase_distribution_0/v3_four_channel_output_collection_0/v3_four_channel_placement_0/v3_channel_selector_late_promotion_0/v3_selector_route_pilot_0/G1_MUX_POS/a_505_21# v3_four_channel_output_load_integration_0/v3_four_channel_shared_support_integration_0/v3_four_channel_bias_reference_distribution_0/v3_four_channel_phase_distribution_0/v3_four_channel_output_collection_0/v3_four_channel_placement_0/v3_channel_selector_late_promotion_0/v3_selector_route_pilot_0/G1_MUX_POS/a_535_374# VDPWR sky130_fd_pr__pfet_01v8_hvt ad=0 pd=0 as=0.0882 ps=1.26 w=0.42 l=0.15
X1435 v3_four_channel_output_load_integration_0/v3_four_channel_shared_support_integration_0/v3_four_channel_bias_reference_distribution_0/v3_four_channel_phase_distribution_0/v3_four_channel_output_collection_0/v3_four_channel_placement_0/v3_channel_selector_late_promotion_0/v3_selector_route_pilot_0/G1_MUX_POS/a_505_21# V3R224 VDPWR VDPWR sky130_fd_pr__pfet_01v8_hvt ad=0.1176 pd=1.4 as=0 ps=0 w=0.42 l=0.15
X1436 v3_four_channel_output_load_integration_0/v3_four_channel_shared_support_integration_0/v3_four_channel_bias_reference_distribution_0/v3_four_channel_phase_distribution_0/v3_four_channel_output_collection_0/v3_four_channel_placement_0/v3_channel_selector_late_promotion_0/v3_selector_route_pilot_0/G1_MUX_POS/a_218_374# V3R224 VDPWR VDPWR sky130_fd_pr__pfet_01v8_hvt ad=0.1533 pd=1.57 as=0 ps=0 w=0.42 l=0.15
X1437 VGND v3_four_channel_output_load_integration_0/v3_four_channel_shared_support_integration_0/v3_four_channel_bias_reference_distribution_0/v3_four_channel_phase_distribution_0/v3_four_channel_output_collection_0/v3_four_channel_placement_0/v3_channel_selector_late_promotion_0/v3_selector_route_pilot_0/G1_MUX_POS/a_505_21# v3_four_channel_output_load_integration_0/v3_four_channel_shared_support_integration_0/v3_four_channel_bias_reference_distribution_0/v3_four_channel_phase_distribution_0/v3_four_channel_output_collection_0/v3_four_channel_placement_0/v3_channel_selector_late_promotion_0/v3_selector_route_pilot_0/G1_MUX_POS/a_439_47# VGND sky130_fd_pr__nfet_01v8 ad=0 pd=0 as=0.1386 ps=1.5 w=0.42 l=0.15
X1438 v3_four_channel_output_load_integration_0/v3_four_channel_shared_support_integration_0/v3_four_channel_bias_reference_distribution_0/v3_four_channel_phase_distribution_0/v3_four_channel_output_collection_0/v3_four_channel_placement_0/v3_channel_selector_late_promotion_0/v3_selector_route_pilot_0/G1_MUX_POS/a_76_199# V3R290 v3_four_channel_output_load_integration_0/v3_four_channel_shared_support_integration_0/v3_four_channel_bias_reference_distribution_0/v3_four_channel_phase_distribution_0/v3_four_channel_output_collection_0/v3_four_channel_placement_0/v3_channel_selector_late_promotion_0/v3_selector_route_pilot_0/G1_MUX_POS/a_218_374# VDPWR sky130_fd_pr__pfet_01v8_hvt ad=0.3864 pd=2.68 as=0 ps=0 w=0.42 l=0.15
X1439 v3_four_channel_output_load_integration_0/v3_four_channel_shared_support_integration_0/v3_four_channel_bias_reference_distribution_0/v3_four_channel_phase_distribution_0/v3_four_channel_output_collection_0/v3_four_channel_placement_0/v3_channel_selector_late_promotion_0/v3_selector_route_pilot_0/G1_MUX_POS/a_505_21# V3R224 VGND VGND sky130_fd_pr__nfet_01v8 ad=0.1092 pd=1.36 as=0 ps=0 w=0.42 l=0.15
X1440 v3_four_channel_output_load_integration_0/v3_four_channel_shared_support_integration_0/v3_four_channel_bias_reference_distribution_0/v3_four_channel_phase_distribution_0/v3_four_channel_output_collection_0/v3_four_channel_placement_0/v3_channel_selector_late_promotion_0/v3_selector_route_pilot_0/G1_MUX_POS/a_439_47# V3R290 v3_four_channel_output_load_integration_0/v3_four_channel_shared_support_integration_0/v3_four_channel_bias_reference_distribution_0/v3_four_channel_phase_distribution_0/v3_four_channel_output_collection_0/v3_four_channel_placement_0/v3_channel_selector_late_promotion_0/v3_selector_route_pilot_0/G1_MUX_POS/a_76_199# VGND sky130_fd_pr__nfet_01v8 ad=0 pd=0 as=0.1995 ps=1.79 w=0.42 l=0.15
X1441 v3_four_channel_output_load_integration_0/v3_four_channel_shared_support_integration_0/v3_four_channel_bias_reference_distribution_0/v3_four_channel_phase_distribution_0/v3_four_channel_output_collection_0/v3_four_channel_placement_0/v3_channel_selector_late_promotion_0/v3_selector_route_pilot_0/G1_MUX_POS/a_535_374# V3R291 v3_four_channel_output_load_integration_0/v3_four_channel_shared_support_integration_0/v3_four_channel_bias_reference_distribution_0/v3_four_channel_phase_distribution_0/v3_four_channel_output_collection_0/v3_four_channel_placement_0/v3_channel_selector_late_promotion_0/v3_selector_route_pilot_0/G1_MUX_POS/a_76_199# VDPWR sky130_fd_pr__pfet_01v8_hvt ad=0 pd=0 as=0 ps=0 w=0.42 l=0.15
X1442 v3_four_channel_output_load_integration_0/v3_four_channel_shared_support_integration_0/v3_four_channel_bias_reference_distribution_0/v3_four_channel_phase_distribution_0/v3_four_channel_output_collection_0/v3_four_channel_placement_0/v3_channel_selector_late_promotion_0/v3_selector_route_pilot_0/G1_MUX_POS/a_76_199# V3R291 v3_four_channel_output_load_integration_0/v3_four_channel_shared_support_integration_0/v3_four_channel_bias_reference_distribution_0/v3_four_channel_phase_distribution_0/v3_four_channel_output_collection_0/v3_four_channel_placement_0/v3_channel_selector_late_promotion_0/v3_selector_route_pilot_0/G1_MUX_POS/a_218_47# VGND sky130_fd_pr__nfet_01v8 ad=0 pd=0 as=0.1386 ps=1.5 w=0.42 l=0.15
X1443 v3_four_channel_output_load_integration_0/v3_four_channel_shared_support_integration_0/v3_four_channel_bias_reference_distribution_0/v3_four_channel_phase_distribution_0/v3_four_channel_output_collection_0/v3_four_channel_placement_0/v3_channel_selector_late_promotion_0/v3_selector_route_pilot_0/G1_MUX_POS/a_218_47# V3R224 VGND VGND sky130_fd_pr__nfet_01v8 ad=0 pd=0 as=0 ps=0 w=0.42 l=0.15
X1444 VDPWR v3_four_channel_output_load_integration_0/v3_four_channel_shared_support_integration_0/v3_four_channel_bias_reference_distribution_0/v3_four_channel_phase_distribution_0/v3_four_channel_output_collection_0/v3_four_channel_placement_0/v3_channel_selector_late_promotion_0/v3_selector_route_pilot_0/G1_MUX_POS/a_76_199# v3_four_channel_output_load_integration_0/v3_four_channel_shared_support_integration_0/v3_four_channel_bias_reference_distribution_0/v3_four_channel_phase_distribution_0/v3_four_channel_output_collection_0/v3_four_channel_placement_0/v3_channel_selector_late_promotion_0/v3_selector_route_pilot_0/G1_MUX_POS/X VDPWR sky130_fd_pr__pfet_01v8_hvt ad=0 pd=0 as=0.26 ps=2.52 w=1 l=0.15
X1445 VGND v3_four_channel_output_load_integration_0/v3_four_channel_shared_support_integration_0/v3_four_channel_bias_reference_distribution_0/v3_four_channel_phase_distribution_0/v3_four_channel_output_collection_0/v3_four_channel_placement_0/v3_channel_selector_late_promotion_0/v3_selector_route_pilot_0/G1_MUX_POS/a_76_199# v3_four_channel_output_load_integration_0/v3_four_channel_shared_support_integration_0/v3_four_channel_bias_reference_distribution_0/v3_four_channel_phase_distribution_0/v3_four_channel_output_collection_0/v3_four_channel_placement_0/v3_channel_selector_late_promotion_0/v3_selector_route_pilot_0/G1_MUX_POS/X VGND sky130_fd_pr__nfet_01v8 ad=0 pd=0 as=0.169 ps=1.82 w=0.65 l=0.15
X1446 VDPWR v3_four_channel_output_load_integration_0/v3_four_channel_shared_support_integration_0/v3_four_channel_bias_reference_distribution_0/v3_four_channel_phase_distribution_0/v3_four_channel_output_collection_0/v3_four_channel_placement_0/v3_channel_selector_late_promotion_0/v3_selector_route_pilot_0/G3_MUX_AXIS/a_505_21# v3_four_channel_output_load_integration_0/v3_four_channel_shared_support_integration_0/v3_four_channel_bias_reference_distribution_0/v3_four_channel_phase_distribution_0/v3_four_channel_output_collection_0/v3_four_channel_placement_0/v3_channel_selector_late_promotion_0/v3_selector_route_pilot_0/G3_MUX_AXIS/a_535_374# VDPWR sky130_fd_pr__pfet_01v8_hvt ad=0 pd=0 as=0.0882 ps=1.26 w=0.42 l=0.15
X1447 v3_four_channel_output_load_integration_0/v3_four_channel_shared_support_integration_0/v3_four_channel_bias_reference_distribution_0/v3_four_channel_phase_distribution_0/v3_four_channel_output_collection_0/v3_four_channel_placement_0/v3_channel_selector_late_promotion_0/v3_selector_route_pilot_0/G3_MUX_AXIS/a_505_21# V3R230 VDPWR VDPWR sky130_fd_pr__pfet_01v8_hvt ad=0.1176 pd=1.4 as=0 ps=0 w=0.42 l=0.15
X1448 v3_four_channel_output_load_integration_0/v3_four_channel_shared_support_integration_0/v3_four_channel_bias_reference_distribution_0/v3_four_channel_phase_distribution_0/v3_four_channel_output_collection_0/v3_four_channel_placement_0/v3_channel_selector_late_promotion_0/v3_selector_route_pilot_0/G3_MUX_AXIS/a_218_374# V3R230 VDPWR VDPWR sky130_fd_pr__pfet_01v8_hvt ad=0.1533 pd=1.57 as=0 ps=0 w=0.42 l=0.15
X1449 VGND v3_four_channel_output_load_integration_0/v3_four_channel_shared_support_integration_0/v3_four_channel_bias_reference_distribution_0/v3_four_channel_phase_distribution_0/v3_four_channel_output_collection_0/v3_four_channel_placement_0/v3_channel_selector_late_promotion_0/v3_selector_route_pilot_0/G3_MUX_AXIS/a_505_21# v3_four_channel_output_load_integration_0/v3_four_channel_shared_support_integration_0/v3_four_channel_bias_reference_distribution_0/v3_four_channel_phase_distribution_0/v3_four_channel_output_collection_0/v3_four_channel_placement_0/v3_channel_selector_late_promotion_0/v3_selector_route_pilot_0/G3_MUX_AXIS/a_439_47# VGND sky130_fd_pr__nfet_01v8 ad=0 pd=0 as=0.1386 ps=1.5 w=0.42 l=0.15
X1450 v3_four_channel_output_load_integration_0/v3_four_channel_shared_support_integration_0/v3_four_channel_bias_reference_distribution_0/v3_four_channel_phase_distribution_0/v3_four_channel_output_collection_0/v3_four_channel_placement_0/v3_channel_selector_late_promotion_0/v3_selector_route_pilot_0/G3_MUX_AXIS/a_76_199# v3_four_channel_output_load_integration_0/v3_four_channel_shared_support_integration_0/v3_four_channel_bias_reference_distribution_0/v3_four_channel_phase_distribution_0/v3_four_channel_output_collection_0/v3_four_channel_placement_0/v3_channel_selector_late_promotion_0/v3_selector_route_pilot_0/G3_MUX_POS/X v3_four_channel_output_load_integration_0/v3_four_channel_shared_support_integration_0/v3_four_channel_bias_reference_distribution_0/v3_four_channel_phase_distribution_0/v3_four_channel_output_collection_0/v3_four_channel_placement_0/v3_channel_selector_late_promotion_0/v3_selector_route_pilot_0/G3_MUX_AXIS/a_218_374# VDPWR sky130_fd_pr__pfet_01v8_hvt ad=0.3864 pd=2.68 as=0 ps=0 w=0.42 l=0.15
X1451 v3_four_channel_output_load_integration_0/v3_four_channel_shared_support_integration_0/v3_four_channel_bias_reference_distribution_0/v3_four_channel_phase_distribution_0/v3_four_channel_output_collection_0/v3_four_channel_placement_0/v3_channel_selector_late_promotion_0/v3_selector_route_pilot_0/G3_MUX_AXIS/a_505_21# V3R230 VGND VGND sky130_fd_pr__nfet_01v8 ad=0.1092 pd=1.36 as=0 ps=0 w=0.42 l=0.15
X1452 v3_four_channel_output_load_integration_0/v3_four_channel_shared_support_integration_0/v3_four_channel_bias_reference_distribution_0/v3_four_channel_phase_distribution_0/v3_four_channel_output_collection_0/v3_four_channel_placement_0/v3_channel_selector_late_promotion_0/v3_selector_route_pilot_0/G3_MUX_AXIS/a_439_47# v3_four_channel_output_load_integration_0/v3_four_channel_shared_support_integration_0/v3_four_channel_bias_reference_distribution_0/v3_four_channel_phase_distribution_0/v3_four_channel_output_collection_0/v3_four_channel_placement_0/v3_channel_selector_late_promotion_0/v3_selector_route_pilot_0/G3_MUX_POS/X v3_four_channel_output_load_integration_0/v3_four_channel_shared_support_integration_0/v3_four_channel_bias_reference_distribution_0/v3_four_channel_phase_distribution_0/v3_four_channel_output_collection_0/v3_four_channel_placement_0/v3_channel_selector_late_promotion_0/v3_selector_route_pilot_0/G3_MUX_AXIS/a_76_199# VGND sky130_fd_pr__nfet_01v8 ad=0 pd=0 as=0.1995 ps=1.79 w=0.42 l=0.15
X1453 v3_four_channel_output_load_integration_0/v3_four_channel_shared_support_integration_0/v3_four_channel_bias_reference_distribution_0/v3_four_channel_phase_distribution_0/v3_four_channel_output_collection_0/v3_four_channel_placement_0/v3_channel_selector_late_promotion_0/v3_selector_route_pilot_0/G3_MUX_AXIS/a_535_374# v3_four_channel_output_load_integration_0/v3_four_channel_shared_support_integration_0/v3_four_channel_bias_reference_distribution_0/v3_four_channel_phase_distribution_0/v3_four_channel_output_collection_0/v3_four_channel_placement_0/v3_channel_selector_late_promotion_0/v3_selector_route_pilot_0/G3_MUX_NEG/X v3_four_channel_output_load_integration_0/v3_four_channel_shared_support_integration_0/v3_four_channel_bias_reference_distribution_0/v3_four_channel_phase_distribution_0/v3_four_channel_output_collection_0/v3_four_channel_placement_0/v3_channel_selector_late_promotion_0/v3_selector_route_pilot_0/G3_MUX_AXIS/a_76_199# VDPWR sky130_fd_pr__pfet_01v8_hvt ad=0 pd=0 as=0 ps=0 w=0.42 l=0.15
X1454 v3_four_channel_output_load_integration_0/v3_four_channel_shared_support_integration_0/v3_four_channel_bias_reference_distribution_0/v3_four_channel_phase_distribution_0/v3_four_channel_output_collection_0/v3_four_channel_placement_0/v3_channel_selector_late_promotion_0/v3_selector_route_pilot_0/G3_MUX_AXIS/a_76_199# v3_four_channel_output_load_integration_0/v3_four_channel_shared_support_integration_0/v3_four_channel_bias_reference_distribution_0/v3_four_channel_phase_distribution_0/v3_four_channel_output_collection_0/v3_four_channel_placement_0/v3_channel_selector_late_promotion_0/v3_selector_route_pilot_0/G3_MUX_NEG/X v3_four_channel_output_load_integration_0/v3_four_channel_shared_support_integration_0/v3_four_channel_bias_reference_distribution_0/v3_four_channel_phase_distribution_0/v3_four_channel_output_collection_0/v3_four_channel_placement_0/v3_channel_selector_late_promotion_0/v3_selector_route_pilot_0/G3_MUX_AXIS/a_218_47# VGND sky130_fd_pr__nfet_01v8 ad=0 pd=0 as=0.1386 ps=1.5 w=0.42 l=0.15
X1455 v3_four_channel_output_load_integration_0/v3_four_channel_shared_support_integration_0/v3_four_channel_bias_reference_distribution_0/v3_four_channel_phase_distribution_0/v3_four_channel_output_collection_0/v3_four_channel_placement_0/v3_channel_selector_late_promotion_0/v3_selector_route_pilot_0/G3_MUX_AXIS/a_218_47# V3R230 VGND VGND sky130_fd_pr__nfet_01v8 ad=0 pd=0 as=0 ps=0 w=0.42 l=0.15
X1456 VDPWR v3_four_channel_output_load_integration_0/v3_four_channel_shared_support_integration_0/v3_four_channel_bias_reference_distribution_0/v3_four_channel_phase_distribution_0/v3_four_channel_output_collection_0/v3_four_channel_placement_0/v3_channel_selector_late_promotion_0/v3_selector_route_pilot_0/G3_MUX_AXIS/a_76_199# v3_four_channel_output_load_integration_0/v3_four_channel_shared_support_integration_0/v3_four_channel_bias_reference_distribution_0/v3_four_channel_phase_distribution_0/v3_four_channel_output_collection_0/v3_four_channel_placement_0/v3_channel_selector_late_promotion_0/v3_selector_route_pilot_0/G3_MUX_AXIS/X VDPWR sky130_fd_pr__pfet_01v8_hvt ad=0 pd=0 as=0.26 ps=2.52 w=1 l=0.15
X1457 VGND v3_four_channel_output_load_integration_0/v3_four_channel_shared_support_integration_0/v3_four_channel_bias_reference_distribution_0/v3_four_channel_phase_distribution_0/v3_four_channel_output_collection_0/v3_four_channel_placement_0/v3_channel_selector_late_promotion_0/v3_selector_route_pilot_0/G3_MUX_AXIS/a_76_199# v3_four_channel_output_load_integration_0/v3_four_channel_shared_support_integration_0/v3_four_channel_bias_reference_distribution_0/v3_four_channel_phase_distribution_0/v3_four_channel_output_collection_0/v3_four_channel_placement_0/v3_channel_selector_late_promotion_0/v3_selector_route_pilot_0/G3_MUX_AXIS/X VGND sky130_fd_pr__nfet_01v8 ad=0 pd=0 as=0.169 ps=1.82 w=0.65 l=0.15
X1458 VDPWR V3R071 v3_four_channel_output_load_integration_0/v3_four_channel_shared_support_integration_0/v3_four_channel_bias_reference_distribution_0/v3_four_channel_phase_distribution_0/v3_four_channel_output_collection_0/v3_four_channel_placement_0/v3_channel_selector_late_promotion_0/v3_selector_route_pilot_0/ENABLE_ANDNOT/a_207_413# VDPWR sky130_fd_pr__pfet_01v8_hvt ad=0 pd=0 as=0.1218 ps=1.42 w=0.42 l=0.15
X1459 v3_four_channel_output_load_integration_0/v3_four_channel_shared_support_integration_0/v3_four_channel_bias_reference_distribution_0/v3_four_channel_phase_distribution_0/v3_four_channel_output_collection_0/v3_four_channel_placement_0/v3_channel_selector_late_promotion_0/v3_selector_route_pilot_0/G3_LO_P_AND/B v3_four_channel_output_load_integration_0/v3_four_channel_shared_support_integration_0/v3_four_channel_bias_reference_distribution_0/v3_four_channel_phase_distribution_0/v3_four_channel_output_collection_0/v3_four_channel_placement_0/v3_channel_selector_late_promotion_0/v3_selector_route_pilot_0/ENABLE_ANDNOT/a_207_413# VDPWR VDPWR sky130_fd_pr__pfet_01v8_hvt ad=0.26 pd=2.52 as=0 ps=0 w=1 l=0.15
X1460 v3_four_channel_output_load_integration_0/v3_four_channel_shared_support_integration_0/v3_four_channel_bias_reference_distribution_0/v3_four_channel_phase_distribution_0/v3_four_channel_output_collection_0/v3_four_channel_placement_0/v3_channel_selector_late_promotion_0/v3_selector_route_pilot_0/ENABLE_ANDNOT/a_297_47# v3_four_channel_output_load_integration_0/v3_four_channel_shared_support_integration_0/v3_four_channel_bias_reference_distribution_0/v3_four_channel_phase_distribution_0/v3_four_channel_output_collection_0/v3_four_channel_placement_0/v3_channel_selector_late_promotion_0/v3_selector_route_pilot_0/ENABLE_ANDNOT/a_27_413# v3_four_channel_output_load_integration_0/v3_four_channel_shared_support_integration_0/v3_four_channel_bias_reference_distribution_0/v3_four_channel_phase_distribution_0/v3_four_channel_output_collection_0/v3_four_channel_placement_0/v3_channel_selector_late_promotion_0/v3_selector_route_pilot_0/ENABLE_ANDNOT/a_207_413# VGND sky130_fd_pr__nfet_01v8 ad=0.1008 pd=1.32 as=0.1092 ps=1.36 w=0.42 l=0.15
X1461 v3_four_channel_output_load_integration_0/v3_four_channel_shared_support_integration_0/v3_four_channel_bias_reference_distribution_0/v3_four_channel_phase_distribution_0/v3_four_channel_output_collection_0/v3_four_channel_placement_0/v3_channel_selector_late_promotion_0/v3_selector_route_pilot_0/G3_LO_P_AND/B v3_four_channel_output_load_integration_0/v3_four_channel_shared_support_integration_0/v3_four_channel_bias_reference_distribution_0/v3_four_channel_phase_distribution_0/v3_four_channel_output_collection_0/v3_four_channel_placement_0/v3_channel_selector_late_promotion_0/v3_selector_route_pilot_0/ENABLE_ANDNOT/a_207_413# VGND VGND sky130_fd_pr__nfet_01v8 ad=0.169 pd=1.82 as=0 ps=0 w=0.65 l=0.15
X1462 v3_four_channel_output_load_integration_0/v3_four_channel_shared_support_integration_0/v3_four_channel_bias_reference_distribution_0/v3_four_channel_phase_distribution_0/v3_four_channel_output_collection_0/v3_four_channel_placement_0/v3_channel_selector_late_promotion_0/v3_selector_route_pilot_0/ENABLE_ANDNOT/a_207_413# v3_four_channel_output_load_integration_0/v3_four_channel_shared_support_integration_0/v3_four_channel_bias_reference_distribution_0/v3_four_channel_phase_distribution_0/v3_four_channel_output_collection_0/v3_four_channel_placement_0/v3_channel_selector_late_promotion_0/v3_selector_route_pilot_0/ENABLE_ANDNOT/a_27_413# VDPWR VDPWR sky130_fd_pr__pfet_01v8_hvt ad=0 pd=0 as=0 ps=0 w=0.42 l=0.15
X1463 VDPWR V3R238 v3_four_channel_output_load_integration_0/v3_four_channel_shared_support_integration_0/v3_four_channel_bias_reference_distribution_0/v3_four_channel_phase_distribution_0/v3_four_channel_output_collection_0/v3_four_channel_placement_0/v3_channel_selector_late_promotion_0/v3_selector_route_pilot_0/ENABLE_ANDNOT/a_27_413# VDPWR sky130_fd_pr__pfet_01v8_hvt ad=0 pd=0 as=0.1092 ps=1.36 w=0.42 l=0.15
X1464 VGND V3R071 v3_four_channel_output_load_integration_0/v3_four_channel_shared_support_integration_0/v3_four_channel_bias_reference_distribution_0/v3_four_channel_phase_distribution_0/v3_four_channel_output_collection_0/v3_four_channel_placement_0/v3_channel_selector_late_promotion_0/v3_selector_route_pilot_0/ENABLE_ANDNOT/a_297_47# VGND sky130_fd_pr__nfet_01v8 ad=0 pd=0 as=0 ps=0 w=0.42 l=0.15
X1465 v3_four_channel_output_load_integration_0/v3_four_channel_shared_support_integration_0/v3_four_channel_bias_reference_distribution_0/v3_four_channel_phase_distribution_0/v3_four_channel_output_collection_0/v3_four_channel_placement_0/v3_channel_selector_late_promotion_0/v3_selector_route_pilot_0/ENABLE_ANDNOT/a_27_413# V3R238 VGND VGND sky130_fd_pr__nfet_01v8 ad=0.1092 pd=1.36 as=0 ps=0 w=0.42 l=0.15
X1466 VDPWR v3_four_channel_output_load_integration_0/v3_four_channel_shared_support_integration_0/v3_four_channel_bias_reference_distribution_0/v3_four_channel_phase_distribution_0/v3_four_channel_output_collection_0/v3_four_channel_placement_0/v3_channel_selector_late_promotion_0/v3_selector_route_pilot_0/G1_MUX_NEG/a_505_21# v3_four_channel_output_load_integration_0/v3_four_channel_shared_support_integration_0/v3_four_channel_bias_reference_distribution_0/v3_four_channel_phase_distribution_0/v3_four_channel_output_collection_0/v3_four_channel_placement_0/v3_channel_selector_late_promotion_0/v3_selector_route_pilot_0/G1_MUX_NEG/a_535_374# VDPWR sky130_fd_pr__pfet_01v8_hvt ad=0 pd=0 as=0.0882 ps=1.26 w=0.42 l=0.15
X1467 v3_four_channel_output_load_integration_0/v3_four_channel_shared_support_integration_0/v3_four_channel_bias_reference_distribution_0/v3_four_channel_phase_distribution_0/v3_four_channel_output_collection_0/v3_four_channel_placement_0/v3_channel_selector_late_promotion_0/v3_selector_route_pilot_0/G1_MUX_NEG/a_505_21# V3R224 VDPWR VDPWR sky130_fd_pr__pfet_01v8_hvt ad=0.1176 pd=1.4 as=0 ps=0 w=0.42 l=0.15
X1468 v3_four_channel_output_load_integration_0/v3_four_channel_shared_support_integration_0/v3_four_channel_bias_reference_distribution_0/v3_four_channel_phase_distribution_0/v3_four_channel_output_collection_0/v3_four_channel_placement_0/v3_channel_selector_late_promotion_0/v3_selector_route_pilot_0/G1_MUX_NEG/a_218_374# V3R224 VDPWR VDPWR sky130_fd_pr__pfet_01v8_hvt ad=0.1533 pd=1.57 as=0 ps=0 w=0.42 l=0.15
X1469 VGND v3_four_channel_output_load_integration_0/v3_four_channel_shared_support_integration_0/v3_four_channel_bias_reference_distribution_0/v3_four_channel_phase_distribution_0/v3_four_channel_output_collection_0/v3_four_channel_placement_0/v3_channel_selector_late_promotion_0/v3_selector_route_pilot_0/G1_MUX_NEG/a_505_21# v3_four_channel_output_load_integration_0/v3_four_channel_shared_support_integration_0/v3_four_channel_bias_reference_distribution_0/v3_four_channel_phase_distribution_0/v3_four_channel_output_collection_0/v3_four_channel_placement_0/v3_channel_selector_late_promotion_0/v3_selector_route_pilot_0/G1_MUX_NEG/a_439_47# VGND sky130_fd_pr__nfet_01v8 ad=0 pd=0 as=0.1386 ps=1.5 w=0.42 l=0.15
X1470 v3_four_channel_output_load_integration_0/v3_four_channel_shared_support_integration_0/v3_four_channel_bias_reference_distribution_0/v3_four_channel_phase_distribution_0/v3_four_channel_output_collection_0/v3_four_channel_placement_0/v3_channel_selector_late_promotion_0/v3_selector_route_pilot_0/G1_MUX_NEG/a_76_199# V3R292 v3_four_channel_output_load_integration_0/v3_four_channel_shared_support_integration_0/v3_four_channel_bias_reference_distribution_0/v3_four_channel_phase_distribution_0/v3_four_channel_output_collection_0/v3_four_channel_placement_0/v3_channel_selector_late_promotion_0/v3_selector_route_pilot_0/G1_MUX_NEG/a_218_374# VDPWR sky130_fd_pr__pfet_01v8_hvt ad=0.3864 pd=2.68 as=0 ps=0 w=0.42 l=0.15
X1471 v3_four_channel_output_load_integration_0/v3_four_channel_shared_support_integration_0/v3_four_channel_bias_reference_distribution_0/v3_four_channel_phase_distribution_0/v3_four_channel_output_collection_0/v3_four_channel_placement_0/v3_channel_selector_late_promotion_0/v3_selector_route_pilot_0/G1_MUX_NEG/a_505_21# V3R224 VGND VGND sky130_fd_pr__nfet_01v8 ad=0.1092 pd=1.36 as=0 ps=0 w=0.42 l=0.15
X1472 v3_four_channel_output_load_integration_0/v3_four_channel_shared_support_integration_0/v3_four_channel_bias_reference_distribution_0/v3_four_channel_phase_distribution_0/v3_four_channel_output_collection_0/v3_four_channel_placement_0/v3_channel_selector_late_promotion_0/v3_selector_route_pilot_0/G1_MUX_NEG/a_439_47# V3R292 v3_four_channel_output_load_integration_0/v3_four_channel_shared_support_integration_0/v3_four_channel_bias_reference_distribution_0/v3_four_channel_phase_distribution_0/v3_four_channel_output_collection_0/v3_four_channel_placement_0/v3_channel_selector_late_promotion_0/v3_selector_route_pilot_0/G1_MUX_NEG/a_76_199# VGND sky130_fd_pr__nfet_01v8 ad=0 pd=0 as=0.1995 ps=1.79 w=0.42 l=0.15
X1473 v3_four_channel_output_load_integration_0/v3_four_channel_shared_support_integration_0/v3_four_channel_bias_reference_distribution_0/v3_four_channel_phase_distribution_0/v3_four_channel_output_collection_0/v3_four_channel_placement_0/v3_channel_selector_late_promotion_0/v3_selector_route_pilot_0/G1_MUX_NEG/a_535_374# V3R293 v3_four_channel_output_load_integration_0/v3_four_channel_shared_support_integration_0/v3_four_channel_bias_reference_distribution_0/v3_four_channel_phase_distribution_0/v3_four_channel_output_collection_0/v3_four_channel_placement_0/v3_channel_selector_late_promotion_0/v3_selector_route_pilot_0/G1_MUX_NEG/a_76_199# VDPWR sky130_fd_pr__pfet_01v8_hvt ad=0 pd=0 as=0 ps=0 w=0.42 l=0.15
X1474 v3_four_channel_output_load_integration_0/v3_four_channel_shared_support_integration_0/v3_four_channel_bias_reference_distribution_0/v3_four_channel_phase_distribution_0/v3_four_channel_output_collection_0/v3_four_channel_placement_0/v3_channel_selector_late_promotion_0/v3_selector_route_pilot_0/G1_MUX_NEG/a_76_199# V3R293 v3_four_channel_output_load_integration_0/v3_four_channel_shared_support_integration_0/v3_four_channel_bias_reference_distribution_0/v3_four_channel_phase_distribution_0/v3_four_channel_output_collection_0/v3_four_channel_placement_0/v3_channel_selector_late_promotion_0/v3_selector_route_pilot_0/G1_MUX_NEG/a_218_47# VGND sky130_fd_pr__nfet_01v8 ad=0 pd=0 as=0.1386 ps=1.5 w=0.42 l=0.15
X1475 v3_four_channel_output_load_integration_0/v3_four_channel_shared_support_integration_0/v3_four_channel_bias_reference_distribution_0/v3_four_channel_phase_distribution_0/v3_four_channel_output_collection_0/v3_four_channel_placement_0/v3_channel_selector_late_promotion_0/v3_selector_route_pilot_0/G1_MUX_NEG/a_218_47# V3R224 VGND VGND sky130_fd_pr__nfet_01v8 ad=0 pd=0 as=0 ps=0 w=0.42 l=0.15
X1476 VDPWR v3_four_channel_output_load_integration_0/v3_four_channel_shared_support_integration_0/v3_four_channel_bias_reference_distribution_0/v3_four_channel_phase_distribution_0/v3_four_channel_output_collection_0/v3_four_channel_placement_0/v3_channel_selector_late_promotion_0/v3_selector_route_pilot_0/G1_MUX_NEG/a_76_199# v3_four_channel_output_load_integration_0/v3_four_channel_shared_support_integration_0/v3_four_channel_bias_reference_distribution_0/v3_four_channel_phase_distribution_0/v3_four_channel_output_collection_0/v3_four_channel_placement_0/v3_channel_selector_late_promotion_0/v3_selector_route_pilot_0/G1_MUX_NEG/X VDPWR sky130_fd_pr__pfet_01v8_hvt ad=0 pd=0 as=0.26 ps=2.52 w=1 l=0.15
X1477 VGND v3_four_channel_output_load_integration_0/v3_four_channel_shared_support_integration_0/v3_four_channel_bias_reference_distribution_0/v3_four_channel_phase_distribution_0/v3_four_channel_output_collection_0/v3_four_channel_placement_0/v3_channel_selector_late_promotion_0/v3_selector_route_pilot_0/G1_MUX_NEG/a_76_199# v3_four_channel_output_load_integration_0/v3_four_channel_shared_support_integration_0/v3_four_channel_bias_reference_distribution_0/v3_four_channel_phase_distribution_0/v3_four_channel_output_collection_0/v3_four_channel_placement_0/v3_channel_selector_late_promotion_0/v3_selector_route_pilot_0/G1_MUX_NEG/X VGND sky130_fd_pr__nfet_01v8 ad=0 pd=0 as=0.169 ps=1.82 w=0.65 l=0.15
X1478 VDPWR v3_four_channel_output_load_integration_0/v3_four_channel_shared_support_integration_0/v3_four_channel_bias_reference_distribution_0/v3_four_channel_phase_distribution_0/v3_four_channel_output_collection_0/v3_four_channel_placement_0/v3_channel_selector_late_promotion_0/v3_selector_route_pilot_0/G3_LO_P_AND/B v3_four_channel_output_load_integration_0/v3_four_channel_shared_support_integration_0/v3_four_channel_bias_reference_distribution_0/v3_four_channel_phase_distribution_0/v3_four_channel_output_collection_0/v3_four_channel_placement_0/v3_channel_selector_late_promotion_0/v3_selector_route_pilot_0/G1_LO_P_AND/a_59_75# VDPWR sky130_fd_pr__pfet_01v8_hvt ad=0 pd=0 as=0.1134 ps=1.38 w=0.42 l=0.15
X1479 v3_four_channel_output_load_integration_0/v3_four_channel_shared_support_integration_0/v3_four_channel_bias_reference_distribution_0/v3_four_channel_phase_distribution_0/v3_four_channel_output_collection_0/v3_four_channel_placement_0/v3_channel_selector_late_promotion_0/v3_selector_route_pilot_0/group1_lo_p v3_four_channel_output_load_integration_0/v3_four_channel_shared_support_integration_0/v3_four_channel_bias_reference_distribution_0/v3_four_channel_phase_distribution_0/v3_four_channel_output_collection_0/v3_four_channel_placement_0/v3_channel_selector_late_promotion_0/v3_selector_route_pilot_0/G1_LO_P_AND/a_59_75# VDPWR VDPWR sky130_fd_pr__pfet_01v8_hvt ad=0.475 pd=2.95 as=0 ps=0 w=1 l=0.15
X1480 VGND v3_four_channel_output_load_integration_0/v3_four_channel_shared_support_integration_0/v3_four_channel_bias_reference_distribution_0/v3_four_channel_phase_distribution_0/v3_four_channel_output_collection_0/v3_four_channel_placement_0/v3_channel_selector_late_promotion_0/v3_selector_route_pilot_0/G3_LO_P_AND/B v3_four_channel_output_load_integration_0/v3_four_channel_shared_support_integration_0/v3_four_channel_bias_reference_distribution_0/v3_four_channel_phase_distribution_0/v3_four_channel_output_collection_0/v3_four_channel_placement_0/v3_channel_selector_late_promotion_0/v3_selector_route_pilot_0/G1_LO_P_AND/a_145_75# VGND sky130_fd_pr__nfet_01v8 ad=0 pd=0 as=0.1134 ps=1.38 w=0.42 l=0.15
X1481 v3_four_channel_output_load_integration_0/v3_four_channel_shared_support_integration_0/v3_four_channel_bias_reference_distribution_0/v3_four_channel_phase_distribution_0/v3_four_channel_output_collection_0/v3_four_channel_placement_0/v3_channel_selector_late_promotion_0/v3_selector_route_pilot_0/G1_LO_P_AND/a_59_75# v3_four_channel_output_load_integration_0/v3_four_channel_shared_support_integration_0/v3_four_channel_bias_reference_distribution_0/v3_four_channel_phase_distribution_0/v3_four_channel_output_collection_0/v3_four_channel_placement_0/v3_channel_selector_late_promotion_0/v3_selector_route_pilot_0/G1_MUX_AXIS/X VDPWR VDPWR sky130_fd_pr__pfet_01v8_hvt ad=0 pd=0 as=0 ps=0 w=0.42 l=0.15
X1482 v3_four_channel_output_load_integration_0/v3_four_channel_shared_support_integration_0/v3_four_channel_bias_reference_distribution_0/v3_four_channel_phase_distribution_0/v3_four_channel_output_collection_0/v3_four_channel_placement_0/v3_channel_selector_late_promotion_0/v3_selector_route_pilot_0/group1_lo_p v3_four_channel_output_load_integration_0/v3_four_channel_shared_support_integration_0/v3_four_channel_bias_reference_distribution_0/v3_four_channel_phase_distribution_0/v3_four_channel_output_collection_0/v3_four_channel_placement_0/v3_channel_selector_late_promotion_0/v3_selector_route_pilot_0/G1_LO_P_AND/a_59_75# VGND VGND sky130_fd_pr__nfet_01v8 ad=0.182 pd=1.86 as=0 ps=0 w=0.65 l=0.15
X1483 v3_four_channel_output_load_integration_0/v3_four_channel_shared_support_integration_0/v3_four_channel_bias_reference_distribution_0/v3_four_channel_phase_distribution_0/v3_four_channel_output_collection_0/v3_four_channel_placement_0/v3_channel_selector_late_promotion_0/v3_selector_route_pilot_0/G1_LO_P_AND/a_145_75# v3_four_channel_output_load_integration_0/v3_four_channel_shared_support_integration_0/v3_four_channel_bias_reference_distribution_0/v3_four_channel_phase_distribution_0/v3_four_channel_output_collection_0/v3_four_channel_placement_0/v3_channel_selector_late_promotion_0/v3_selector_route_pilot_0/G1_MUX_AXIS/X v3_four_channel_output_load_integration_0/v3_four_channel_shared_support_integration_0/v3_four_channel_bias_reference_distribution_0/v3_four_channel_phase_distribution_0/v3_four_channel_output_collection_0/v3_four_channel_placement_0/v3_channel_selector_late_promotion_0/v3_selector_route_pilot_0/G1_LO_P_AND/a_59_75# VGND sky130_fd_pr__nfet_01v8 ad=0 pd=0 as=0.1176 ps=1.4 w=0.42 l=0.15
X1484 VDPWR v3_four_channel_output_load_integration_0/v3_four_channel_shared_support_integration_0/v3_four_channel_bias_reference_distribution_0/v3_four_channel_phase_distribution_0/v3_four_channel_output_collection_0/v3_four_channel_placement_0/v3_channel_selector_late_promotion_0/v3_selector_route_pilot_0/G0_MUX_POS/a_505_21# v3_four_channel_output_load_integration_0/v3_four_channel_shared_support_integration_0/v3_four_channel_bias_reference_distribution_0/v3_four_channel_phase_distribution_0/v3_four_channel_output_collection_0/v3_four_channel_placement_0/v3_channel_selector_late_promotion_0/v3_selector_route_pilot_0/G0_MUX_POS/a_535_374# VDPWR sky130_fd_pr__pfet_01v8_hvt ad=0 pd=0 as=0.0882 ps=1.26 w=0.42 l=0.15
X1485 v3_four_channel_output_load_integration_0/v3_four_channel_shared_support_integration_0/v3_four_channel_bias_reference_distribution_0/v3_four_channel_phase_distribution_0/v3_four_channel_output_collection_0/v3_four_channel_placement_0/v3_channel_selector_late_promotion_0/v3_selector_route_pilot_0/G0_MUX_POS/a_505_21# V3R222 VDPWR VDPWR sky130_fd_pr__pfet_01v8_hvt ad=0.1176 pd=1.4 as=0 ps=0 w=0.42 l=0.15
X1486 v3_four_channel_output_load_integration_0/v3_four_channel_shared_support_integration_0/v3_four_channel_bias_reference_distribution_0/v3_four_channel_phase_distribution_0/v3_four_channel_output_collection_0/v3_four_channel_placement_0/v3_channel_selector_late_promotion_0/v3_selector_route_pilot_0/G0_MUX_POS/a_218_374# V3R222 VDPWR VDPWR sky130_fd_pr__pfet_01v8_hvt ad=0.1533 pd=1.57 as=0 ps=0 w=0.42 l=0.15
X1487 VGND v3_four_channel_output_load_integration_0/v3_four_channel_shared_support_integration_0/v3_four_channel_bias_reference_distribution_0/v3_four_channel_phase_distribution_0/v3_four_channel_output_collection_0/v3_four_channel_placement_0/v3_channel_selector_late_promotion_0/v3_selector_route_pilot_0/G0_MUX_POS/a_505_21# v3_four_channel_output_load_integration_0/v3_four_channel_shared_support_integration_0/v3_four_channel_bias_reference_distribution_0/v3_four_channel_phase_distribution_0/v3_four_channel_output_collection_0/v3_four_channel_placement_0/v3_channel_selector_late_promotion_0/v3_selector_route_pilot_0/G0_MUX_POS/a_439_47# VGND sky130_fd_pr__nfet_01v8 ad=0 pd=0 as=0.1386 ps=1.5 w=0.42 l=0.15
X1488 v3_four_channel_output_load_integration_0/v3_four_channel_shared_support_integration_0/v3_four_channel_bias_reference_distribution_0/v3_four_channel_phase_distribution_0/v3_four_channel_output_collection_0/v3_four_channel_placement_0/v3_channel_selector_late_promotion_0/v3_selector_route_pilot_0/G0_MUX_POS/a_76_199# V3R290 v3_four_channel_output_load_integration_0/v3_four_channel_shared_support_integration_0/v3_four_channel_bias_reference_distribution_0/v3_four_channel_phase_distribution_0/v3_four_channel_output_collection_0/v3_four_channel_placement_0/v3_channel_selector_late_promotion_0/v3_selector_route_pilot_0/G0_MUX_POS/a_218_374# VDPWR sky130_fd_pr__pfet_01v8_hvt ad=0.3864 pd=2.68 as=0 ps=0 w=0.42 l=0.15
X1489 v3_four_channel_output_load_integration_0/v3_four_channel_shared_support_integration_0/v3_four_channel_bias_reference_distribution_0/v3_four_channel_phase_distribution_0/v3_four_channel_output_collection_0/v3_four_channel_placement_0/v3_channel_selector_late_promotion_0/v3_selector_route_pilot_0/G0_MUX_POS/a_505_21# V3R222 VGND VGND sky130_fd_pr__nfet_01v8 ad=0.1092 pd=1.36 as=0 ps=0 w=0.42 l=0.15
X1490 v3_four_channel_output_load_integration_0/v3_four_channel_shared_support_integration_0/v3_four_channel_bias_reference_distribution_0/v3_four_channel_phase_distribution_0/v3_four_channel_output_collection_0/v3_four_channel_placement_0/v3_channel_selector_late_promotion_0/v3_selector_route_pilot_0/G0_MUX_POS/a_439_47# V3R290 v3_four_channel_output_load_integration_0/v3_four_channel_shared_support_integration_0/v3_four_channel_bias_reference_distribution_0/v3_four_channel_phase_distribution_0/v3_four_channel_output_collection_0/v3_four_channel_placement_0/v3_channel_selector_late_promotion_0/v3_selector_route_pilot_0/G0_MUX_POS/a_76_199# VGND sky130_fd_pr__nfet_01v8 ad=0 pd=0 as=0.1995 ps=1.79 w=0.42 l=0.15
X1491 v3_four_channel_output_load_integration_0/v3_four_channel_shared_support_integration_0/v3_four_channel_bias_reference_distribution_0/v3_four_channel_phase_distribution_0/v3_four_channel_output_collection_0/v3_four_channel_placement_0/v3_channel_selector_late_promotion_0/v3_selector_route_pilot_0/G0_MUX_POS/a_535_374# V3R291 v3_four_channel_output_load_integration_0/v3_four_channel_shared_support_integration_0/v3_four_channel_bias_reference_distribution_0/v3_four_channel_phase_distribution_0/v3_four_channel_output_collection_0/v3_four_channel_placement_0/v3_channel_selector_late_promotion_0/v3_selector_route_pilot_0/G0_MUX_POS/a_76_199# VDPWR sky130_fd_pr__pfet_01v8_hvt ad=0 pd=0 as=0 ps=0 w=0.42 l=0.15
X1492 v3_four_channel_output_load_integration_0/v3_four_channel_shared_support_integration_0/v3_four_channel_bias_reference_distribution_0/v3_four_channel_phase_distribution_0/v3_four_channel_output_collection_0/v3_four_channel_placement_0/v3_channel_selector_late_promotion_0/v3_selector_route_pilot_0/G0_MUX_POS/a_76_199# V3R291 v3_four_channel_output_load_integration_0/v3_four_channel_shared_support_integration_0/v3_four_channel_bias_reference_distribution_0/v3_four_channel_phase_distribution_0/v3_four_channel_output_collection_0/v3_four_channel_placement_0/v3_channel_selector_late_promotion_0/v3_selector_route_pilot_0/G0_MUX_POS/a_218_47# VGND sky130_fd_pr__nfet_01v8 ad=0 pd=0 as=0.1386 ps=1.5 w=0.42 l=0.15
X1493 v3_four_channel_output_load_integration_0/v3_four_channel_shared_support_integration_0/v3_four_channel_bias_reference_distribution_0/v3_four_channel_phase_distribution_0/v3_four_channel_output_collection_0/v3_four_channel_placement_0/v3_channel_selector_late_promotion_0/v3_selector_route_pilot_0/G0_MUX_POS/a_218_47# V3R222 VGND VGND sky130_fd_pr__nfet_01v8 ad=0 pd=0 as=0 ps=0 w=0.42 l=0.15
X1494 VDPWR v3_four_channel_output_load_integration_0/v3_four_channel_shared_support_integration_0/v3_four_channel_bias_reference_distribution_0/v3_four_channel_phase_distribution_0/v3_four_channel_output_collection_0/v3_four_channel_placement_0/v3_channel_selector_late_promotion_0/v3_selector_route_pilot_0/G0_MUX_POS/a_76_199# v3_four_channel_output_load_integration_0/v3_four_channel_shared_support_integration_0/v3_four_channel_bias_reference_distribution_0/v3_four_channel_phase_distribution_0/v3_four_channel_output_collection_0/v3_four_channel_placement_0/v3_channel_selector_late_promotion_0/v3_selector_route_pilot_0/G0_MUX_POS/X VDPWR sky130_fd_pr__pfet_01v8_hvt ad=0 pd=0 as=0.26 ps=2.52 w=1 l=0.15
X1495 VGND v3_four_channel_output_load_integration_0/v3_four_channel_shared_support_integration_0/v3_four_channel_bias_reference_distribution_0/v3_four_channel_phase_distribution_0/v3_four_channel_output_collection_0/v3_four_channel_placement_0/v3_channel_selector_late_promotion_0/v3_selector_route_pilot_0/G0_MUX_POS/a_76_199# v3_four_channel_output_load_integration_0/v3_four_channel_shared_support_integration_0/v3_four_channel_bias_reference_distribution_0/v3_four_channel_phase_distribution_0/v3_four_channel_output_collection_0/v3_four_channel_placement_0/v3_channel_selector_late_promotion_0/v3_selector_route_pilot_0/G0_MUX_POS/X VGND sky130_fd_pr__nfet_01v8 ad=0 pd=0 as=0.169 ps=1.82 w=0.65 l=0.15
X1496 VDPWR v3_four_channel_output_load_integration_0/v3_four_channel_shared_support_integration_0/v3_four_channel_bias_reference_distribution_0/v3_four_channel_phase_distribution_0/v3_four_channel_output_collection_0/v3_four_channel_placement_0/v3_channel_selector_late_promotion_0/v3_selector_route_pilot_0/G0_MUX_NEG/a_505_21# v3_four_channel_output_load_integration_0/v3_four_channel_shared_support_integration_0/v3_four_channel_bias_reference_distribution_0/v3_four_channel_phase_distribution_0/v3_four_channel_output_collection_0/v3_four_channel_placement_0/v3_channel_selector_late_promotion_0/v3_selector_route_pilot_0/G0_MUX_NEG/a_535_374# VDPWR sky130_fd_pr__pfet_01v8_hvt ad=0 pd=0 as=0.0882 ps=1.26 w=0.42 l=0.15
X1497 v3_four_channel_output_load_integration_0/v3_four_channel_shared_support_integration_0/v3_four_channel_bias_reference_distribution_0/v3_four_channel_phase_distribution_0/v3_four_channel_output_collection_0/v3_four_channel_placement_0/v3_channel_selector_late_promotion_0/v3_selector_route_pilot_0/G0_MUX_NEG/a_505_21# V3R222 VDPWR VDPWR sky130_fd_pr__pfet_01v8_hvt ad=0.1176 pd=1.4 as=0 ps=0 w=0.42 l=0.15
X1498 v3_four_channel_output_load_integration_0/v3_four_channel_shared_support_integration_0/v3_four_channel_bias_reference_distribution_0/v3_four_channel_phase_distribution_0/v3_four_channel_output_collection_0/v3_four_channel_placement_0/v3_channel_selector_late_promotion_0/v3_selector_route_pilot_0/G0_MUX_NEG/a_218_374# V3R222 VDPWR VDPWR sky130_fd_pr__pfet_01v8_hvt ad=0.1533 pd=1.57 as=0 ps=0 w=0.42 l=0.15
X1499 VGND v3_four_channel_output_load_integration_0/v3_four_channel_shared_support_integration_0/v3_four_channel_bias_reference_distribution_0/v3_four_channel_phase_distribution_0/v3_four_channel_output_collection_0/v3_four_channel_placement_0/v3_channel_selector_late_promotion_0/v3_selector_route_pilot_0/G0_MUX_NEG/a_505_21# v3_four_channel_output_load_integration_0/v3_four_channel_shared_support_integration_0/v3_four_channel_bias_reference_distribution_0/v3_four_channel_phase_distribution_0/v3_four_channel_output_collection_0/v3_four_channel_placement_0/v3_channel_selector_late_promotion_0/v3_selector_route_pilot_0/G0_MUX_NEG/a_439_47# VGND sky130_fd_pr__nfet_01v8 ad=0 pd=0 as=0.1386 ps=1.5 w=0.42 l=0.15
X1500 v3_four_channel_output_load_integration_0/v3_four_channel_shared_support_integration_0/v3_four_channel_bias_reference_distribution_0/v3_four_channel_phase_distribution_0/v3_four_channel_output_collection_0/v3_four_channel_placement_0/v3_channel_selector_late_promotion_0/v3_selector_route_pilot_0/G0_MUX_NEG/a_76_199# V3R292 v3_four_channel_output_load_integration_0/v3_four_channel_shared_support_integration_0/v3_four_channel_bias_reference_distribution_0/v3_four_channel_phase_distribution_0/v3_four_channel_output_collection_0/v3_four_channel_placement_0/v3_channel_selector_late_promotion_0/v3_selector_route_pilot_0/G0_MUX_NEG/a_218_374# VDPWR sky130_fd_pr__pfet_01v8_hvt ad=0.3864 pd=2.68 as=0 ps=0 w=0.42 l=0.15
X1501 v3_four_channel_output_load_integration_0/v3_four_channel_shared_support_integration_0/v3_four_channel_bias_reference_distribution_0/v3_four_channel_phase_distribution_0/v3_four_channel_output_collection_0/v3_four_channel_placement_0/v3_channel_selector_late_promotion_0/v3_selector_route_pilot_0/G0_MUX_NEG/a_505_21# V3R222 VGND VGND sky130_fd_pr__nfet_01v8 ad=0.1092 pd=1.36 as=0 ps=0 w=0.42 l=0.15
X1502 v3_four_channel_output_load_integration_0/v3_four_channel_shared_support_integration_0/v3_four_channel_bias_reference_distribution_0/v3_four_channel_phase_distribution_0/v3_four_channel_output_collection_0/v3_four_channel_placement_0/v3_channel_selector_late_promotion_0/v3_selector_route_pilot_0/G0_MUX_NEG/a_439_47# V3R292 v3_four_channel_output_load_integration_0/v3_four_channel_shared_support_integration_0/v3_four_channel_bias_reference_distribution_0/v3_four_channel_phase_distribution_0/v3_four_channel_output_collection_0/v3_four_channel_placement_0/v3_channel_selector_late_promotion_0/v3_selector_route_pilot_0/G0_MUX_NEG/a_76_199# VGND sky130_fd_pr__nfet_01v8 ad=0 pd=0 as=0.1995 ps=1.79 w=0.42 l=0.15
X1503 v3_four_channel_output_load_integration_0/v3_four_channel_shared_support_integration_0/v3_four_channel_bias_reference_distribution_0/v3_four_channel_phase_distribution_0/v3_four_channel_output_collection_0/v3_four_channel_placement_0/v3_channel_selector_late_promotion_0/v3_selector_route_pilot_0/G0_MUX_NEG/a_535_374# V3R293 v3_four_channel_output_load_integration_0/v3_four_channel_shared_support_integration_0/v3_four_channel_bias_reference_distribution_0/v3_four_channel_phase_distribution_0/v3_four_channel_output_collection_0/v3_four_channel_placement_0/v3_channel_selector_late_promotion_0/v3_selector_route_pilot_0/G0_MUX_NEG/a_76_199# VDPWR sky130_fd_pr__pfet_01v8_hvt ad=0 pd=0 as=0 ps=0 w=0.42 l=0.15
X1504 v3_four_channel_output_load_integration_0/v3_four_channel_shared_support_integration_0/v3_four_channel_bias_reference_distribution_0/v3_four_channel_phase_distribution_0/v3_four_channel_output_collection_0/v3_four_channel_placement_0/v3_channel_selector_late_promotion_0/v3_selector_route_pilot_0/G0_MUX_NEG/a_76_199# V3R293 v3_four_channel_output_load_integration_0/v3_four_channel_shared_support_integration_0/v3_four_channel_bias_reference_distribution_0/v3_four_channel_phase_distribution_0/v3_four_channel_output_collection_0/v3_four_channel_placement_0/v3_channel_selector_late_promotion_0/v3_selector_route_pilot_0/G0_MUX_NEG/a_218_47# VGND sky130_fd_pr__nfet_01v8 ad=0 pd=0 as=0.1386 ps=1.5 w=0.42 l=0.15
X1505 v3_four_channel_output_load_integration_0/v3_four_channel_shared_support_integration_0/v3_four_channel_bias_reference_distribution_0/v3_four_channel_phase_distribution_0/v3_four_channel_output_collection_0/v3_four_channel_placement_0/v3_channel_selector_late_promotion_0/v3_selector_route_pilot_0/G0_MUX_NEG/a_218_47# V3R222 VGND VGND sky130_fd_pr__nfet_01v8 ad=0 pd=0 as=0 ps=0 w=0.42 l=0.15
X1506 VDPWR v3_four_channel_output_load_integration_0/v3_four_channel_shared_support_integration_0/v3_four_channel_bias_reference_distribution_0/v3_four_channel_phase_distribution_0/v3_four_channel_output_collection_0/v3_four_channel_placement_0/v3_channel_selector_late_promotion_0/v3_selector_route_pilot_0/G0_MUX_NEG/a_76_199# v3_four_channel_output_load_integration_0/v3_four_channel_shared_support_integration_0/v3_four_channel_bias_reference_distribution_0/v3_four_channel_phase_distribution_0/v3_four_channel_output_collection_0/v3_four_channel_placement_0/v3_channel_selector_late_promotion_0/v3_selector_route_pilot_0/G0_MUX_NEG/X VDPWR sky130_fd_pr__pfet_01v8_hvt ad=0 pd=0 as=0.26 ps=2.52 w=1 l=0.15
X1507 VGND v3_four_channel_output_load_integration_0/v3_four_channel_shared_support_integration_0/v3_four_channel_bias_reference_distribution_0/v3_four_channel_phase_distribution_0/v3_four_channel_output_collection_0/v3_four_channel_placement_0/v3_channel_selector_late_promotion_0/v3_selector_route_pilot_0/G0_MUX_NEG/a_76_199# v3_four_channel_output_load_integration_0/v3_four_channel_shared_support_integration_0/v3_four_channel_bias_reference_distribution_0/v3_four_channel_phase_distribution_0/v3_four_channel_output_collection_0/v3_four_channel_placement_0/v3_channel_selector_late_promotion_0/v3_selector_route_pilot_0/G0_MUX_NEG/X VGND sky130_fd_pr__nfet_01v8 ad=0 pd=0 as=0.169 ps=1.82 w=0.65 l=0.15
X1508 VDPWR v3_four_channel_output_load_integration_0/v3_four_channel_shared_support_integration_0/v3_four_channel_bias_reference_distribution_0/v3_four_channel_phase_distribution_0/v3_four_channel_output_collection_0/v3_four_channel_placement_0/v3_channel_selector_late_promotion_0/v3_selector_route_pilot_0/G2_MUX_AXIS/a_505_21# v3_four_channel_output_load_integration_0/v3_four_channel_shared_support_integration_0/v3_four_channel_bias_reference_distribution_0/v3_four_channel_phase_distribution_0/v3_four_channel_output_collection_0/v3_four_channel_placement_0/v3_channel_selector_late_promotion_0/v3_selector_route_pilot_0/G2_MUX_AXIS/a_535_374# VDPWR sky130_fd_pr__pfet_01v8_hvt ad=0 pd=0 as=0.0882 ps=1.26 w=0.42 l=0.15
X1509 v3_four_channel_output_load_integration_0/v3_four_channel_shared_support_integration_0/v3_four_channel_bias_reference_distribution_0/v3_four_channel_phase_distribution_0/v3_four_channel_output_collection_0/v3_four_channel_placement_0/v3_channel_selector_late_promotion_0/v3_selector_route_pilot_0/G2_MUX_AXIS/a_505_21# V3R227 VDPWR VDPWR sky130_fd_pr__pfet_01v8_hvt ad=0.1176 pd=1.4 as=0 ps=0 w=0.42 l=0.15
X1510 v3_four_channel_output_load_integration_0/v3_four_channel_shared_support_integration_0/v3_four_channel_bias_reference_distribution_0/v3_four_channel_phase_distribution_0/v3_four_channel_output_collection_0/v3_four_channel_placement_0/v3_channel_selector_late_promotion_0/v3_selector_route_pilot_0/G2_MUX_AXIS/a_218_374# V3R227 VDPWR VDPWR sky130_fd_pr__pfet_01v8_hvt ad=0.1533 pd=1.57 as=0 ps=0 w=0.42 l=0.15
X1511 VGND v3_four_channel_output_load_integration_0/v3_four_channel_shared_support_integration_0/v3_four_channel_bias_reference_distribution_0/v3_four_channel_phase_distribution_0/v3_four_channel_output_collection_0/v3_four_channel_placement_0/v3_channel_selector_late_promotion_0/v3_selector_route_pilot_0/G2_MUX_AXIS/a_505_21# v3_four_channel_output_load_integration_0/v3_four_channel_shared_support_integration_0/v3_four_channel_bias_reference_distribution_0/v3_four_channel_phase_distribution_0/v3_four_channel_output_collection_0/v3_four_channel_placement_0/v3_channel_selector_late_promotion_0/v3_selector_route_pilot_0/G2_MUX_AXIS/a_439_47# VGND sky130_fd_pr__nfet_01v8 ad=0 pd=0 as=0.1386 ps=1.5 w=0.42 l=0.15
X1512 v3_four_channel_output_load_integration_0/v3_four_channel_shared_support_integration_0/v3_four_channel_bias_reference_distribution_0/v3_four_channel_phase_distribution_0/v3_four_channel_output_collection_0/v3_four_channel_placement_0/v3_channel_selector_late_promotion_0/v3_selector_route_pilot_0/G2_MUX_AXIS/a_76_199# v3_four_channel_output_load_integration_0/v3_four_channel_shared_support_integration_0/v3_four_channel_bias_reference_distribution_0/v3_four_channel_phase_distribution_0/v3_four_channel_output_collection_0/v3_four_channel_placement_0/v3_channel_selector_late_promotion_0/v3_selector_route_pilot_0/G2_MUX_POS/X v3_four_channel_output_load_integration_0/v3_four_channel_shared_support_integration_0/v3_four_channel_bias_reference_distribution_0/v3_four_channel_phase_distribution_0/v3_four_channel_output_collection_0/v3_four_channel_placement_0/v3_channel_selector_late_promotion_0/v3_selector_route_pilot_0/G2_MUX_AXIS/a_218_374# VDPWR sky130_fd_pr__pfet_01v8_hvt ad=0.3864 pd=2.68 as=0 ps=0 w=0.42 l=0.15
X1513 v3_four_channel_output_load_integration_0/v3_four_channel_shared_support_integration_0/v3_four_channel_bias_reference_distribution_0/v3_four_channel_phase_distribution_0/v3_four_channel_output_collection_0/v3_four_channel_placement_0/v3_channel_selector_late_promotion_0/v3_selector_route_pilot_0/G2_MUX_AXIS/a_505_21# V3R227 VGND VGND sky130_fd_pr__nfet_01v8 ad=0.1092 pd=1.36 as=0 ps=0 w=0.42 l=0.15
X1514 v3_four_channel_output_load_integration_0/v3_four_channel_shared_support_integration_0/v3_four_channel_bias_reference_distribution_0/v3_four_channel_phase_distribution_0/v3_four_channel_output_collection_0/v3_four_channel_placement_0/v3_channel_selector_late_promotion_0/v3_selector_route_pilot_0/G2_MUX_AXIS/a_439_47# v3_four_channel_output_load_integration_0/v3_four_channel_shared_support_integration_0/v3_four_channel_bias_reference_distribution_0/v3_four_channel_phase_distribution_0/v3_four_channel_output_collection_0/v3_four_channel_placement_0/v3_channel_selector_late_promotion_0/v3_selector_route_pilot_0/G2_MUX_POS/X v3_four_channel_output_load_integration_0/v3_four_channel_shared_support_integration_0/v3_four_channel_bias_reference_distribution_0/v3_four_channel_phase_distribution_0/v3_four_channel_output_collection_0/v3_four_channel_placement_0/v3_channel_selector_late_promotion_0/v3_selector_route_pilot_0/G2_MUX_AXIS/a_76_199# VGND sky130_fd_pr__nfet_01v8 ad=0 pd=0 as=0.1995 ps=1.79 w=0.42 l=0.15
X1515 v3_four_channel_output_load_integration_0/v3_four_channel_shared_support_integration_0/v3_four_channel_bias_reference_distribution_0/v3_four_channel_phase_distribution_0/v3_four_channel_output_collection_0/v3_four_channel_placement_0/v3_channel_selector_late_promotion_0/v3_selector_route_pilot_0/G2_MUX_AXIS/a_535_374# v3_four_channel_output_load_integration_0/v3_four_channel_shared_support_integration_0/v3_four_channel_bias_reference_distribution_0/v3_four_channel_phase_distribution_0/v3_four_channel_output_collection_0/v3_four_channel_placement_0/v3_channel_selector_late_promotion_0/v3_selector_route_pilot_0/G2_MUX_NEG/X v3_four_channel_output_load_integration_0/v3_four_channel_shared_support_integration_0/v3_four_channel_bias_reference_distribution_0/v3_four_channel_phase_distribution_0/v3_four_channel_output_collection_0/v3_four_channel_placement_0/v3_channel_selector_late_promotion_0/v3_selector_route_pilot_0/G2_MUX_AXIS/a_76_199# VDPWR sky130_fd_pr__pfet_01v8_hvt ad=0 pd=0 as=0 ps=0 w=0.42 l=0.15
X1516 v3_four_channel_output_load_integration_0/v3_four_channel_shared_support_integration_0/v3_four_channel_bias_reference_distribution_0/v3_four_channel_phase_distribution_0/v3_four_channel_output_collection_0/v3_four_channel_placement_0/v3_channel_selector_late_promotion_0/v3_selector_route_pilot_0/G2_MUX_AXIS/a_76_199# v3_four_channel_output_load_integration_0/v3_four_channel_shared_support_integration_0/v3_four_channel_bias_reference_distribution_0/v3_four_channel_phase_distribution_0/v3_four_channel_output_collection_0/v3_four_channel_placement_0/v3_channel_selector_late_promotion_0/v3_selector_route_pilot_0/G2_MUX_NEG/X v3_four_channel_output_load_integration_0/v3_four_channel_shared_support_integration_0/v3_four_channel_bias_reference_distribution_0/v3_four_channel_phase_distribution_0/v3_four_channel_output_collection_0/v3_four_channel_placement_0/v3_channel_selector_late_promotion_0/v3_selector_route_pilot_0/G2_MUX_AXIS/a_218_47# VGND sky130_fd_pr__nfet_01v8 ad=0 pd=0 as=0.1386 ps=1.5 w=0.42 l=0.15
X1517 v3_four_channel_output_load_integration_0/v3_four_channel_shared_support_integration_0/v3_four_channel_bias_reference_distribution_0/v3_four_channel_phase_distribution_0/v3_four_channel_output_collection_0/v3_four_channel_placement_0/v3_channel_selector_late_promotion_0/v3_selector_route_pilot_0/G2_MUX_AXIS/a_218_47# V3R227 VGND VGND sky130_fd_pr__nfet_01v8 ad=0 pd=0 as=0 ps=0 w=0.42 l=0.15
X1518 VDPWR v3_four_channel_output_load_integration_0/v3_four_channel_shared_support_integration_0/v3_four_channel_bias_reference_distribution_0/v3_four_channel_phase_distribution_0/v3_four_channel_output_collection_0/v3_four_channel_placement_0/v3_channel_selector_late_promotion_0/v3_selector_route_pilot_0/G2_MUX_AXIS/a_76_199# v3_four_channel_output_load_integration_0/v3_four_channel_shared_support_integration_0/v3_four_channel_bias_reference_distribution_0/v3_four_channel_phase_distribution_0/v3_four_channel_output_collection_0/v3_four_channel_placement_0/v3_channel_selector_late_promotion_0/v3_selector_route_pilot_0/G2_MUX_AXIS/X VDPWR sky130_fd_pr__pfet_01v8_hvt ad=0 pd=0 as=0.26 ps=2.52 w=1 l=0.15
X1519 VGND v3_four_channel_output_load_integration_0/v3_four_channel_shared_support_integration_0/v3_four_channel_bias_reference_distribution_0/v3_four_channel_phase_distribution_0/v3_four_channel_output_collection_0/v3_four_channel_placement_0/v3_channel_selector_late_promotion_0/v3_selector_route_pilot_0/G2_MUX_AXIS/a_76_199# v3_four_channel_output_load_integration_0/v3_four_channel_shared_support_integration_0/v3_four_channel_bias_reference_distribution_0/v3_four_channel_phase_distribution_0/v3_four_channel_output_collection_0/v3_four_channel_placement_0/v3_channel_selector_late_promotion_0/v3_selector_route_pilot_0/G2_MUX_AXIS/X VGND sky130_fd_pr__nfet_01v8 ad=0 pd=0 as=0.169 ps=1.82 w=0.65 l=0.15
X1520 VDPWR v3_four_channel_output_load_integration_0/v3_four_channel_shared_support_integration_0/v3_four_channel_bias_reference_distribution_0/v3_four_channel_phase_distribution_0/v3_four_channel_output_collection_0/v3_four_channel_placement_0/v3_channel_selector_late_promotion_0/v3_selector_route_pilot_0/G3_MUX_POS/a_505_21# v3_four_channel_output_load_integration_0/v3_four_channel_shared_support_integration_0/v3_four_channel_bias_reference_distribution_0/v3_four_channel_phase_distribution_0/v3_four_channel_output_collection_0/v3_four_channel_placement_0/v3_channel_selector_late_promotion_0/v3_selector_route_pilot_0/G3_MUX_POS/a_535_374# VDPWR sky130_fd_pr__pfet_01v8_hvt ad=0 pd=0 as=0.0882 ps=1.26 w=0.42 l=0.15
X1521 v3_four_channel_output_load_integration_0/v3_four_channel_shared_support_integration_0/v3_four_channel_bias_reference_distribution_0/v3_four_channel_phase_distribution_0/v3_four_channel_output_collection_0/v3_four_channel_placement_0/v3_channel_selector_late_promotion_0/v3_selector_route_pilot_0/G3_MUX_POS/a_505_21# V3R229 VDPWR VDPWR sky130_fd_pr__pfet_01v8_hvt ad=0.1176 pd=1.4 as=0 ps=0 w=0.42 l=0.15
X1522 v3_four_channel_output_load_integration_0/v3_four_channel_shared_support_integration_0/v3_four_channel_bias_reference_distribution_0/v3_four_channel_phase_distribution_0/v3_four_channel_output_collection_0/v3_four_channel_placement_0/v3_channel_selector_late_promotion_0/v3_selector_route_pilot_0/G3_MUX_POS/a_218_374# V3R229 VDPWR VDPWR sky130_fd_pr__pfet_01v8_hvt ad=0.1533 pd=1.57 as=0 ps=0 w=0.42 l=0.15
X1523 VGND v3_four_channel_output_load_integration_0/v3_four_channel_shared_support_integration_0/v3_four_channel_bias_reference_distribution_0/v3_four_channel_phase_distribution_0/v3_four_channel_output_collection_0/v3_four_channel_placement_0/v3_channel_selector_late_promotion_0/v3_selector_route_pilot_0/G3_MUX_POS/a_505_21# v3_four_channel_output_load_integration_0/v3_four_channel_shared_support_integration_0/v3_four_channel_bias_reference_distribution_0/v3_four_channel_phase_distribution_0/v3_four_channel_output_collection_0/v3_four_channel_placement_0/v3_channel_selector_late_promotion_0/v3_selector_route_pilot_0/G3_MUX_POS/a_439_47# VGND sky130_fd_pr__nfet_01v8 ad=0 pd=0 as=0.1386 ps=1.5 w=0.42 l=0.15
X1524 v3_four_channel_output_load_integration_0/v3_four_channel_shared_support_integration_0/v3_four_channel_bias_reference_distribution_0/v3_four_channel_phase_distribution_0/v3_four_channel_output_collection_0/v3_four_channel_placement_0/v3_channel_selector_late_promotion_0/v3_selector_route_pilot_0/G3_MUX_POS/a_76_199# V3R290 v3_four_channel_output_load_integration_0/v3_four_channel_shared_support_integration_0/v3_four_channel_bias_reference_distribution_0/v3_four_channel_phase_distribution_0/v3_four_channel_output_collection_0/v3_four_channel_placement_0/v3_channel_selector_late_promotion_0/v3_selector_route_pilot_0/G3_MUX_POS/a_218_374# VDPWR sky130_fd_pr__pfet_01v8_hvt ad=0.3864 pd=2.68 as=0 ps=0 w=0.42 l=0.15
X1525 v3_four_channel_output_load_integration_0/v3_four_channel_shared_support_integration_0/v3_four_channel_bias_reference_distribution_0/v3_four_channel_phase_distribution_0/v3_four_channel_output_collection_0/v3_four_channel_placement_0/v3_channel_selector_late_promotion_0/v3_selector_route_pilot_0/G3_MUX_POS/a_505_21# V3R229 VGND VGND sky130_fd_pr__nfet_01v8 ad=0.1092 pd=1.36 as=0 ps=0 w=0.42 l=0.15
X1526 v3_four_channel_output_load_integration_0/v3_four_channel_shared_support_integration_0/v3_four_channel_bias_reference_distribution_0/v3_four_channel_phase_distribution_0/v3_four_channel_output_collection_0/v3_four_channel_placement_0/v3_channel_selector_late_promotion_0/v3_selector_route_pilot_0/G3_MUX_POS/a_439_47# V3R290 v3_four_channel_output_load_integration_0/v3_four_channel_shared_support_integration_0/v3_four_channel_bias_reference_distribution_0/v3_four_channel_phase_distribution_0/v3_four_channel_output_collection_0/v3_four_channel_placement_0/v3_channel_selector_late_promotion_0/v3_selector_route_pilot_0/G3_MUX_POS/a_76_199# VGND sky130_fd_pr__nfet_01v8 ad=0 pd=0 as=0.1995 ps=1.79 w=0.42 l=0.15
X1527 v3_four_channel_output_load_integration_0/v3_four_channel_shared_support_integration_0/v3_four_channel_bias_reference_distribution_0/v3_four_channel_phase_distribution_0/v3_four_channel_output_collection_0/v3_four_channel_placement_0/v3_channel_selector_late_promotion_0/v3_selector_route_pilot_0/G3_MUX_POS/a_535_374# V3R291 v3_four_channel_output_load_integration_0/v3_four_channel_shared_support_integration_0/v3_four_channel_bias_reference_distribution_0/v3_four_channel_phase_distribution_0/v3_four_channel_output_collection_0/v3_four_channel_placement_0/v3_channel_selector_late_promotion_0/v3_selector_route_pilot_0/G3_MUX_POS/a_76_199# VDPWR sky130_fd_pr__pfet_01v8_hvt ad=0 pd=0 as=0 ps=0 w=0.42 l=0.15
X1528 v3_four_channel_output_load_integration_0/v3_four_channel_shared_support_integration_0/v3_four_channel_bias_reference_distribution_0/v3_four_channel_phase_distribution_0/v3_four_channel_output_collection_0/v3_four_channel_placement_0/v3_channel_selector_late_promotion_0/v3_selector_route_pilot_0/G3_MUX_POS/a_76_199# V3R291 v3_four_channel_output_load_integration_0/v3_four_channel_shared_support_integration_0/v3_four_channel_bias_reference_distribution_0/v3_four_channel_phase_distribution_0/v3_four_channel_output_collection_0/v3_four_channel_placement_0/v3_channel_selector_late_promotion_0/v3_selector_route_pilot_0/G3_MUX_POS/a_218_47# VGND sky130_fd_pr__nfet_01v8 ad=0 pd=0 as=0.1386 ps=1.5 w=0.42 l=0.15
X1529 v3_four_channel_output_load_integration_0/v3_four_channel_shared_support_integration_0/v3_four_channel_bias_reference_distribution_0/v3_four_channel_phase_distribution_0/v3_four_channel_output_collection_0/v3_four_channel_placement_0/v3_channel_selector_late_promotion_0/v3_selector_route_pilot_0/G3_MUX_POS/a_218_47# V3R229 VGND VGND sky130_fd_pr__nfet_01v8 ad=0 pd=0 as=0 ps=0 w=0.42 l=0.15
X1530 VDPWR v3_four_channel_output_load_integration_0/v3_four_channel_shared_support_integration_0/v3_four_channel_bias_reference_distribution_0/v3_four_channel_phase_distribution_0/v3_four_channel_output_collection_0/v3_four_channel_placement_0/v3_channel_selector_late_promotion_0/v3_selector_route_pilot_0/G3_MUX_POS/a_76_199# v3_four_channel_output_load_integration_0/v3_four_channel_shared_support_integration_0/v3_four_channel_bias_reference_distribution_0/v3_four_channel_phase_distribution_0/v3_four_channel_output_collection_0/v3_four_channel_placement_0/v3_channel_selector_late_promotion_0/v3_selector_route_pilot_0/G3_MUX_POS/X VDPWR sky130_fd_pr__pfet_01v8_hvt ad=0 pd=0 as=0.26 ps=2.52 w=1 l=0.15
X1531 VGND v3_four_channel_output_load_integration_0/v3_four_channel_shared_support_integration_0/v3_four_channel_bias_reference_distribution_0/v3_four_channel_phase_distribution_0/v3_four_channel_output_collection_0/v3_four_channel_placement_0/v3_channel_selector_late_promotion_0/v3_selector_route_pilot_0/G3_MUX_POS/a_76_199# v3_four_channel_output_load_integration_0/v3_four_channel_shared_support_integration_0/v3_four_channel_bias_reference_distribution_0/v3_four_channel_phase_distribution_0/v3_four_channel_output_collection_0/v3_four_channel_placement_0/v3_channel_selector_late_promotion_0/v3_selector_route_pilot_0/G3_MUX_POS/X VGND sky130_fd_pr__nfet_01v8 ad=0 pd=0 as=0.169 ps=1.82 w=0.65 l=0.15
X1532 VDPWR v3_four_channel_output_load_integration_0/v3_four_channel_shared_support_integration_0/v3_four_channel_bias_reference_distribution_0/v3_four_channel_phase_distribution_0/v3_four_channel_output_collection_0/v3_four_channel_placement_0/v3_channel_selector_late_promotion_0/v3_selector_route_pilot_0/G3_MUX_NEG/a_505_21# v3_four_channel_output_load_integration_0/v3_four_channel_shared_support_integration_0/v3_four_channel_bias_reference_distribution_0/v3_four_channel_phase_distribution_0/v3_four_channel_output_collection_0/v3_four_channel_placement_0/v3_channel_selector_late_promotion_0/v3_selector_route_pilot_0/G3_MUX_NEG/a_535_374# VDPWR sky130_fd_pr__pfet_01v8_hvt ad=0 pd=0 as=0.0882 ps=1.26 w=0.42 l=0.15
X1533 v3_four_channel_output_load_integration_0/v3_four_channel_shared_support_integration_0/v3_four_channel_bias_reference_distribution_0/v3_four_channel_phase_distribution_0/v3_four_channel_output_collection_0/v3_four_channel_placement_0/v3_channel_selector_late_promotion_0/v3_selector_route_pilot_0/G3_MUX_NEG/a_505_21# V3R229 VDPWR VDPWR sky130_fd_pr__pfet_01v8_hvt ad=0.1176 pd=1.4 as=0 ps=0 w=0.42 l=0.15
X1534 v3_four_channel_output_load_integration_0/v3_four_channel_shared_support_integration_0/v3_four_channel_bias_reference_distribution_0/v3_four_channel_phase_distribution_0/v3_four_channel_output_collection_0/v3_four_channel_placement_0/v3_channel_selector_late_promotion_0/v3_selector_route_pilot_0/G3_MUX_NEG/a_218_374# V3R229 VDPWR VDPWR sky130_fd_pr__pfet_01v8_hvt ad=0.1533 pd=1.57 as=0 ps=0 w=0.42 l=0.15
X1535 VGND v3_four_channel_output_load_integration_0/v3_four_channel_shared_support_integration_0/v3_four_channel_bias_reference_distribution_0/v3_four_channel_phase_distribution_0/v3_four_channel_output_collection_0/v3_four_channel_placement_0/v3_channel_selector_late_promotion_0/v3_selector_route_pilot_0/G3_MUX_NEG/a_505_21# v3_four_channel_output_load_integration_0/v3_four_channel_shared_support_integration_0/v3_four_channel_bias_reference_distribution_0/v3_four_channel_phase_distribution_0/v3_four_channel_output_collection_0/v3_four_channel_placement_0/v3_channel_selector_late_promotion_0/v3_selector_route_pilot_0/G3_MUX_NEG/a_439_47# VGND sky130_fd_pr__nfet_01v8 ad=0 pd=0 as=0.1386 ps=1.5 w=0.42 l=0.15
X1536 v3_four_channel_output_load_integration_0/v3_four_channel_shared_support_integration_0/v3_four_channel_bias_reference_distribution_0/v3_four_channel_phase_distribution_0/v3_four_channel_output_collection_0/v3_four_channel_placement_0/v3_channel_selector_late_promotion_0/v3_selector_route_pilot_0/G3_MUX_NEG/a_76_199# V3R292 v3_four_channel_output_load_integration_0/v3_four_channel_shared_support_integration_0/v3_four_channel_bias_reference_distribution_0/v3_four_channel_phase_distribution_0/v3_four_channel_output_collection_0/v3_four_channel_placement_0/v3_channel_selector_late_promotion_0/v3_selector_route_pilot_0/G3_MUX_NEG/a_218_374# VDPWR sky130_fd_pr__pfet_01v8_hvt ad=0.3864 pd=2.68 as=0 ps=0 w=0.42 l=0.15
X1537 v3_four_channel_output_load_integration_0/v3_four_channel_shared_support_integration_0/v3_four_channel_bias_reference_distribution_0/v3_four_channel_phase_distribution_0/v3_four_channel_output_collection_0/v3_four_channel_placement_0/v3_channel_selector_late_promotion_0/v3_selector_route_pilot_0/G3_MUX_NEG/a_505_21# V3R229 VGND VGND sky130_fd_pr__nfet_01v8 ad=0.1092 pd=1.36 as=0 ps=0 w=0.42 l=0.15
X1538 v3_four_channel_output_load_integration_0/v3_four_channel_shared_support_integration_0/v3_four_channel_bias_reference_distribution_0/v3_four_channel_phase_distribution_0/v3_four_channel_output_collection_0/v3_four_channel_placement_0/v3_channel_selector_late_promotion_0/v3_selector_route_pilot_0/G3_MUX_NEG/a_439_47# V3R292 v3_four_channel_output_load_integration_0/v3_four_channel_shared_support_integration_0/v3_four_channel_bias_reference_distribution_0/v3_four_channel_phase_distribution_0/v3_four_channel_output_collection_0/v3_four_channel_placement_0/v3_channel_selector_late_promotion_0/v3_selector_route_pilot_0/G3_MUX_NEG/a_76_199# VGND sky130_fd_pr__nfet_01v8 ad=0 pd=0 as=0.1995 ps=1.79 w=0.42 l=0.15
X1539 v3_four_channel_output_load_integration_0/v3_four_channel_shared_support_integration_0/v3_four_channel_bias_reference_distribution_0/v3_four_channel_phase_distribution_0/v3_four_channel_output_collection_0/v3_four_channel_placement_0/v3_channel_selector_late_promotion_0/v3_selector_route_pilot_0/G3_MUX_NEG/a_535_374# V3R293 v3_four_channel_output_load_integration_0/v3_four_channel_shared_support_integration_0/v3_four_channel_bias_reference_distribution_0/v3_four_channel_phase_distribution_0/v3_four_channel_output_collection_0/v3_four_channel_placement_0/v3_channel_selector_late_promotion_0/v3_selector_route_pilot_0/G3_MUX_NEG/a_76_199# VDPWR sky130_fd_pr__pfet_01v8_hvt ad=0 pd=0 as=0 ps=0 w=0.42 l=0.15
X1540 v3_four_channel_output_load_integration_0/v3_four_channel_shared_support_integration_0/v3_four_channel_bias_reference_distribution_0/v3_four_channel_phase_distribution_0/v3_four_channel_output_collection_0/v3_four_channel_placement_0/v3_channel_selector_late_promotion_0/v3_selector_route_pilot_0/G3_MUX_NEG/a_76_199# V3R293 v3_four_channel_output_load_integration_0/v3_four_channel_shared_support_integration_0/v3_four_channel_bias_reference_distribution_0/v3_four_channel_phase_distribution_0/v3_four_channel_output_collection_0/v3_four_channel_placement_0/v3_channel_selector_late_promotion_0/v3_selector_route_pilot_0/G3_MUX_NEG/a_218_47# VGND sky130_fd_pr__nfet_01v8 ad=0 pd=0 as=0.1386 ps=1.5 w=0.42 l=0.15
X1541 v3_four_channel_output_load_integration_0/v3_four_channel_shared_support_integration_0/v3_four_channel_bias_reference_distribution_0/v3_four_channel_phase_distribution_0/v3_four_channel_output_collection_0/v3_four_channel_placement_0/v3_channel_selector_late_promotion_0/v3_selector_route_pilot_0/G3_MUX_NEG/a_218_47# V3R229 VGND VGND sky130_fd_pr__nfet_01v8 ad=0 pd=0 as=0 ps=0 w=0.42 l=0.15
X1542 VDPWR v3_four_channel_output_load_integration_0/v3_four_channel_shared_support_integration_0/v3_four_channel_bias_reference_distribution_0/v3_four_channel_phase_distribution_0/v3_four_channel_output_collection_0/v3_four_channel_placement_0/v3_channel_selector_late_promotion_0/v3_selector_route_pilot_0/G3_MUX_NEG/a_76_199# v3_four_channel_output_load_integration_0/v3_four_channel_shared_support_integration_0/v3_four_channel_bias_reference_distribution_0/v3_four_channel_phase_distribution_0/v3_four_channel_output_collection_0/v3_four_channel_placement_0/v3_channel_selector_late_promotion_0/v3_selector_route_pilot_0/G3_MUX_NEG/X VDPWR sky130_fd_pr__pfet_01v8_hvt ad=0 pd=0 as=0.26 ps=2.52 w=1 l=0.15
X1543 VGND v3_four_channel_output_load_integration_0/v3_four_channel_shared_support_integration_0/v3_four_channel_bias_reference_distribution_0/v3_four_channel_phase_distribution_0/v3_four_channel_output_collection_0/v3_four_channel_placement_0/v3_channel_selector_late_promotion_0/v3_selector_route_pilot_0/G3_MUX_NEG/a_76_199# v3_four_channel_output_load_integration_0/v3_four_channel_shared_support_integration_0/v3_four_channel_bias_reference_distribution_0/v3_four_channel_phase_distribution_0/v3_four_channel_output_collection_0/v3_four_channel_placement_0/v3_channel_selector_late_promotion_0/v3_selector_route_pilot_0/G3_MUX_NEG/X VGND sky130_fd_pr__nfet_01v8 ad=0 pd=0 as=0.169 ps=1.82 w=0.65 l=0.15
X1544 VDPWR v3_four_channel_output_load_integration_0/v3_four_channel_shared_support_integration_0/v3_four_channel_bias_reference_distribution_0/v3_four_channel_phase_distribution_0/v3_four_channel_output_collection_0/v3_four_channel_placement_0/v3_channel_selector_late_promotion_0/v3_selector_route_pilot_0/G3_LO_P_AND/B v3_four_channel_output_load_integration_0/v3_four_channel_shared_support_integration_0/v3_four_channel_bias_reference_distribution_0/v3_four_channel_phase_distribution_0/v3_four_channel_output_collection_0/v3_four_channel_placement_0/v3_channel_selector_late_promotion_0/v3_selector_route_pilot_0/G0_LO_P_AND/a_59_75# VDPWR sky130_fd_pr__pfet_01v8_hvt ad=0 pd=0 as=0.1134 ps=1.38 w=0.42 l=0.15
X1545 v3_four_channel_output_load_integration_0/v3_four_channel_shared_support_integration_0/v3_four_channel_bias_reference_distribution_0/v3_four_channel_phase_distribution_0/v3_four_channel_output_collection_0/v3_four_channel_placement_0/v3_channel_selector_late_promotion_0/v3_selector_route_pilot_0/group0_lo_p v3_four_channel_output_load_integration_0/v3_four_channel_shared_support_integration_0/v3_four_channel_bias_reference_distribution_0/v3_four_channel_phase_distribution_0/v3_four_channel_output_collection_0/v3_four_channel_placement_0/v3_channel_selector_late_promotion_0/v3_selector_route_pilot_0/G0_LO_P_AND/a_59_75# VDPWR VDPWR sky130_fd_pr__pfet_01v8_hvt ad=0.475 pd=2.95 as=0 ps=0 w=1 l=0.15
X1546 VGND v3_four_channel_output_load_integration_0/v3_four_channel_shared_support_integration_0/v3_four_channel_bias_reference_distribution_0/v3_four_channel_phase_distribution_0/v3_four_channel_output_collection_0/v3_four_channel_placement_0/v3_channel_selector_late_promotion_0/v3_selector_route_pilot_0/G3_LO_P_AND/B v3_four_channel_output_load_integration_0/v3_four_channel_shared_support_integration_0/v3_four_channel_bias_reference_distribution_0/v3_four_channel_phase_distribution_0/v3_four_channel_output_collection_0/v3_four_channel_placement_0/v3_channel_selector_late_promotion_0/v3_selector_route_pilot_0/G0_LO_P_AND/a_145_75# VGND sky130_fd_pr__nfet_01v8 ad=0 pd=0 as=0.1134 ps=1.38 w=0.42 l=0.15
X1547 v3_four_channel_output_load_integration_0/v3_four_channel_shared_support_integration_0/v3_four_channel_bias_reference_distribution_0/v3_four_channel_phase_distribution_0/v3_four_channel_output_collection_0/v3_four_channel_placement_0/v3_channel_selector_late_promotion_0/v3_selector_route_pilot_0/G0_LO_P_AND/a_59_75# v3_four_channel_output_load_integration_0/v3_four_channel_shared_support_integration_0/v3_four_channel_bias_reference_distribution_0/v3_four_channel_phase_distribution_0/v3_four_channel_output_collection_0/v3_four_channel_placement_0/v3_channel_selector_late_promotion_0/v3_selector_route_pilot_0/G0_MUX_AXIS/X VDPWR VDPWR sky130_fd_pr__pfet_01v8_hvt ad=0 pd=0 as=0 ps=0 w=0.42 l=0.15
X1548 v3_four_channel_output_load_integration_0/v3_four_channel_shared_support_integration_0/v3_four_channel_bias_reference_distribution_0/v3_four_channel_phase_distribution_0/v3_four_channel_output_collection_0/v3_four_channel_placement_0/v3_channel_selector_late_promotion_0/v3_selector_route_pilot_0/group0_lo_p v3_four_channel_output_load_integration_0/v3_four_channel_shared_support_integration_0/v3_four_channel_bias_reference_distribution_0/v3_four_channel_phase_distribution_0/v3_four_channel_output_collection_0/v3_four_channel_placement_0/v3_channel_selector_late_promotion_0/v3_selector_route_pilot_0/G0_LO_P_AND/a_59_75# VGND VGND sky130_fd_pr__nfet_01v8 ad=0.182 pd=1.86 as=0 ps=0 w=0.65 l=0.15
X1549 v3_four_channel_output_load_integration_0/v3_four_channel_shared_support_integration_0/v3_four_channel_bias_reference_distribution_0/v3_four_channel_phase_distribution_0/v3_four_channel_output_collection_0/v3_four_channel_placement_0/v3_channel_selector_late_promotion_0/v3_selector_route_pilot_0/G0_LO_P_AND/a_145_75# v3_four_channel_output_load_integration_0/v3_four_channel_shared_support_integration_0/v3_four_channel_bias_reference_distribution_0/v3_four_channel_phase_distribution_0/v3_four_channel_output_collection_0/v3_four_channel_placement_0/v3_channel_selector_late_promotion_0/v3_selector_route_pilot_0/G0_MUX_AXIS/X v3_four_channel_output_load_integration_0/v3_four_channel_shared_support_integration_0/v3_four_channel_bias_reference_distribution_0/v3_four_channel_phase_distribution_0/v3_four_channel_output_collection_0/v3_four_channel_placement_0/v3_channel_selector_late_promotion_0/v3_selector_route_pilot_0/G0_LO_P_AND/a_59_75# VGND sky130_fd_pr__nfet_01v8 ad=0 pd=0 as=0.1176 ps=1.4 w=0.42 l=0.15
X1550 VDPWR v3_four_channel_output_load_integration_0/v3_four_channel_shared_support_integration_0/v3_four_channel_bias_reference_distribution_0/v3_four_channel_phase_distribution_0/v3_four_channel_output_collection_0/v3_four_channel_placement_0/v3_channel_selector_late_promotion_0/v3_selector_route_pilot_0/G3_LO_P_AND/B v3_four_channel_output_load_integration_0/v3_four_channel_shared_support_integration_0/v3_four_channel_bias_reference_distribution_0/v3_four_channel_phase_distribution_0/v3_four_channel_output_collection_0/v3_four_channel_placement_0/v3_channel_selector_late_promotion_0/v3_selector_route_pilot_0/G3_LO_N_ANDNOT/a_207_413# VDPWR sky130_fd_pr__pfet_01v8_hvt ad=0 pd=0 as=0.1218 ps=1.42 w=0.42 l=0.15
X1551 v3_four_channel_output_load_integration_0/v3_four_channel_shared_support_integration_0/v3_four_channel_bias_reference_distribution_0/v3_four_channel_phase_distribution_0/v3_four_channel_output_collection_0/v3_four_channel_placement_0/v3_channel_selector_late_promotion_0/v3_selector_route_pilot_0/group3_lo_n v3_four_channel_output_load_integration_0/v3_four_channel_shared_support_integration_0/v3_four_channel_bias_reference_distribution_0/v3_four_channel_phase_distribution_0/v3_four_channel_output_collection_0/v3_four_channel_placement_0/v3_channel_selector_late_promotion_0/v3_selector_route_pilot_0/G3_LO_N_ANDNOT/a_207_413# VDPWR VDPWR sky130_fd_pr__pfet_01v8_hvt ad=0.26 pd=2.52 as=0 ps=0 w=1 l=0.15
X1552 v3_four_channel_output_load_integration_0/v3_four_channel_shared_support_integration_0/v3_four_channel_bias_reference_distribution_0/v3_four_channel_phase_distribution_0/v3_four_channel_output_collection_0/v3_four_channel_placement_0/v3_channel_selector_late_promotion_0/v3_selector_route_pilot_0/G3_LO_N_ANDNOT/a_297_47# v3_four_channel_output_load_integration_0/v3_four_channel_shared_support_integration_0/v3_four_channel_bias_reference_distribution_0/v3_four_channel_phase_distribution_0/v3_four_channel_output_collection_0/v3_four_channel_placement_0/v3_channel_selector_late_promotion_0/v3_selector_route_pilot_0/G3_LO_N_ANDNOT/a_27_413# v3_four_channel_output_load_integration_0/v3_four_channel_shared_support_integration_0/v3_four_channel_bias_reference_distribution_0/v3_four_channel_phase_distribution_0/v3_four_channel_output_collection_0/v3_four_channel_placement_0/v3_channel_selector_late_promotion_0/v3_selector_route_pilot_0/G3_LO_N_ANDNOT/a_207_413# VGND sky130_fd_pr__nfet_01v8 ad=0.1008 pd=1.32 as=0.1092 ps=1.36 w=0.42 l=0.15
X1553 v3_four_channel_output_load_integration_0/v3_four_channel_shared_support_integration_0/v3_four_channel_bias_reference_distribution_0/v3_four_channel_phase_distribution_0/v3_four_channel_output_collection_0/v3_four_channel_placement_0/v3_channel_selector_late_promotion_0/v3_selector_route_pilot_0/group3_lo_n v3_four_channel_output_load_integration_0/v3_four_channel_shared_support_integration_0/v3_four_channel_bias_reference_distribution_0/v3_four_channel_phase_distribution_0/v3_four_channel_output_collection_0/v3_four_channel_placement_0/v3_channel_selector_late_promotion_0/v3_selector_route_pilot_0/G3_LO_N_ANDNOT/a_207_413# VGND VGND sky130_fd_pr__nfet_01v8 ad=0.169 pd=1.82 as=0 ps=0 w=0.65 l=0.15
X1554 v3_four_channel_output_load_integration_0/v3_four_channel_shared_support_integration_0/v3_four_channel_bias_reference_distribution_0/v3_four_channel_phase_distribution_0/v3_four_channel_output_collection_0/v3_four_channel_placement_0/v3_channel_selector_late_promotion_0/v3_selector_route_pilot_0/G3_LO_N_ANDNOT/a_207_413# v3_four_channel_output_load_integration_0/v3_four_channel_shared_support_integration_0/v3_four_channel_bias_reference_distribution_0/v3_four_channel_phase_distribution_0/v3_four_channel_output_collection_0/v3_four_channel_placement_0/v3_channel_selector_late_promotion_0/v3_selector_route_pilot_0/G3_LO_N_ANDNOT/a_27_413# VDPWR VDPWR sky130_fd_pr__pfet_01v8_hvt ad=0 pd=0 as=0 ps=0 w=0.42 l=0.15
X1555 VDPWR v3_four_channel_output_load_integration_0/v3_four_channel_shared_support_integration_0/v3_four_channel_bias_reference_distribution_0/v3_four_channel_phase_distribution_0/v3_four_channel_output_collection_0/v3_four_channel_placement_0/v3_channel_selector_late_promotion_0/v3_selector_route_pilot_0/G3_MUX_AXIS/X v3_four_channel_output_load_integration_0/v3_four_channel_shared_support_integration_0/v3_four_channel_bias_reference_distribution_0/v3_four_channel_phase_distribution_0/v3_four_channel_output_collection_0/v3_four_channel_placement_0/v3_channel_selector_late_promotion_0/v3_selector_route_pilot_0/G3_LO_N_ANDNOT/a_27_413# VDPWR sky130_fd_pr__pfet_01v8_hvt ad=0 pd=0 as=0.1092 ps=1.36 w=0.42 l=0.15
X1556 VGND v3_four_channel_output_load_integration_0/v3_four_channel_shared_support_integration_0/v3_four_channel_bias_reference_distribution_0/v3_four_channel_phase_distribution_0/v3_four_channel_output_collection_0/v3_four_channel_placement_0/v3_channel_selector_late_promotion_0/v3_selector_route_pilot_0/G3_LO_P_AND/B v3_four_channel_output_load_integration_0/v3_four_channel_shared_support_integration_0/v3_four_channel_bias_reference_distribution_0/v3_four_channel_phase_distribution_0/v3_four_channel_output_collection_0/v3_four_channel_placement_0/v3_channel_selector_late_promotion_0/v3_selector_route_pilot_0/G3_LO_N_ANDNOT/a_297_47# VGND sky130_fd_pr__nfet_01v8 ad=0 pd=0 as=0 ps=0 w=0.42 l=0.15
X1557 v3_four_channel_output_load_integration_0/v3_four_channel_shared_support_integration_0/v3_four_channel_bias_reference_distribution_0/v3_four_channel_phase_distribution_0/v3_four_channel_output_collection_0/v3_four_channel_placement_0/v3_channel_selector_late_promotion_0/v3_selector_route_pilot_0/G3_LO_N_ANDNOT/a_27_413# v3_four_channel_output_load_integration_0/v3_four_channel_shared_support_integration_0/v3_four_channel_bias_reference_distribution_0/v3_four_channel_phase_distribution_0/v3_four_channel_output_collection_0/v3_four_channel_placement_0/v3_channel_selector_late_promotion_0/v3_selector_route_pilot_0/G3_MUX_AXIS/X VGND VGND sky130_fd_pr__nfet_01v8 ad=0.1092 pd=1.36 as=0 ps=0 w=0.42 l=0.15
X1558 VDPWR v3_four_channel_output_load_integration_0/v3_four_channel_shared_support_integration_0/v3_four_channel_bias_reference_distribution_0/v3_four_channel_phase_distribution_0/v3_four_channel_output_collection_0/v3_four_channel_placement_0/v3_channel_selector_late_promotion_0/v3_selector_route_pilot_0/G3_LO_P_AND/B v3_four_channel_output_load_integration_0/v3_four_channel_shared_support_integration_0/v3_four_channel_bias_reference_distribution_0/v3_four_channel_phase_distribution_0/v3_four_channel_output_collection_0/v3_four_channel_placement_0/v3_channel_selector_late_promotion_0/v3_selector_route_pilot_0/G2_LO_N_ANDNOT/a_207_413# VDPWR sky130_fd_pr__pfet_01v8_hvt ad=0 pd=0 as=0.1218 ps=1.42 w=0.42 l=0.15
X1559 v3_four_channel_output_load_integration_0/v3_four_channel_shared_support_integration_0/v3_four_channel_bias_reference_distribution_0/v3_four_channel_phase_distribution_0/v3_four_channel_output_collection_0/v3_four_channel_placement_0/v3_channel_selector_late_promotion_0/v3_selector_route_pilot_0/group2_lo_n v3_four_channel_output_load_integration_0/v3_four_channel_shared_support_integration_0/v3_four_channel_bias_reference_distribution_0/v3_four_channel_phase_distribution_0/v3_four_channel_output_collection_0/v3_four_channel_placement_0/v3_channel_selector_late_promotion_0/v3_selector_route_pilot_0/G2_LO_N_ANDNOT/a_207_413# VDPWR VDPWR sky130_fd_pr__pfet_01v8_hvt ad=0.26 pd=2.52 as=0 ps=0 w=1 l=0.15
X1560 v3_four_channel_output_load_integration_0/v3_four_channel_shared_support_integration_0/v3_four_channel_bias_reference_distribution_0/v3_four_channel_phase_distribution_0/v3_four_channel_output_collection_0/v3_four_channel_placement_0/v3_channel_selector_late_promotion_0/v3_selector_route_pilot_0/G2_LO_N_ANDNOT/a_297_47# v3_four_channel_output_load_integration_0/v3_four_channel_shared_support_integration_0/v3_four_channel_bias_reference_distribution_0/v3_four_channel_phase_distribution_0/v3_four_channel_output_collection_0/v3_four_channel_placement_0/v3_channel_selector_late_promotion_0/v3_selector_route_pilot_0/G2_LO_N_ANDNOT/a_27_413# v3_four_channel_output_load_integration_0/v3_four_channel_shared_support_integration_0/v3_four_channel_bias_reference_distribution_0/v3_four_channel_phase_distribution_0/v3_four_channel_output_collection_0/v3_four_channel_placement_0/v3_channel_selector_late_promotion_0/v3_selector_route_pilot_0/G2_LO_N_ANDNOT/a_207_413# VGND sky130_fd_pr__nfet_01v8 ad=0.1008 pd=1.32 as=0.1092 ps=1.36 w=0.42 l=0.15
X1561 v3_four_channel_output_load_integration_0/v3_four_channel_shared_support_integration_0/v3_four_channel_bias_reference_distribution_0/v3_four_channel_phase_distribution_0/v3_four_channel_output_collection_0/v3_four_channel_placement_0/v3_channel_selector_late_promotion_0/v3_selector_route_pilot_0/group2_lo_n v3_four_channel_output_load_integration_0/v3_four_channel_shared_support_integration_0/v3_four_channel_bias_reference_distribution_0/v3_four_channel_phase_distribution_0/v3_four_channel_output_collection_0/v3_four_channel_placement_0/v3_channel_selector_late_promotion_0/v3_selector_route_pilot_0/G2_LO_N_ANDNOT/a_207_413# VGND VGND sky130_fd_pr__nfet_01v8 ad=0.169 pd=1.82 as=0 ps=0 w=0.65 l=0.15
X1562 v3_four_channel_output_load_integration_0/v3_four_channel_shared_support_integration_0/v3_four_channel_bias_reference_distribution_0/v3_four_channel_phase_distribution_0/v3_four_channel_output_collection_0/v3_four_channel_placement_0/v3_channel_selector_late_promotion_0/v3_selector_route_pilot_0/G2_LO_N_ANDNOT/a_207_413# v3_four_channel_output_load_integration_0/v3_four_channel_shared_support_integration_0/v3_four_channel_bias_reference_distribution_0/v3_four_channel_phase_distribution_0/v3_four_channel_output_collection_0/v3_four_channel_placement_0/v3_channel_selector_late_promotion_0/v3_selector_route_pilot_0/G2_LO_N_ANDNOT/a_27_413# VDPWR VDPWR sky130_fd_pr__pfet_01v8_hvt ad=0 pd=0 as=0 ps=0 w=0.42 l=0.15
X1563 VDPWR v3_four_channel_output_load_integration_0/v3_four_channel_shared_support_integration_0/v3_four_channel_bias_reference_distribution_0/v3_four_channel_phase_distribution_0/v3_four_channel_output_collection_0/v3_four_channel_placement_0/v3_channel_selector_late_promotion_0/v3_selector_route_pilot_0/G2_MUX_AXIS/X v3_four_channel_output_load_integration_0/v3_four_channel_shared_support_integration_0/v3_four_channel_bias_reference_distribution_0/v3_four_channel_phase_distribution_0/v3_four_channel_output_collection_0/v3_four_channel_placement_0/v3_channel_selector_late_promotion_0/v3_selector_route_pilot_0/G2_LO_N_ANDNOT/a_27_413# VDPWR sky130_fd_pr__pfet_01v8_hvt ad=0 pd=0 as=0.1092 ps=1.36 w=0.42 l=0.15
X1564 VGND v3_four_channel_output_load_integration_0/v3_four_channel_shared_support_integration_0/v3_four_channel_bias_reference_distribution_0/v3_four_channel_phase_distribution_0/v3_four_channel_output_collection_0/v3_four_channel_placement_0/v3_channel_selector_late_promotion_0/v3_selector_route_pilot_0/G3_LO_P_AND/B v3_four_channel_output_load_integration_0/v3_four_channel_shared_support_integration_0/v3_four_channel_bias_reference_distribution_0/v3_four_channel_phase_distribution_0/v3_four_channel_output_collection_0/v3_four_channel_placement_0/v3_channel_selector_late_promotion_0/v3_selector_route_pilot_0/G2_LO_N_ANDNOT/a_297_47# VGND sky130_fd_pr__nfet_01v8 ad=0 pd=0 as=0 ps=0 w=0.42 l=0.15
X1565 v3_four_channel_output_load_integration_0/v3_four_channel_shared_support_integration_0/v3_four_channel_bias_reference_distribution_0/v3_four_channel_phase_distribution_0/v3_four_channel_output_collection_0/v3_four_channel_placement_0/v3_channel_selector_late_promotion_0/v3_selector_route_pilot_0/G2_LO_N_ANDNOT/a_27_413# v3_four_channel_output_load_integration_0/v3_four_channel_shared_support_integration_0/v3_four_channel_bias_reference_distribution_0/v3_four_channel_phase_distribution_0/v3_four_channel_output_collection_0/v3_four_channel_placement_0/v3_channel_selector_late_promotion_0/v3_selector_route_pilot_0/G2_MUX_AXIS/X VGND VGND sky130_fd_pr__nfet_01v8 ad=0.1092 pd=1.36 as=0 ps=0 w=0.42 l=0.15
X1566 VDPWR v3_four_channel_output_load_integration_0/v3_four_channel_shared_support_integration_0/v3_four_channel_bias_reference_distribution_0/v3_four_channel_phase_distribution_0/v3_four_channel_output_collection_0/v3_four_channel_placement_0/v3_channel_selector_late_promotion_0/v3_selector_route_pilot_0/G3_LO_P_AND/B v3_four_channel_output_load_integration_0/v3_four_channel_shared_support_integration_0/v3_four_channel_bias_reference_distribution_0/v3_four_channel_phase_distribution_0/v3_four_channel_output_collection_0/v3_four_channel_placement_0/v3_channel_selector_late_promotion_0/v3_selector_route_pilot_0/G0_LO_N_ANDNOT/a_207_413# VDPWR sky130_fd_pr__pfet_01v8_hvt ad=0 pd=0 as=0.1218 ps=1.42 w=0.42 l=0.15
X1567 v3_four_channel_output_load_integration_0/v3_four_channel_shared_support_integration_0/v3_four_channel_bias_reference_distribution_0/v3_four_channel_phase_distribution_0/v3_four_channel_output_collection_0/v3_four_channel_placement_0/v3_channel_selector_late_promotion_0/v3_selector_route_pilot_0/group0_lo_n v3_four_channel_output_load_integration_0/v3_four_channel_shared_support_integration_0/v3_four_channel_bias_reference_distribution_0/v3_four_channel_phase_distribution_0/v3_four_channel_output_collection_0/v3_four_channel_placement_0/v3_channel_selector_late_promotion_0/v3_selector_route_pilot_0/G0_LO_N_ANDNOT/a_207_413# VDPWR VDPWR sky130_fd_pr__pfet_01v8_hvt ad=0.26 pd=2.52 as=0 ps=0 w=1 l=0.15
X1568 v3_four_channel_output_load_integration_0/v3_four_channel_shared_support_integration_0/v3_four_channel_bias_reference_distribution_0/v3_four_channel_phase_distribution_0/v3_four_channel_output_collection_0/v3_four_channel_placement_0/v3_channel_selector_late_promotion_0/v3_selector_route_pilot_0/G0_LO_N_ANDNOT/a_297_47# v3_four_channel_output_load_integration_0/v3_four_channel_shared_support_integration_0/v3_four_channel_bias_reference_distribution_0/v3_four_channel_phase_distribution_0/v3_four_channel_output_collection_0/v3_four_channel_placement_0/v3_channel_selector_late_promotion_0/v3_selector_route_pilot_0/G0_LO_N_ANDNOT/a_27_413# v3_four_channel_output_load_integration_0/v3_four_channel_shared_support_integration_0/v3_four_channel_bias_reference_distribution_0/v3_four_channel_phase_distribution_0/v3_four_channel_output_collection_0/v3_four_channel_placement_0/v3_channel_selector_late_promotion_0/v3_selector_route_pilot_0/G0_LO_N_ANDNOT/a_207_413# VGND sky130_fd_pr__nfet_01v8 ad=0.1008 pd=1.32 as=0.1092 ps=1.36 w=0.42 l=0.15
X1569 v3_four_channel_output_load_integration_0/v3_four_channel_shared_support_integration_0/v3_four_channel_bias_reference_distribution_0/v3_four_channel_phase_distribution_0/v3_four_channel_output_collection_0/v3_four_channel_placement_0/v3_channel_selector_late_promotion_0/v3_selector_route_pilot_0/group0_lo_n v3_four_channel_output_load_integration_0/v3_four_channel_shared_support_integration_0/v3_four_channel_bias_reference_distribution_0/v3_four_channel_phase_distribution_0/v3_four_channel_output_collection_0/v3_four_channel_placement_0/v3_channel_selector_late_promotion_0/v3_selector_route_pilot_0/G0_LO_N_ANDNOT/a_207_413# VGND VGND sky130_fd_pr__nfet_01v8 ad=0.169 pd=1.82 as=0 ps=0 w=0.65 l=0.15
X1570 v3_four_channel_output_load_integration_0/v3_four_channel_shared_support_integration_0/v3_four_channel_bias_reference_distribution_0/v3_four_channel_phase_distribution_0/v3_four_channel_output_collection_0/v3_four_channel_placement_0/v3_channel_selector_late_promotion_0/v3_selector_route_pilot_0/G0_LO_N_ANDNOT/a_207_413# v3_four_channel_output_load_integration_0/v3_four_channel_shared_support_integration_0/v3_four_channel_bias_reference_distribution_0/v3_four_channel_phase_distribution_0/v3_four_channel_output_collection_0/v3_four_channel_placement_0/v3_channel_selector_late_promotion_0/v3_selector_route_pilot_0/G0_LO_N_ANDNOT/a_27_413# VDPWR VDPWR sky130_fd_pr__pfet_01v8_hvt ad=0 pd=0 as=0 ps=0 w=0.42 l=0.15
X1571 VDPWR v3_four_channel_output_load_integration_0/v3_four_channel_shared_support_integration_0/v3_four_channel_bias_reference_distribution_0/v3_four_channel_phase_distribution_0/v3_four_channel_output_collection_0/v3_four_channel_placement_0/v3_channel_selector_late_promotion_0/v3_selector_route_pilot_0/G0_MUX_AXIS/X v3_four_channel_output_load_integration_0/v3_four_channel_shared_support_integration_0/v3_four_channel_bias_reference_distribution_0/v3_four_channel_phase_distribution_0/v3_four_channel_output_collection_0/v3_four_channel_placement_0/v3_channel_selector_late_promotion_0/v3_selector_route_pilot_0/G0_LO_N_ANDNOT/a_27_413# VDPWR sky130_fd_pr__pfet_01v8_hvt ad=0 pd=0 as=0.1092 ps=1.36 w=0.42 l=0.15
X1572 VGND v3_four_channel_output_load_integration_0/v3_four_channel_shared_support_integration_0/v3_four_channel_bias_reference_distribution_0/v3_four_channel_phase_distribution_0/v3_four_channel_output_collection_0/v3_four_channel_placement_0/v3_channel_selector_late_promotion_0/v3_selector_route_pilot_0/G3_LO_P_AND/B v3_four_channel_output_load_integration_0/v3_four_channel_shared_support_integration_0/v3_four_channel_bias_reference_distribution_0/v3_four_channel_phase_distribution_0/v3_four_channel_output_collection_0/v3_four_channel_placement_0/v3_channel_selector_late_promotion_0/v3_selector_route_pilot_0/G0_LO_N_ANDNOT/a_297_47# VGND sky130_fd_pr__nfet_01v8 ad=0 pd=0 as=0 ps=0 w=0.42 l=0.15
X1573 v3_four_channel_output_load_integration_0/v3_four_channel_shared_support_integration_0/v3_four_channel_bias_reference_distribution_0/v3_four_channel_phase_distribution_0/v3_four_channel_output_collection_0/v3_four_channel_placement_0/v3_channel_selector_late_promotion_0/v3_selector_route_pilot_0/G0_LO_N_ANDNOT/a_27_413# v3_four_channel_output_load_integration_0/v3_four_channel_shared_support_integration_0/v3_four_channel_bias_reference_distribution_0/v3_four_channel_phase_distribution_0/v3_four_channel_output_collection_0/v3_four_channel_placement_0/v3_channel_selector_late_promotion_0/v3_selector_route_pilot_0/G0_MUX_AXIS/X VGND VGND sky130_fd_pr__nfet_01v8 ad=0.1092 pd=1.36 as=0 ps=0 w=0.42 l=0.15
X1574 VDPWR v3_four_channel_output_load_integration_0/v3_four_channel_shared_support_integration_0/v3_four_channel_bias_reference_distribution_0/v3_four_channel_phase_distribution_0/v3_four_channel_output_collection_0/v3_four_channel_placement_0/v3_channel_selector_late_promotion_0/v3_selector_route_pilot_0/G1_MUX_AXIS/a_505_21# v3_four_channel_output_load_integration_0/v3_four_channel_shared_support_integration_0/v3_four_channel_bias_reference_distribution_0/v3_four_channel_phase_distribution_0/v3_four_channel_output_collection_0/v3_four_channel_placement_0/v3_channel_selector_late_promotion_0/v3_selector_route_pilot_0/G1_MUX_AXIS/a_535_374# VDPWR sky130_fd_pr__pfet_01v8_hvt ad=0 pd=0 as=0.0882 ps=1.26 w=0.42 l=0.15
X1575 v3_four_channel_output_load_integration_0/v3_four_channel_shared_support_integration_0/v3_four_channel_bias_reference_distribution_0/v3_four_channel_phase_distribution_0/v3_four_channel_output_collection_0/v3_four_channel_placement_0/v3_channel_selector_late_promotion_0/v3_selector_route_pilot_0/G1_MUX_AXIS/a_505_21# V3R225 VDPWR VDPWR sky130_fd_pr__pfet_01v8_hvt ad=0.1176 pd=1.4 as=0 ps=0 w=0.42 l=0.15
X1576 v3_four_channel_output_load_integration_0/v3_four_channel_shared_support_integration_0/v3_four_channel_bias_reference_distribution_0/v3_four_channel_phase_distribution_0/v3_four_channel_output_collection_0/v3_four_channel_placement_0/v3_channel_selector_late_promotion_0/v3_selector_route_pilot_0/G1_MUX_AXIS/a_218_374# V3R225 VDPWR VDPWR sky130_fd_pr__pfet_01v8_hvt ad=0.1533 pd=1.57 as=0 ps=0 w=0.42 l=0.15
X1577 VGND v3_four_channel_output_load_integration_0/v3_four_channel_shared_support_integration_0/v3_four_channel_bias_reference_distribution_0/v3_four_channel_phase_distribution_0/v3_four_channel_output_collection_0/v3_four_channel_placement_0/v3_channel_selector_late_promotion_0/v3_selector_route_pilot_0/G1_MUX_AXIS/a_505_21# v3_four_channel_output_load_integration_0/v3_four_channel_shared_support_integration_0/v3_four_channel_bias_reference_distribution_0/v3_four_channel_phase_distribution_0/v3_four_channel_output_collection_0/v3_four_channel_placement_0/v3_channel_selector_late_promotion_0/v3_selector_route_pilot_0/G1_MUX_AXIS/a_439_47# VGND sky130_fd_pr__nfet_01v8 ad=0 pd=0 as=0.1386 ps=1.5 w=0.42 l=0.15
X1578 v3_four_channel_output_load_integration_0/v3_four_channel_shared_support_integration_0/v3_four_channel_bias_reference_distribution_0/v3_four_channel_phase_distribution_0/v3_four_channel_output_collection_0/v3_four_channel_placement_0/v3_channel_selector_late_promotion_0/v3_selector_route_pilot_0/G1_MUX_AXIS/a_76_199# v3_four_channel_output_load_integration_0/v3_four_channel_shared_support_integration_0/v3_four_channel_bias_reference_distribution_0/v3_four_channel_phase_distribution_0/v3_four_channel_output_collection_0/v3_four_channel_placement_0/v3_channel_selector_late_promotion_0/v3_selector_route_pilot_0/G1_MUX_POS/X v3_four_channel_output_load_integration_0/v3_four_channel_shared_support_integration_0/v3_four_channel_bias_reference_distribution_0/v3_four_channel_phase_distribution_0/v3_four_channel_output_collection_0/v3_four_channel_placement_0/v3_channel_selector_late_promotion_0/v3_selector_route_pilot_0/G1_MUX_AXIS/a_218_374# VDPWR sky130_fd_pr__pfet_01v8_hvt ad=0.3864 pd=2.68 as=0 ps=0 w=0.42 l=0.15
X1579 v3_four_channel_output_load_integration_0/v3_four_channel_shared_support_integration_0/v3_four_channel_bias_reference_distribution_0/v3_four_channel_phase_distribution_0/v3_four_channel_output_collection_0/v3_four_channel_placement_0/v3_channel_selector_late_promotion_0/v3_selector_route_pilot_0/G1_MUX_AXIS/a_505_21# V3R225 VGND VGND sky130_fd_pr__nfet_01v8 ad=0.1092 pd=1.36 as=0 ps=0 w=0.42 l=0.15
X1580 v3_four_channel_output_load_integration_0/v3_four_channel_shared_support_integration_0/v3_four_channel_bias_reference_distribution_0/v3_four_channel_phase_distribution_0/v3_four_channel_output_collection_0/v3_four_channel_placement_0/v3_channel_selector_late_promotion_0/v3_selector_route_pilot_0/G1_MUX_AXIS/a_439_47# v3_four_channel_output_load_integration_0/v3_four_channel_shared_support_integration_0/v3_four_channel_bias_reference_distribution_0/v3_four_channel_phase_distribution_0/v3_four_channel_output_collection_0/v3_four_channel_placement_0/v3_channel_selector_late_promotion_0/v3_selector_route_pilot_0/G1_MUX_POS/X v3_four_channel_output_load_integration_0/v3_four_channel_shared_support_integration_0/v3_four_channel_bias_reference_distribution_0/v3_four_channel_phase_distribution_0/v3_four_channel_output_collection_0/v3_four_channel_placement_0/v3_channel_selector_late_promotion_0/v3_selector_route_pilot_0/G1_MUX_AXIS/a_76_199# VGND sky130_fd_pr__nfet_01v8 ad=0 pd=0 as=0.1995 ps=1.79 w=0.42 l=0.15
X1581 v3_four_channel_output_load_integration_0/v3_four_channel_shared_support_integration_0/v3_four_channel_bias_reference_distribution_0/v3_four_channel_phase_distribution_0/v3_four_channel_output_collection_0/v3_four_channel_placement_0/v3_channel_selector_late_promotion_0/v3_selector_route_pilot_0/G1_MUX_AXIS/a_535_374# v3_four_channel_output_load_integration_0/v3_four_channel_shared_support_integration_0/v3_four_channel_bias_reference_distribution_0/v3_four_channel_phase_distribution_0/v3_four_channel_output_collection_0/v3_four_channel_placement_0/v3_channel_selector_late_promotion_0/v3_selector_route_pilot_0/G1_MUX_NEG/X v3_four_channel_output_load_integration_0/v3_four_channel_shared_support_integration_0/v3_four_channel_bias_reference_distribution_0/v3_four_channel_phase_distribution_0/v3_four_channel_output_collection_0/v3_four_channel_placement_0/v3_channel_selector_late_promotion_0/v3_selector_route_pilot_0/G1_MUX_AXIS/a_76_199# VDPWR sky130_fd_pr__pfet_01v8_hvt ad=0 pd=0 as=0 ps=0 w=0.42 l=0.15
X1582 v3_four_channel_output_load_integration_0/v3_four_channel_shared_support_integration_0/v3_four_channel_bias_reference_distribution_0/v3_four_channel_phase_distribution_0/v3_four_channel_output_collection_0/v3_four_channel_placement_0/v3_channel_selector_late_promotion_0/v3_selector_route_pilot_0/G1_MUX_AXIS/a_76_199# v3_four_channel_output_load_integration_0/v3_four_channel_shared_support_integration_0/v3_four_channel_bias_reference_distribution_0/v3_four_channel_phase_distribution_0/v3_four_channel_output_collection_0/v3_four_channel_placement_0/v3_channel_selector_late_promotion_0/v3_selector_route_pilot_0/G1_MUX_NEG/X v3_four_channel_output_load_integration_0/v3_four_channel_shared_support_integration_0/v3_four_channel_bias_reference_distribution_0/v3_four_channel_phase_distribution_0/v3_four_channel_output_collection_0/v3_four_channel_placement_0/v3_channel_selector_late_promotion_0/v3_selector_route_pilot_0/G1_MUX_AXIS/a_218_47# VGND sky130_fd_pr__nfet_01v8 ad=0 pd=0 as=0.1386 ps=1.5 w=0.42 l=0.15
X1583 v3_four_channel_output_load_integration_0/v3_four_channel_shared_support_integration_0/v3_four_channel_bias_reference_distribution_0/v3_four_channel_phase_distribution_0/v3_four_channel_output_collection_0/v3_four_channel_placement_0/v3_channel_selector_late_promotion_0/v3_selector_route_pilot_0/G1_MUX_AXIS/a_218_47# V3R225 VGND VGND sky130_fd_pr__nfet_01v8 ad=0 pd=0 as=0 ps=0 w=0.42 l=0.15
X1584 VDPWR v3_four_channel_output_load_integration_0/v3_four_channel_shared_support_integration_0/v3_four_channel_bias_reference_distribution_0/v3_four_channel_phase_distribution_0/v3_four_channel_output_collection_0/v3_four_channel_placement_0/v3_channel_selector_late_promotion_0/v3_selector_route_pilot_0/G1_MUX_AXIS/a_76_199# v3_four_channel_output_load_integration_0/v3_four_channel_shared_support_integration_0/v3_four_channel_bias_reference_distribution_0/v3_four_channel_phase_distribution_0/v3_four_channel_output_collection_0/v3_four_channel_placement_0/v3_channel_selector_late_promotion_0/v3_selector_route_pilot_0/G1_MUX_AXIS/X VDPWR sky130_fd_pr__pfet_01v8_hvt ad=0 pd=0 as=0.26 ps=2.52 w=1 l=0.15
X1585 VGND v3_four_channel_output_load_integration_0/v3_four_channel_shared_support_integration_0/v3_four_channel_bias_reference_distribution_0/v3_four_channel_phase_distribution_0/v3_four_channel_output_collection_0/v3_four_channel_placement_0/v3_channel_selector_late_promotion_0/v3_selector_route_pilot_0/G1_MUX_AXIS/a_76_199# v3_four_channel_output_load_integration_0/v3_four_channel_shared_support_integration_0/v3_four_channel_bias_reference_distribution_0/v3_four_channel_phase_distribution_0/v3_four_channel_output_collection_0/v3_four_channel_placement_0/v3_channel_selector_late_promotion_0/v3_selector_route_pilot_0/G1_MUX_AXIS/X VGND sky130_fd_pr__nfet_01v8 ad=0 pd=0 as=0.169 ps=1.82 w=0.65 l=0.15
X1586 VDPWR v3_four_channel_output_load_integration_0/v3_four_channel_shared_support_integration_0/v3_four_channel_bias_reference_distribution_0/v3_four_channel_phase_distribution_0/v3_four_channel_output_collection_0/v3_four_channel_placement_0/v3_channel_selector_late_promotion_0/v3_selector_route_pilot_0/G3_LO_P_AND/B v3_four_channel_output_load_integration_0/v3_four_channel_shared_support_integration_0/v3_four_channel_bias_reference_distribution_0/v3_four_channel_phase_distribution_0/v3_four_channel_output_collection_0/v3_four_channel_placement_0/v3_channel_selector_late_promotion_0/v3_selector_route_pilot_0/G1_LO_N_ANDNOT/a_207_413# VDPWR sky130_fd_pr__pfet_01v8_hvt ad=0 pd=0 as=0.1218 ps=1.42 w=0.42 l=0.15
X1587 v3_four_channel_output_load_integration_0/v3_four_channel_shared_support_integration_0/v3_four_channel_bias_reference_distribution_0/v3_four_channel_phase_distribution_0/v3_four_channel_output_collection_0/v3_four_channel_placement_0/v3_channel_selector_late_promotion_0/v3_selector_route_pilot_0/group1_lo_n v3_four_channel_output_load_integration_0/v3_four_channel_shared_support_integration_0/v3_four_channel_bias_reference_distribution_0/v3_four_channel_phase_distribution_0/v3_four_channel_output_collection_0/v3_four_channel_placement_0/v3_channel_selector_late_promotion_0/v3_selector_route_pilot_0/G1_LO_N_ANDNOT/a_207_413# VDPWR VDPWR sky130_fd_pr__pfet_01v8_hvt ad=0.26 pd=2.52 as=0 ps=0 w=1 l=0.15
X1588 v3_four_channel_output_load_integration_0/v3_four_channel_shared_support_integration_0/v3_four_channel_bias_reference_distribution_0/v3_four_channel_phase_distribution_0/v3_four_channel_output_collection_0/v3_four_channel_placement_0/v3_channel_selector_late_promotion_0/v3_selector_route_pilot_0/G1_LO_N_ANDNOT/a_297_47# v3_four_channel_output_load_integration_0/v3_four_channel_shared_support_integration_0/v3_four_channel_bias_reference_distribution_0/v3_four_channel_phase_distribution_0/v3_four_channel_output_collection_0/v3_four_channel_placement_0/v3_channel_selector_late_promotion_0/v3_selector_route_pilot_0/G1_LO_N_ANDNOT/a_27_413# v3_four_channel_output_load_integration_0/v3_four_channel_shared_support_integration_0/v3_four_channel_bias_reference_distribution_0/v3_four_channel_phase_distribution_0/v3_four_channel_output_collection_0/v3_four_channel_placement_0/v3_channel_selector_late_promotion_0/v3_selector_route_pilot_0/G1_LO_N_ANDNOT/a_207_413# VGND sky130_fd_pr__nfet_01v8 ad=0.1008 pd=1.32 as=0.1092 ps=1.36 w=0.42 l=0.15
X1589 v3_four_channel_output_load_integration_0/v3_four_channel_shared_support_integration_0/v3_four_channel_bias_reference_distribution_0/v3_four_channel_phase_distribution_0/v3_four_channel_output_collection_0/v3_four_channel_placement_0/v3_channel_selector_late_promotion_0/v3_selector_route_pilot_0/group1_lo_n v3_four_channel_output_load_integration_0/v3_four_channel_shared_support_integration_0/v3_four_channel_bias_reference_distribution_0/v3_four_channel_phase_distribution_0/v3_four_channel_output_collection_0/v3_four_channel_placement_0/v3_channel_selector_late_promotion_0/v3_selector_route_pilot_0/G1_LO_N_ANDNOT/a_207_413# VGND VGND sky130_fd_pr__nfet_01v8 ad=0.169 pd=1.82 as=0 ps=0 w=0.65 l=0.15
X1590 v3_four_channel_output_load_integration_0/v3_four_channel_shared_support_integration_0/v3_four_channel_bias_reference_distribution_0/v3_four_channel_phase_distribution_0/v3_four_channel_output_collection_0/v3_four_channel_placement_0/v3_channel_selector_late_promotion_0/v3_selector_route_pilot_0/G1_LO_N_ANDNOT/a_207_413# v3_four_channel_output_load_integration_0/v3_four_channel_shared_support_integration_0/v3_four_channel_bias_reference_distribution_0/v3_four_channel_phase_distribution_0/v3_four_channel_output_collection_0/v3_four_channel_placement_0/v3_channel_selector_late_promotion_0/v3_selector_route_pilot_0/G1_LO_N_ANDNOT/a_27_413# VDPWR VDPWR sky130_fd_pr__pfet_01v8_hvt ad=0 pd=0 as=0 ps=0 w=0.42 l=0.15
X1591 VDPWR v3_four_channel_output_load_integration_0/v3_four_channel_shared_support_integration_0/v3_four_channel_bias_reference_distribution_0/v3_four_channel_phase_distribution_0/v3_four_channel_output_collection_0/v3_four_channel_placement_0/v3_channel_selector_late_promotion_0/v3_selector_route_pilot_0/G1_MUX_AXIS/X v3_four_channel_output_load_integration_0/v3_four_channel_shared_support_integration_0/v3_four_channel_bias_reference_distribution_0/v3_four_channel_phase_distribution_0/v3_four_channel_output_collection_0/v3_four_channel_placement_0/v3_channel_selector_late_promotion_0/v3_selector_route_pilot_0/G1_LO_N_ANDNOT/a_27_413# VDPWR sky130_fd_pr__pfet_01v8_hvt ad=0 pd=0 as=0.1092 ps=1.36 w=0.42 l=0.15
X1592 VGND v3_four_channel_output_load_integration_0/v3_four_channel_shared_support_integration_0/v3_four_channel_bias_reference_distribution_0/v3_four_channel_phase_distribution_0/v3_four_channel_output_collection_0/v3_four_channel_placement_0/v3_channel_selector_late_promotion_0/v3_selector_route_pilot_0/G3_LO_P_AND/B v3_four_channel_output_load_integration_0/v3_four_channel_shared_support_integration_0/v3_four_channel_bias_reference_distribution_0/v3_four_channel_phase_distribution_0/v3_four_channel_output_collection_0/v3_four_channel_placement_0/v3_channel_selector_late_promotion_0/v3_selector_route_pilot_0/G1_LO_N_ANDNOT/a_297_47# VGND sky130_fd_pr__nfet_01v8 ad=0 pd=0 as=0 ps=0 w=0.42 l=0.15
X1593 v3_four_channel_output_load_integration_0/v3_four_channel_shared_support_integration_0/v3_four_channel_bias_reference_distribution_0/v3_four_channel_phase_distribution_0/v3_four_channel_output_collection_0/v3_four_channel_placement_0/v3_channel_selector_late_promotion_0/v3_selector_route_pilot_0/G1_LO_N_ANDNOT/a_27_413# v3_four_channel_output_load_integration_0/v3_four_channel_shared_support_integration_0/v3_four_channel_bias_reference_distribution_0/v3_four_channel_phase_distribution_0/v3_four_channel_output_collection_0/v3_four_channel_placement_0/v3_channel_selector_late_promotion_0/v3_selector_route_pilot_0/G1_MUX_AXIS/X VGND VGND sky130_fd_pr__nfet_01v8 ad=0.1092 pd=1.36 as=0 ps=0 w=0.42 l=0.15
X1594 VDPWR v3_four_channel_output_load_integration_0/v3_four_channel_shared_support_integration_0/v3_four_channel_bias_reference_distribution_0/v3_four_channel_phase_distribution_0/v3_four_channel_output_collection_0/v3_four_channel_placement_0/v3_channel_selector_late_promotion_0/v3_selector_route_pilot_0/G3_LO_P_AND/B v3_four_channel_output_load_integration_0/v3_four_channel_shared_support_integration_0/v3_four_channel_bias_reference_distribution_0/v3_four_channel_phase_distribution_0/v3_four_channel_output_collection_0/v3_four_channel_placement_0/v3_channel_selector_late_promotion_0/v3_selector_route_pilot_0/G3_LO_P_AND/a_59_75# VDPWR sky130_fd_pr__pfet_01v8_hvt ad=0 pd=0 as=0.1134 ps=1.38 w=0.42 l=0.15
X1595 v3_four_channel_output_load_integration_0/v3_four_channel_shared_support_integration_0/v3_four_channel_bias_reference_distribution_0/v3_four_channel_phase_distribution_0/v3_four_channel_output_collection_0/v3_four_channel_placement_0/v3_channel_selector_late_promotion_0/v3_selector_route_pilot_0/group3_lo_p v3_four_channel_output_load_integration_0/v3_four_channel_shared_support_integration_0/v3_four_channel_bias_reference_distribution_0/v3_four_channel_phase_distribution_0/v3_four_channel_output_collection_0/v3_four_channel_placement_0/v3_channel_selector_late_promotion_0/v3_selector_route_pilot_0/G3_LO_P_AND/a_59_75# VDPWR VDPWR sky130_fd_pr__pfet_01v8_hvt ad=0.475 pd=2.95 as=0 ps=0 w=1 l=0.15
X1596 VGND v3_four_channel_output_load_integration_0/v3_four_channel_shared_support_integration_0/v3_four_channel_bias_reference_distribution_0/v3_four_channel_phase_distribution_0/v3_four_channel_output_collection_0/v3_four_channel_placement_0/v3_channel_selector_late_promotion_0/v3_selector_route_pilot_0/G3_LO_P_AND/B v3_four_channel_output_load_integration_0/v3_four_channel_shared_support_integration_0/v3_four_channel_bias_reference_distribution_0/v3_four_channel_phase_distribution_0/v3_four_channel_output_collection_0/v3_four_channel_placement_0/v3_channel_selector_late_promotion_0/v3_selector_route_pilot_0/G3_LO_P_AND/a_145_75# VGND sky130_fd_pr__nfet_01v8 ad=0 pd=0 as=0.1134 ps=1.38 w=0.42 l=0.15
X1597 v3_four_channel_output_load_integration_0/v3_four_channel_shared_support_integration_0/v3_four_channel_bias_reference_distribution_0/v3_four_channel_phase_distribution_0/v3_four_channel_output_collection_0/v3_four_channel_placement_0/v3_channel_selector_late_promotion_0/v3_selector_route_pilot_0/G3_LO_P_AND/a_59_75# v3_four_channel_output_load_integration_0/v3_four_channel_shared_support_integration_0/v3_four_channel_bias_reference_distribution_0/v3_four_channel_phase_distribution_0/v3_four_channel_output_collection_0/v3_four_channel_placement_0/v3_channel_selector_late_promotion_0/v3_selector_route_pilot_0/G3_MUX_AXIS/X VDPWR VDPWR sky130_fd_pr__pfet_01v8_hvt ad=0 pd=0 as=0 ps=0 w=0.42 l=0.15
X1598 v3_four_channel_output_load_integration_0/v3_four_channel_shared_support_integration_0/v3_four_channel_bias_reference_distribution_0/v3_four_channel_phase_distribution_0/v3_four_channel_output_collection_0/v3_four_channel_placement_0/v3_channel_selector_late_promotion_0/v3_selector_route_pilot_0/group3_lo_p v3_four_channel_output_load_integration_0/v3_four_channel_shared_support_integration_0/v3_four_channel_bias_reference_distribution_0/v3_four_channel_phase_distribution_0/v3_four_channel_output_collection_0/v3_four_channel_placement_0/v3_channel_selector_late_promotion_0/v3_selector_route_pilot_0/G3_LO_P_AND/a_59_75# VGND VGND sky130_fd_pr__nfet_01v8 ad=0.182 pd=1.86 as=0 ps=0 w=0.65 l=0.15
X1599 v3_four_channel_output_load_integration_0/v3_four_channel_shared_support_integration_0/v3_four_channel_bias_reference_distribution_0/v3_four_channel_phase_distribution_0/v3_four_channel_output_collection_0/v3_four_channel_placement_0/v3_channel_selector_late_promotion_0/v3_selector_route_pilot_0/G3_LO_P_AND/a_145_75# v3_four_channel_output_load_integration_0/v3_four_channel_shared_support_integration_0/v3_four_channel_bias_reference_distribution_0/v3_four_channel_phase_distribution_0/v3_four_channel_output_collection_0/v3_four_channel_placement_0/v3_channel_selector_late_promotion_0/v3_selector_route_pilot_0/G3_MUX_AXIS/X v3_four_channel_output_load_integration_0/v3_four_channel_shared_support_integration_0/v3_four_channel_bias_reference_distribution_0/v3_four_channel_phase_distribution_0/v3_four_channel_output_collection_0/v3_four_channel_placement_0/v3_channel_selector_late_promotion_0/v3_selector_route_pilot_0/G3_LO_P_AND/a_59_75# VGND sky130_fd_pr__nfet_01v8 ad=0 pd=0 as=0.1176 ps=1.4 w=0.42 l=0.15
X1600 VDPWR v3_four_channel_output_load_integration_0/v3_four_channel_shared_support_integration_0/v3_four_channel_bias_reference_distribution_0/v3_four_channel_phase_distribution_0/v3_four_channel_output_collection_0/v3_four_channel_placement_0/v3_channel_selector_late_promotion_0/v3_selector_route_pilot_0/G2_MUX_POS/a_505_21# v3_four_channel_output_load_integration_0/v3_four_channel_shared_support_integration_0/v3_four_channel_bias_reference_distribution_0/v3_four_channel_phase_distribution_0/v3_four_channel_output_collection_0/v3_four_channel_placement_0/v3_channel_selector_late_promotion_0/v3_selector_route_pilot_0/G2_MUX_POS/a_535_374# VDPWR sky130_fd_pr__pfet_01v8_hvt ad=0 pd=0 as=0.0882 ps=1.26 w=0.42 l=0.15
X1601 v3_four_channel_output_load_integration_0/v3_four_channel_shared_support_integration_0/v3_four_channel_bias_reference_distribution_0/v3_four_channel_phase_distribution_0/v3_four_channel_output_collection_0/v3_four_channel_placement_0/v3_channel_selector_late_promotion_0/v3_selector_route_pilot_0/G2_MUX_POS/a_505_21# V3R226 VDPWR VDPWR sky130_fd_pr__pfet_01v8_hvt ad=0.1176 pd=1.4 as=0 ps=0 w=0.42 l=0.15
X1602 v3_four_channel_output_load_integration_0/v3_four_channel_shared_support_integration_0/v3_four_channel_bias_reference_distribution_0/v3_four_channel_phase_distribution_0/v3_four_channel_output_collection_0/v3_four_channel_placement_0/v3_channel_selector_late_promotion_0/v3_selector_route_pilot_0/G2_MUX_POS/a_218_374# V3R226 VDPWR VDPWR sky130_fd_pr__pfet_01v8_hvt ad=0.1533 pd=1.57 as=0 ps=0 w=0.42 l=0.15
X1603 VGND v3_four_channel_output_load_integration_0/v3_four_channel_shared_support_integration_0/v3_four_channel_bias_reference_distribution_0/v3_four_channel_phase_distribution_0/v3_four_channel_output_collection_0/v3_four_channel_placement_0/v3_channel_selector_late_promotion_0/v3_selector_route_pilot_0/G2_MUX_POS/a_505_21# v3_four_channel_output_load_integration_0/v3_four_channel_shared_support_integration_0/v3_four_channel_bias_reference_distribution_0/v3_four_channel_phase_distribution_0/v3_four_channel_output_collection_0/v3_four_channel_placement_0/v3_channel_selector_late_promotion_0/v3_selector_route_pilot_0/G2_MUX_POS/a_439_47# VGND sky130_fd_pr__nfet_01v8 ad=0 pd=0 as=0.1386 ps=1.5 w=0.42 l=0.15
X1604 v3_four_channel_output_load_integration_0/v3_four_channel_shared_support_integration_0/v3_four_channel_bias_reference_distribution_0/v3_four_channel_phase_distribution_0/v3_four_channel_output_collection_0/v3_four_channel_placement_0/v3_channel_selector_late_promotion_0/v3_selector_route_pilot_0/G2_MUX_POS/a_76_199# V3R290 v3_four_channel_output_load_integration_0/v3_four_channel_shared_support_integration_0/v3_four_channel_bias_reference_distribution_0/v3_four_channel_phase_distribution_0/v3_four_channel_output_collection_0/v3_four_channel_placement_0/v3_channel_selector_late_promotion_0/v3_selector_route_pilot_0/G2_MUX_POS/a_218_374# VDPWR sky130_fd_pr__pfet_01v8_hvt ad=0.3864 pd=2.68 as=0 ps=0 w=0.42 l=0.15
X1605 v3_four_channel_output_load_integration_0/v3_four_channel_shared_support_integration_0/v3_four_channel_bias_reference_distribution_0/v3_four_channel_phase_distribution_0/v3_four_channel_output_collection_0/v3_four_channel_placement_0/v3_channel_selector_late_promotion_0/v3_selector_route_pilot_0/G2_MUX_POS/a_505_21# V3R226 VGND VGND sky130_fd_pr__nfet_01v8 ad=0.1092 pd=1.36 as=0 ps=0 w=0.42 l=0.15
X1606 v3_four_channel_output_load_integration_0/v3_four_channel_shared_support_integration_0/v3_four_channel_bias_reference_distribution_0/v3_four_channel_phase_distribution_0/v3_four_channel_output_collection_0/v3_four_channel_placement_0/v3_channel_selector_late_promotion_0/v3_selector_route_pilot_0/G2_MUX_POS/a_439_47# V3R290 v3_four_channel_output_load_integration_0/v3_four_channel_shared_support_integration_0/v3_four_channel_bias_reference_distribution_0/v3_four_channel_phase_distribution_0/v3_four_channel_output_collection_0/v3_four_channel_placement_0/v3_channel_selector_late_promotion_0/v3_selector_route_pilot_0/G2_MUX_POS/a_76_199# VGND sky130_fd_pr__nfet_01v8 ad=0 pd=0 as=0.1995 ps=1.79 w=0.42 l=0.15
X1607 v3_four_channel_output_load_integration_0/v3_four_channel_shared_support_integration_0/v3_four_channel_bias_reference_distribution_0/v3_four_channel_phase_distribution_0/v3_four_channel_output_collection_0/v3_four_channel_placement_0/v3_channel_selector_late_promotion_0/v3_selector_route_pilot_0/G2_MUX_POS/a_535_374# V3R291 v3_four_channel_output_load_integration_0/v3_four_channel_shared_support_integration_0/v3_four_channel_bias_reference_distribution_0/v3_four_channel_phase_distribution_0/v3_four_channel_output_collection_0/v3_four_channel_placement_0/v3_channel_selector_late_promotion_0/v3_selector_route_pilot_0/G2_MUX_POS/a_76_199# VDPWR sky130_fd_pr__pfet_01v8_hvt ad=0 pd=0 as=0 ps=0 w=0.42 l=0.15
X1608 v3_four_channel_output_load_integration_0/v3_four_channel_shared_support_integration_0/v3_four_channel_bias_reference_distribution_0/v3_four_channel_phase_distribution_0/v3_four_channel_output_collection_0/v3_four_channel_placement_0/v3_channel_selector_late_promotion_0/v3_selector_route_pilot_0/G2_MUX_POS/a_76_199# V3R291 v3_four_channel_output_load_integration_0/v3_four_channel_shared_support_integration_0/v3_four_channel_bias_reference_distribution_0/v3_four_channel_phase_distribution_0/v3_four_channel_output_collection_0/v3_four_channel_placement_0/v3_channel_selector_late_promotion_0/v3_selector_route_pilot_0/G2_MUX_POS/a_218_47# VGND sky130_fd_pr__nfet_01v8 ad=0 pd=0 as=0.1386 ps=1.5 w=0.42 l=0.15
X1609 v3_four_channel_output_load_integration_0/v3_four_channel_shared_support_integration_0/v3_four_channel_bias_reference_distribution_0/v3_four_channel_phase_distribution_0/v3_four_channel_output_collection_0/v3_four_channel_placement_0/v3_channel_selector_late_promotion_0/v3_selector_route_pilot_0/G2_MUX_POS/a_218_47# V3R226 VGND VGND sky130_fd_pr__nfet_01v8 ad=0 pd=0 as=0 ps=0 w=0.42 l=0.15
X1610 VDPWR v3_four_channel_output_load_integration_0/v3_four_channel_shared_support_integration_0/v3_four_channel_bias_reference_distribution_0/v3_four_channel_phase_distribution_0/v3_four_channel_output_collection_0/v3_four_channel_placement_0/v3_channel_selector_late_promotion_0/v3_selector_route_pilot_0/G2_MUX_POS/a_76_199# v3_four_channel_output_load_integration_0/v3_four_channel_shared_support_integration_0/v3_four_channel_bias_reference_distribution_0/v3_four_channel_phase_distribution_0/v3_four_channel_output_collection_0/v3_four_channel_placement_0/v3_channel_selector_late_promotion_0/v3_selector_route_pilot_0/G2_MUX_POS/X VDPWR sky130_fd_pr__pfet_01v8_hvt ad=0 pd=0 as=0.26 ps=2.52 w=1 l=0.15
X1611 VGND v3_four_channel_output_load_integration_0/v3_four_channel_shared_support_integration_0/v3_four_channel_bias_reference_distribution_0/v3_four_channel_phase_distribution_0/v3_four_channel_output_collection_0/v3_four_channel_placement_0/v3_channel_selector_late_promotion_0/v3_selector_route_pilot_0/G2_MUX_POS/a_76_199# v3_four_channel_output_load_integration_0/v3_four_channel_shared_support_integration_0/v3_four_channel_bias_reference_distribution_0/v3_four_channel_phase_distribution_0/v3_four_channel_output_collection_0/v3_four_channel_placement_0/v3_channel_selector_late_promotion_0/v3_selector_route_pilot_0/G2_MUX_POS/X VGND sky130_fd_pr__nfet_01v8 ad=0 pd=0 as=0.169 ps=1.82 w=0.65 l=0.15
X1612 VDPWR v3_four_channel_output_load_integration_0/v3_four_channel_shared_support_integration_0/v3_four_channel_bias_reference_distribution_0/v3_four_channel_phase_distribution_0/v3_four_channel_output_collection_0/v3_four_channel_placement_0/v3_channel_selector_late_promotion_0/v3_selector_route_pilot_0/G2_MUX_NEG/a_505_21# v3_four_channel_output_load_integration_0/v3_four_channel_shared_support_integration_0/v3_four_channel_bias_reference_distribution_0/v3_four_channel_phase_distribution_0/v3_four_channel_output_collection_0/v3_four_channel_placement_0/v3_channel_selector_late_promotion_0/v3_selector_route_pilot_0/G2_MUX_NEG/a_535_374# VDPWR sky130_fd_pr__pfet_01v8_hvt ad=0 pd=0 as=0.0882 ps=1.26 w=0.42 l=0.15
X1613 v3_four_channel_output_load_integration_0/v3_four_channel_shared_support_integration_0/v3_four_channel_bias_reference_distribution_0/v3_four_channel_phase_distribution_0/v3_four_channel_output_collection_0/v3_four_channel_placement_0/v3_channel_selector_late_promotion_0/v3_selector_route_pilot_0/G2_MUX_NEG/a_505_21# V3R226 VDPWR VDPWR sky130_fd_pr__pfet_01v8_hvt ad=0.1176 pd=1.4 as=0 ps=0 w=0.42 l=0.15
X1614 v3_four_channel_output_load_integration_0/v3_four_channel_shared_support_integration_0/v3_four_channel_bias_reference_distribution_0/v3_four_channel_phase_distribution_0/v3_four_channel_output_collection_0/v3_four_channel_placement_0/v3_channel_selector_late_promotion_0/v3_selector_route_pilot_0/G2_MUX_NEG/a_218_374# V3R226 VDPWR VDPWR sky130_fd_pr__pfet_01v8_hvt ad=0.1533 pd=1.57 as=0 ps=0 w=0.42 l=0.15
X1615 VGND v3_four_channel_output_load_integration_0/v3_four_channel_shared_support_integration_0/v3_four_channel_bias_reference_distribution_0/v3_four_channel_phase_distribution_0/v3_four_channel_output_collection_0/v3_four_channel_placement_0/v3_channel_selector_late_promotion_0/v3_selector_route_pilot_0/G2_MUX_NEG/a_505_21# v3_four_channel_output_load_integration_0/v3_four_channel_shared_support_integration_0/v3_four_channel_bias_reference_distribution_0/v3_four_channel_phase_distribution_0/v3_four_channel_output_collection_0/v3_four_channel_placement_0/v3_channel_selector_late_promotion_0/v3_selector_route_pilot_0/G2_MUX_NEG/a_439_47# VGND sky130_fd_pr__nfet_01v8 ad=0 pd=0 as=0.1386 ps=1.5 w=0.42 l=0.15
X1616 v3_four_channel_output_load_integration_0/v3_four_channel_shared_support_integration_0/v3_four_channel_bias_reference_distribution_0/v3_four_channel_phase_distribution_0/v3_four_channel_output_collection_0/v3_four_channel_placement_0/v3_channel_selector_late_promotion_0/v3_selector_route_pilot_0/G2_MUX_NEG/a_76_199# V3R292 v3_four_channel_output_load_integration_0/v3_four_channel_shared_support_integration_0/v3_four_channel_bias_reference_distribution_0/v3_four_channel_phase_distribution_0/v3_four_channel_output_collection_0/v3_four_channel_placement_0/v3_channel_selector_late_promotion_0/v3_selector_route_pilot_0/G2_MUX_NEG/a_218_374# VDPWR sky130_fd_pr__pfet_01v8_hvt ad=0.3864 pd=2.68 as=0 ps=0 w=0.42 l=0.15
X1617 v3_four_channel_output_load_integration_0/v3_four_channel_shared_support_integration_0/v3_four_channel_bias_reference_distribution_0/v3_four_channel_phase_distribution_0/v3_four_channel_output_collection_0/v3_four_channel_placement_0/v3_channel_selector_late_promotion_0/v3_selector_route_pilot_0/G2_MUX_NEG/a_505_21# V3R226 VGND VGND sky130_fd_pr__nfet_01v8 ad=0.1092 pd=1.36 as=0 ps=0 w=0.42 l=0.15
X1618 v3_four_channel_output_load_integration_0/v3_four_channel_shared_support_integration_0/v3_four_channel_bias_reference_distribution_0/v3_four_channel_phase_distribution_0/v3_four_channel_output_collection_0/v3_four_channel_placement_0/v3_channel_selector_late_promotion_0/v3_selector_route_pilot_0/G2_MUX_NEG/a_439_47# V3R292 v3_four_channel_output_load_integration_0/v3_four_channel_shared_support_integration_0/v3_four_channel_bias_reference_distribution_0/v3_four_channel_phase_distribution_0/v3_four_channel_output_collection_0/v3_four_channel_placement_0/v3_channel_selector_late_promotion_0/v3_selector_route_pilot_0/G2_MUX_NEG/a_76_199# VGND sky130_fd_pr__nfet_01v8 ad=0 pd=0 as=0.1995 ps=1.79 w=0.42 l=0.15
X1619 v3_four_channel_output_load_integration_0/v3_four_channel_shared_support_integration_0/v3_four_channel_bias_reference_distribution_0/v3_four_channel_phase_distribution_0/v3_four_channel_output_collection_0/v3_four_channel_placement_0/v3_channel_selector_late_promotion_0/v3_selector_route_pilot_0/G2_MUX_NEG/a_535_374# V3R293 v3_four_channel_output_load_integration_0/v3_four_channel_shared_support_integration_0/v3_four_channel_bias_reference_distribution_0/v3_four_channel_phase_distribution_0/v3_four_channel_output_collection_0/v3_four_channel_placement_0/v3_channel_selector_late_promotion_0/v3_selector_route_pilot_0/G2_MUX_NEG/a_76_199# VDPWR sky130_fd_pr__pfet_01v8_hvt ad=0 pd=0 as=0 ps=0 w=0.42 l=0.15
X1620 v3_four_channel_output_load_integration_0/v3_four_channel_shared_support_integration_0/v3_four_channel_bias_reference_distribution_0/v3_four_channel_phase_distribution_0/v3_four_channel_output_collection_0/v3_four_channel_placement_0/v3_channel_selector_late_promotion_0/v3_selector_route_pilot_0/G2_MUX_NEG/a_76_199# V3R293 v3_four_channel_output_load_integration_0/v3_four_channel_shared_support_integration_0/v3_four_channel_bias_reference_distribution_0/v3_four_channel_phase_distribution_0/v3_four_channel_output_collection_0/v3_four_channel_placement_0/v3_channel_selector_late_promotion_0/v3_selector_route_pilot_0/G2_MUX_NEG/a_218_47# VGND sky130_fd_pr__nfet_01v8 ad=0 pd=0 as=0.1386 ps=1.5 w=0.42 l=0.15
X1621 v3_four_channel_output_load_integration_0/v3_four_channel_shared_support_integration_0/v3_four_channel_bias_reference_distribution_0/v3_four_channel_phase_distribution_0/v3_four_channel_output_collection_0/v3_four_channel_placement_0/v3_channel_selector_late_promotion_0/v3_selector_route_pilot_0/G2_MUX_NEG/a_218_47# V3R226 VGND VGND sky130_fd_pr__nfet_01v8 ad=0 pd=0 as=0 ps=0 w=0.42 l=0.15
X1622 VDPWR v3_four_channel_output_load_integration_0/v3_four_channel_shared_support_integration_0/v3_four_channel_bias_reference_distribution_0/v3_four_channel_phase_distribution_0/v3_four_channel_output_collection_0/v3_four_channel_placement_0/v3_channel_selector_late_promotion_0/v3_selector_route_pilot_0/G2_MUX_NEG/a_76_199# v3_four_channel_output_load_integration_0/v3_four_channel_shared_support_integration_0/v3_four_channel_bias_reference_distribution_0/v3_four_channel_phase_distribution_0/v3_four_channel_output_collection_0/v3_four_channel_placement_0/v3_channel_selector_late_promotion_0/v3_selector_route_pilot_0/G2_MUX_NEG/X VDPWR sky130_fd_pr__pfet_01v8_hvt ad=0 pd=0 as=0.26 ps=2.52 w=1 l=0.15
X1623 VGND v3_four_channel_output_load_integration_0/v3_four_channel_shared_support_integration_0/v3_four_channel_bias_reference_distribution_0/v3_four_channel_phase_distribution_0/v3_four_channel_output_collection_0/v3_four_channel_placement_0/v3_channel_selector_late_promotion_0/v3_selector_route_pilot_0/G2_MUX_NEG/a_76_199# v3_four_channel_output_load_integration_0/v3_four_channel_shared_support_integration_0/v3_four_channel_bias_reference_distribution_0/v3_four_channel_phase_distribution_0/v3_four_channel_output_collection_0/v3_four_channel_placement_0/v3_channel_selector_late_promotion_0/v3_selector_route_pilot_0/G2_MUX_NEG/X VGND sky130_fd_pr__nfet_01v8 ad=0 pd=0 as=0.169 ps=1.82 w=0.65 l=0.15
X1624 VDPWR v3_four_channel_output_load_integration_0/v3_four_channel_shared_support_integration_0/v3_four_channel_bias_reference_distribution_0/v3_four_channel_phase_distribution_0/v3_four_channel_output_collection_0/v3_four_channel_placement_0/v3_channel_selector_late_promotion_0/v3_selector_route_pilot_0/G0_MUX_AXIS/a_505_21# v3_four_channel_output_load_integration_0/v3_four_channel_shared_support_integration_0/v3_four_channel_bias_reference_distribution_0/v3_four_channel_phase_distribution_0/v3_four_channel_output_collection_0/v3_four_channel_placement_0/v3_channel_selector_late_promotion_0/v3_selector_route_pilot_0/G0_MUX_AXIS/a_535_374# VDPWR sky130_fd_pr__pfet_01v8_hvt ad=0 pd=0 as=0.0882 ps=1.26 w=0.42 l=0.15
X1625 v3_four_channel_output_load_integration_0/v3_four_channel_shared_support_integration_0/v3_four_channel_bias_reference_distribution_0/v3_four_channel_phase_distribution_0/v3_four_channel_output_collection_0/v3_four_channel_placement_0/v3_channel_selector_late_promotion_0/v3_selector_route_pilot_0/G0_MUX_AXIS/a_505_21# V3R223 VDPWR VDPWR sky130_fd_pr__pfet_01v8_hvt ad=0.1176 pd=1.4 as=0 ps=0 w=0.42 l=0.15
X1626 v3_four_channel_output_load_integration_0/v3_four_channel_shared_support_integration_0/v3_four_channel_bias_reference_distribution_0/v3_four_channel_phase_distribution_0/v3_four_channel_output_collection_0/v3_four_channel_placement_0/v3_channel_selector_late_promotion_0/v3_selector_route_pilot_0/G0_MUX_AXIS/a_218_374# V3R223 VDPWR VDPWR sky130_fd_pr__pfet_01v8_hvt ad=0.1533 pd=1.57 as=0 ps=0 w=0.42 l=0.15
X1627 VGND v3_four_channel_output_load_integration_0/v3_four_channel_shared_support_integration_0/v3_four_channel_bias_reference_distribution_0/v3_four_channel_phase_distribution_0/v3_four_channel_output_collection_0/v3_four_channel_placement_0/v3_channel_selector_late_promotion_0/v3_selector_route_pilot_0/G0_MUX_AXIS/a_505_21# v3_four_channel_output_load_integration_0/v3_four_channel_shared_support_integration_0/v3_four_channel_bias_reference_distribution_0/v3_four_channel_phase_distribution_0/v3_four_channel_output_collection_0/v3_four_channel_placement_0/v3_channel_selector_late_promotion_0/v3_selector_route_pilot_0/G0_MUX_AXIS/a_439_47# VGND sky130_fd_pr__nfet_01v8 ad=0 pd=0 as=0.1386 ps=1.5 w=0.42 l=0.15
X1628 v3_four_channel_output_load_integration_0/v3_four_channel_shared_support_integration_0/v3_four_channel_bias_reference_distribution_0/v3_four_channel_phase_distribution_0/v3_four_channel_output_collection_0/v3_four_channel_placement_0/v3_channel_selector_late_promotion_0/v3_selector_route_pilot_0/G0_MUX_AXIS/a_76_199# v3_four_channel_output_load_integration_0/v3_four_channel_shared_support_integration_0/v3_four_channel_bias_reference_distribution_0/v3_four_channel_phase_distribution_0/v3_four_channel_output_collection_0/v3_four_channel_placement_0/v3_channel_selector_late_promotion_0/v3_selector_route_pilot_0/G0_MUX_POS/X v3_four_channel_output_load_integration_0/v3_four_channel_shared_support_integration_0/v3_four_channel_bias_reference_distribution_0/v3_four_channel_phase_distribution_0/v3_four_channel_output_collection_0/v3_four_channel_placement_0/v3_channel_selector_late_promotion_0/v3_selector_route_pilot_0/G0_MUX_AXIS/a_218_374# VDPWR sky130_fd_pr__pfet_01v8_hvt ad=0.3864 pd=2.68 as=0 ps=0 w=0.42 l=0.15
X1629 v3_four_channel_output_load_integration_0/v3_four_channel_shared_support_integration_0/v3_four_channel_bias_reference_distribution_0/v3_four_channel_phase_distribution_0/v3_four_channel_output_collection_0/v3_four_channel_placement_0/v3_channel_selector_late_promotion_0/v3_selector_route_pilot_0/G0_MUX_AXIS/a_505_21# V3R223 VGND VGND sky130_fd_pr__nfet_01v8 ad=0.1092 pd=1.36 as=0 ps=0 w=0.42 l=0.15
X1630 v3_four_channel_output_load_integration_0/v3_four_channel_shared_support_integration_0/v3_four_channel_bias_reference_distribution_0/v3_four_channel_phase_distribution_0/v3_four_channel_output_collection_0/v3_four_channel_placement_0/v3_channel_selector_late_promotion_0/v3_selector_route_pilot_0/G0_MUX_AXIS/a_439_47# v3_four_channel_output_load_integration_0/v3_four_channel_shared_support_integration_0/v3_four_channel_bias_reference_distribution_0/v3_four_channel_phase_distribution_0/v3_four_channel_output_collection_0/v3_four_channel_placement_0/v3_channel_selector_late_promotion_0/v3_selector_route_pilot_0/G0_MUX_POS/X v3_four_channel_output_load_integration_0/v3_four_channel_shared_support_integration_0/v3_four_channel_bias_reference_distribution_0/v3_four_channel_phase_distribution_0/v3_four_channel_output_collection_0/v3_four_channel_placement_0/v3_channel_selector_late_promotion_0/v3_selector_route_pilot_0/G0_MUX_AXIS/a_76_199# VGND sky130_fd_pr__nfet_01v8 ad=0 pd=0 as=0.1995 ps=1.79 w=0.42 l=0.15
X1631 v3_four_channel_output_load_integration_0/v3_four_channel_shared_support_integration_0/v3_four_channel_bias_reference_distribution_0/v3_four_channel_phase_distribution_0/v3_four_channel_output_collection_0/v3_four_channel_placement_0/v3_channel_selector_late_promotion_0/v3_selector_route_pilot_0/G0_MUX_AXIS/a_535_374# v3_four_channel_output_load_integration_0/v3_four_channel_shared_support_integration_0/v3_four_channel_bias_reference_distribution_0/v3_four_channel_phase_distribution_0/v3_four_channel_output_collection_0/v3_four_channel_placement_0/v3_channel_selector_late_promotion_0/v3_selector_route_pilot_0/G0_MUX_NEG/X v3_four_channel_output_load_integration_0/v3_four_channel_shared_support_integration_0/v3_four_channel_bias_reference_distribution_0/v3_four_channel_phase_distribution_0/v3_four_channel_output_collection_0/v3_four_channel_placement_0/v3_channel_selector_late_promotion_0/v3_selector_route_pilot_0/G0_MUX_AXIS/a_76_199# VDPWR sky130_fd_pr__pfet_01v8_hvt ad=0 pd=0 as=0 ps=0 w=0.42 l=0.15
X1632 v3_four_channel_output_load_integration_0/v3_four_channel_shared_support_integration_0/v3_four_channel_bias_reference_distribution_0/v3_four_channel_phase_distribution_0/v3_four_channel_output_collection_0/v3_four_channel_placement_0/v3_channel_selector_late_promotion_0/v3_selector_route_pilot_0/G0_MUX_AXIS/a_76_199# v3_four_channel_output_load_integration_0/v3_four_channel_shared_support_integration_0/v3_four_channel_bias_reference_distribution_0/v3_four_channel_phase_distribution_0/v3_four_channel_output_collection_0/v3_four_channel_placement_0/v3_channel_selector_late_promotion_0/v3_selector_route_pilot_0/G0_MUX_NEG/X v3_four_channel_output_load_integration_0/v3_four_channel_shared_support_integration_0/v3_four_channel_bias_reference_distribution_0/v3_four_channel_phase_distribution_0/v3_four_channel_output_collection_0/v3_four_channel_placement_0/v3_channel_selector_late_promotion_0/v3_selector_route_pilot_0/G0_MUX_AXIS/a_218_47# VGND sky130_fd_pr__nfet_01v8 ad=0 pd=0 as=0.1386 ps=1.5 w=0.42 l=0.15
X1633 v3_four_channel_output_load_integration_0/v3_four_channel_shared_support_integration_0/v3_four_channel_bias_reference_distribution_0/v3_four_channel_phase_distribution_0/v3_four_channel_output_collection_0/v3_four_channel_placement_0/v3_channel_selector_late_promotion_0/v3_selector_route_pilot_0/G0_MUX_AXIS/a_218_47# V3R223 VGND VGND sky130_fd_pr__nfet_01v8 ad=0 pd=0 as=0 ps=0 w=0.42 l=0.15
X1634 VDPWR v3_four_channel_output_load_integration_0/v3_four_channel_shared_support_integration_0/v3_four_channel_bias_reference_distribution_0/v3_four_channel_phase_distribution_0/v3_four_channel_output_collection_0/v3_four_channel_placement_0/v3_channel_selector_late_promotion_0/v3_selector_route_pilot_0/G0_MUX_AXIS/a_76_199# v3_four_channel_output_load_integration_0/v3_four_channel_shared_support_integration_0/v3_four_channel_bias_reference_distribution_0/v3_four_channel_phase_distribution_0/v3_four_channel_output_collection_0/v3_four_channel_placement_0/v3_channel_selector_late_promotion_0/v3_selector_route_pilot_0/G0_MUX_AXIS/X VDPWR sky130_fd_pr__pfet_01v8_hvt ad=0 pd=0 as=0.26 ps=2.52 w=1 l=0.15
X1635 VGND v3_four_channel_output_load_integration_0/v3_four_channel_shared_support_integration_0/v3_four_channel_bias_reference_distribution_0/v3_four_channel_phase_distribution_0/v3_four_channel_output_collection_0/v3_four_channel_placement_0/v3_channel_selector_late_promotion_0/v3_selector_route_pilot_0/G0_MUX_AXIS/a_76_199# v3_four_channel_output_load_integration_0/v3_four_channel_shared_support_integration_0/v3_four_channel_bias_reference_distribution_0/v3_four_channel_phase_distribution_0/v3_four_channel_output_collection_0/v3_four_channel_placement_0/v3_channel_selector_late_promotion_0/v3_selector_route_pilot_0/G0_MUX_AXIS/X VGND sky130_fd_pr__nfet_01v8 ad=0 pd=0 as=0.169 ps=1.82 w=0.65 l=0.15
X1636 VDPWR v3_four_channel_output_load_integration_0/v3_four_channel_shared_support_integration_0/v3_four_channel_bias_reference_distribution_0/v3_four_channel_phase_distribution_0/v3_four_channel_output_collection_0/v3_four_channel_placement_0/v3_channel_selector_late_promotion_0/v3_selector_route_pilot_0/G3_LO_P_AND/B v3_four_channel_output_load_integration_0/v3_four_channel_shared_support_integration_0/v3_four_channel_bias_reference_distribution_0/v3_four_channel_phase_distribution_0/v3_four_channel_output_collection_0/v3_four_channel_placement_0/v3_channel_selector_late_promotion_0/v3_selector_route_pilot_0/G2_LO_P_AND/a_59_75# VDPWR sky130_fd_pr__pfet_01v8_hvt ad=0 pd=0 as=0.1134 ps=1.38 w=0.42 l=0.15
X1637 v3_four_channel_output_load_integration_0/v3_four_channel_shared_support_integration_0/v3_four_channel_bias_reference_distribution_0/v3_four_channel_phase_distribution_0/v3_four_channel_output_collection_0/v3_four_channel_placement_0/v3_channel_selector_late_promotion_0/v3_selector_route_pilot_0/group2_lo_p v3_four_channel_output_load_integration_0/v3_four_channel_shared_support_integration_0/v3_four_channel_bias_reference_distribution_0/v3_four_channel_phase_distribution_0/v3_four_channel_output_collection_0/v3_four_channel_placement_0/v3_channel_selector_late_promotion_0/v3_selector_route_pilot_0/G2_LO_P_AND/a_59_75# VDPWR VDPWR sky130_fd_pr__pfet_01v8_hvt ad=0.475 pd=2.95 as=0 ps=0 w=1 l=0.15
X1638 VGND v3_four_channel_output_load_integration_0/v3_four_channel_shared_support_integration_0/v3_four_channel_bias_reference_distribution_0/v3_four_channel_phase_distribution_0/v3_four_channel_output_collection_0/v3_four_channel_placement_0/v3_channel_selector_late_promotion_0/v3_selector_route_pilot_0/G3_LO_P_AND/B v3_four_channel_output_load_integration_0/v3_four_channel_shared_support_integration_0/v3_four_channel_bias_reference_distribution_0/v3_four_channel_phase_distribution_0/v3_four_channel_output_collection_0/v3_four_channel_placement_0/v3_channel_selector_late_promotion_0/v3_selector_route_pilot_0/G2_LO_P_AND/a_145_75# VGND sky130_fd_pr__nfet_01v8 ad=0 pd=0 as=0.1134 ps=1.38 w=0.42 l=0.15
X1639 v3_four_channel_output_load_integration_0/v3_four_channel_shared_support_integration_0/v3_four_channel_bias_reference_distribution_0/v3_four_channel_phase_distribution_0/v3_four_channel_output_collection_0/v3_four_channel_placement_0/v3_channel_selector_late_promotion_0/v3_selector_route_pilot_0/G2_LO_P_AND/a_59_75# v3_four_channel_output_load_integration_0/v3_four_channel_shared_support_integration_0/v3_four_channel_bias_reference_distribution_0/v3_four_channel_phase_distribution_0/v3_four_channel_output_collection_0/v3_four_channel_placement_0/v3_channel_selector_late_promotion_0/v3_selector_route_pilot_0/G2_MUX_AXIS/X VDPWR VDPWR sky130_fd_pr__pfet_01v8_hvt ad=0 pd=0 as=0 ps=0 w=0.42 l=0.15
X1640 v3_four_channel_output_load_integration_0/v3_four_channel_shared_support_integration_0/v3_four_channel_bias_reference_distribution_0/v3_four_channel_phase_distribution_0/v3_four_channel_output_collection_0/v3_four_channel_placement_0/v3_channel_selector_late_promotion_0/v3_selector_route_pilot_0/group2_lo_p v3_four_channel_output_load_integration_0/v3_four_channel_shared_support_integration_0/v3_four_channel_bias_reference_distribution_0/v3_four_channel_phase_distribution_0/v3_four_channel_output_collection_0/v3_four_channel_placement_0/v3_channel_selector_late_promotion_0/v3_selector_route_pilot_0/G2_LO_P_AND/a_59_75# VGND VGND sky130_fd_pr__nfet_01v8 ad=0.182 pd=1.86 as=0 ps=0 w=0.65 l=0.15
X1641 v3_four_channel_output_load_integration_0/v3_four_channel_shared_support_integration_0/v3_four_channel_bias_reference_distribution_0/v3_four_channel_phase_distribution_0/v3_four_channel_output_collection_0/v3_four_channel_placement_0/v3_channel_selector_late_promotion_0/v3_selector_route_pilot_0/G2_LO_P_AND/a_145_75# v3_four_channel_output_load_integration_0/v3_four_channel_shared_support_integration_0/v3_four_channel_bias_reference_distribution_0/v3_four_channel_phase_distribution_0/v3_four_channel_output_collection_0/v3_four_channel_placement_0/v3_channel_selector_late_promotion_0/v3_selector_route_pilot_0/G2_MUX_AXIS/X v3_four_channel_output_load_integration_0/v3_four_channel_shared_support_integration_0/v3_four_channel_bias_reference_distribution_0/v3_four_channel_phase_distribution_0/v3_four_channel_output_collection_0/v3_four_channel_placement_0/v3_channel_selector_late_promotion_0/v3_selector_route_pilot_0/G2_LO_P_AND/a_59_75# VGND sky130_fd_pr__nfet_01v8 ad=0 pd=0 as=0.1176 ps=1.4 w=0.42 l=0.15
X1642 v3_four_channel_output_load_integration_0/v3_four_channel_shared_support_integration_0/v3_four_channel_bias_reference_distribution_0/v3_four_channel_phase_distribution_0/v3_four_channel_output_collection_0/v3_four_channel_placement_0/v3_channel_selector_late_promotion_1/v3_channel_input_bias_late_promotion_0/a_4678_23422# v3_four_channel_output_load_integration_0/v3_four_channel_shared_support_integration_0/v3_four_channel_bias_reference_distribution_0/v3_four_channel_phase_distribution_0/v3_four_channel_output_collection_0/v3_four_channel_placement_0/v3_channel_selector_late_promotion_1/v3_selector_route_pilot_0/group3_lo_p v3_four_channel_output_load_integration_0/combined_n VGND sky130_fd_pr__nfet_01v8 ad=0.6206 pd=6.02 as=22.62 ps=225.60001 w=0.65 l=0.15
X1643 v3_four_channel_output_load_integration_0/combined_n v3_four_channel_output_load_integration_0/v3_four_channel_shared_support_integration_0/v3_four_channel_bias_reference_distribution_0/v3_four_channel_phase_distribution_0/v3_four_channel_output_collection_0/v3_four_channel_placement_0/v3_channel_selector_late_promotion_1/v3_selector_route_pilot_0/group3_lo_p v3_four_channel_output_load_integration_0/v3_four_channel_shared_support_integration_0/v3_four_channel_bias_reference_distribution_0/v3_four_channel_phase_distribution_0/v3_four_channel_output_collection_0/v3_four_channel_placement_0/v3_channel_selector_late_promotion_1/v3_channel_input_bias_late_promotion_0/a_4254_6978# VGND sky130_fd_pr__nfet_01v8 ad=0 pd=0 as=0.6206 ps=6.02 w=0.65 l=0.15
X1644 v3_four_channel_output_load_integration_0/v3_four_channel_shared_support_integration_0/v3_four_channel_bias_reference_distribution_0/v3_four_channel_phase_distribution_0/v3_four_channel_output_collection_0/v3_four_channel_placement_0/v3_channel_selector_late_promotion_1/v3_channel_input_bias_late_promotion_0/a_4678_23422# v3_four_channel_output_load_integration_0/v3_four_channel_shared_support_integration_0/v3_vcm_support_block_0/ref v3_four_channel_output_load_integration_0/v3_four_channel_shared_support_integration_0/v3_four_channel_bias_reference_distribution_0/v3_four_channel_phase_distribution_0/v3_four_channel_output_collection_0/v3_four_channel_placement_0/v3_channel_selector_late_promotion_1/v3_channel_input_bias_late_promotion_0/a_4382_21688# VGND sky130_fd_pr__nfet_01v8 ad=0 pd=0 as=1.9575 ps=15.24 w=0.84 l=0.6
X1645 v3_four_channel_output_load_integration_0/combined_n v3_four_channel_output_load_integration_0/v3_four_channel_shared_support_integration_0/v3_four_channel_bias_reference_distribution_0/v3_four_channel_phase_distribution_0/v3_four_channel_output_collection_0/v3_four_channel_placement_0/v3_channel_selector_late_promotion_1/v3_selector_route_pilot_0/group3_lo_n v3_four_channel_output_load_integration_0/v3_four_channel_shared_support_integration_0/v3_four_channel_bias_reference_distribution_0/v3_four_channel_phase_distribution_0/v3_four_channel_output_collection_0/v3_four_channel_placement_0/v3_channel_selector_late_promotion_1/v3_channel_input_bias_late_promotion_0/a_7038_22978# VGND sky130_fd_pr__nfet_01v8 ad=0 pd=0 as=0.6206 ps=6.02 w=0.65 l=0.15
X1646 v3_four_channel_output_load_integration_0/combined_n v3_four_channel_output_load_integration_0/v3_four_channel_shared_support_integration_0/v3_four_channel_bias_reference_distribution_0/v3_four_channel_phase_distribution_0/v3_four_channel_output_collection_0/v3_four_channel_placement_0/v3_channel_selector_late_promotion_1/v3_selector_route_pilot_0/group3_lo_p v3_four_channel_output_load_integration_0/v3_four_channel_shared_support_integration_0/v3_four_channel_bias_reference_distribution_0/v3_four_channel_phase_distribution_0/v3_four_channel_output_collection_0/v3_four_channel_placement_0/v3_channel_selector_late_promotion_1/v3_channel_input_bias_late_promotion_0/a_7038_6978# VGND sky130_fd_pr__nfet_01v8 ad=0 pd=0 as=0.6206 ps=6.02 w=0.65 l=0.15
X1647 v3_four_channel_output_load_integration_0/v3_four_channel_shared_support_integration_0/v3_four_channel_bias_reference_distribution_0/v3_four_channel_phase_distribution_0/v3_four_channel_output_collection_0/v3_four_channel_placement_0/v3_channel_selector_late_promotion_1/v3_channel_input_bias_late_promotion_0/a_7462_11422# V3I002 v3_four_channel_output_load_integration_0/v3_four_channel_shared_support_integration_0/v3_four_channel_bias_reference_distribution_0/v3_four_channel_phase_distribution_0/v3_four_channel_output_collection_0/v3_four_channel_placement_0/v3_channel_selector_late_promotion_1/v3_channel_input_bias_late_promotion_0/a_7216_10978# VGND sky130_fd_pr__nfet_01v8 ad=0.6206 pd=6.02 as=1.9575 ps=15.24 w=0.84 l=0.6
X1648 v3_four_channel_output_load_integration_0/v3_four_channel_shared_support_integration_0/v3_four_channel_bias_reference_distribution_0/v3_four_channel_phase_distribution_0/v3_four_channel_output_collection_0/v3_four_channel_placement_0/v3_channel_selector_late_promotion_1/v3_channel_input_bias_late_promotion_0/a_7462_11422# v3_four_channel_output_load_integration_0/v3_four_channel_shared_support_integration_0/v3_four_channel_bias_reference_distribution_0/v3_four_channel_phase_distribution_0/v3_four_channel_output_collection_0/v3_four_channel_placement_0/v3_channel_selector_late_promotion_1/v3_selector_route_pilot_0/group2_lo_n v3_four_channel_output_load_integration_0/combined_n VGND sky130_fd_pr__nfet_01v8 ad=0 pd=0 as=0 ps=0 w=0.65 l=0.15
X1649 v3_four_channel_output_load_integration_0/v3_four_channel_shared_support_integration_0/v3_four_channel_bias_reference_distribution_0/v3_four_channel_phase_distribution_0/v3_four_channel_output_collection_0/v3_four_channel_placement_0/v3_channel_selector_late_promotion_1/v3_channel_input_bias_late_promotion_0/a_5774_21688# V3I002 v3_four_channel_output_load_integration_0/v3_four_channel_shared_support_integration_0/v3_four_channel_bias_reference_distribution_0/v3_four_channel_phase_distribution_0/v3_four_channel_output_collection_0/v3_four_channel_placement_0/v3_channel_selector_late_promotion_1/v3_channel_input_bias_late_promotion_0/a_5646_22978# VGND sky130_fd_pr__nfet_01v8 ad=1.9575 pd=15.24 as=0.6206 ps=6.02 w=0.84 l=0.6
X1650 VGND v3_four_channel_output_load_integration_0/v3_four_channel_shared_support_integration_0/v3_tail_bias_support_block_0/vbias v3_four_channel_output_load_integration_0/v3_four_channel_shared_support_integration_0/v3_four_channel_bias_reference_distribution_0/v3_four_channel_phase_distribution_0/v3_four_channel_output_collection_0/v3_four_channel_placement_0/v3_channel_selector_late_promotion_1/v3_channel_input_bias_late_promotion_0/a_5774_17688# VGND sky130_fd_pr__nfet_01v8 ad=0 pd=0 as=1.9575 ps=15.24 w=5.07 l=1
X1651 v3_four_channel_output_load_integration_0/v3_four_channel_shared_support_integration_0/v3_four_channel_bias_reference_distribution_0/v3_four_channel_phase_distribution_0/v3_four_channel_output_collection_0/v3_four_channel_placement_0/v3_channel_selector_late_promotion_1/v3_channel_input_bias_late_promotion_0/a_6070_7422# V3I002 v3_four_channel_output_load_integration_0/v3_four_channel_shared_support_integration_0/v3_four_channel_bias_reference_distribution_0/v3_four_channel_phase_distribution_0/v3_four_channel_output_collection_0/v3_four_channel_placement_0/v3_channel_selector_late_promotion_1/v3_channel_input_bias_late_promotion_0/a_5824_6978# VGND sky130_fd_pr__nfet_01v8 ad=0.6206 pd=6.02 as=1.9575 ps=15.24 w=0.84 l=0.6
X1652 v3_four_channel_output_load_integration_0/v3_four_channel_shared_support_integration_0/v3_four_channel_bias_reference_distribution_0/v3_four_channel_phase_distribution_0/v3_four_channel_output_collection_0/v3_four_channel_placement_0/v3_channel_selector_late_promotion_1/v3_channel_input_bias_late_promotion_0/a_6070_7422# v3_four_channel_output_load_integration_0/v3_four_channel_shared_support_integration_0/v3_four_channel_bias_reference_distribution_0/v3_four_channel_phase_distribution_0/v3_four_channel_output_collection_0/v3_four_channel_placement_0/v3_channel_selector_late_promotion_1/v3_selector_route_pilot_0/group3_lo_n v3_four_channel_output_load_integration_0/combined_n VGND sky130_fd_pr__nfet_01v8 ad=0 pd=0 as=0 ps=0 w=0.65 l=0.15
X1653 v3_four_channel_output_load_integration_0/v3_four_channel_shared_support_integration_0/v3_vcm_support_block_0/ref V3I002 VGND sky130_fd_pr__res_xhigh_po_0p35 l=17.36
X1654 v3_four_channel_output_load_integration_0/v3_four_channel_shared_support_integration_0/v3_four_channel_bias_reference_distribution_0/v3_four_channel_phase_distribution_0/v3_four_channel_output_collection_0/v3_four_channel_placement_0/v3_channel_selector_late_promotion_1/v3_channel_input_bias_late_promotion_0/a_7462_23422# v3_four_channel_output_load_integration_0/v3_four_channel_shared_support_integration_0/v3_vcm_support_block_0/ref v3_four_channel_output_load_integration_0/v3_four_channel_shared_support_integration_0/v3_four_channel_bias_reference_distribution_0/v3_four_channel_phase_distribution_0/v3_four_channel_output_collection_0/v3_four_channel_placement_0/v3_channel_selector_late_promotion_1/v3_channel_input_bias_late_promotion_0/a_7166_21688# VGND sky130_fd_pr__nfet_01v8 ad=0.6206 pd=6.02 as=1.9575 ps=15.24 w=0.84 l=0.6
X1655 v3_four_channel_output_load_integration_0/v3_four_channel_shared_support_integration_0/v3_four_channel_bias_reference_distribution_0/v3_four_channel_phase_distribution_0/v3_four_channel_output_collection_0/v3_four_channel_placement_0/v3_channel_selector_late_promotion_1/v3_channel_input_bias_late_promotion_0/a_7462_23422# v3_four_channel_output_load_integration_0/v3_four_channel_shared_support_integration_0/v3_four_channel_bias_reference_distribution_0/v3_four_channel_phase_distribution_0/v3_four_channel_output_collection_0/v3_four_channel_placement_0/v3_channel_selector_late_promotion_1/v3_selector_route_pilot_0/group3_lo_p v3_four_channel_output_load_integration_0/combined_n VGND sky130_fd_pr__nfet_01v8 ad=0 pd=0 as=0 ps=0 w=0.65 l=0.15
X1656 VGND v3_four_channel_output_load_integration_0/v3_four_channel_shared_support_integration_0/v3_tail_bias_support_block_0/vbias v3_four_channel_output_load_integration_0/v3_four_channel_shared_support_integration_0/v3_four_channel_bias_reference_distribution_0/v3_four_channel_phase_distribution_0/v3_four_channel_output_collection_0/v3_four_channel_placement_0/v3_channel_selector_late_promotion_1/v3_channel_input_bias_late_promotion_0/a_4382_21688# VGND sky130_fd_pr__nfet_01v8 ad=0 pd=0 as=0 ps=0 w=5.07 l=1
X1657 VGND v3_four_channel_output_load_integration_0/v3_four_channel_shared_support_integration_0/v3_tail_bias_support_block_0/vbias v3_four_channel_output_load_integration_0/v3_four_channel_shared_support_integration_0/v3_four_channel_bias_reference_distribution_0/v3_four_channel_phase_distribution_0/v3_four_channel_output_collection_0/v3_four_channel_placement_0/v3_channel_selector_late_promotion_1/v3_channel_input_bias_late_promotion_0/a_5774_13688# VGND sky130_fd_pr__nfet_01v8 ad=0 pd=0 as=1.9575 ps=15.24 w=5.07 l=1
X1658 VGND v3_four_channel_output_load_integration_0/v3_four_channel_shared_support_integration_0/v3_tail_bias_support_block_0/vbias v3_four_channel_output_load_integration_0/v3_four_channel_shared_support_integration_0/v3_four_channel_bias_reference_distribution_0/v3_four_channel_phase_distribution_0/v3_four_channel_output_collection_0/v3_four_channel_placement_0/v3_channel_selector_late_promotion_1/v3_channel_input_bias_late_promotion_0/a_7166_17688# VGND sky130_fd_pr__nfet_01v8 ad=0 pd=0 as=1.9575 ps=15.24 w=5.07 l=1
X1659 VGND VGND VGND VGND sky130_fd_pr__nfet_01v8 ad=0 pd=0 as=0 ps=0 w=0.65 l=0.15
X1660 v3_four_channel_output_load_integration_0/combined_p v3_four_channel_output_load_integration_0/v3_four_channel_shared_support_integration_0/v3_four_channel_bias_reference_distribution_0/v3_four_channel_phase_distribution_0/v3_four_channel_output_collection_0/v3_four_channel_placement_0/v3_channel_selector_late_promotion_1/v3_selector_route_pilot_0/group3_lo_p v3_four_channel_output_load_integration_0/v3_four_channel_shared_support_integration_0/v3_four_channel_bias_reference_distribution_0/v3_four_channel_phase_distribution_0/v3_four_channel_output_collection_0/v3_four_channel_placement_0/v3_channel_selector_late_promotion_1/v3_channel_input_bias_late_promotion_0/a_5646_18978# VGND sky130_fd_pr__nfet_01v8 ad=22.62 pd=225.60001 as=0.6206 ps=6.02 w=0.65 l=0.15
X1661 VGND VGND VGND VGND sky130_fd_pr__nfet_01v8 ad=0 pd=0 as=0 ps=0 w=0.65 l=0.15
X1662 v3_four_channel_output_load_integration_0/v3_four_channel_shared_support_integration_0/v3_four_channel_bias_reference_distribution_0/v3_four_channel_phase_distribution_0/v3_four_channel_output_collection_0/v3_four_channel_placement_0/v3_channel_selector_late_promotion_1/v3_channel_input_bias_late_promotion_0/a_6070_19422# v3_four_channel_output_load_integration_0/v3_four_channel_shared_support_integration_0/v3_four_channel_bias_reference_distribution_0/v3_four_channel_phase_distribution_0/v3_four_channel_output_collection_0/v3_four_channel_placement_0/v3_channel_selector_late_promotion_1/v3_selector_route_pilot_0/group3_lo_n v3_four_channel_output_load_integration_0/combined_p VGND sky130_fd_pr__nfet_01v8 ad=0.6206 pd=6.02 as=0 ps=0 w=0.65 l=0.15
X1663 VGND VGND VGND VGND sky130_fd_pr__nfet_01v8 ad=0 pd=0 as=0 ps=0 w=0.65 l=0.15
X1664 v3_four_channel_output_load_integration_0/combined_p v3_four_channel_output_load_integration_0/v3_four_channel_shared_support_integration_0/v3_four_channel_bias_reference_distribution_0/v3_four_channel_phase_distribution_0/v3_four_channel_output_collection_0/v3_four_channel_placement_0/v3_channel_selector_late_promotion_1/v3_selector_route_pilot_0/group2_lo_p v3_four_channel_output_load_integration_0/v3_four_channel_shared_support_integration_0/v3_four_channel_bias_reference_distribution_0/v3_four_channel_phase_distribution_0/v3_four_channel_output_collection_0/v3_four_channel_placement_0/v3_channel_selector_late_promotion_1/v3_channel_input_bias_late_promotion_0/a_4254_18978# VGND sky130_fd_pr__nfet_01v8 ad=0 pd=0 as=0.6206 ps=6.02 w=0.65 l=0.15
X1665 v3_four_channel_output_load_integration_0/v3_four_channel_shared_support_integration_0/v3_four_channel_bias_reference_distribution_0/v3_four_channel_phase_distribution_0/v3_four_channel_output_collection_0/v3_four_channel_placement_0/v3_channel_selector_late_promotion_1/v3_channel_input_bias_late_promotion_0/a_7216_14978# v3_four_channel_output_load_integration_0/v3_four_channel_shared_support_integration_0/v3_tail_bias_support_block_0/vbias VGND VGND sky130_fd_pr__nfet_01v8 ad=1.9575 pd=15.24 as=0 ps=0 w=5.07 l=1
X1666 VGND VGND VGND VGND sky130_fd_pr__nfet_01v8 ad=0 pd=0 as=0 ps=0 w=0.65 l=0.15
X1667 VGND VGND VGND VGND sky130_fd_pr__nfet_01v8 ad=0 pd=0 as=0 ps=0 w=0.65 l=0.15
X1668 v3_four_channel_output_load_integration_0/v3_four_channel_shared_support_integration_0/v3_four_channel_bias_reference_distribution_0/v3_four_channel_phase_distribution_0/v3_four_channel_output_collection_0/v3_four_channel_placement_0/v3_channel_selector_late_promotion_1/v3_channel_input_bias_late_promotion_0/a_4382_17688# V3I002 v3_four_channel_output_load_integration_0/v3_four_channel_shared_support_integration_0/v3_four_channel_bias_reference_distribution_0/v3_four_channel_phase_distribution_0/v3_four_channel_output_collection_0/v3_four_channel_placement_0/v3_channel_selector_late_promotion_1/v3_channel_input_bias_late_promotion_0/a_4254_18978# VGND sky130_fd_pr__nfet_01v8 ad=1.9575 pd=15.24 as=0 ps=0 w=0.84 l=0.6
X1669 v3_four_channel_output_load_integration_0/v3_four_channel_shared_support_integration_0/v3_four_channel_bias_reference_distribution_0/v3_four_channel_phase_distribution_0/v3_four_channel_output_collection_0/v3_four_channel_placement_0/v3_channel_selector_late_promotion_1/v3_channel_input_bias_late_promotion_0/a_4678_19422# v3_four_channel_output_load_integration_0/v3_four_channel_shared_support_integration_0/v3_four_channel_bias_reference_distribution_0/v3_four_channel_phase_distribution_0/v3_four_channel_output_collection_0/v3_four_channel_placement_0/v3_channel_selector_late_promotion_1/v3_selector_route_pilot_0/group2_lo_n v3_four_channel_output_load_integration_0/combined_p VGND sky130_fd_pr__nfet_01v8 ad=0.6206 pd=6.02 as=0 ps=0 w=0.65 l=0.15
X1670 v3_four_channel_output_load_integration_0/combined_p v3_four_channel_output_load_integration_0/v3_four_channel_shared_support_integration_0/v3_four_channel_bias_reference_distribution_0/v3_four_channel_phase_distribution_0/v3_four_channel_output_collection_0/v3_four_channel_placement_0/v3_channel_selector_late_promotion_1/v3_selector_route_pilot_0/group0_lo_p v3_four_channel_output_load_integration_0/v3_four_channel_shared_support_integration_0/v3_four_channel_bias_reference_distribution_0/v3_four_channel_phase_distribution_0/v3_four_channel_output_collection_0/v3_four_channel_placement_0/v3_channel_selector_late_promotion_1/v3_channel_input_bias_late_promotion_0/a_5646_14978# VGND sky130_fd_pr__nfet_01v8 ad=0 pd=0 as=0.6206 ps=6.02 w=0.65 l=0.15
X1671 v3_four_channel_output_load_integration_0/combined_p v3_four_channel_output_load_integration_0/v3_four_channel_shared_support_integration_0/v3_four_channel_bias_reference_distribution_0/v3_four_channel_phase_distribution_0/v3_four_channel_output_collection_0/v3_four_channel_placement_0/v3_channel_selector_late_promotion_1/v3_selector_route_pilot_0/group2_lo_p v3_four_channel_output_load_integration_0/v3_four_channel_shared_support_integration_0/v3_four_channel_bias_reference_distribution_0/v3_four_channel_phase_distribution_0/v3_four_channel_output_collection_0/v3_four_channel_placement_0/v3_channel_selector_late_promotion_1/v3_channel_input_bias_late_promotion_0/a_7038_18978# VGND sky130_fd_pr__nfet_01v8 ad=0 pd=0 as=0.6206 ps=6.02 w=0.65 l=0.15
X1672 VGND VGND VGND VGND sky130_fd_pr__nfet_01v8 ad=0 pd=0 as=0 ps=0 w=5.07 l=1
X1673 v3_four_channel_output_load_integration_0/v3_four_channel_shared_support_integration_0/v3_four_channel_bias_reference_distribution_0/v3_four_channel_phase_distribution_0/v3_four_channel_output_collection_0/v3_four_channel_placement_0/v3_channel_selector_late_promotion_1/v3_channel_input_bias_late_promotion_0/a_6070_15422# v3_four_channel_output_load_integration_0/v3_four_channel_shared_support_integration_0/v3_four_channel_bias_reference_distribution_0/v3_four_channel_phase_distribution_0/v3_four_channel_output_collection_0/v3_four_channel_placement_0/v3_channel_selector_late_promotion_1/v3_selector_route_pilot_0/group0_lo_n v3_four_channel_output_load_integration_0/combined_p VGND sky130_fd_pr__nfet_01v8 ad=0.6206 pd=6.02 as=0 ps=0 w=0.65 l=0.15
X1674 v3_four_channel_output_load_integration_0/v3_four_channel_shared_support_integration_0/v3_four_channel_bias_reference_distribution_0/v3_four_channel_phase_distribution_0/v3_four_channel_output_collection_0/v3_four_channel_placement_0/v3_channel_selector_late_promotion_1/v3_channel_input_bias_late_promotion_0/a_7166_17688# V3I002 v3_four_channel_output_load_integration_0/v3_four_channel_shared_support_integration_0/v3_four_channel_bias_reference_distribution_0/v3_four_channel_phase_distribution_0/v3_four_channel_output_collection_0/v3_four_channel_placement_0/v3_channel_selector_late_promotion_1/v3_channel_input_bias_late_promotion_0/a_7038_18978# VGND sky130_fd_pr__nfet_01v8 ad=0 pd=0 as=0 ps=0 w=0.84 l=0.6
X1675 v3_four_channel_output_load_integration_0/combined_n v3_four_channel_output_load_integration_0/v3_four_channel_shared_support_integration_0/v3_four_channel_bias_reference_distribution_0/v3_four_channel_phase_distribution_0/v3_four_channel_output_collection_0/v3_four_channel_placement_0/v3_channel_selector_late_promotion_1/v3_selector_route_pilot_0/group3_lo_n v3_four_channel_output_load_integration_0/v3_four_channel_shared_support_integration_0/v3_four_channel_bias_reference_distribution_0/v3_four_channel_phase_distribution_0/v3_four_channel_output_collection_0/v3_four_channel_placement_0/v3_channel_selector_late_promotion_1/v3_channel_input_bias_late_promotion_0/a_5646_18978# VGND sky130_fd_pr__nfet_01v8 ad=0 pd=0 as=0 ps=0 w=0.65 l=0.15
X1676 VGND v3_four_channel_output_load_integration_0/v3_four_channel_shared_support_integration_0/v3_tail_bias_support_block_0/vbias v3_four_channel_output_load_integration_0/v3_four_channel_shared_support_integration_0/v3_four_channel_bias_reference_distribution_0/v3_four_channel_phase_distribution_0/v3_four_channel_output_collection_0/v3_four_channel_placement_0/v3_channel_selector_late_promotion_1/v3_channel_input_bias_late_promotion_0/a_5774_21688# VGND sky130_fd_pr__nfet_01v8 ad=0 pd=0 as=0 ps=0 w=5.07 l=1
X1677 v3_four_channel_output_load_integration_0/v3_four_channel_shared_support_integration_0/v3_four_channel_bias_reference_distribution_0/v3_four_channel_phase_distribution_0/v3_four_channel_output_collection_0/v3_four_channel_placement_0/v3_channel_selector_late_promotion_1/v3_channel_input_bias_late_promotion_0/a_6070_19422# v3_four_channel_output_load_integration_0/v3_four_channel_shared_support_integration_0/v3_vcm_support_block_0/ref v3_four_channel_output_load_integration_0/v3_four_channel_shared_support_integration_0/v3_four_channel_bias_reference_distribution_0/v3_four_channel_phase_distribution_0/v3_four_channel_output_collection_0/v3_four_channel_placement_0/v3_channel_selector_late_promotion_1/v3_channel_input_bias_late_promotion_0/a_5774_17688# VGND sky130_fd_pr__nfet_01v8 ad=0 pd=0 as=0 ps=0 w=0.84 l=0.6
X1678 VGND VGND VGND VGND sky130_fd_pr__nfet_01v8 ad=0 pd=0 as=0 ps=0 w=5.07 l=1
X1679 v3_four_channel_output_load_integration_0/combined_p v3_four_channel_output_load_integration_0/v3_four_channel_shared_support_integration_0/v3_four_channel_bias_reference_distribution_0/v3_four_channel_phase_distribution_0/v3_four_channel_output_collection_0/v3_four_channel_placement_0/v3_channel_selector_late_promotion_1/v3_selector_route_pilot_0/group1_lo_p v3_four_channel_output_load_integration_0/v3_four_channel_shared_support_integration_0/v3_four_channel_bias_reference_distribution_0/v3_four_channel_phase_distribution_0/v3_four_channel_output_collection_0/v3_four_channel_placement_0/v3_channel_selector_late_promotion_1/v3_channel_input_bias_late_promotion_0/a_4254_14978# VGND sky130_fd_pr__nfet_01v8 ad=0 pd=0 as=0.6206 ps=6.02 w=0.65 l=0.15
X1680 v3_four_channel_output_load_integration_0/v3_four_channel_shared_support_integration_0/v3_four_channel_bias_reference_distribution_0/v3_four_channel_phase_distribution_0/v3_four_channel_output_collection_0/v3_four_channel_placement_0/v3_channel_selector_late_promotion_1/v3_channel_input_bias_late_promotion_0/a_6070_19422# v3_four_channel_output_load_integration_0/v3_four_channel_shared_support_integration_0/v3_four_channel_bias_reference_distribution_0/v3_four_channel_phase_distribution_0/v3_four_channel_output_collection_0/v3_four_channel_placement_0/v3_channel_selector_late_promotion_1/v3_selector_route_pilot_0/group3_lo_p v3_four_channel_output_load_integration_0/combined_n VGND sky130_fd_pr__nfet_01v8 ad=0 pd=0 as=0 ps=0 w=0.65 l=0.15
X1681 VGND VGND VGND VGND sky130_fd_pr__nfet_01v8 ad=0 pd=0 as=0 ps=0 w=0.65 l=0.15
X1682 v3_four_channel_output_load_integration_0/v3_four_channel_shared_support_integration_0/v3_four_channel_bias_reference_distribution_0/v3_four_channel_phase_distribution_0/v3_four_channel_output_collection_0/v3_four_channel_placement_0/v3_channel_selector_late_promotion_1/v3_channel_input_bias_late_promotion_0/a_5824_10978# v3_four_channel_output_load_integration_0/v3_four_channel_shared_support_integration_0/v3_tail_bias_support_block_0/vbias VGND VGND sky130_fd_pr__nfet_01v8 ad=1.9575 pd=15.24 as=0 ps=0 w=5.07 l=1
X1683 v3_four_channel_output_load_integration_0/v3_four_channel_shared_support_integration_0/v3_four_channel_bias_reference_distribution_0/v3_four_channel_phase_distribution_0/v3_four_channel_output_collection_0/v3_four_channel_placement_0/v3_channel_selector_late_promotion_1/v3_channel_input_bias_late_promotion_0/a_4382_13688# V3I002 v3_four_channel_output_load_integration_0/v3_four_channel_shared_support_integration_0/v3_four_channel_bias_reference_distribution_0/v3_four_channel_phase_distribution_0/v3_four_channel_output_collection_0/v3_four_channel_placement_0/v3_channel_selector_late_promotion_1/v3_channel_input_bias_late_promotion_0/a_4254_14978# VGND sky130_fd_pr__nfet_01v8 ad=1.9575 pd=15.24 as=0 ps=0 w=0.84 l=0.6
X1684 v3_four_channel_output_load_integration_0/v3_four_channel_shared_support_integration_0/v3_four_channel_bias_reference_distribution_0/v3_four_channel_phase_distribution_0/v3_four_channel_output_collection_0/v3_four_channel_placement_0/v3_channel_selector_late_promotion_1/v3_channel_input_bias_late_promotion_0/a_4678_15422# v3_four_channel_output_load_integration_0/v3_four_channel_shared_support_integration_0/v3_four_channel_bias_reference_distribution_0/v3_four_channel_phase_distribution_0/v3_four_channel_output_collection_0/v3_four_channel_placement_0/v3_channel_selector_late_promotion_1/v3_selector_route_pilot_0/group1_lo_n v3_four_channel_output_load_integration_0/combined_p VGND sky130_fd_pr__nfet_01v8 ad=0.6206 pd=6.02 as=0 ps=0 w=0.65 l=0.15
X1685 v3_four_channel_output_load_integration_0/combined_n v3_four_channel_output_load_integration_0/v3_four_channel_shared_support_integration_0/v3_four_channel_bias_reference_distribution_0/v3_four_channel_phase_distribution_0/v3_four_channel_output_collection_0/v3_four_channel_placement_0/v3_channel_selector_late_promotion_1/v3_selector_route_pilot_0/group2_lo_n v3_four_channel_output_load_integration_0/v3_four_channel_shared_support_integration_0/v3_four_channel_bias_reference_distribution_0/v3_four_channel_phase_distribution_0/v3_four_channel_output_collection_0/v3_four_channel_placement_0/v3_channel_selector_late_promotion_1/v3_channel_input_bias_late_promotion_0/a_4254_18978# VGND sky130_fd_pr__nfet_01v8 ad=0 pd=0 as=0 ps=0 w=0.65 l=0.15
X1686 v3_four_channel_output_load_integration_0/combined_p v3_four_channel_output_load_integration_0/v3_four_channel_shared_support_integration_0/v3_four_channel_bias_reference_distribution_0/v3_four_channel_phase_distribution_0/v3_four_channel_output_collection_0/v3_four_channel_placement_0/v3_channel_selector_late_promotion_1/v3_selector_route_pilot_0/group3_lo_n v3_four_channel_output_load_integration_0/v3_four_channel_shared_support_integration_0/v3_four_channel_bias_reference_distribution_0/v3_four_channel_phase_distribution_0/v3_four_channel_output_collection_0/v3_four_channel_placement_0/v3_channel_selector_late_promotion_1/v3_channel_input_bias_late_promotion_0/a_5646_10978# VGND sky130_fd_pr__nfet_01v8 ad=0 pd=0 as=0.6206 ps=6.02 w=0.65 l=0.15
X1687 v3_four_channel_output_load_integration_0/combined_p v3_four_channel_output_load_integration_0/v3_four_channel_shared_support_integration_0/v3_four_channel_bias_reference_distribution_0/v3_four_channel_phase_distribution_0/v3_four_channel_output_collection_0/v3_four_channel_placement_0/v3_channel_selector_late_promotion_1/v3_selector_route_pilot_0/group1_lo_n v3_four_channel_output_load_integration_0/v3_four_channel_shared_support_integration_0/v3_four_channel_bias_reference_distribution_0/v3_four_channel_phase_distribution_0/v3_four_channel_output_collection_0/v3_four_channel_placement_0/v3_channel_selector_late_promotion_1/v3_channel_input_bias_late_promotion_0/a_7038_14978# VGND sky130_fd_pr__nfet_01v8 ad=0 pd=0 as=0.6206 ps=6.02 w=0.65 l=0.15
X1688 v3_four_channel_output_load_integration_0/v3_four_channel_shared_support_integration_0/v3_four_channel_bias_reference_distribution_0/v3_four_channel_phase_distribution_0/v3_four_channel_output_collection_0/v3_four_channel_placement_0/v3_channel_selector_late_promotion_1/v3_channel_input_bias_late_promotion_0/a_7462_19422# v3_four_channel_output_load_integration_0/v3_four_channel_shared_support_integration_0/v3_four_channel_bias_reference_distribution_0/v3_four_channel_phase_distribution_0/v3_four_channel_output_collection_0/v3_four_channel_placement_0/v3_channel_selector_late_promotion_1/v3_selector_route_pilot_0/group2_lo_n v3_four_channel_output_load_integration_0/combined_p VGND sky130_fd_pr__nfet_01v8 ad=0.6206 pd=6.02 as=0 ps=0 w=0.65 l=0.15
X1689 v3_four_channel_output_load_integration_0/v3_four_channel_shared_support_integration_0/v3_four_channel_bias_reference_distribution_0/v3_four_channel_phase_distribution_0/v3_four_channel_output_collection_0/v3_four_channel_placement_0/v3_channel_selector_late_promotion_1/v3_channel_input_bias_late_promotion_0/a_4678_7422# v3_four_channel_output_load_integration_0/v3_four_channel_shared_support_integration_0/v3_four_channel_bias_reference_distribution_0/v3_four_channel_phase_distribution_0/v3_four_channel_output_collection_0/v3_four_channel_placement_0/v3_channel_selector_late_promotion_1/v3_selector_route_pilot_0/group3_lo_p v3_four_channel_output_load_integration_0/combined_p VGND sky130_fd_pr__nfet_01v8 ad=0.6206 pd=6.02 as=0 ps=0 w=0.65 l=0.15
X1690 v3_four_channel_output_load_integration_0/v3_four_channel_shared_support_integration_0/v3_four_channel_bias_reference_distribution_0/v3_four_channel_phase_distribution_0/v3_four_channel_output_collection_0/v3_four_channel_placement_0/v3_channel_selector_late_promotion_1/v3_channel_input_bias_late_promotion_0/a_6070_11422# v3_four_channel_output_load_integration_0/v3_four_channel_shared_support_integration_0/v3_four_channel_bias_reference_distribution_0/v3_four_channel_phase_distribution_0/v3_four_channel_output_collection_0/v3_four_channel_placement_0/v3_channel_selector_late_promotion_1/v3_selector_route_pilot_0/group3_lo_p v3_four_channel_output_load_integration_0/combined_p VGND sky130_fd_pr__nfet_01v8 ad=0.6206 pd=6.02 as=0 ps=0 w=0.65 l=0.15
X1691 v3_four_channel_output_load_integration_0/v3_four_channel_shared_support_integration_0/v3_four_channel_bias_reference_distribution_0/v3_four_channel_phase_distribution_0/v3_four_channel_output_collection_0/v3_four_channel_placement_0/v3_channel_selector_late_promotion_1/v3_channel_input_bias_late_promotion_0/a_7216_10978# v3_four_channel_output_load_integration_0/v3_four_channel_shared_support_integration_0/v3_tail_bias_support_block_0/vbias VGND VGND sky130_fd_pr__nfet_01v8 ad=0 pd=0 as=0 ps=0 w=5.07 l=1
X1692 v3_four_channel_output_load_integration_0/v3_four_channel_shared_support_integration_0/v3_four_channel_bias_reference_distribution_0/v3_four_channel_phase_distribution_0/v3_four_channel_output_collection_0/v3_four_channel_placement_0/v3_channel_selector_late_promotion_1/v3_channel_input_bias_late_promotion_0/a_7216_14978# v3_four_channel_output_load_integration_0/v3_four_channel_shared_support_integration_0/v3_vcm_support_block_0/ref v3_four_channel_output_load_integration_0/v3_four_channel_shared_support_integration_0/v3_four_channel_bias_reference_distribution_0/v3_four_channel_phase_distribution_0/v3_four_channel_output_collection_0/v3_four_channel_placement_0/v3_channel_selector_late_promotion_1/v3_channel_input_bias_late_promotion_0/a_7038_14978# VGND sky130_fd_pr__nfet_01v8 ad=0 pd=0 as=0 ps=0 w=0.84 l=0.6
X1693 v3_four_channel_output_load_integration_0/v3_four_channel_shared_support_integration_0/v3_four_channel_bias_reference_distribution_0/v3_four_channel_phase_distribution_0/v3_four_channel_output_collection_0/v3_four_channel_placement_0/v3_channel_selector_late_promotion_1/v3_channel_input_bias_late_promotion_0/a_4678_19422# v3_four_channel_output_load_integration_0/v3_four_channel_shared_support_integration_0/v3_vcm_support_block_0/ref v3_four_channel_output_load_integration_0/v3_four_channel_shared_support_integration_0/v3_four_channel_bias_reference_distribution_0/v3_four_channel_phase_distribution_0/v3_four_channel_output_collection_0/v3_four_channel_placement_0/v3_channel_selector_late_promotion_1/v3_channel_input_bias_late_promotion_0/a_4382_17688# VGND sky130_fd_pr__nfet_01v8 ad=0 pd=0 as=0 ps=0 w=0.84 l=0.6
X1694 v3_four_channel_output_load_integration_0/v3_four_channel_shared_support_integration_0/v3_four_channel_bias_reference_distribution_0/v3_four_channel_phase_distribution_0/v3_four_channel_output_collection_0/v3_four_channel_placement_0/v3_channel_selector_late_promotion_1/v3_channel_input_bias_late_promotion_0/a_4678_19422# v3_four_channel_output_load_integration_0/v3_four_channel_shared_support_integration_0/v3_four_channel_bias_reference_distribution_0/v3_four_channel_phase_distribution_0/v3_four_channel_output_collection_0/v3_four_channel_placement_0/v3_channel_selector_late_promotion_1/v3_selector_route_pilot_0/group2_lo_p v3_four_channel_output_load_integration_0/combined_n VGND sky130_fd_pr__nfet_01v8 ad=0 pd=0 as=0 ps=0 w=0.65 l=0.15
X1695 v3_four_channel_output_load_integration_0/combined_n v3_four_channel_output_load_integration_0/v3_four_channel_shared_support_integration_0/v3_four_channel_bias_reference_distribution_0/v3_four_channel_phase_distribution_0/v3_four_channel_output_collection_0/v3_four_channel_placement_0/v3_channel_selector_late_promotion_1/v3_selector_route_pilot_0/group0_lo_n v3_four_channel_output_load_integration_0/v3_four_channel_shared_support_integration_0/v3_four_channel_bias_reference_distribution_0/v3_four_channel_phase_distribution_0/v3_four_channel_output_collection_0/v3_four_channel_placement_0/v3_channel_selector_late_promotion_1/v3_channel_input_bias_late_promotion_0/a_5646_14978# VGND sky130_fd_pr__nfet_01v8 ad=0 pd=0 as=0 ps=0 w=0.65 l=0.15
X1696 v3_four_channel_output_load_integration_0/combined_n v3_four_channel_output_load_integration_0/v3_four_channel_shared_support_integration_0/v3_four_channel_bias_reference_distribution_0/v3_four_channel_phase_distribution_0/v3_four_channel_output_collection_0/v3_four_channel_placement_0/v3_channel_selector_late_promotion_1/v3_selector_route_pilot_0/group2_lo_n v3_four_channel_output_load_integration_0/v3_four_channel_shared_support_integration_0/v3_four_channel_bias_reference_distribution_0/v3_four_channel_phase_distribution_0/v3_four_channel_output_collection_0/v3_four_channel_placement_0/v3_channel_selector_late_promotion_1/v3_channel_input_bias_late_promotion_0/a_7038_18978# VGND sky130_fd_pr__nfet_01v8 ad=0 pd=0 as=0 ps=0 w=0.65 l=0.15
X1697 v3_four_channel_output_load_integration_0/v3_four_channel_shared_support_integration_0/v3_four_channel_bias_reference_distribution_0/v3_four_channel_phase_distribution_0/v3_four_channel_output_collection_0/v3_four_channel_placement_0/v3_channel_selector_late_promotion_1/v3_channel_input_bias_late_promotion_0/a_7462_7422# v3_four_channel_output_load_integration_0/v3_four_channel_shared_support_integration_0/v3_four_channel_bias_reference_distribution_0/v3_four_channel_phase_distribution_0/v3_four_channel_output_collection_0/v3_four_channel_placement_0/v3_channel_selector_late_promotion_1/v3_selector_route_pilot_0/group3_lo_p v3_four_channel_output_load_integration_0/combined_p VGND sky130_fd_pr__nfet_01v8 ad=0.6206 pd=6.02 as=0 ps=0 w=0.65 l=0.15
X1698 VGND v3_four_channel_output_load_integration_0/v3_four_channel_shared_support_integration_0/v3_tail_bias_support_block_0/vbias v3_four_channel_output_load_integration_0/v3_four_channel_shared_support_integration_0/v3_four_channel_bias_reference_distribution_0/v3_four_channel_phase_distribution_0/v3_four_channel_output_collection_0/v3_four_channel_placement_0/v3_channel_selector_late_promotion_1/v3_channel_input_bias_late_promotion_0/a_7166_21688# VGND sky130_fd_pr__nfet_01v8 ad=0 pd=0 as=0 ps=0 w=5.07 l=1
X1699 v3_four_channel_output_load_integration_0/v3_four_channel_shared_support_integration_0/v3_four_channel_bias_reference_distribution_0/v3_four_channel_phase_distribution_0/v3_four_channel_output_collection_0/v3_four_channel_placement_0/v3_channel_selector_late_promotion_1/v3_channel_input_bias_late_promotion_0/a_6070_15422# v3_four_channel_output_load_integration_0/v3_four_channel_shared_support_integration_0/v3_vcm_support_block_0/ref v3_four_channel_output_load_integration_0/v3_four_channel_shared_support_integration_0/v3_four_channel_bias_reference_distribution_0/v3_four_channel_phase_distribution_0/v3_four_channel_output_collection_0/v3_four_channel_placement_0/v3_channel_selector_late_promotion_1/v3_channel_input_bias_late_promotion_0/a_5774_13688# VGND sky130_fd_pr__nfet_01v8 ad=0 pd=0 as=0 ps=0 w=0.84 l=0.6
X1700 v3_four_channel_output_load_integration_0/combined_p v3_four_channel_output_load_integration_0/v3_four_channel_shared_support_integration_0/v3_four_channel_bias_reference_distribution_0/v3_four_channel_phase_distribution_0/v3_four_channel_output_collection_0/v3_four_channel_placement_0/v3_channel_selector_late_promotion_1/v3_selector_route_pilot_0/group2_lo_n v3_four_channel_output_load_integration_0/v3_four_channel_shared_support_integration_0/v3_four_channel_bias_reference_distribution_0/v3_four_channel_phase_distribution_0/v3_four_channel_output_collection_0/v3_four_channel_placement_0/v3_channel_selector_late_promotion_1/v3_channel_input_bias_late_promotion_0/a_4254_10978# VGND sky130_fd_pr__nfet_01v8 ad=0 pd=0 as=0.6206 ps=6.02 w=0.65 l=0.15
X1701 v3_four_channel_output_load_integration_0/v3_four_channel_shared_support_integration_0/v3_four_channel_bias_reference_distribution_0/v3_four_channel_phase_distribution_0/v3_four_channel_output_collection_0/v3_four_channel_placement_0/v3_channel_selector_late_promotion_1/v3_channel_input_bias_late_promotion_0/a_6070_15422# v3_four_channel_output_load_integration_0/v3_four_channel_shared_support_integration_0/v3_four_channel_bias_reference_distribution_0/v3_four_channel_phase_distribution_0/v3_four_channel_output_collection_0/v3_four_channel_placement_0/v3_channel_selector_late_promotion_1/v3_selector_route_pilot_0/group0_lo_p v3_four_channel_output_load_integration_0/combined_n VGND sky130_fd_pr__nfet_01v8 ad=0 pd=0 as=0 ps=0 w=0.65 l=0.15
X1702 v3_four_channel_output_load_integration_0/v3_four_channel_shared_support_integration_0/v3_four_channel_bias_reference_distribution_0/v3_four_channel_phase_distribution_0/v3_four_channel_output_collection_0/v3_four_channel_placement_0/v3_channel_selector_late_promotion_1/v3_channel_input_bias_late_promotion_0/a_5824_6978# v3_four_channel_output_load_integration_0/v3_four_channel_shared_support_integration_0/v3_vcm_support_block_0/ref v3_four_channel_output_load_integration_0/v3_four_channel_shared_support_integration_0/v3_four_channel_bias_reference_distribution_0/v3_four_channel_phase_distribution_0/v3_four_channel_output_collection_0/v3_four_channel_placement_0/v3_channel_selector_late_promotion_1/v3_channel_input_bias_late_promotion_0/a_5646_6978# VGND sky130_fd_pr__nfet_01v8 ad=0 pd=0 as=0.6206 ps=6.02 w=0.84 l=0.6
X1703 v3_four_channel_output_load_integration_0/v3_four_channel_shared_support_integration_0/v3_four_channel_bias_reference_distribution_0/v3_four_channel_phase_distribution_0/v3_four_channel_output_collection_0/v3_four_channel_placement_0/v3_channel_selector_late_promotion_1/v3_channel_input_bias_late_promotion_0/a_5774_17688# V3I002 v3_four_channel_output_load_integration_0/v3_four_channel_shared_support_integration_0/v3_four_channel_bias_reference_distribution_0/v3_four_channel_phase_distribution_0/v3_four_channel_output_collection_0/v3_four_channel_placement_0/v3_channel_selector_late_promotion_1/v3_channel_input_bias_late_promotion_0/a_5646_18978# VGND sky130_fd_pr__nfet_01v8 ad=0 pd=0 as=0 ps=0 w=0.84 l=0.6
X1704 v3_four_channel_output_load_integration_0/combined_p v3_four_channel_output_load_integration_0/v3_four_channel_shared_support_integration_0/v3_four_channel_bias_reference_distribution_0/v3_four_channel_phase_distribution_0/v3_four_channel_output_collection_0/v3_four_channel_placement_0/v3_channel_selector_late_promotion_1/v3_selector_route_pilot_0/group3_lo_p v3_four_channel_output_load_integration_0/v3_four_channel_shared_support_integration_0/v3_four_channel_bias_reference_distribution_0/v3_four_channel_phase_distribution_0/v3_four_channel_output_collection_0/v3_four_channel_placement_0/v3_channel_selector_late_promotion_1/v3_channel_input_bias_late_promotion_0/a_5646_22978# VGND sky130_fd_pr__nfet_01v8 ad=0 pd=0 as=0 ps=0 w=0.65 l=0.15
X1705 v3_four_channel_output_load_integration_0/v3_four_channel_shared_support_integration_0/v3_four_channel_bias_reference_distribution_0/v3_four_channel_phase_distribution_0/v3_four_channel_output_collection_0/v3_four_channel_placement_0/v3_channel_selector_late_promotion_1/v3_channel_input_bias_late_promotion_0/a_5824_6978# v3_four_channel_output_load_integration_0/v3_four_channel_shared_support_integration_0/v3_tail_bias_support_block_0/vbias VGND VGND sky130_fd_pr__nfet_01v8 ad=0 pd=0 as=0 ps=0 w=5.07 l=1
X1706 v3_four_channel_output_load_integration_0/v3_four_channel_shared_support_integration_0/v3_four_channel_bias_reference_distribution_0/v3_four_channel_phase_distribution_0/v3_four_channel_output_collection_0/v3_four_channel_placement_0/v3_channel_selector_late_promotion_1/v3_channel_input_bias_late_promotion_0/a_4432_10978# v3_four_channel_output_load_integration_0/v3_four_channel_shared_support_integration_0/v3_vcm_support_block_0/ref v3_four_channel_output_load_integration_0/v3_four_channel_shared_support_integration_0/v3_four_channel_bias_reference_distribution_0/v3_four_channel_phase_distribution_0/v3_four_channel_output_collection_0/v3_four_channel_placement_0/v3_channel_selector_late_promotion_1/v3_channel_input_bias_late_promotion_0/a_4254_10978# VGND sky130_fd_pr__nfet_01v8 ad=1.9575 pd=15.24 as=0 ps=0 w=0.84 l=0.6
X1707 v3_four_channel_output_load_integration_0/v3_four_channel_shared_support_integration_0/v3_four_channel_bias_reference_distribution_0/v3_four_channel_phase_distribution_0/v3_four_channel_output_collection_0/v3_four_channel_placement_0/v3_channel_selector_late_promotion_1/v3_channel_input_bias_late_promotion_0/a_4678_11422# v3_four_channel_output_load_integration_0/v3_four_channel_shared_support_integration_0/v3_four_channel_bias_reference_distribution_0/v3_four_channel_phase_distribution_0/v3_four_channel_output_collection_0/v3_four_channel_placement_0/v3_channel_selector_late_promotion_1/v3_selector_route_pilot_0/group2_lo_p v3_four_channel_output_load_integration_0/combined_p VGND sky130_fd_pr__nfet_01v8 ad=0.6206 pd=6.02 as=0 ps=0 w=0.65 l=0.15
X1708 v3_four_channel_output_load_integration_0/v3_four_channel_shared_support_integration_0/v3_four_channel_bias_reference_distribution_0/v3_four_channel_phase_distribution_0/v3_four_channel_output_collection_0/v3_four_channel_placement_0/v3_channel_selector_late_promotion_1/v3_channel_input_bias_late_promotion_0/a_6070_23422# v3_four_channel_output_load_integration_0/v3_four_channel_shared_support_integration_0/v3_four_channel_bias_reference_distribution_0/v3_four_channel_phase_distribution_0/v3_four_channel_output_collection_0/v3_four_channel_placement_0/v3_channel_selector_late_promotion_1/v3_selector_route_pilot_0/group3_lo_n v3_four_channel_output_load_integration_0/combined_p VGND sky130_fd_pr__nfet_01v8 ad=0.6206 pd=6.02 as=0 ps=0 w=0.65 l=0.15
X1709 v3_four_channel_output_load_integration_0/combined_n v3_four_channel_output_load_integration_0/v3_four_channel_shared_support_integration_0/v3_four_channel_bias_reference_distribution_0/v3_four_channel_phase_distribution_0/v3_four_channel_output_collection_0/v3_four_channel_placement_0/v3_channel_selector_late_promotion_1/v3_selector_route_pilot_0/group1_lo_n v3_four_channel_output_load_integration_0/v3_four_channel_shared_support_integration_0/v3_four_channel_bias_reference_distribution_0/v3_four_channel_phase_distribution_0/v3_four_channel_output_collection_0/v3_four_channel_placement_0/v3_channel_selector_late_promotion_1/v3_channel_input_bias_late_promotion_0/a_4254_14978# VGND sky130_fd_pr__nfet_01v8 ad=0 pd=0 as=0 ps=0 w=0.65 l=0.15
X1710 v3_four_channel_output_load_integration_0/combined_p v3_four_channel_output_load_integration_0/v3_four_channel_shared_support_integration_0/v3_four_channel_bias_reference_distribution_0/v3_four_channel_phase_distribution_0/v3_four_channel_output_collection_0/v3_four_channel_placement_0/v3_channel_selector_late_promotion_1/v3_selector_route_pilot_0/group2_lo_n v3_four_channel_output_load_integration_0/v3_four_channel_shared_support_integration_0/v3_four_channel_bias_reference_distribution_0/v3_four_channel_phase_distribution_0/v3_four_channel_output_collection_0/v3_four_channel_placement_0/v3_channel_selector_late_promotion_1/v3_channel_input_bias_late_promotion_0/a_7038_10978# VGND sky130_fd_pr__nfet_01v8 ad=0 pd=0 as=0.6206 ps=6.02 w=0.65 l=0.15
X1711 v3_four_channel_output_load_integration_0/v3_four_channel_shared_support_integration_0/v3_four_channel_bias_reference_distribution_0/v3_four_channel_phase_distribution_0/v3_four_channel_output_collection_0/v3_four_channel_placement_0/v3_channel_selector_late_promotion_1/v3_channel_input_bias_late_promotion_0/a_7462_15422# v3_four_channel_output_load_integration_0/v3_four_channel_shared_support_integration_0/v3_four_channel_bias_reference_distribution_0/v3_four_channel_phase_distribution_0/v3_four_channel_output_collection_0/v3_four_channel_placement_0/v3_channel_selector_late_promotion_1/v3_selector_route_pilot_0/group1_lo_p v3_four_channel_output_load_integration_0/combined_p VGND sky130_fd_pr__nfet_01v8 ad=0.6206 pd=6.02 as=0 ps=0 w=0.65 l=0.15
X1712 VGND VGND VGND VGND sky130_fd_pr__nfet_01v8 ad=0 pd=0 as=0 ps=0 w=5.07 l=1
X1713 v3_four_channel_output_load_integration_0/v3_four_channel_shared_support_integration_0/v3_four_channel_bias_reference_distribution_0/v3_four_channel_phase_distribution_0/v3_four_channel_output_collection_0/v3_four_channel_placement_0/v3_channel_selector_late_promotion_1/v3_channel_input_bias_late_promotion_0/a_7216_6978# v3_four_channel_output_load_integration_0/v3_four_channel_shared_support_integration_0/v3_tail_bias_support_block_0/vbias VGND VGND sky130_fd_pr__nfet_01v8 ad=1.9575 pd=15.24 as=0 ps=0 w=5.07 l=1
X1714 v3_four_channel_output_load_integration_0/v3_four_channel_shared_support_integration_0/v3_four_channel_bias_reference_distribution_0/v3_four_channel_phase_distribution_0/v3_four_channel_output_collection_0/v3_four_channel_placement_0/v3_channel_selector_late_promotion_1/v3_channel_input_bias_late_promotion_0/a_7216_10978# v3_four_channel_output_load_integration_0/v3_four_channel_shared_support_integration_0/v3_vcm_support_block_0/ref v3_four_channel_output_load_integration_0/v3_four_channel_shared_support_integration_0/v3_four_channel_bias_reference_distribution_0/v3_four_channel_phase_distribution_0/v3_four_channel_output_collection_0/v3_four_channel_placement_0/v3_channel_selector_late_promotion_1/v3_channel_input_bias_late_promotion_0/a_7038_10978# VGND sky130_fd_pr__nfet_01v8 ad=0 pd=0 as=0 ps=0 w=0.84 l=0.6
X1715 v3_four_channel_output_load_integration_0/v3_four_channel_shared_support_integration_0/v3_four_channel_bias_reference_distribution_0/v3_four_channel_phase_distribution_0/v3_four_channel_output_collection_0/v3_four_channel_placement_0/v3_channel_selector_late_promotion_1/v3_channel_input_bias_late_promotion_0/a_4678_15422# v3_four_channel_output_load_integration_0/v3_four_channel_shared_support_integration_0/v3_vcm_support_block_0/ref v3_four_channel_output_load_integration_0/v3_four_channel_shared_support_integration_0/v3_four_channel_bias_reference_distribution_0/v3_four_channel_phase_distribution_0/v3_four_channel_output_collection_0/v3_four_channel_placement_0/v3_channel_selector_late_promotion_1/v3_channel_input_bias_late_promotion_0/a_4382_13688# VGND sky130_fd_pr__nfet_01v8 ad=0 pd=0 as=0 ps=0 w=0.84 l=0.6
X1716 v3_four_channel_output_load_integration_0/v3_four_channel_shared_support_integration_0/v3_four_channel_bias_reference_distribution_0/v3_four_channel_phase_distribution_0/v3_four_channel_output_collection_0/v3_four_channel_placement_0/v3_channel_selector_late_promotion_1/v3_channel_input_bias_late_promotion_0/a_4678_15422# v3_four_channel_output_load_integration_0/v3_four_channel_shared_support_integration_0/v3_four_channel_bias_reference_distribution_0/v3_four_channel_phase_distribution_0/v3_four_channel_output_collection_0/v3_four_channel_placement_0/v3_channel_selector_late_promotion_1/v3_selector_route_pilot_0/group1_lo_p v3_four_channel_output_load_integration_0/combined_n VGND sky130_fd_pr__nfet_01v8 ad=0 pd=0 as=0 ps=0 w=0.65 l=0.15
X1717 v3_four_channel_output_load_integration_0/combined_p v3_four_channel_output_load_integration_0/v3_four_channel_shared_support_integration_0/v3_four_channel_bias_reference_distribution_0/v3_four_channel_phase_distribution_0/v3_four_channel_output_collection_0/v3_four_channel_placement_0/v3_channel_selector_late_promotion_1/v3_selector_route_pilot_0/group3_lo_p v3_four_channel_output_load_integration_0/v3_four_channel_shared_support_integration_0/v3_four_channel_bias_reference_distribution_0/v3_four_channel_phase_distribution_0/v3_four_channel_output_collection_0/v3_four_channel_placement_0/v3_channel_selector_late_promotion_1/v3_channel_input_bias_late_promotion_0/a_4254_22978# VGND sky130_fd_pr__nfet_01v8 ad=0 pd=0 as=0.6206 ps=6.02 w=0.65 l=0.15
X1718 v3_four_channel_output_load_integration_0/v3_four_channel_shared_support_integration_0/v3_four_channel_bias_reference_distribution_0/v3_four_channel_phase_distribution_0/v3_four_channel_output_collection_0/v3_four_channel_placement_0/v3_channel_selector_late_promotion_1/v3_channel_input_bias_late_promotion_0/a_7462_19422# v3_four_channel_output_load_integration_0/v3_four_channel_shared_support_integration_0/v3_vcm_support_block_0/ref v3_four_channel_output_load_integration_0/v3_four_channel_shared_support_integration_0/v3_four_channel_bias_reference_distribution_0/v3_four_channel_phase_distribution_0/v3_four_channel_output_collection_0/v3_four_channel_placement_0/v3_channel_selector_late_promotion_1/v3_channel_input_bias_late_promotion_0/a_7166_17688# VGND sky130_fd_pr__nfet_01v8 ad=0 pd=0 as=0 ps=0 w=0.84 l=0.6
X1719 v3_four_channel_output_load_integration_0/combined_n v3_four_channel_output_load_integration_0/v3_four_channel_shared_support_integration_0/v3_four_channel_bias_reference_distribution_0/v3_four_channel_phase_distribution_0/v3_four_channel_output_collection_0/v3_four_channel_placement_0/v3_channel_selector_late_promotion_1/v3_selector_route_pilot_0/group3_lo_p v3_four_channel_output_load_integration_0/v3_four_channel_shared_support_integration_0/v3_four_channel_bias_reference_distribution_0/v3_four_channel_phase_distribution_0/v3_four_channel_output_collection_0/v3_four_channel_placement_0/v3_channel_selector_late_promotion_1/v3_channel_input_bias_late_promotion_0/a_5646_10978# VGND sky130_fd_pr__nfet_01v8 ad=0 pd=0 as=0 ps=0 w=0.65 l=0.15
X1720 v3_four_channel_output_load_integration_0/combined_n v3_four_channel_output_load_integration_0/v3_four_channel_shared_support_integration_0/v3_four_channel_bias_reference_distribution_0/v3_four_channel_phase_distribution_0/v3_four_channel_output_collection_0/v3_four_channel_placement_0/v3_channel_selector_late_promotion_1/v3_selector_route_pilot_0/group1_lo_p v3_four_channel_output_load_integration_0/v3_four_channel_shared_support_integration_0/v3_four_channel_bias_reference_distribution_0/v3_four_channel_phase_distribution_0/v3_four_channel_output_collection_0/v3_four_channel_placement_0/v3_channel_selector_late_promotion_1/v3_channel_input_bias_late_promotion_0/a_7038_14978# VGND sky130_fd_pr__nfet_01v8 ad=0 pd=0 as=0 ps=0 w=0.65 l=0.15
X1721 v3_four_channel_output_load_integration_0/v3_four_channel_shared_support_integration_0/v3_four_channel_bias_reference_distribution_0/v3_four_channel_phase_distribution_0/v3_four_channel_output_collection_0/v3_four_channel_placement_0/v3_channel_selector_late_promotion_1/v3_channel_input_bias_late_promotion_0/a_7462_19422# v3_four_channel_output_load_integration_0/v3_four_channel_shared_support_integration_0/v3_four_channel_bias_reference_distribution_0/v3_four_channel_phase_distribution_0/v3_four_channel_output_collection_0/v3_four_channel_placement_0/v3_channel_selector_late_promotion_1/v3_selector_route_pilot_0/group2_lo_p v3_four_channel_output_load_integration_0/combined_n VGND sky130_fd_pr__nfet_01v8 ad=0 pd=0 as=0 ps=0 w=0.65 l=0.15
X1722 v3_four_channel_output_load_integration_0/v3_four_channel_shared_support_integration_0/v3_four_channel_bias_reference_distribution_0/v3_four_channel_phase_distribution_0/v3_four_channel_output_collection_0/v3_four_channel_placement_0/v3_channel_selector_late_promotion_1/v3_channel_input_bias_late_promotion_0/a_4678_7422# V3I002 v3_four_channel_output_load_integration_0/v3_four_channel_shared_support_integration_0/v3_four_channel_bias_reference_distribution_0/v3_four_channel_phase_distribution_0/v3_four_channel_output_collection_0/v3_four_channel_placement_0/v3_channel_selector_late_promotion_1/v3_channel_input_bias_late_promotion_0/a_4432_6978# VGND sky130_fd_pr__nfet_01v8 ad=0 pd=0 as=1.9575 ps=15.24 w=0.84 l=0.6
X1723 v3_four_channel_output_load_integration_0/combined_p v3_four_channel_output_load_integration_0/v3_four_channel_shared_support_integration_0/v3_four_channel_bias_reference_distribution_0/v3_four_channel_phase_distribution_0/v3_four_channel_output_collection_0/v3_four_channel_placement_0/v3_channel_selector_late_promotion_1/v3_selector_route_pilot_0/group3_lo_n v3_four_channel_output_load_integration_0/v3_four_channel_shared_support_integration_0/v3_four_channel_bias_reference_distribution_0/v3_four_channel_phase_distribution_0/v3_four_channel_output_collection_0/v3_four_channel_placement_0/v3_channel_selector_late_promotion_1/v3_channel_input_bias_late_promotion_0/a_5646_6978# VGND sky130_fd_pr__nfet_01v8 ad=0 pd=0 as=0 ps=0 w=0.65 l=0.15
X1724 v3_four_channel_output_load_integration_0/v3_four_channel_shared_support_integration_0/v3_four_channel_bias_reference_distribution_0/v3_four_channel_phase_distribution_0/v3_four_channel_output_collection_0/v3_four_channel_placement_0/v3_channel_selector_late_promotion_1/v3_channel_input_bias_late_promotion_0/a_4678_7422# v3_four_channel_output_load_integration_0/v3_four_channel_shared_support_integration_0/v3_four_channel_bias_reference_distribution_0/v3_four_channel_phase_distribution_0/v3_four_channel_output_collection_0/v3_four_channel_placement_0/v3_channel_selector_late_promotion_1/v3_selector_route_pilot_0/group3_lo_n v3_four_channel_output_load_integration_0/combined_n VGND sky130_fd_pr__nfet_01v8 ad=0 pd=0 as=0 ps=0 w=0.65 l=0.15
X1725 v3_four_channel_output_load_integration_0/v3_four_channel_shared_support_integration_0/v3_four_channel_bias_reference_distribution_0/v3_four_channel_phase_distribution_0/v3_four_channel_output_collection_0/v3_four_channel_placement_0/v3_channel_selector_late_promotion_1/v3_channel_input_bias_late_promotion_0/a_6070_11422# V3I002 v3_four_channel_output_load_integration_0/v3_four_channel_shared_support_integration_0/v3_four_channel_bias_reference_distribution_0/v3_four_channel_phase_distribution_0/v3_four_channel_output_collection_0/v3_four_channel_placement_0/v3_channel_selector_late_promotion_1/v3_channel_input_bias_late_promotion_0/a_5824_10978# VGND sky130_fd_pr__nfet_01v8 ad=0 pd=0 as=0 ps=0 w=0.84 l=0.6
X1726 v3_four_channel_output_load_integration_0/v3_four_channel_shared_support_integration_0/v3_four_channel_bias_reference_distribution_0/v3_four_channel_phase_distribution_0/v3_four_channel_output_collection_0/v3_four_channel_placement_0/v3_channel_selector_late_promotion_1/v3_channel_input_bias_late_promotion_0/a_6070_11422# v3_four_channel_output_load_integration_0/v3_four_channel_shared_support_integration_0/v3_four_channel_bias_reference_distribution_0/v3_four_channel_phase_distribution_0/v3_four_channel_output_collection_0/v3_four_channel_placement_0/v3_channel_selector_late_promotion_1/v3_selector_route_pilot_0/group3_lo_n v3_four_channel_output_load_integration_0/combined_n VGND sky130_fd_pr__nfet_01v8 ad=0 pd=0 as=0 ps=0 w=0.65 l=0.15
X1727 v3_four_channel_output_load_integration_0/v3_four_channel_shared_support_integration_0/v3_four_channel_bias_reference_distribution_0/v3_four_channel_phase_distribution_0/v3_four_channel_output_collection_0/v3_four_channel_placement_0/v3_channel_selector_late_promotion_1/v3_channel_input_bias_late_promotion_0/a_4382_21688# V3I002 v3_four_channel_output_load_integration_0/v3_four_channel_shared_support_integration_0/v3_four_channel_bias_reference_distribution_0/v3_four_channel_phase_distribution_0/v3_four_channel_output_collection_0/v3_four_channel_placement_0/v3_channel_selector_late_promotion_1/v3_channel_input_bias_late_promotion_0/a_4254_22978# VGND sky130_fd_pr__nfet_01v8 ad=0 pd=0 as=0 ps=0 w=0.84 l=0.6
X1728 v3_four_channel_output_load_integration_0/v3_four_channel_shared_support_integration_0/v3_four_channel_bias_reference_distribution_0/v3_four_channel_phase_distribution_0/v3_four_channel_output_collection_0/v3_four_channel_placement_0/v3_channel_selector_late_promotion_1/v3_channel_input_bias_late_promotion_0/a_4678_23422# v3_four_channel_output_load_integration_0/v3_four_channel_shared_support_integration_0/v3_four_channel_bias_reference_distribution_0/v3_four_channel_phase_distribution_0/v3_four_channel_output_collection_0/v3_four_channel_placement_0/v3_channel_selector_late_promotion_1/v3_selector_route_pilot_0/group3_lo_n v3_four_channel_output_load_integration_0/combined_p VGND sky130_fd_pr__nfet_01v8 ad=0 pd=0 as=0 ps=0 w=0.65 l=0.15
X1729 v3_four_channel_output_load_integration_0/combined_p v3_four_channel_output_load_integration_0/v3_four_channel_shared_support_integration_0/v3_four_channel_bias_reference_distribution_0/v3_four_channel_phase_distribution_0/v3_four_channel_output_collection_0/v3_four_channel_placement_0/v3_channel_selector_late_promotion_1/v3_selector_route_pilot_0/group3_lo_n v3_four_channel_output_load_integration_0/v3_four_channel_shared_support_integration_0/v3_four_channel_bias_reference_distribution_0/v3_four_channel_phase_distribution_0/v3_four_channel_output_collection_0/v3_four_channel_placement_0/v3_channel_selector_late_promotion_1/v3_channel_input_bias_late_promotion_0/a_4254_6978# VGND sky130_fd_pr__nfet_01v8 ad=0 pd=0 as=0 ps=0 w=0.65 l=0.15
X1730 v3_four_channel_output_load_integration_0/v3_four_channel_shared_support_integration_0/v3_four_channel_bias_reference_distribution_0/v3_four_channel_phase_distribution_0/v3_four_channel_output_collection_0/v3_four_channel_placement_0/v3_channel_selector_late_promotion_1/v3_channel_input_bias_late_promotion_0/a_5774_13688# V3I002 v3_four_channel_output_load_integration_0/v3_four_channel_shared_support_integration_0/v3_four_channel_bias_reference_distribution_0/v3_four_channel_phase_distribution_0/v3_four_channel_output_collection_0/v3_four_channel_placement_0/v3_channel_selector_late_promotion_1/v3_channel_input_bias_late_promotion_0/a_5646_14978# VGND sky130_fd_pr__nfet_01v8 ad=0 pd=0 as=0 ps=0 w=0.84 l=0.6
X1731 v3_four_channel_output_load_integration_0/combined_p v3_four_channel_output_load_integration_0/v3_four_channel_shared_support_integration_0/v3_four_channel_bias_reference_distribution_0/v3_four_channel_phase_distribution_0/v3_four_channel_output_collection_0/v3_four_channel_placement_0/v3_channel_selector_late_promotion_1/v3_selector_route_pilot_0/group3_lo_p v3_four_channel_output_load_integration_0/v3_four_channel_shared_support_integration_0/v3_four_channel_bias_reference_distribution_0/v3_four_channel_phase_distribution_0/v3_four_channel_output_collection_0/v3_four_channel_placement_0/v3_channel_selector_late_promotion_1/v3_channel_input_bias_late_promotion_0/a_7038_22978# VGND sky130_fd_pr__nfet_01v8 ad=0 pd=0 as=0 ps=0 w=0.65 l=0.15
X1732 v3_four_channel_output_load_integration_0/v3_four_channel_shared_support_integration_0/v3_four_channel_bias_reference_distribution_0/v3_four_channel_phase_distribution_0/v3_four_channel_output_collection_0/v3_four_channel_placement_0/v3_channel_selector_late_promotion_1/v3_channel_input_bias_late_promotion_0/a_7462_7422# V3I002 v3_four_channel_output_load_integration_0/v3_four_channel_shared_support_integration_0/v3_four_channel_bias_reference_distribution_0/v3_four_channel_phase_distribution_0/v3_four_channel_output_collection_0/v3_four_channel_placement_0/v3_channel_selector_late_promotion_1/v3_channel_input_bias_late_promotion_0/a_7216_6978# VGND sky130_fd_pr__nfet_01v8 ad=0 pd=0 as=0 ps=0 w=0.84 l=0.6
X1733 v3_four_channel_output_load_integration_0/v3_four_channel_shared_support_integration_0/v3_four_channel_bias_reference_distribution_0/v3_four_channel_phase_distribution_0/v3_four_channel_output_collection_0/v3_four_channel_placement_0/v3_channel_selector_late_promotion_1/v3_channel_input_bias_late_promotion_0/a_4432_10978# v3_four_channel_output_load_integration_0/v3_four_channel_shared_support_integration_0/v3_tail_bias_support_block_0/vbias VGND VGND sky130_fd_pr__nfet_01v8 ad=0 pd=0 as=0 ps=0 w=5.07 l=1
X1734 v3_four_channel_output_load_integration_0/v3_four_channel_shared_support_integration_0/v3_four_channel_bias_reference_distribution_0/v3_four_channel_phase_distribution_0/v3_four_channel_output_collection_0/v3_four_channel_placement_0/v3_channel_selector_late_promotion_1/v3_channel_input_bias_late_promotion_0/a_7462_7422# v3_four_channel_output_load_integration_0/v3_four_channel_shared_support_integration_0/v3_four_channel_bias_reference_distribution_0/v3_four_channel_phase_distribution_0/v3_four_channel_output_collection_0/v3_four_channel_placement_0/v3_channel_selector_late_promotion_1/v3_selector_route_pilot_0/group3_lo_n v3_four_channel_output_load_integration_0/combined_n VGND sky130_fd_pr__nfet_01v8 ad=0 pd=0 as=0 ps=0 w=0.65 l=0.15
X1735 VGND v3_four_channel_output_load_integration_0/v3_four_channel_shared_support_integration_0/v3_tail_bias_support_block_0/vbias v3_four_channel_output_load_integration_0/v3_four_channel_shared_support_integration_0/v3_four_channel_bias_reference_distribution_0/v3_four_channel_phase_distribution_0/v3_four_channel_output_collection_0/v3_four_channel_placement_0/v3_channel_selector_late_promotion_1/v3_channel_input_bias_late_promotion_0/a_4382_17688# VGND sky130_fd_pr__nfet_01v8 ad=0 pd=0 as=0 ps=0 w=5.07 l=1
X1736 v3_four_channel_output_load_integration_0/combined_p v3_four_channel_output_load_integration_0/v3_four_channel_shared_support_integration_0/v3_four_channel_bias_reference_distribution_0/v3_four_channel_phase_distribution_0/v3_four_channel_output_collection_0/v3_four_channel_placement_0/v3_channel_selector_late_promotion_1/v3_selector_route_pilot_0/group3_lo_n v3_four_channel_output_load_integration_0/v3_four_channel_shared_support_integration_0/v3_four_channel_bias_reference_distribution_0/v3_four_channel_phase_distribution_0/v3_four_channel_output_collection_0/v3_four_channel_placement_0/v3_channel_selector_late_promotion_1/v3_channel_input_bias_late_promotion_0/a_7038_6978# VGND sky130_fd_pr__nfet_01v8 ad=0 pd=0 as=0 ps=0 w=0.65 l=0.15
X1737 v3_four_channel_output_load_integration_0/combined_n v3_four_channel_output_load_integration_0/v3_four_channel_shared_support_integration_0/v3_four_channel_bias_reference_distribution_0/v3_four_channel_phase_distribution_0/v3_four_channel_output_collection_0/v3_four_channel_placement_0/v3_channel_selector_late_promotion_1/v3_selector_route_pilot_0/group2_lo_p v3_four_channel_output_load_integration_0/v3_four_channel_shared_support_integration_0/v3_four_channel_bias_reference_distribution_0/v3_four_channel_phase_distribution_0/v3_four_channel_output_collection_0/v3_four_channel_placement_0/v3_channel_selector_late_promotion_1/v3_channel_input_bias_late_promotion_0/a_4254_10978# VGND sky130_fd_pr__nfet_01v8 ad=0 pd=0 as=0 ps=0 w=0.65 l=0.15
X1738 v3_four_channel_output_load_integration_0/v3_four_channel_shared_support_integration_0/v3_four_channel_bias_reference_distribution_0/v3_four_channel_phase_distribution_0/v3_four_channel_output_collection_0/v3_four_channel_placement_0/v3_channel_selector_late_promotion_1/v3_channel_input_bias_late_promotion_0/a_7462_11422# v3_four_channel_output_load_integration_0/v3_four_channel_shared_support_integration_0/v3_four_channel_bias_reference_distribution_0/v3_four_channel_phase_distribution_0/v3_four_channel_output_collection_0/v3_four_channel_placement_0/v3_channel_selector_late_promotion_1/v3_selector_route_pilot_0/group2_lo_p v3_four_channel_output_load_integration_0/combined_p VGND sky130_fd_pr__nfet_01v8 ad=0 pd=0 as=0 ps=0 w=0.65 l=0.15
X1739 v3_four_channel_output_load_integration_0/v3_four_channel_shared_support_integration_0/v3_four_channel_bias_reference_distribution_0/v3_four_channel_phase_distribution_0/v3_four_channel_output_collection_0/v3_four_channel_placement_0/v3_channel_selector_late_promotion_1/v3_channel_input_bias_late_promotion_0/a_7166_21688# V3I002 v3_four_channel_output_load_integration_0/v3_four_channel_shared_support_integration_0/v3_four_channel_bias_reference_distribution_0/v3_four_channel_phase_distribution_0/v3_four_channel_output_collection_0/v3_four_channel_placement_0/v3_channel_selector_late_promotion_1/v3_channel_input_bias_late_promotion_0/a_7038_22978# VGND sky130_fd_pr__nfet_01v8 ad=0 pd=0 as=0 ps=0 w=0.84 l=0.6
X1740 v3_four_channel_output_load_integration_0/combined_n v3_four_channel_output_load_integration_0/v3_four_channel_shared_support_integration_0/v3_four_channel_bias_reference_distribution_0/v3_four_channel_phase_distribution_0/v3_four_channel_output_collection_0/v3_four_channel_placement_0/v3_channel_selector_late_promotion_1/v3_selector_route_pilot_0/group3_lo_n v3_four_channel_output_load_integration_0/v3_four_channel_shared_support_integration_0/v3_four_channel_bias_reference_distribution_0/v3_four_channel_phase_distribution_0/v3_four_channel_output_collection_0/v3_four_channel_placement_0/v3_channel_selector_late_promotion_1/v3_channel_input_bias_late_promotion_0/a_5646_22978# VGND sky130_fd_pr__nfet_01v8 ad=0 pd=0 as=0 ps=0 w=0.65 l=0.15
X1741 v3_four_channel_output_load_integration_0/v3_four_channel_shared_support_integration_0/v3_four_channel_bias_reference_distribution_0/v3_four_channel_phase_distribution_0/v3_four_channel_output_collection_0/v3_four_channel_placement_0/v3_channel_selector_late_promotion_1/v3_channel_input_bias_late_promotion_0/a_4678_11422# V3I002 v3_four_channel_output_load_integration_0/v3_four_channel_shared_support_integration_0/v3_four_channel_bias_reference_distribution_0/v3_four_channel_phase_distribution_0/v3_four_channel_output_collection_0/v3_four_channel_placement_0/v3_channel_selector_late_promotion_1/v3_channel_input_bias_late_promotion_0/a_4432_10978# VGND sky130_fd_pr__nfet_01v8 ad=0 pd=0 as=0 ps=0 w=0.84 l=0.6
X1742 v3_four_channel_output_load_integration_0/v3_four_channel_shared_support_integration_0/v3_four_channel_bias_reference_distribution_0/v3_four_channel_phase_distribution_0/v3_four_channel_output_collection_0/v3_four_channel_placement_0/v3_channel_selector_late_promotion_1/v3_channel_input_bias_late_promotion_0/a_6070_23422# v3_four_channel_output_load_integration_0/v3_four_channel_shared_support_integration_0/v3_vcm_support_block_0/ref v3_four_channel_output_load_integration_0/v3_four_channel_shared_support_integration_0/v3_four_channel_bias_reference_distribution_0/v3_four_channel_phase_distribution_0/v3_four_channel_output_collection_0/v3_four_channel_placement_0/v3_channel_selector_late_promotion_1/v3_channel_input_bias_late_promotion_0/a_5774_21688# VGND sky130_fd_pr__nfet_01v8 ad=0 pd=0 as=0 ps=0 w=0.84 l=0.6
X1743 v3_four_channel_output_load_integration_0/v3_four_channel_shared_support_integration_0/v3_four_channel_bias_reference_distribution_0/v3_four_channel_phase_distribution_0/v3_four_channel_output_collection_0/v3_four_channel_placement_0/v3_channel_selector_late_promotion_1/v3_channel_input_bias_late_promotion_0/a_6070_23422# v3_four_channel_output_load_integration_0/v3_four_channel_shared_support_integration_0/v3_four_channel_bias_reference_distribution_0/v3_four_channel_phase_distribution_0/v3_four_channel_output_collection_0/v3_four_channel_placement_0/v3_channel_selector_late_promotion_1/v3_selector_route_pilot_0/group3_lo_p v3_four_channel_output_load_integration_0/combined_n VGND sky130_fd_pr__nfet_01v8 ad=0 pd=0 as=0 ps=0 w=0.65 l=0.15
X1744 v3_four_channel_output_load_integration_0/v3_four_channel_shared_support_integration_0/v3_four_channel_bias_reference_distribution_0/v3_four_channel_phase_distribution_0/v3_four_channel_output_collection_0/v3_four_channel_placement_0/v3_channel_selector_late_promotion_1/v3_channel_input_bias_late_promotion_0/a_4678_11422# v3_four_channel_output_load_integration_0/v3_four_channel_shared_support_integration_0/v3_four_channel_bias_reference_distribution_0/v3_four_channel_phase_distribution_0/v3_four_channel_output_collection_0/v3_four_channel_placement_0/v3_channel_selector_late_promotion_1/v3_selector_route_pilot_0/group2_lo_n v3_four_channel_output_load_integration_0/combined_n VGND sky130_fd_pr__nfet_01v8 ad=0 pd=0 as=0 ps=0 w=0.65 l=0.15
X1745 v3_four_channel_output_load_integration_0/v3_four_channel_shared_support_integration_0/v3_four_channel_bias_reference_distribution_0/v3_four_channel_phase_distribution_0/v3_four_channel_output_collection_0/v3_four_channel_placement_0/v3_channel_selector_late_promotion_1/v3_channel_input_bias_late_promotion_0/a_7462_15422# V3I002 v3_four_channel_output_load_integration_0/v3_four_channel_shared_support_integration_0/v3_four_channel_bias_reference_distribution_0/v3_four_channel_phase_distribution_0/v3_four_channel_output_collection_0/v3_four_channel_placement_0/v3_channel_selector_late_promotion_1/v3_channel_input_bias_late_promotion_0/a_7216_14978# VGND sky130_fd_pr__nfet_01v8 ad=0 pd=0 as=0 ps=0 w=0.84 l=0.6
X1746 v3_four_channel_output_load_integration_0/v3_four_channel_shared_support_integration_0/v3_four_channel_bias_reference_distribution_0/v3_four_channel_phase_distribution_0/v3_four_channel_output_collection_0/v3_four_channel_placement_0/v3_channel_selector_late_promotion_1/v3_channel_input_bias_late_promotion_0/a_6070_7422# v3_four_channel_output_load_integration_0/v3_four_channel_shared_support_integration_0/v3_four_channel_bias_reference_distribution_0/v3_four_channel_phase_distribution_0/v3_four_channel_output_collection_0/v3_four_channel_placement_0/v3_channel_selector_late_promotion_1/v3_selector_route_pilot_0/group3_lo_p v3_four_channel_output_load_integration_0/combined_p VGND sky130_fd_pr__nfet_01v8 ad=0 pd=0 as=0 ps=0 w=0.65 l=0.15
X1747 v3_four_channel_output_load_integration_0/combined_n v3_four_channel_output_load_integration_0/v3_four_channel_shared_support_integration_0/v3_four_channel_bias_reference_distribution_0/v3_four_channel_phase_distribution_0/v3_four_channel_output_collection_0/v3_four_channel_placement_0/v3_channel_selector_late_promotion_1/v3_selector_route_pilot_0/group2_lo_p v3_four_channel_output_load_integration_0/v3_four_channel_shared_support_integration_0/v3_four_channel_bias_reference_distribution_0/v3_four_channel_phase_distribution_0/v3_four_channel_output_collection_0/v3_four_channel_placement_0/v3_channel_selector_late_promotion_1/v3_channel_input_bias_late_promotion_0/a_7038_10978# VGND sky130_fd_pr__nfet_01v8 ad=0 pd=0 as=0 ps=0 w=0.65 l=0.15
X1748 v3_four_channel_output_load_integration_0/v3_four_channel_shared_support_integration_0/v3_four_channel_bias_reference_distribution_0/v3_four_channel_phase_distribution_0/v3_four_channel_output_collection_0/v3_four_channel_placement_0/v3_channel_selector_late_promotion_1/v3_channel_input_bias_late_promotion_0/a_7462_15422# v3_four_channel_output_load_integration_0/v3_four_channel_shared_support_integration_0/v3_four_channel_bias_reference_distribution_0/v3_four_channel_phase_distribution_0/v3_four_channel_output_collection_0/v3_four_channel_placement_0/v3_channel_selector_late_promotion_1/v3_selector_route_pilot_0/group1_lo_n v3_four_channel_output_load_integration_0/combined_n VGND sky130_fd_pr__nfet_01v8 ad=0 pd=0 as=0 ps=0 w=0.65 l=0.15
X1749 v3_four_channel_output_load_integration_0/v3_four_channel_shared_support_integration_0/v3_four_channel_bias_reference_distribution_0/v3_four_channel_phase_distribution_0/v3_four_channel_output_collection_0/v3_four_channel_placement_0/v3_channel_selector_late_promotion_1/v3_channel_input_bias_late_promotion_0/a_4432_6978# v3_four_channel_output_load_integration_0/v3_four_channel_shared_support_integration_0/v3_vcm_support_block_0/ref v3_four_channel_output_load_integration_0/v3_four_channel_shared_support_integration_0/v3_four_channel_bias_reference_distribution_0/v3_four_channel_phase_distribution_0/v3_four_channel_output_collection_0/v3_four_channel_placement_0/v3_channel_selector_late_promotion_1/v3_channel_input_bias_late_promotion_0/a_4254_6978# VGND sky130_fd_pr__nfet_01v8 ad=0 pd=0 as=0 ps=0 w=0.84 l=0.6
X1750 v3_four_channel_output_load_integration_0/v3_four_channel_shared_support_integration_0/v3_four_channel_bias_reference_distribution_0/v3_four_channel_phase_distribution_0/v3_four_channel_output_collection_0/v3_four_channel_placement_0/v3_channel_selector_late_promotion_1/v3_channel_input_bias_late_promotion_0/a_5824_10978# v3_four_channel_output_load_integration_0/v3_four_channel_shared_support_integration_0/v3_vcm_support_block_0/ref v3_four_channel_output_load_integration_0/v3_four_channel_shared_support_integration_0/v3_four_channel_bias_reference_distribution_0/v3_four_channel_phase_distribution_0/v3_four_channel_output_collection_0/v3_four_channel_placement_0/v3_channel_selector_late_promotion_1/v3_channel_input_bias_late_promotion_0/a_5646_10978# VGND sky130_fd_pr__nfet_01v8 ad=0 pd=0 as=0 ps=0 w=0.84 l=0.6
X1751 v3_four_channel_output_load_integration_0/combined_n v3_four_channel_output_load_integration_0/v3_four_channel_shared_support_integration_0/v3_four_channel_bias_reference_distribution_0/v3_four_channel_phase_distribution_0/v3_four_channel_output_collection_0/v3_four_channel_placement_0/v3_channel_selector_late_promotion_1/v3_selector_route_pilot_0/group3_lo_n v3_four_channel_output_load_integration_0/v3_four_channel_shared_support_integration_0/v3_four_channel_bias_reference_distribution_0/v3_four_channel_phase_distribution_0/v3_four_channel_output_collection_0/v3_four_channel_placement_0/v3_channel_selector_late_promotion_1/v3_channel_input_bias_late_promotion_0/a_4254_22978# VGND sky130_fd_pr__nfet_01v8 ad=0 pd=0 as=0 ps=0 w=0.65 l=0.15
X1752 v3_four_channel_output_load_integration_0/v3_four_channel_shared_support_integration_0/v3_four_channel_bias_reference_distribution_0/v3_four_channel_phase_distribution_0/v3_four_channel_output_collection_0/v3_four_channel_placement_0/v3_channel_selector_late_promotion_1/v3_channel_input_bias_late_promotion_0/a_7462_23422# v3_four_channel_output_load_integration_0/v3_four_channel_shared_support_integration_0/v3_four_channel_bias_reference_distribution_0/v3_four_channel_phase_distribution_0/v3_four_channel_output_collection_0/v3_four_channel_placement_0/v3_channel_selector_late_promotion_1/v3_selector_route_pilot_0/group3_lo_n v3_four_channel_output_load_integration_0/combined_p VGND sky130_fd_pr__nfet_01v8 ad=0 pd=0 as=0 ps=0 w=0.65 l=0.15
X1753 v3_four_channel_output_load_integration_0/v3_four_channel_shared_support_integration_0/v3_four_channel_bias_reference_distribution_0/v3_four_channel_phase_distribution_0/v3_four_channel_output_collection_0/v3_four_channel_placement_0/v3_channel_selector_late_promotion_1/v3_channel_input_bias_late_promotion_0/a_4432_6978# v3_four_channel_output_load_integration_0/v3_four_channel_shared_support_integration_0/v3_tail_bias_support_block_0/vbias VGND VGND sky130_fd_pr__nfet_01v8 ad=0 pd=0 as=0 ps=0 w=5.07 l=1
X1754 v3_four_channel_output_load_integration_0/v3_four_channel_shared_support_integration_0/v3_four_channel_bias_reference_distribution_0/v3_four_channel_phase_distribution_0/v3_four_channel_output_collection_0/v3_four_channel_placement_0/v3_channel_selector_late_promotion_1/v3_channel_input_bias_late_promotion_0/a_7216_6978# v3_four_channel_output_load_integration_0/v3_four_channel_shared_support_integration_0/v3_vcm_support_block_0/ref v3_four_channel_output_load_integration_0/v3_four_channel_shared_support_integration_0/v3_four_channel_bias_reference_distribution_0/v3_four_channel_phase_distribution_0/v3_four_channel_output_collection_0/v3_four_channel_placement_0/v3_channel_selector_late_promotion_1/v3_channel_input_bias_late_promotion_0/a_7038_6978# VGND sky130_fd_pr__nfet_01v8 ad=0 pd=0 as=0 ps=0 w=0.84 l=0.6
X1755 v3_four_channel_output_load_integration_0/combined_n v3_four_channel_output_load_integration_0/v3_four_channel_shared_support_integration_0/v3_four_channel_bias_reference_distribution_0/v3_four_channel_phase_distribution_0/v3_four_channel_output_collection_0/v3_four_channel_placement_0/v3_channel_selector_late_promotion_1/v3_selector_route_pilot_0/group3_lo_p v3_four_channel_output_load_integration_0/v3_four_channel_shared_support_integration_0/v3_four_channel_bias_reference_distribution_0/v3_four_channel_phase_distribution_0/v3_four_channel_output_collection_0/v3_four_channel_placement_0/v3_channel_selector_late_promotion_1/v3_channel_input_bias_late_promotion_0/a_5646_6978# VGND sky130_fd_pr__nfet_01v8 ad=0 pd=0 as=0 ps=0 w=0.65 l=0.15
X1756 VGND v3_four_channel_output_load_integration_0/v3_four_channel_shared_support_integration_0/v3_tail_bias_support_block_0/vbias v3_four_channel_output_load_integration_0/v3_four_channel_shared_support_integration_0/v3_four_channel_bias_reference_distribution_0/v3_four_channel_phase_distribution_0/v3_four_channel_output_collection_0/v3_four_channel_placement_0/v3_channel_selector_late_promotion_1/v3_channel_input_bias_late_promotion_0/a_4382_13688# VGND sky130_fd_pr__nfet_01v8 ad=0 pd=0 as=0 ps=0 w=5.07 l=1
X1757 VDPWR v3_four_channel_output_load_integration_0/v3_four_channel_shared_support_integration_0/v3_four_channel_bias_reference_distribution_0/v3_four_channel_phase_distribution_0/v3_four_channel_output_collection_0/v3_four_channel_placement_0/v3_channel_selector_late_promotion_1/v3_selector_route_pilot_0/G1_MUX_POS/a_505_21# v3_four_channel_output_load_integration_0/v3_four_channel_shared_support_integration_0/v3_four_channel_bias_reference_distribution_0/v3_four_channel_phase_distribution_0/v3_four_channel_output_collection_0/v3_four_channel_placement_0/v3_channel_selector_late_promotion_1/v3_selector_route_pilot_0/G1_MUX_POS/a_535_374# VDPWR sky130_fd_pr__pfet_01v8_hvt ad=0 pd=0 as=0.0882 ps=1.26 w=0.42 l=0.15
X1758 v3_four_channel_output_load_integration_0/v3_four_channel_shared_support_integration_0/v3_four_channel_bias_reference_distribution_0/v3_four_channel_phase_distribution_0/v3_four_channel_output_collection_0/v3_four_channel_placement_0/v3_channel_selector_late_promotion_1/v3_selector_route_pilot_0/G1_MUX_POS/a_505_21# V3R215 VDPWR VDPWR sky130_fd_pr__pfet_01v8_hvt ad=0.1176 pd=1.4 as=0 ps=0 w=0.42 l=0.15
X1759 v3_four_channel_output_load_integration_0/v3_four_channel_shared_support_integration_0/v3_four_channel_bias_reference_distribution_0/v3_four_channel_phase_distribution_0/v3_four_channel_output_collection_0/v3_four_channel_placement_0/v3_channel_selector_late_promotion_1/v3_selector_route_pilot_0/G1_MUX_POS/a_218_374# V3R215 VDPWR VDPWR sky130_fd_pr__pfet_01v8_hvt ad=0.1533 pd=1.57 as=0 ps=0 w=0.42 l=0.15
X1760 VGND v3_four_channel_output_load_integration_0/v3_four_channel_shared_support_integration_0/v3_four_channel_bias_reference_distribution_0/v3_four_channel_phase_distribution_0/v3_four_channel_output_collection_0/v3_four_channel_placement_0/v3_channel_selector_late_promotion_1/v3_selector_route_pilot_0/G1_MUX_POS/a_505_21# v3_four_channel_output_load_integration_0/v3_four_channel_shared_support_integration_0/v3_four_channel_bias_reference_distribution_0/v3_four_channel_phase_distribution_0/v3_four_channel_output_collection_0/v3_four_channel_placement_0/v3_channel_selector_late_promotion_1/v3_selector_route_pilot_0/G1_MUX_POS/a_439_47# VGND sky130_fd_pr__nfet_01v8 ad=0 pd=0 as=0.1386 ps=1.5 w=0.42 l=0.15
X1761 v3_four_channel_output_load_integration_0/v3_four_channel_shared_support_integration_0/v3_four_channel_bias_reference_distribution_0/v3_four_channel_phase_distribution_0/v3_four_channel_output_collection_0/v3_four_channel_placement_0/v3_channel_selector_late_promotion_1/v3_selector_route_pilot_0/G1_MUX_POS/a_76_199# V3R290 v3_four_channel_output_load_integration_0/v3_four_channel_shared_support_integration_0/v3_four_channel_bias_reference_distribution_0/v3_four_channel_phase_distribution_0/v3_four_channel_output_collection_0/v3_four_channel_placement_0/v3_channel_selector_late_promotion_1/v3_selector_route_pilot_0/G1_MUX_POS/a_218_374# VDPWR sky130_fd_pr__pfet_01v8_hvt ad=0.3864 pd=2.68 as=0 ps=0 w=0.42 l=0.15
X1762 v3_four_channel_output_load_integration_0/v3_four_channel_shared_support_integration_0/v3_four_channel_bias_reference_distribution_0/v3_four_channel_phase_distribution_0/v3_four_channel_output_collection_0/v3_four_channel_placement_0/v3_channel_selector_late_promotion_1/v3_selector_route_pilot_0/G1_MUX_POS/a_505_21# V3R215 VGND VGND sky130_fd_pr__nfet_01v8 ad=0.1092 pd=1.36 as=0 ps=0 w=0.42 l=0.15
X1763 v3_four_channel_output_load_integration_0/v3_four_channel_shared_support_integration_0/v3_four_channel_bias_reference_distribution_0/v3_four_channel_phase_distribution_0/v3_four_channel_output_collection_0/v3_four_channel_placement_0/v3_channel_selector_late_promotion_1/v3_selector_route_pilot_0/G1_MUX_POS/a_439_47# V3R290 v3_four_channel_output_load_integration_0/v3_four_channel_shared_support_integration_0/v3_four_channel_bias_reference_distribution_0/v3_four_channel_phase_distribution_0/v3_four_channel_output_collection_0/v3_four_channel_placement_0/v3_channel_selector_late_promotion_1/v3_selector_route_pilot_0/G1_MUX_POS/a_76_199# VGND sky130_fd_pr__nfet_01v8 ad=0 pd=0 as=0.1995 ps=1.79 w=0.42 l=0.15
X1764 v3_four_channel_output_load_integration_0/v3_four_channel_shared_support_integration_0/v3_four_channel_bias_reference_distribution_0/v3_four_channel_phase_distribution_0/v3_four_channel_output_collection_0/v3_four_channel_placement_0/v3_channel_selector_late_promotion_1/v3_selector_route_pilot_0/G1_MUX_POS/a_535_374# V3R291 v3_four_channel_output_load_integration_0/v3_four_channel_shared_support_integration_0/v3_four_channel_bias_reference_distribution_0/v3_four_channel_phase_distribution_0/v3_four_channel_output_collection_0/v3_four_channel_placement_0/v3_channel_selector_late_promotion_1/v3_selector_route_pilot_0/G1_MUX_POS/a_76_199# VDPWR sky130_fd_pr__pfet_01v8_hvt ad=0 pd=0 as=0 ps=0 w=0.42 l=0.15
X1765 v3_four_channel_output_load_integration_0/v3_four_channel_shared_support_integration_0/v3_four_channel_bias_reference_distribution_0/v3_four_channel_phase_distribution_0/v3_four_channel_output_collection_0/v3_four_channel_placement_0/v3_channel_selector_late_promotion_1/v3_selector_route_pilot_0/G1_MUX_POS/a_76_199# V3R291 v3_four_channel_output_load_integration_0/v3_four_channel_shared_support_integration_0/v3_four_channel_bias_reference_distribution_0/v3_four_channel_phase_distribution_0/v3_four_channel_output_collection_0/v3_four_channel_placement_0/v3_channel_selector_late_promotion_1/v3_selector_route_pilot_0/G1_MUX_POS/a_218_47# VGND sky130_fd_pr__nfet_01v8 ad=0 pd=0 as=0.1386 ps=1.5 w=0.42 l=0.15
X1766 v3_four_channel_output_load_integration_0/v3_four_channel_shared_support_integration_0/v3_four_channel_bias_reference_distribution_0/v3_four_channel_phase_distribution_0/v3_four_channel_output_collection_0/v3_four_channel_placement_0/v3_channel_selector_late_promotion_1/v3_selector_route_pilot_0/G1_MUX_POS/a_218_47# V3R215 VGND VGND sky130_fd_pr__nfet_01v8 ad=0 pd=0 as=0 ps=0 w=0.42 l=0.15
X1767 VDPWR v3_four_channel_output_load_integration_0/v3_four_channel_shared_support_integration_0/v3_four_channel_bias_reference_distribution_0/v3_four_channel_phase_distribution_0/v3_four_channel_output_collection_0/v3_four_channel_placement_0/v3_channel_selector_late_promotion_1/v3_selector_route_pilot_0/G1_MUX_POS/a_76_199# v3_four_channel_output_load_integration_0/v3_four_channel_shared_support_integration_0/v3_four_channel_bias_reference_distribution_0/v3_four_channel_phase_distribution_0/v3_four_channel_output_collection_0/v3_four_channel_placement_0/v3_channel_selector_late_promotion_1/v3_selector_route_pilot_0/G1_MUX_POS/X VDPWR sky130_fd_pr__pfet_01v8_hvt ad=0 pd=0 as=0.26 ps=2.52 w=1 l=0.15
X1768 VGND v3_four_channel_output_load_integration_0/v3_four_channel_shared_support_integration_0/v3_four_channel_bias_reference_distribution_0/v3_four_channel_phase_distribution_0/v3_four_channel_output_collection_0/v3_four_channel_placement_0/v3_channel_selector_late_promotion_1/v3_selector_route_pilot_0/G1_MUX_POS/a_76_199# v3_four_channel_output_load_integration_0/v3_four_channel_shared_support_integration_0/v3_four_channel_bias_reference_distribution_0/v3_four_channel_phase_distribution_0/v3_four_channel_output_collection_0/v3_four_channel_placement_0/v3_channel_selector_late_promotion_1/v3_selector_route_pilot_0/G1_MUX_POS/X VGND sky130_fd_pr__nfet_01v8 ad=0 pd=0 as=0.169 ps=1.82 w=0.65 l=0.15
X1769 VDPWR v3_four_channel_output_load_integration_0/v3_four_channel_shared_support_integration_0/v3_four_channel_bias_reference_distribution_0/v3_four_channel_phase_distribution_0/v3_four_channel_output_collection_0/v3_four_channel_placement_0/v3_channel_selector_late_promotion_1/v3_selector_route_pilot_0/G3_MUX_AXIS/a_505_21# v3_four_channel_output_load_integration_0/v3_four_channel_shared_support_integration_0/v3_four_channel_bias_reference_distribution_0/v3_four_channel_phase_distribution_0/v3_four_channel_output_collection_0/v3_four_channel_placement_0/v3_channel_selector_late_promotion_1/v3_selector_route_pilot_0/G3_MUX_AXIS/a_535_374# VDPWR sky130_fd_pr__pfet_01v8_hvt ad=0 pd=0 as=0.0882 ps=1.26 w=0.42 l=0.15
X1770 v3_four_channel_output_load_integration_0/v3_four_channel_shared_support_integration_0/v3_four_channel_bias_reference_distribution_0/v3_four_channel_phase_distribution_0/v3_four_channel_output_collection_0/v3_four_channel_placement_0/v3_channel_selector_late_promotion_1/v3_selector_route_pilot_0/G3_MUX_AXIS/a_505_21# V3R221 VDPWR VDPWR sky130_fd_pr__pfet_01v8_hvt ad=0.1176 pd=1.4 as=0 ps=0 w=0.42 l=0.15
X1771 v3_four_channel_output_load_integration_0/v3_four_channel_shared_support_integration_0/v3_four_channel_bias_reference_distribution_0/v3_four_channel_phase_distribution_0/v3_four_channel_output_collection_0/v3_four_channel_placement_0/v3_channel_selector_late_promotion_1/v3_selector_route_pilot_0/G3_MUX_AXIS/a_218_374# V3R221 VDPWR VDPWR sky130_fd_pr__pfet_01v8_hvt ad=0.1533 pd=1.57 as=0 ps=0 w=0.42 l=0.15
X1772 VGND v3_four_channel_output_load_integration_0/v3_four_channel_shared_support_integration_0/v3_four_channel_bias_reference_distribution_0/v3_four_channel_phase_distribution_0/v3_four_channel_output_collection_0/v3_four_channel_placement_0/v3_channel_selector_late_promotion_1/v3_selector_route_pilot_0/G3_MUX_AXIS/a_505_21# v3_four_channel_output_load_integration_0/v3_four_channel_shared_support_integration_0/v3_four_channel_bias_reference_distribution_0/v3_four_channel_phase_distribution_0/v3_four_channel_output_collection_0/v3_four_channel_placement_0/v3_channel_selector_late_promotion_1/v3_selector_route_pilot_0/G3_MUX_AXIS/a_439_47# VGND sky130_fd_pr__nfet_01v8 ad=0 pd=0 as=0.1386 ps=1.5 w=0.42 l=0.15
X1773 v3_four_channel_output_load_integration_0/v3_four_channel_shared_support_integration_0/v3_four_channel_bias_reference_distribution_0/v3_four_channel_phase_distribution_0/v3_four_channel_output_collection_0/v3_four_channel_placement_0/v3_channel_selector_late_promotion_1/v3_selector_route_pilot_0/G3_MUX_AXIS/a_76_199# v3_four_channel_output_load_integration_0/v3_four_channel_shared_support_integration_0/v3_four_channel_bias_reference_distribution_0/v3_four_channel_phase_distribution_0/v3_four_channel_output_collection_0/v3_four_channel_placement_0/v3_channel_selector_late_promotion_1/v3_selector_route_pilot_0/G3_MUX_POS/X v3_four_channel_output_load_integration_0/v3_four_channel_shared_support_integration_0/v3_four_channel_bias_reference_distribution_0/v3_four_channel_phase_distribution_0/v3_four_channel_output_collection_0/v3_four_channel_placement_0/v3_channel_selector_late_promotion_1/v3_selector_route_pilot_0/G3_MUX_AXIS/a_218_374# VDPWR sky130_fd_pr__pfet_01v8_hvt ad=0.3864 pd=2.68 as=0 ps=0 w=0.42 l=0.15
X1774 v3_four_channel_output_load_integration_0/v3_four_channel_shared_support_integration_0/v3_four_channel_bias_reference_distribution_0/v3_four_channel_phase_distribution_0/v3_four_channel_output_collection_0/v3_four_channel_placement_0/v3_channel_selector_late_promotion_1/v3_selector_route_pilot_0/G3_MUX_AXIS/a_505_21# V3R221 VGND VGND sky130_fd_pr__nfet_01v8 ad=0.1092 pd=1.36 as=0 ps=0 w=0.42 l=0.15
X1775 v3_four_channel_output_load_integration_0/v3_four_channel_shared_support_integration_0/v3_four_channel_bias_reference_distribution_0/v3_four_channel_phase_distribution_0/v3_four_channel_output_collection_0/v3_four_channel_placement_0/v3_channel_selector_late_promotion_1/v3_selector_route_pilot_0/G3_MUX_AXIS/a_439_47# v3_four_channel_output_load_integration_0/v3_four_channel_shared_support_integration_0/v3_four_channel_bias_reference_distribution_0/v3_four_channel_phase_distribution_0/v3_four_channel_output_collection_0/v3_four_channel_placement_0/v3_channel_selector_late_promotion_1/v3_selector_route_pilot_0/G3_MUX_POS/X v3_four_channel_output_load_integration_0/v3_four_channel_shared_support_integration_0/v3_four_channel_bias_reference_distribution_0/v3_four_channel_phase_distribution_0/v3_four_channel_output_collection_0/v3_four_channel_placement_0/v3_channel_selector_late_promotion_1/v3_selector_route_pilot_0/G3_MUX_AXIS/a_76_199# VGND sky130_fd_pr__nfet_01v8 ad=0 pd=0 as=0.1995 ps=1.79 w=0.42 l=0.15
X1776 v3_four_channel_output_load_integration_0/v3_four_channel_shared_support_integration_0/v3_four_channel_bias_reference_distribution_0/v3_four_channel_phase_distribution_0/v3_four_channel_output_collection_0/v3_four_channel_placement_0/v3_channel_selector_late_promotion_1/v3_selector_route_pilot_0/G3_MUX_AXIS/a_535_374# v3_four_channel_output_load_integration_0/v3_four_channel_shared_support_integration_0/v3_four_channel_bias_reference_distribution_0/v3_four_channel_phase_distribution_0/v3_four_channel_output_collection_0/v3_four_channel_placement_0/v3_channel_selector_late_promotion_1/v3_selector_route_pilot_0/G3_MUX_NEG/X v3_four_channel_output_load_integration_0/v3_four_channel_shared_support_integration_0/v3_four_channel_bias_reference_distribution_0/v3_four_channel_phase_distribution_0/v3_four_channel_output_collection_0/v3_four_channel_placement_0/v3_channel_selector_late_promotion_1/v3_selector_route_pilot_0/G3_MUX_AXIS/a_76_199# VDPWR sky130_fd_pr__pfet_01v8_hvt ad=0 pd=0 as=0 ps=0 w=0.42 l=0.15
X1777 v3_four_channel_output_load_integration_0/v3_four_channel_shared_support_integration_0/v3_four_channel_bias_reference_distribution_0/v3_four_channel_phase_distribution_0/v3_four_channel_output_collection_0/v3_four_channel_placement_0/v3_channel_selector_late_promotion_1/v3_selector_route_pilot_0/G3_MUX_AXIS/a_76_199# v3_four_channel_output_load_integration_0/v3_four_channel_shared_support_integration_0/v3_four_channel_bias_reference_distribution_0/v3_four_channel_phase_distribution_0/v3_four_channel_output_collection_0/v3_four_channel_placement_0/v3_channel_selector_late_promotion_1/v3_selector_route_pilot_0/G3_MUX_NEG/X v3_four_channel_output_load_integration_0/v3_four_channel_shared_support_integration_0/v3_four_channel_bias_reference_distribution_0/v3_four_channel_phase_distribution_0/v3_four_channel_output_collection_0/v3_four_channel_placement_0/v3_channel_selector_late_promotion_1/v3_selector_route_pilot_0/G3_MUX_AXIS/a_218_47# VGND sky130_fd_pr__nfet_01v8 ad=0 pd=0 as=0.1386 ps=1.5 w=0.42 l=0.15
X1778 v3_four_channel_output_load_integration_0/v3_four_channel_shared_support_integration_0/v3_four_channel_bias_reference_distribution_0/v3_four_channel_phase_distribution_0/v3_four_channel_output_collection_0/v3_four_channel_placement_0/v3_channel_selector_late_promotion_1/v3_selector_route_pilot_0/G3_MUX_AXIS/a_218_47# V3R221 VGND VGND sky130_fd_pr__nfet_01v8 ad=0 pd=0 as=0 ps=0 w=0.42 l=0.15
X1779 VDPWR v3_four_channel_output_load_integration_0/v3_four_channel_shared_support_integration_0/v3_four_channel_bias_reference_distribution_0/v3_four_channel_phase_distribution_0/v3_four_channel_output_collection_0/v3_four_channel_placement_0/v3_channel_selector_late_promotion_1/v3_selector_route_pilot_0/G3_MUX_AXIS/a_76_199# v3_four_channel_output_load_integration_0/v3_four_channel_shared_support_integration_0/v3_four_channel_bias_reference_distribution_0/v3_four_channel_phase_distribution_0/v3_four_channel_output_collection_0/v3_four_channel_placement_0/v3_channel_selector_late_promotion_1/v3_selector_route_pilot_0/G3_MUX_AXIS/X VDPWR sky130_fd_pr__pfet_01v8_hvt ad=0 pd=0 as=0.26 ps=2.52 w=1 l=0.15
X1780 VGND v3_four_channel_output_load_integration_0/v3_four_channel_shared_support_integration_0/v3_four_channel_bias_reference_distribution_0/v3_four_channel_phase_distribution_0/v3_four_channel_output_collection_0/v3_four_channel_placement_0/v3_channel_selector_late_promotion_1/v3_selector_route_pilot_0/G3_MUX_AXIS/a_76_199# v3_four_channel_output_load_integration_0/v3_four_channel_shared_support_integration_0/v3_four_channel_bias_reference_distribution_0/v3_four_channel_phase_distribution_0/v3_four_channel_output_collection_0/v3_four_channel_placement_0/v3_channel_selector_late_promotion_1/v3_selector_route_pilot_0/G3_MUX_AXIS/X VGND sky130_fd_pr__nfet_01v8 ad=0 pd=0 as=0.169 ps=1.82 w=0.65 l=0.15
X1781 VDPWR V3R070 v3_four_channel_output_load_integration_0/v3_four_channel_shared_support_integration_0/v3_four_channel_bias_reference_distribution_0/v3_four_channel_phase_distribution_0/v3_four_channel_output_collection_0/v3_four_channel_placement_0/v3_channel_selector_late_promotion_1/v3_selector_route_pilot_0/ENABLE_ANDNOT/a_207_413# VDPWR sky130_fd_pr__pfet_01v8_hvt ad=0 pd=0 as=0.1218 ps=1.42 w=0.42 l=0.15
X1782 v3_four_channel_output_load_integration_0/v3_four_channel_shared_support_integration_0/v3_four_channel_bias_reference_distribution_0/v3_four_channel_phase_distribution_0/v3_four_channel_output_collection_0/v3_four_channel_placement_0/v3_channel_selector_late_promotion_1/v3_selector_route_pilot_0/G3_LO_P_AND/B v3_four_channel_output_load_integration_0/v3_four_channel_shared_support_integration_0/v3_four_channel_bias_reference_distribution_0/v3_four_channel_phase_distribution_0/v3_four_channel_output_collection_0/v3_four_channel_placement_0/v3_channel_selector_late_promotion_1/v3_selector_route_pilot_0/ENABLE_ANDNOT/a_207_413# VDPWR VDPWR sky130_fd_pr__pfet_01v8_hvt ad=0.26 pd=2.52 as=0 ps=0 w=1 l=0.15
X1783 v3_four_channel_output_load_integration_0/v3_four_channel_shared_support_integration_0/v3_four_channel_bias_reference_distribution_0/v3_four_channel_phase_distribution_0/v3_four_channel_output_collection_0/v3_four_channel_placement_0/v3_channel_selector_late_promotion_1/v3_selector_route_pilot_0/ENABLE_ANDNOT/a_297_47# v3_four_channel_output_load_integration_0/v3_four_channel_shared_support_integration_0/v3_four_channel_bias_reference_distribution_0/v3_four_channel_phase_distribution_0/v3_four_channel_output_collection_0/v3_four_channel_placement_0/v3_channel_selector_late_promotion_1/v3_selector_route_pilot_0/ENABLE_ANDNOT/a_27_413# v3_four_channel_output_load_integration_0/v3_four_channel_shared_support_integration_0/v3_four_channel_bias_reference_distribution_0/v3_four_channel_phase_distribution_0/v3_four_channel_output_collection_0/v3_four_channel_placement_0/v3_channel_selector_late_promotion_1/v3_selector_route_pilot_0/ENABLE_ANDNOT/a_207_413# VGND sky130_fd_pr__nfet_01v8 ad=0.1008 pd=1.32 as=0.1092 ps=1.36 w=0.42 l=0.15
X1784 v3_four_channel_output_load_integration_0/v3_four_channel_shared_support_integration_0/v3_four_channel_bias_reference_distribution_0/v3_four_channel_phase_distribution_0/v3_four_channel_output_collection_0/v3_four_channel_placement_0/v3_channel_selector_late_promotion_1/v3_selector_route_pilot_0/G3_LO_P_AND/B v3_four_channel_output_load_integration_0/v3_four_channel_shared_support_integration_0/v3_four_channel_bias_reference_distribution_0/v3_four_channel_phase_distribution_0/v3_four_channel_output_collection_0/v3_four_channel_placement_0/v3_channel_selector_late_promotion_1/v3_selector_route_pilot_0/ENABLE_ANDNOT/a_207_413# VGND VGND sky130_fd_pr__nfet_01v8 ad=0.169 pd=1.82 as=0 ps=0 w=0.65 l=0.15
X1785 v3_four_channel_output_load_integration_0/v3_four_channel_shared_support_integration_0/v3_four_channel_bias_reference_distribution_0/v3_four_channel_phase_distribution_0/v3_four_channel_output_collection_0/v3_four_channel_placement_0/v3_channel_selector_late_promotion_1/v3_selector_route_pilot_0/ENABLE_ANDNOT/a_207_413# v3_four_channel_output_load_integration_0/v3_four_channel_shared_support_integration_0/v3_four_channel_bias_reference_distribution_0/v3_four_channel_phase_distribution_0/v3_four_channel_output_collection_0/v3_four_channel_placement_0/v3_channel_selector_late_promotion_1/v3_selector_route_pilot_0/ENABLE_ANDNOT/a_27_413# VDPWR VDPWR sky130_fd_pr__pfet_01v8_hvt ad=0 pd=0 as=0 ps=0 w=0.42 l=0.15
X1786 VDPWR V3R238 v3_four_channel_output_load_integration_0/v3_four_channel_shared_support_integration_0/v3_four_channel_bias_reference_distribution_0/v3_four_channel_phase_distribution_0/v3_four_channel_output_collection_0/v3_four_channel_placement_0/v3_channel_selector_late_promotion_1/v3_selector_route_pilot_0/ENABLE_ANDNOT/a_27_413# VDPWR sky130_fd_pr__pfet_01v8_hvt ad=0 pd=0 as=0.1092 ps=1.36 w=0.42 l=0.15
X1787 VGND V3R070 v3_four_channel_output_load_integration_0/v3_four_channel_shared_support_integration_0/v3_four_channel_bias_reference_distribution_0/v3_four_channel_phase_distribution_0/v3_four_channel_output_collection_0/v3_four_channel_placement_0/v3_channel_selector_late_promotion_1/v3_selector_route_pilot_0/ENABLE_ANDNOT/a_297_47# VGND sky130_fd_pr__nfet_01v8 ad=0 pd=0 as=0 ps=0 w=0.42 l=0.15
X1788 v3_four_channel_output_load_integration_0/v3_four_channel_shared_support_integration_0/v3_four_channel_bias_reference_distribution_0/v3_four_channel_phase_distribution_0/v3_four_channel_output_collection_0/v3_four_channel_placement_0/v3_channel_selector_late_promotion_1/v3_selector_route_pilot_0/ENABLE_ANDNOT/a_27_413# V3R238 VGND VGND sky130_fd_pr__nfet_01v8 ad=0.1092 pd=1.36 as=0 ps=0 w=0.42 l=0.15
X1789 VDPWR v3_four_channel_output_load_integration_0/v3_four_channel_shared_support_integration_0/v3_four_channel_bias_reference_distribution_0/v3_four_channel_phase_distribution_0/v3_four_channel_output_collection_0/v3_four_channel_placement_0/v3_channel_selector_late_promotion_1/v3_selector_route_pilot_0/G1_MUX_NEG/a_505_21# v3_four_channel_output_load_integration_0/v3_four_channel_shared_support_integration_0/v3_four_channel_bias_reference_distribution_0/v3_four_channel_phase_distribution_0/v3_four_channel_output_collection_0/v3_four_channel_placement_0/v3_channel_selector_late_promotion_1/v3_selector_route_pilot_0/G1_MUX_NEG/a_535_374# VDPWR sky130_fd_pr__pfet_01v8_hvt ad=0 pd=0 as=0.0882 ps=1.26 w=0.42 l=0.15
X1790 v3_four_channel_output_load_integration_0/v3_four_channel_shared_support_integration_0/v3_four_channel_bias_reference_distribution_0/v3_four_channel_phase_distribution_0/v3_four_channel_output_collection_0/v3_four_channel_placement_0/v3_channel_selector_late_promotion_1/v3_selector_route_pilot_0/G1_MUX_NEG/a_505_21# V3R215 VDPWR VDPWR sky130_fd_pr__pfet_01v8_hvt ad=0.1176 pd=1.4 as=0 ps=0 w=0.42 l=0.15
X1791 v3_four_channel_output_load_integration_0/v3_four_channel_shared_support_integration_0/v3_four_channel_bias_reference_distribution_0/v3_four_channel_phase_distribution_0/v3_four_channel_output_collection_0/v3_four_channel_placement_0/v3_channel_selector_late_promotion_1/v3_selector_route_pilot_0/G1_MUX_NEG/a_218_374# V3R215 VDPWR VDPWR sky130_fd_pr__pfet_01v8_hvt ad=0.1533 pd=1.57 as=0 ps=0 w=0.42 l=0.15
X1792 VGND v3_four_channel_output_load_integration_0/v3_four_channel_shared_support_integration_0/v3_four_channel_bias_reference_distribution_0/v3_four_channel_phase_distribution_0/v3_four_channel_output_collection_0/v3_four_channel_placement_0/v3_channel_selector_late_promotion_1/v3_selector_route_pilot_0/G1_MUX_NEG/a_505_21# v3_four_channel_output_load_integration_0/v3_four_channel_shared_support_integration_0/v3_four_channel_bias_reference_distribution_0/v3_four_channel_phase_distribution_0/v3_four_channel_output_collection_0/v3_four_channel_placement_0/v3_channel_selector_late_promotion_1/v3_selector_route_pilot_0/G1_MUX_NEG/a_439_47# VGND sky130_fd_pr__nfet_01v8 ad=0 pd=0 as=0.1386 ps=1.5 w=0.42 l=0.15
X1793 v3_four_channel_output_load_integration_0/v3_four_channel_shared_support_integration_0/v3_four_channel_bias_reference_distribution_0/v3_four_channel_phase_distribution_0/v3_four_channel_output_collection_0/v3_four_channel_placement_0/v3_channel_selector_late_promotion_1/v3_selector_route_pilot_0/G1_MUX_NEG/a_76_199# V3R292 v3_four_channel_output_load_integration_0/v3_four_channel_shared_support_integration_0/v3_four_channel_bias_reference_distribution_0/v3_four_channel_phase_distribution_0/v3_four_channel_output_collection_0/v3_four_channel_placement_0/v3_channel_selector_late_promotion_1/v3_selector_route_pilot_0/G1_MUX_NEG/a_218_374# VDPWR sky130_fd_pr__pfet_01v8_hvt ad=0.3864 pd=2.68 as=0 ps=0 w=0.42 l=0.15
X1794 v3_four_channel_output_load_integration_0/v3_four_channel_shared_support_integration_0/v3_four_channel_bias_reference_distribution_0/v3_four_channel_phase_distribution_0/v3_four_channel_output_collection_0/v3_four_channel_placement_0/v3_channel_selector_late_promotion_1/v3_selector_route_pilot_0/G1_MUX_NEG/a_505_21# V3R215 VGND VGND sky130_fd_pr__nfet_01v8 ad=0.1092 pd=1.36 as=0 ps=0 w=0.42 l=0.15
X1795 v3_four_channel_output_load_integration_0/v3_four_channel_shared_support_integration_0/v3_four_channel_bias_reference_distribution_0/v3_four_channel_phase_distribution_0/v3_four_channel_output_collection_0/v3_four_channel_placement_0/v3_channel_selector_late_promotion_1/v3_selector_route_pilot_0/G1_MUX_NEG/a_439_47# V3R292 v3_four_channel_output_load_integration_0/v3_four_channel_shared_support_integration_0/v3_four_channel_bias_reference_distribution_0/v3_four_channel_phase_distribution_0/v3_four_channel_output_collection_0/v3_four_channel_placement_0/v3_channel_selector_late_promotion_1/v3_selector_route_pilot_0/G1_MUX_NEG/a_76_199# VGND sky130_fd_pr__nfet_01v8 ad=0 pd=0 as=0.1995 ps=1.79 w=0.42 l=0.15
X1796 v3_four_channel_output_load_integration_0/v3_four_channel_shared_support_integration_0/v3_four_channel_bias_reference_distribution_0/v3_four_channel_phase_distribution_0/v3_four_channel_output_collection_0/v3_four_channel_placement_0/v3_channel_selector_late_promotion_1/v3_selector_route_pilot_0/G1_MUX_NEG/a_535_374# V3R293 v3_four_channel_output_load_integration_0/v3_four_channel_shared_support_integration_0/v3_four_channel_bias_reference_distribution_0/v3_four_channel_phase_distribution_0/v3_four_channel_output_collection_0/v3_four_channel_placement_0/v3_channel_selector_late_promotion_1/v3_selector_route_pilot_0/G1_MUX_NEG/a_76_199# VDPWR sky130_fd_pr__pfet_01v8_hvt ad=0 pd=0 as=0 ps=0 w=0.42 l=0.15
X1797 v3_four_channel_output_load_integration_0/v3_four_channel_shared_support_integration_0/v3_four_channel_bias_reference_distribution_0/v3_four_channel_phase_distribution_0/v3_four_channel_output_collection_0/v3_four_channel_placement_0/v3_channel_selector_late_promotion_1/v3_selector_route_pilot_0/G1_MUX_NEG/a_76_199# V3R293 v3_four_channel_output_load_integration_0/v3_four_channel_shared_support_integration_0/v3_four_channel_bias_reference_distribution_0/v3_four_channel_phase_distribution_0/v3_four_channel_output_collection_0/v3_four_channel_placement_0/v3_channel_selector_late_promotion_1/v3_selector_route_pilot_0/G1_MUX_NEG/a_218_47# VGND sky130_fd_pr__nfet_01v8 ad=0 pd=0 as=0.1386 ps=1.5 w=0.42 l=0.15
X1798 v3_four_channel_output_load_integration_0/v3_four_channel_shared_support_integration_0/v3_four_channel_bias_reference_distribution_0/v3_four_channel_phase_distribution_0/v3_four_channel_output_collection_0/v3_four_channel_placement_0/v3_channel_selector_late_promotion_1/v3_selector_route_pilot_0/G1_MUX_NEG/a_218_47# V3R215 VGND VGND sky130_fd_pr__nfet_01v8 ad=0 pd=0 as=0 ps=0 w=0.42 l=0.15
X1799 VDPWR v3_four_channel_output_load_integration_0/v3_four_channel_shared_support_integration_0/v3_four_channel_bias_reference_distribution_0/v3_four_channel_phase_distribution_0/v3_four_channel_output_collection_0/v3_four_channel_placement_0/v3_channel_selector_late_promotion_1/v3_selector_route_pilot_0/G1_MUX_NEG/a_76_199# v3_four_channel_output_load_integration_0/v3_four_channel_shared_support_integration_0/v3_four_channel_bias_reference_distribution_0/v3_four_channel_phase_distribution_0/v3_four_channel_output_collection_0/v3_four_channel_placement_0/v3_channel_selector_late_promotion_1/v3_selector_route_pilot_0/G1_MUX_NEG/X VDPWR sky130_fd_pr__pfet_01v8_hvt ad=0 pd=0 as=0.26 ps=2.52 w=1 l=0.15
X1800 VGND v3_four_channel_output_load_integration_0/v3_four_channel_shared_support_integration_0/v3_four_channel_bias_reference_distribution_0/v3_four_channel_phase_distribution_0/v3_four_channel_output_collection_0/v3_four_channel_placement_0/v3_channel_selector_late_promotion_1/v3_selector_route_pilot_0/G1_MUX_NEG/a_76_199# v3_four_channel_output_load_integration_0/v3_four_channel_shared_support_integration_0/v3_four_channel_bias_reference_distribution_0/v3_four_channel_phase_distribution_0/v3_four_channel_output_collection_0/v3_four_channel_placement_0/v3_channel_selector_late_promotion_1/v3_selector_route_pilot_0/G1_MUX_NEG/X VGND sky130_fd_pr__nfet_01v8 ad=0 pd=0 as=0.169 ps=1.82 w=0.65 l=0.15
X1801 VDPWR v3_four_channel_output_load_integration_0/v3_four_channel_shared_support_integration_0/v3_four_channel_bias_reference_distribution_0/v3_four_channel_phase_distribution_0/v3_four_channel_output_collection_0/v3_four_channel_placement_0/v3_channel_selector_late_promotion_1/v3_selector_route_pilot_0/G3_LO_P_AND/B v3_four_channel_output_load_integration_0/v3_four_channel_shared_support_integration_0/v3_four_channel_bias_reference_distribution_0/v3_four_channel_phase_distribution_0/v3_four_channel_output_collection_0/v3_four_channel_placement_0/v3_channel_selector_late_promotion_1/v3_selector_route_pilot_0/G1_LO_P_AND/a_59_75# VDPWR sky130_fd_pr__pfet_01v8_hvt ad=0 pd=0 as=0.1134 ps=1.38 w=0.42 l=0.15
X1802 v3_four_channel_output_load_integration_0/v3_four_channel_shared_support_integration_0/v3_four_channel_bias_reference_distribution_0/v3_four_channel_phase_distribution_0/v3_four_channel_output_collection_0/v3_four_channel_placement_0/v3_channel_selector_late_promotion_1/v3_selector_route_pilot_0/group1_lo_p v3_four_channel_output_load_integration_0/v3_four_channel_shared_support_integration_0/v3_four_channel_bias_reference_distribution_0/v3_four_channel_phase_distribution_0/v3_four_channel_output_collection_0/v3_four_channel_placement_0/v3_channel_selector_late_promotion_1/v3_selector_route_pilot_0/G1_LO_P_AND/a_59_75# VDPWR VDPWR sky130_fd_pr__pfet_01v8_hvt ad=0.475 pd=2.95 as=0 ps=0 w=1 l=0.15
X1803 VGND v3_four_channel_output_load_integration_0/v3_four_channel_shared_support_integration_0/v3_four_channel_bias_reference_distribution_0/v3_four_channel_phase_distribution_0/v3_four_channel_output_collection_0/v3_four_channel_placement_0/v3_channel_selector_late_promotion_1/v3_selector_route_pilot_0/G3_LO_P_AND/B v3_four_channel_output_load_integration_0/v3_four_channel_shared_support_integration_0/v3_four_channel_bias_reference_distribution_0/v3_four_channel_phase_distribution_0/v3_four_channel_output_collection_0/v3_four_channel_placement_0/v3_channel_selector_late_promotion_1/v3_selector_route_pilot_0/G1_LO_P_AND/a_145_75# VGND sky130_fd_pr__nfet_01v8 ad=0 pd=0 as=0.1134 ps=1.38 w=0.42 l=0.15
X1804 v3_four_channel_output_load_integration_0/v3_four_channel_shared_support_integration_0/v3_four_channel_bias_reference_distribution_0/v3_four_channel_phase_distribution_0/v3_four_channel_output_collection_0/v3_four_channel_placement_0/v3_channel_selector_late_promotion_1/v3_selector_route_pilot_0/G1_LO_P_AND/a_59_75# v3_four_channel_output_load_integration_0/v3_four_channel_shared_support_integration_0/v3_four_channel_bias_reference_distribution_0/v3_four_channel_phase_distribution_0/v3_four_channel_output_collection_0/v3_four_channel_placement_0/v3_channel_selector_late_promotion_1/v3_selector_route_pilot_0/G1_MUX_AXIS/X VDPWR VDPWR sky130_fd_pr__pfet_01v8_hvt ad=0 pd=0 as=0 ps=0 w=0.42 l=0.15
X1805 v3_four_channel_output_load_integration_0/v3_four_channel_shared_support_integration_0/v3_four_channel_bias_reference_distribution_0/v3_four_channel_phase_distribution_0/v3_four_channel_output_collection_0/v3_four_channel_placement_0/v3_channel_selector_late_promotion_1/v3_selector_route_pilot_0/group1_lo_p v3_four_channel_output_load_integration_0/v3_four_channel_shared_support_integration_0/v3_four_channel_bias_reference_distribution_0/v3_four_channel_phase_distribution_0/v3_four_channel_output_collection_0/v3_four_channel_placement_0/v3_channel_selector_late_promotion_1/v3_selector_route_pilot_0/G1_LO_P_AND/a_59_75# VGND VGND sky130_fd_pr__nfet_01v8 ad=0.182 pd=1.86 as=0 ps=0 w=0.65 l=0.15
X1806 v3_four_channel_output_load_integration_0/v3_four_channel_shared_support_integration_0/v3_four_channel_bias_reference_distribution_0/v3_four_channel_phase_distribution_0/v3_four_channel_output_collection_0/v3_four_channel_placement_0/v3_channel_selector_late_promotion_1/v3_selector_route_pilot_0/G1_LO_P_AND/a_145_75# v3_four_channel_output_load_integration_0/v3_four_channel_shared_support_integration_0/v3_four_channel_bias_reference_distribution_0/v3_four_channel_phase_distribution_0/v3_four_channel_output_collection_0/v3_four_channel_placement_0/v3_channel_selector_late_promotion_1/v3_selector_route_pilot_0/G1_MUX_AXIS/X v3_four_channel_output_load_integration_0/v3_four_channel_shared_support_integration_0/v3_four_channel_bias_reference_distribution_0/v3_four_channel_phase_distribution_0/v3_four_channel_output_collection_0/v3_four_channel_placement_0/v3_channel_selector_late_promotion_1/v3_selector_route_pilot_0/G1_LO_P_AND/a_59_75# VGND sky130_fd_pr__nfet_01v8 ad=0 pd=0 as=0.1176 ps=1.4 w=0.42 l=0.15
X1807 VDPWR v3_four_channel_output_load_integration_0/v3_four_channel_shared_support_integration_0/v3_four_channel_bias_reference_distribution_0/v3_four_channel_phase_distribution_0/v3_four_channel_output_collection_0/v3_four_channel_placement_0/v3_channel_selector_late_promotion_1/v3_selector_route_pilot_0/G0_MUX_POS/a_505_21# v3_four_channel_output_load_integration_0/v3_four_channel_shared_support_integration_0/v3_four_channel_bias_reference_distribution_0/v3_four_channel_phase_distribution_0/v3_four_channel_output_collection_0/v3_four_channel_placement_0/v3_channel_selector_late_promotion_1/v3_selector_route_pilot_0/G0_MUX_POS/a_535_374# VDPWR sky130_fd_pr__pfet_01v8_hvt ad=0 pd=0 as=0.0882 ps=1.26 w=0.42 l=0.15
X1808 v3_four_channel_output_load_integration_0/v3_four_channel_shared_support_integration_0/v3_four_channel_bias_reference_distribution_0/v3_four_channel_phase_distribution_0/v3_four_channel_output_collection_0/v3_four_channel_placement_0/v3_channel_selector_late_promotion_1/v3_selector_route_pilot_0/G0_MUX_POS/a_505_21# V3R213 VDPWR VDPWR sky130_fd_pr__pfet_01v8_hvt ad=0.1176 pd=1.4 as=0 ps=0 w=0.42 l=0.15
X1809 v3_four_channel_output_load_integration_0/v3_four_channel_shared_support_integration_0/v3_four_channel_bias_reference_distribution_0/v3_four_channel_phase_distribution_0/v3_four_channel_output_collection_0/v3_four_channel_placement_0/v3_channel_selector_late_promotion_1/v3_selector_route_pilot_0/G0_MUX_POS/a_218_374# V3R213 VDPWR VDPWR sky130_fd_pr__pfet_01v8_hvt ad=0.1533 pd=1.57 as=0 ps=0 w=0.42 l=0.15
X1810 VGND v3_four_channel_output_load_integration_0/v3_four_channel_shared_support_integration_0/v3_four_channel_bias_reference_distribution_0/v3_four_channel_phase_distribution_0/v3_four_channel_output_collection_0/v3_four_channel_placement_0/v3_channel_selector_late_promotion_1/v3_selector_route_pilot_0/G0_MUX_POS/a_505_21# v3_four_channel_output_load_integration_0/v3_four_channel_shared_support_integration_0/v3_four_channel_bias_reference_distribution_0/v3_four_channel_phase_distribution_0/v3_four_channel_output_collection_0/v3_four_channel_placement_0/v3_channel_selector_late_promotion_1/v3_selector_route_pilot_0/G0_MUX_POS/a_439_47# VGND sky130_fd_pr__nfet_01v8 ad=0 pd=0 as=0.1386 ps=1.5 w=0.42 l=0.15
X1811 v3_four_channel_output_load_integration_0/v3_four_channel_shared_support_integration_0/v3_four_channel_bias_reference_distribution_0/v3_four_channel_phase_distribution_0/v3_four_channel_output_collection_0/v3_four_channel_placement_0/v3_channel_selector_late_promotion_1/v3_selector_route_pilot_0/G0_MUX_POS/a_76_199# V3R290 v3_four_channel_output_load_integration_0/v3_four_channel_shared_support_integration_0/v3_four_channel_bias_reference_distribution_0/v3_four_channel_phase_distribution_0/v3_four_channel_output_collection_0/v3_four_channel_placement_0/v3_channel_selector_late_promotion_1/v3_selector_route_pilot_0/G0_MUX_POS/a_218_374# VDPWR sky130_fd_pr__pfet_01v8_hvt ad=0.3864 pd=2.68 as=0 ps=0 w=0.42 l=0.15
X1812 v3_four_channel_output_load_integration_0/v3_four_channel_shared_support_integration_0/v3_four_channel_bias_reference_distribution_0/v3_four_channel_phase_distribution_0/v3_four_channel_output_collection_0/v3_four_channel_placement_0/v3_channel_selector_late_promotion_1/v3_selector_route_pilot_0/G0_MUX_POS/a_505_21# V3R213 VGND VGND sky130_fd_pr__nfet_01v8 ad=0.1092 pd=1.36 as=0 ps=0 w=0.42 l=0.15
X1813 v3_four_channel_output_load_integration_0/v3_four_channel_shared_support_integration_0/v3_four_channel_bias_reference_distribution_0/v3_four_channel_phase_distribution_0/v3_four_channel_output_collection_0/v3_four_channel_placement_0/v3_channel_selector_late_promotion_1/v3_selector_route_pilot_0/G0_MUX_POS/a_439_47# V3R290 v3_four_channel_output_load_integration_0/v3_four_channel_shared_support_integration_0/v3_four_channel_bias_reference_distribution_0/v3_four_channel_phase_distribution_0/v3_four_channel_output_collection_0/v3_four_channel_placement_0/v3_channel_selector_late_promotion_1/v3_selector_route_pilot_0/G0_MUX_POS/a_76_199# VGND sky130_fd_pr__nfet_01v8 ad=0 pd=0 as=0.1995 ps=1.79 w=0.42 l=0.15
X1814 v3_four_channel_output_load_integration_0/v3_four_channel_shared_support_integration_0/v3_four_channel_bias_reference_distribution_0/v3_four_channel_phase_distribution_0/v3_four_channel_output_collection_0/v3_four_channel_placement_0/v3_channel_selector_late_promotion_1/v3_selector_route_pilot_0/G0_MUX_POS/a_535_374# V3R291 v3_four_channel_output_load_integration_0/v3_four_channel_shared_support_integration_0/v3_four_channel_bias_reference_distribution_0/v3_four_channel_phase_distribution_0/v3_four_channel_output_collection_0/v3_four_channel_placement_0/v3_channel_selector_late_promotion_1/v3_selector_route_pilot_0/G0_MUX_POS/a_76_199# VDPWR sky130_fd_pr__pfet_01v8_hvt ad=0 pd=0 as=0 ps=0 w=0.42 l=0.15
X1815 v3_four_channel_output_load_integration_0/v3_four_channel_shared_support_integration_0/v3_four_channel_bias_reference_distribution_0/v3_four_channel_phase_distribution_0/v3_four_channel_output_collection_0/v3_four_channel_placement_0/v3_channel_selector_late_promotion_1/v3_selector_route_pilot_0/G0_MUX_POS/a_76_199# V3R291 v3_four_channel_output_load_integration_0/v3_four_channel_shared_support_integration_0/v3_four_channel_bias_reference_distribution_0/v3_four_channel_phase_distribution_0/v3_four_channel_output_collection_0/v3_four_channel_placement_0/v3_channel_selector_late_promotion_1/v3_selector_route_pilot_0/G0_MUX_POS/a_218_47# VGND sky130_fd_pr__nfet_01v8 ad=0 pd=0 as=0.1386 ps=1.5 w=0.42 l=0.15
X1816 v3_four_channel_output_load_integration_0/v3_four_channel_shared_support_integration_0/v3_four_channel_bias_reference_distribution_0/v3_four_channel_phase_distribution_0/v3_four_channel_output_collection_0/v3_four_channel_placement_0/v3_channel_selector_late_promotion_1/v3_selector_route_pilot_0/G0_MUX_POS/a_218_47# V3R213 VGND VGND sky130_fd_pr__nfet_01v8 ad=0 pd=0 as=0 ps=0 w=0.42 l=0.15
X1817 VDPWR v3_four_channel_output_load_integration_0/v3_four_channel_shared_support_integration_0/v3_four_channel_bias_reference_distribution_0/v3_four_channel_phase_distribution_0/v3_four_channel_output_collection_0/v3_four_channel_placement_0/v3_channel_selector_late_promotion_1/v3_selector_route_pilot_0/G0_MUX_POS/a_76_199# v3_four_channel_output_load_integration_0/v3_four_channel_shared_support_integration_0/v3_four_channel_bias_reference_distribution_0/v3_four_channel_phase_distribution_0/v3_four_channel_output_collection_0/v3_four_channel_placement_0/v3_channel_selector_late_promotion_1/v3_selector_route_pilot_0/G0_MUX_POS/X VDPWR sky130_fd_pr__pfet_01v8_hvt ad=0 pd=0 as=0.26 ps=2.52 w=1 l=0.15
X1818 VGND v3_four_channel_output_load_integration_0/v3_four_channel_shared_support_integration_0/v3_four_channel_bias_reference_distribution_0/v3_four_channel_phase_distribution_0/v3_four_channel_output_collection_0/v3_four_channel_placement_0/v3_channel_selector_late_promotion_1/v3_selector_route_pilot_0/G0_MUX_POS/a_76_199# v3_four_channel_output_load_integration_0/v3_four_channel_shared_support_integration_0/v3_four_channel_bias_reference_distribution_0/v3_four_channel_phase_distribution_0/v3_four_channel_output_collection_0/v3_four_channel_placement_0/v3_channel_selector_late_promotion_1/v3_selector_route_pilot_0/G0_MUX_POS/X VGND sky130_fd_pr__nfet_01v8 ad=0 pd=0 as=0.169 ps=1.82 w=0.65 l=0.15
X1819 VDPWR v3_four_channel_output_load_integration_0/v3_four_channel_shared_support_integration_0/v3_four_channel_bias_reference_distribution_0/v3_four_channel_phase_distribution_0/v3_four_channel_output_collection_0/v3_four_channel_placement_0/v3_channel_selector_late_promotion_1/v3_selector_route_pilot_0/G0_MUX_NEG/a_505_21# v3_four_channel_output_load_integration_0/v3_four_channel_shared_support_integration_0/v3_four_channel_bias_reference_distribution_0/v3_four_channel_phase_distribution_0/v3_four_channel_output_collection_0/v3_four_channel_placement_0/v3_channel_selector_late_promotion_1/v3_selector_route_pilot_0/G0_MUX_NEG/a_535_374# VDPWR sky130_fd_pr__pfet_01v8_hvt ad=0 pd=0 as=0.0882 ps=1.26 w=0.42 l=0.15
X1820 v3_four_channel_output_load_integration_0/v3_four_channel_shared_support_integration_0/v3_four_channel_bias_reference_distribution_0/v3_four_channel_phase_distribution_0/v3_four_channel_output_collection_0/v3_four_channel_placement_0/v3_channel_selector_late_promotion_1/v3_selector_route_pilot_0/G0_MUX_NEG/a_505_21# V3R213 VDPWR VDPWR sky130_fd_pr__pfet_01v8_hvt ad=0.1176 pd=1.4 as=0 ps=0 w=0.42 l=0.15
X1821 v3_four_channel_output_load_integration_0/v3_four_channel_shared_support_integration_0/v3_four_channel_bias_reference_distribution_0/v3_four_channel_phase_distribution_0/v3_four_channel_output_collection_0/v3_four_channel_placement_0/v3_channel_selector_late_promotion_1/v3_selector_route_pilot_0/G0_MUX_NEG/a_218_374# V3R213 VDPWR VDPWR sky130_fd_pr__pfet_01v8_hvt ad=0.1533 pd=1.57 as=0 ps=0 w=0.42 l=0.15
X1822 VGND v3_four_channel_output_load_integration_0/v3_four_channel_shared_support_integration_0/v3_four_channel_bias_reference_distribution_0/v3_four_channel_phase_distribution_0/v3_four_channel_output_collection_0/v3_four_channel_placement_0/v3_channel_selector_late_promotion_1/v3_selector_route_pilot_0/G0_MUX_NEG/a_505_21# v3_four_channel_output_load_integration_0/v3_four_channel_shared_support_integration_0/v3_four_channel_bias_reference_distribution_0/v3_four_channel_phase_distribution_0/v3_four_channel_output_collection_0/v3_four_channel_placement_0/v3_channel_selector_late_promotion_1/v3_selector_route_pilot_0/G0_MUX_NEG/a_439_47# VGND sky130_fd_pr__nfet_01v8 ad=0 pd=0 as=0.1386 ps=1.5 w=0.42 l=0.15
X1823 v3_four_channel_output_load_integration_0/v3_four_channel_shared_support_integration_0/v3_four_channel_bias_reference_distribution_0/v3_four_channel_phase_distribution_0/v3_four_channel_output_collection_0/v3_four_channel_placement_0/v3_channel_selector_late_promotion_1/v3_selector_route_pilot_0/G0_MUX_NEG/a_76_199# V3R292 v3_four_channel_output_load_integration_0/v3_four_channel_shared_support_integration_0/v3_four_channel_bias_reference_distribution_0/v3_four_channel_phase_distribution_0/v3_four_channel_output_collection_0/v3_four_channel_placement_0/v3_channel_selector_late_promotion_1/v3_selector_route_pilot_0/G0_MUX_NEG/a_218_374# VDPWR sky130_fd_pr__pfet_01v8_hvt ad=0.3864 pd=2.68 as=0 ps=0 w=0.42 l=0.15
X1824 v3_four_channel_output_load_integration_0/v3_four_channel_shared_support_integration_0/v3_four_channel_bias_reference_distribution_0/v3_four_channel_phase_distribution_0/v3_four_channel_output_collection_0/v3_four_channel_placement_0/v3_channel_selector_late_promotion_1/v3_selector_route_pilot_0/G0_MUX_NEG/a_505_21# V3R213 VGND VGND sky130_fd_pr__nfet_01v8 ad=0.1092 pd=1.36 as=0 ps=0 w=0.42 l=0.15
X1825 v3_four_channel_output_load_integration_0/v3_four_channel_shared_support_integration_0/v3_four_channel_bias_reference_distribution_0/v3_four_channel_phase_distribution_0/v3_four_channel_output_collection_0/v3_four_channel_placement_0/v3_channel_selector_late_promotion_1/v3_selector_route_pilot_0/G0_MUX_NEG/a_439_47# V3R292 v3_four_channel_output_load_integration_0/v3_four_channel_shared_support_integration_0/v3_four_channel_bias_reference_distribution_0/v3_four_channel_phase_distribution_0/v3_four_channel_output_collection_0/v3_four_channel_placement_0/v3_channel_selector_late_promotion_1/v3_selector_route_pilot_0/G0_MUX_NEG/a_76_199# VGND sky130_fd_pr__nfet_01v8 ad=0 pd=0 as=0.1995 ps=1.79 w=0.42 l=0.15
X1826 v3_four_channel_output_load_integration_0/v3_four_channel_shared_support_integration_0/v3_four_channel_bias_reference_distribution_0/v3_four_channel_phase_distribution_0/v3_four_channel_output_collection_0/v3_four_channel_placement_0/v3_channel_selector_late_promotion_1/v3_selector_route_pilot_0/G0_MUX_NEG/a_535_374# V3R293 v3_four_channel_output_load_integration_0/v3_four_channel_shared_support_integration_0/v3_four_channel_bias_reference_distribution_0/v3_four_channel_phase_distribution_0/v3_four_channel_output_collection_0/v3_four_channel_placement_0/v3_channel_selector_late_promotion_1/v3_selector_route_pilot_0/G0_MUX_NEG/a_76_199# VDPWR sky130_fd_pr__pfet_01v8_hvt ad=0 pd=0 as=0 ps=0 w=0.42 l=0.15
X1827 v3_four_channel_output_load_integration_0/v3_four_channel_shared_support_integration_0/v3_four_channel_bias_reference_distribution_0/v3_four_channel_phase_distribution_0/v3_four_channel_output_collection_0/v3_four_channel_placement_0/v3_channel_selector_late_promotion_1/v3_selector_route_pilot_0/G0_MUX_NEG/a_76_199# V3R293 v3_four_channel_output_load_integration_0/v3_four_channel_shared_support_integration_0/v3_four_channel_bias_reference_distribution_0/v3_four_channel_phase_distribution_0/v3_four_channel_output_collection_0/v3_four_channel_placement_0/v3_channel_selector_late_promotion_1/v3_selector_route_pilot_0/G0_MUX_NEG/a_218_47# VGND sky130_fd_pr__nfet_01v8 ad=0 pd=0 as=0.1386 ps=1.5 w=0.42 l=0.15
X1828 v3_four_channel_output_load_integration_0/v3_four_channel_shared_support_integration_0/v3_four_channel_bias_reference_distribution_0/v3_four_channel_phase_distribution_0/v3_four_channel_output_collection_0/v3_four_channel_placement_0/v3_channel_selector_late_promotion_1/v3_selector_route_pilot_0/G0_MUX_NEG/a_218_47# V3R213 VGND VGND sky130_fd_pr__nfet_01v8 ad=0 pd=0 as=0 ps=0 w=0.42 l=0.15
X1829 VDPWR v3_four_channel_output_load_integration_0/v3_four_channel_shared_support_integration_0/v3_four_channel_bias_reference_distribution_0/v3_four_channel_phase_distribution_0/v3_four_channel_output_collection_0/v3_four_channel_placement_0/v3_channel_selector_late_promotion_1/v3_selector_route_pilot_0/G0_MUX_NEG/a_76_199# v3_four_channel_output_load_integration_0/v3_four_channel_shared_support_integration_0/v3_four_channel_bias_reference_distribution_0/v3_four_channel_phase_distribution_0/v3_four_channel_output_collection_0/v3_four_channel_placement_0/v3_channel_selector_late_promotion_1/v3_selector_route_pilot_0/G0_MUX_NEG/X VDPWR sky130_fd_pr__pfet_01v8_hvt ad=0 pd=0 as=0.26 ps=2.52 w=1 l=0.15
X1830 VGND v3_four_channel_output_load_integration_0/v3_four_channel_shared_support_integration_0/v3_four_channel_bias_reference_distribution_0/v3_four_channel_phase_distribution_0/v3_four_channel_output_collection_0/v3_four_channel_placement_0/v3_channel_selector_late_promotion_1/v3_selector_route_pilot_0/G0_MUX_NEG/a_76_199# v3_four_channel_output_load_integration_0/v3_four_channel_shared_support_integration_0/v3_four_channel_bias_reference_distribution_0/v3_four_channel_phase_distribution_0/v3_four_channel_output_collection_0/v3_four_channel_placement_0/v3_channel_selector_late_promotion_1/v3_selector_route_pilot_0/G0_MUX_NEG/X VGND sky130_fd_pr__nfet_01v8 ad=0 pd=0 as=0.169 ps=1.82 w=0.65 l=0.15
X1831 VDPWR v3_four_channel_output_load_integration_0/v3_four_channel_shared_support_integration_0/v3_four_channel_bias_reference_distribution_0/v3_four_channel_phase_distribution_0/v3_four_channel_output_collection_0/v3_four_channel_placement_0/v3_channel_selector_late_promotion_1/v3_selector_route_pilot_0/G2_MUX_AXIS/a_505_21# v3_four_channel_output_load_integration_0/v3_four_channel_shared_support_integration_0/v3_four_channel_bias_reference_distribution_0/v3_four_channel_phase_distribution_0/v3_four_channel_output_collection_0/v3_four_channel_placement_0/v3_channel_selector_late_promotion_1/v3_selector_route_pilot_0/G2_MUX_AXIS/a_535_374# VDPWR sky130_fd_pr__pfet_01v8_hvt ad=0 pd=0 as=0.0882 ps=1.26 w=0.42 l=0.15
X1832 v3_four_channel_output_load_integration_0/v3_four_channel_shared_support_integration_0/v3_four_channel_bias_reference_distribution_0/v3_four_channel_phase_distribution_0/v3_four_channel_output_collection_0/v3_four_channel_placement_0/v3_channel_selector_late_promotion_1/v3_selector_route_pilot_0/G2_MUX_AXIS/a_505_21# V3R219 VDPWR VDPWR sky130_fd_pr__pfet_01v8_hvt ad=0.1176 pd=1.4 as=0 ps=0 w=0.42 l=0.15
X1833 v3_four_channel_output_load_integration_0/v3_four_channel_shared_support_integration_0/v3_four_channel_bias_reference_distribution_0/v3_four_channel_phase_distribution_0/v3_four_channel_output_collection_0/v3_four_channel_placement_0/v3_channel_selector_late_promotion_1/v3_selector_route_pilot_0/G2_MUX_AXIS/a_218_374# V3R219 VDPWR VDPWR sky130_fd_pr__pfet_01v8_hvt ad=0.1533 pd=1.57 as=0 ps=0 w=0.42 l=0.15
X1834 VGND v3_four_channel_output_load_integration_0/v3_four_channel_shared_support_integration_0/v3_four_channel_bias_reference_distribution_0/v3_four_channel_phase_distribution_0/v3_four_channel_output_collection_0/v3_four_channel_placement_0/v3_channel_selector_late_promotion_1/v3_selector_route_pilot_0/G2_MUX_AXIS/a_505_21# v3_four_channel_output_load_integration_0/v3_four_channel_shared_support_integration_0/v3_four_channel_bias_reference_distribution_0/v3_four_channel_phase_distribution_0/v3_four_channel_output_collection_0/v3_four_channel_placement_0/v3_channel_selector_late_promotion_1/v3_selector_route_pilot_0/G2_MUX_AXIS/a_439_47# VGND sky130_fd_pr__nfet_01v8 ad=0 pd=0 as=0.1386 ps=1.5 w=0.42 l=0.15
X1835 v3_four_channel_output_load_integration_0/v3_four_channel_shared_support_integration_0/v3_four_channel_bias_reference_distribution_0/v3_four_channel_phase_distribution_0/v3_four_channel_output_collection_0/v3_four_channel_placement_0/v3_channel_selector_late_promotion_1/v3_selector_route_pilot_0/G2_MUX_AXIS/a_76_199# v3_four_channel_output_load_integration_0/v3_four_channel_shared_support_integration_0/v3_four_channel_bias_reference_distribution_0/v3_four_channel_phase_distribution_0/v3_four_channel_output_collection_0/v3_four_channel_placement_0/v3_channel_selector_late_promotion_1/v3_selector_route_pilot_0/G2_MUX_POS/X v3_four_channel_output_load_integration_0/v3_four_channel_shared_support_integration_0/v3_four_channel_bias_reference_distribution_0/v3_four_channel_phase_distribution_0/v3_four_channel_output_collection_0/v3_four_channel_placement_0/v3_channel_selector_late_promotion_1/v3_selector_route_pilot_0/G2_MUX_AXIS/a_218_374# VDPWR sky130_fd_pr__pfet_01v8_hvt ad=0.3864 pd=2.68 as=0 ps=0 w=0.42 l=0.15
X1836 v3_four_channel_output_load_integration_0/v3_four_channel_shared_support_integration_0/v3_four_channel_bias_reference_distribution_0/v3_four_channel_phase_distribution_0/v3_four_channel_output_collection_0/v3_four_channel_placement_0/v3_channel_selector_late_promotion_1/v3_selector_route_pilot_0/G2_MUX_AXIS/a_505_21# V3R219 VGND VGND sky130_fd_pr__nfet_01v8 ad=0.1092 pd=1.36 as=0 ps=0 w=0.42 l=0.15
X1837 v3_four_channel_output_load_integration_0/v3_four_channel_shared_support_integration_0/v3_four_channel_bias_reference_distribution_0/v3_four_channel_phase_distribution_0/v3_four_channel_output_collection_0/v3_four_channel_placement_0/v3_channel_selector_late_promotion_1/v3_selector_route_pilot_0/G2_MUX_AXIS/a_439_47# v3_four_channel_output_load_integration_0/v3_four_channel_shared_support_integration_0/v3_four_channel_bias_reference_distribution_0/v3_four_channel_phase_distribution_0/v3_four_channel_output_collection_0/v3_four_channel_placement_0/v3_channel_selector_late_promotion_1/v3_selector_route_pilot_0/G2_MUX_POS/X v3_four_channel_output_load_integration_0/v3_four_channel_shared_support_integration_0/v3_four_channel_bias_reference_distribution_0/v3_four_channel_phase_distribution_0/v3_four_channel_output_collection_0/v3_four_channel_placement_0/v3_channel_selector_late_promotion_1/v3_selector_route_pilot_0/G2_MUX_AXIS/a_76_199# VGND sky130_fd_pr__nfet_01v8 ad=0 pd=0 as=0.1995 ps=1.79 w=0.42 l=0.15
X1838 v3_four_channel_output_load_integration_0/v3_four_channel_shared_support_integration_0/v3_four_channel_bias_reference_distribution_0/v3_four_channel_phase_distribution_0/v3_four_channel_output_collection_0/v3_four_channel_placement_0/v3_channel_selector_late_promotion_1/v3_selector_route_pilot_0/G2_MUX_AXIS/a_535_374# v3_four_channel_output_load_integration_0/v3_four_channel_shared_support_integration_0/v3_four_channel_bias_reference_distribution_0/v3_four_channel_phase_distribution_0/v3_four_channel_output_collection_0/v3_four_channel_placement_0/v3_channel_selector_late_promotion_1/v3_selector_route_pilot_0/G2_MUX_NEG/X v3_four_channel_output_load_integration_0/v3_four_channel_shared_support_integration_0/v3_four_channel_bias_reference_distribution_0/v3_four_channel_phase_distribution_0/v3_four_channel_output_collection_0/v3_four_channel_placement_0/v3_channel_selector_late_promotion_1/v3_selector_route_pilot_0/G2_MUX_AXIS/a_76_199# VDPWR sky130_fd_pr__pfet_01v8_hvt ad=0 pd=0 as=0 ps=0 w=0.42 l=0.15
X1839 v3_four_channel_output_load_integration_0/v3_four_channel_shared_support_integration_0/v3_four_channel_bias_reference_distribution_0/v3_four_channel_phase_distribution_0/v3_four_channel_output_collection_0/v3_four_channel_placement_0/v3_channel_selector_late_promotion_1/v3_selector_route_pilot_0/G2_MUX_AXIS/a_76_199# v3_four_channel_output_load_integration_0/v3_four_channel_shared_support_integration_0/v3_four_channel_bias_reference_distribution_0/v3_four_channel_phase_distribution_0/v3_four_channel_output_collection_0/v3_four_channel_placement_0/v3_channel_selector_late_promotion_1/v3_selector_route_pilot_0/G2_MUX_NEG/X v3_four_channel_output_load_integration_0/v3_four_channel_shared_support_integration_0/v3_four_channel_bias_reference_distribution_0/v3_four_channel_phase_distribution_0/v3_four_channel_output_collection_0/v3_four_channel_placement_0/v3_channel_selector_late_promotion_1/v3_selector_route_pilot_0/G2_MUX_AXIS/a_218_47# VGND sky130_fd_pr__nfet_01v8 ad=0 pd=0 as=0.1386 ps=1.5 w=0.42 l=0.15
X1840 v3_four_channel_output_load_integration_0/v3_four_channel_shared_support_integration_0/v3_four_channel_bias_reference_distribution_0/v3_four_channel_phase_distribution_0/v3_four_channel_output_collection_0/v3_four_channel_placement_0/v3_channel_selector_late_promotion_1/v3_selector_route_pilot_0/G2_MUX_AXIS/a_218_47# V3R219 VGND VGND sky130_fd_pr__nfet_01v8 ad=0 pd=0 as=0 ps=0 w=0.42 l=0.15
X1841 VDPWR v3_four_channel_output_load_integration_0/v3_four_channel_shared_support_integration_0/v3_four_channel_bias_reference_distribution_0/v3_four_channel_phase_distribution_0/v3_four_channel_output_collection_0/v3_four_channel_placement_0/v3_channel_selector_late_promotion_1/v3_selector_route_pilot_0/G2_MUX_AXIS/a_76_199# v3_four_channel_output_load_integration_0/v3_four_channel_shared_support_integration_0/v3_four_channel_bias_reference_distribution_0/v3_four_channel_phase_distribution_0/v3_four_channel_output_collection_0/v3_four_channel_placement_0/v3_channel_selector_late_promotion_1/v3_selector_route_pilot_0/G2_MUX_AXIS/X VDPWR sky130_fd_pr__pfet_01v8_hvt ad=0 pd=0 as=0.26 ps=2.52 w=1 l=0.15
X1842 VGND v3_four_channel_output_load_integration_0/v3_four_channel_shared_support_integration_0/v3_four_channel_bias_reference_distribution_0/v3_four_channel_phase_distribution_0/v3_four_channel_output_collection_0/v3_four_channel_placement_0/v3_channel_selector_late_promotion_1/v3_selector_route_pilot_0/G2_MUX_AXIS/a_76_199# v3_four_channel_output_load_integration_0/v3_four_channel_shared_support_integration_0/v3_four_channel_bias_reference_distribution_0/v3_four_channel_phase_distribution_0/v3_four_channel_output_collection_0/v3_four_channel_placement_0/v3_channel_selector_late_promotion_1/v3_selector_route_pilot_0/G2_MUX_AXIS/X VGND sky130_fd_pr__nfet_01v8 ad=0 pd=0 as=0.169 ps=1.82 w=0.65 l=0.15
X1843 VDPWR v3_four_channel_output_load_integration_0/v3_four_channel_shared_support_integration_0/v3_four_channel_bias_reference_distribution_0/v3_four_channel_phase_distribution_0/v3_four_channel_output_collection_0/v3_four_channel_placement_0/v3_channel_selector_late_promotion_1/v3_selector_route_pilot_0/G3_MUX_POS/a_505_21# v3_four_channel_output_load_integration_0/v3_four_channel_shared_support_integration_0/v3_four_channel_bias_reference_distribution_0/v3_four_channel_phase_distribution_0/v3_four_channel_output_collection_0/v3_four_channel_placement_0/v3_channel_selector_late_promotion_1/v3_selector_route_pilot_0/G3_MUX_POS/a_535_374# VDPWR sky130_fd_pr__pfet_01v8_hvt ad=0 pd=0 as=0.0882 ps=1.26 w=0.42 l=0.15
X1844 v3_four_channel_output_load_integration_0/v3_four_channel_shared_support_integration_0/v3_four_channel_bias_reference_distribution_0/v3_four_channel_phase_distribution_0/v3_four_channel_output_collection_0/v3_four_channel_placement_0/v3_channel_selector_late_promotion_1/v3_selector_route_pilot_0/G3_MUX_POS/a_505_21# V3R220 VDPWR VDPWR sky130_fd_pr__pfet_01v8_hvt ad=0.1176 pd=1.4 as=0 ps=0 w=0.42 l=0.15
X1845 v3_four_channel_output_load_integration_0/v3_four_channel_shared_support_integration_0/v3_four_channel_bias_reference_distribution_0/v3_four_channel_phase_distribution_0/v3_four_channel_output_collection_0/v3_four_channel_placement_0/v3_channel_selector_late_promotion_1/v3_selector_route_pilot_0/G3_MUX_POS/a_218_374# V3R220 VDPWR VDPWR sky130_fd_pr__pfet_01v8_hvt ad=0.1533 pd=1.57 as=0 ps=0 w=0.42 l=0.15
X1846 VGND v3_four_channel_output_load_integration_0/v3_four_channel_shared_support_integration_0/v3_four_channel_bias_reference_distribution_0/v3_four_channel_phase_distribution_0/v3_four_channel_output_collection_0/v3_four_channel_placement_0/v3_channel_selector_late_promotion_1/v3_selector_route_pilot_0/G3_MUX_POS/a_505_21# v3_four_channel_output_load_integration_0/v3_four_channel_shared_support_integration_0/v3_four_channel_bias_reference_distribution_0/v3_four_channel_phase_distribution_0/v3_four_channel_output_collection_0/v3_four_channel_placement_0/v3_channel_selector_late_promotion_1/v3_selector_route_pilot_0/G3_MUX_POS/a_439_47# VGND sky130_fd_pr__nfet_01v8 ad=0 pd=0 as=0.1386 ps=1.5 w=0.42 l=0.15
X1847 v3_four_channel_output_load_integration_0/v3_four_channel_shared_support_integration_0/v3_four_channel_bias_reference_distribution_0/v3_four_channel_phase_distribution_0/v3_four_channel_output_collection_0/v3_four_channel_placement_0/v3_channel_selector_late_promotion_1/v3_selector_route_pilot_0/G3_MUX_POS/a_76_199# V3R290 v3_four_channel_output_load_integration_0/v3_four_channel_shared_support_integration_0/v3_four_channel_bias_reference_distribution_0/v3_four_channel_phase_distribution_0/v3_four_channel_output_collection_0/v3_four_channel_placement_0/v3_channel_selector_late_promotion_1/v3_selector_route_pilot_0/G3_MUX_POS/a_218_374# VDPWR sky130_fd_pr__pfet_01v8_hvt ad=0.3864 pd=2.68 as=0 ps=0 w=0.42 l=0.15
X1848 v3_four_channel_output_load_integration_0/v3_four_channel_shared_support_integration_0/v3_four_channel_bias_reference_distribution_0/v3_four_channel_phase_distribution_0/v3_four_channel_output_collection_0/v3_four_channel_placement_0/v3_channel_selector_late_promotion_1/v3_selector_route_pilot_0/G3_MUX_POS/a_505_21# V3R220 VGND VGND sky130_fd_pr__nfet_01v8 ad=0.1092 pd=1.36 as=0 ps=0 w=0.42 l=0.15
X1849 v3_four_channel_output_load_integration_0/v3_four_channel_shared_support_integration_0/v3_four_channel_bias_reference_distribution_0/v3_four_channel_phase_distribution_0/v3_four_channel_output_collection_0/v3_four_channel_placement_0/v3_channel_selector_late_promotion_1/v3_selector_route_pilot_0/G3_MUX_POS/a_439_47# V3R290 v3_four_channel_output_load_integration_0/v3_four_channel_shared_support_integration_0/v3_four_channel_bias_reference_distribution_0/v3_four_channel_phase_distribution_0/v3_four_channel_output_collection_0/v3_four_channel_placement_0/v3_channel_selector_late_promotion_1/v3_selector_route_pilot_0/G3_MUX_POS/a_76_199# VGND sky130_fd_pr__nfet_01v8 ad=0 pd=0 as=0.1995 ps=1.79 w=0.42 l=0.15
X1850 v3_four_channel_output_load_integration_0/v3_four_channel_shared_support_integration_0/v3_four_channel_bias_reference_distribution_0/v3_four_channel_phase_distribution_0/v3_four_channel_output_collection_0/v3_four_channel_placement_0/v3_channel_selector_late_promotion_1/v3_selector_route_pilot_0/G3_MUX_POS/a_535_374# V3R291 v3_four_channel_output_load_integration_0/v3_four_channel_shared_support_integration_0/v3_four_channel_bias_reference_distribution_0/v3_four_channel_phase_distribution_0/v3_four_channel_output_collection_0/v3_four_channel_placement_0/v3_channel_selector_late_promotion_1/v3_selector_route_pilot_0/G3_MUX_POS/a_76_199# VDPWR sky130_fd_pr__pfet_01v8_hvt ad=0 pd=0 as=0 ps=0 w=0.42 l=0.15
X1851 v3_four_channel_output_load_integration_0/v3_four_channel_shared_support_integration_0/v3_four_channel_bias_reference_distribution_0/v3_four_channel_phase_distribution_0/v3_four_channel_output_collection_0/v3_four_channel_placement_0/v3_channel_selector_late_promotion_1/v3_selector_route_pilot_0/G3_MUX_POS/a_76_199# V3R291 v3_four_channel_output_load_integration_0/v3_four_channel_shared_support_integration_0/v3_four_channel_bias_reference_distribution_0/v3_four_channel_phase_distribution_0/v3_four_channel_output_collection_0/v3_four_channel_placement_0/v3_channel_selector_late_promotion_1/v3_selector_route_pilot_0/G3_MUX_POS/a_218_47# VGND sky130_fd_pr__nfet_01v8 ad=0 pd=0 as=0.1386 ps=1.5 w=0.42 l=0.15
X1852 v3_four_channel_output_load_integration_0/v3_four_channel_shared_support_integration_0/v3_four_channel_bias_reference_distribution_0/v3_four_channel_phase_distribution_0/v3_four_channel_output_collection_0/v3_four_channel_placement_0/v3_channel_selector_late_promotion_1/v3_selector_route_pilot_0/G3_MUX_POS/a_218_47# V3R220 VGND VGND sky130_fd_pr__nfet_01v8 ad=0 pd=0 as=0 ps=0 w=0.42 l=0.15
X1853 VDPWR v3_four_channel_output_load_integration_0/v3_four_channel_shared_support_integration_0/v3_four_channel_bias_reference_distribution_0/v3_four_channel_phase_distribution_0/v3_four_channel_output_collection_0/v3_four_channel_placement_0/v3_channel_selector_late_promotion_1/v3_selector_route_pilot_0/G3_MUX_POS/a_76_199# v3_four_channel_output_load_integration_0/v3_four_channel_shared_support_integration_0/v3_four_channel_bias_reference_distribution_0/v3_four_channel_phase_distribution_0/v3_four_channel_output_collection_0/v3_four_channel_placement_0/v3_channel_selector_late_promotion_1/v3_selector_route_pilot_0/G3_MUX_POS/X VDPWR sky130_fd_pr__pfet_01v8_hvt ad=0 pd=0 as=0.26 ps=2.52 w=1 l=0.15
X1854 VGND v3_four_channel_output_load_integration_0/v3_four_channel_shared_support_integration_0/v3_four_channel_bias_reference_distribution_0/v3_four_channel_phase_distribution_0/v3_four_channel_output_collection_0/v3_four_channel_placement_0/v3_channel_selector_late_promotion_1/v3_selector_route_pilot_0/G3_MUX_POS/a_76_199# v3_four_channel_output_load_integration_0/v3_four_channel_shared_support_integration_0/v3_four_channel_bias_reference_distribution_0/v3_four_channel_phase_distribution_0/v3_four_channel_output_collection_0/v3_four_channel_placement_0/v3_channel_selector_late_promotion_1/v3_selector_route_pilot_0/G3_MUX_POS/X VGND sky130_fd_pr__nfet_01v8 ad=0 pd=0 as=0.169 ps=1.82 w=0.65 l=0.15
X1855 VDPWR v3_four_channel_output_load_integration_0/v3_four_channel_shared_support_integration_0/v3_four_channel_bias_reference_distribution_0/v3_four_channel_phase_distribution_0/v3_four_channel_output_collection_0/v3_four_channel_placement_0/v3_channel_selector_late_promotion_1/v3_selector_route_pilot_0/G3_MUX_NEG/a_505_21# v3_four_channel_output_load_integration_0/v3_four_channel_shared_support_integration_0/v3_four_channel_bias_reference_distribution_0/v3_four_channel_phase_distribution_0/v3_four_channel_output_collection_0/v3_four_channel_placement_0/v3_channel_selector_late_promotion_1/v3_selector_route_pilot_0/G3_MUX_NEG/a_535_374# VDPWR sky130_fd_pr__pfet_01v8_hvt ad=0 pd=0 as=0.0882 ps=1.26 w=0.42 l=0.15
X1856 v3_four_channel_output_load_integration_0/v3_four_channel_shared_support_integration_0/v3_four_channel_bias_reference_distribution_0/v3_four_channel_phase_distribution_0/v3_four_channel_output_collection_0/v3_four_channel_placement_0/v3_channel_selector_late_promotion_1/v3_selector_route_pilot_0/G3_MUX_NEG/a_505_21# V3R220 VDPWR VDPWR sky130_fd_pr__pfet_01v8_hvt ad=0.1176 pd=1.4 as=0 ps=0 w=0.42 l=0.15
X1857 v3_four_channel_output_load_integration_0/v3_four_channel_shared_support_integration_0/v3_four_channel_bias_reference_distribution_0/v3_four_channel_phase_distribution_0/v3_four_channel_output_collection_0/v3_four_channel_placement_0/v3_channel_selector_late_promotion_1/v3_selector_route_pilot_0/G3_MUX_NEG/a_218_374# V3R220 VDPWR VDPWR sky130_fd_pr__pfet_01v8_hvt ad=0.1533 pd=1.57 as=0 ps=0 w=0.42 l=0.15
X1858 VGND v3_four_channel_output_load_integration_0/v3_four_channel_shared_support_integration_0/v3_four_channel_bias_reference_distribution_0/v3_four_channel_phase_distribution_0/v3_four_channel_output_collection_0/v3_four_channel_placement_0/v3_channel_selector_late_promotion_1/v3_selector_route_pilot_0/G3_MUX_NEG/a_505_21# v3_four_channel_output_load_integration_0/v3_four_channel_shared_support_integration_0/v3_four_channel_bias_reference_distribution_0/v3_four_channel_phase_distribution_0/v3_four_channel_output_collection_0/v3_four_channel_placement_0/v3_channel_selector_late_promotion_1/v3_selector_route_pilot_0/G3_MUX_NEG/a_439_47# VGND sky130_fd_pr__nfet_01v8 ad=0 pd=0 as=0.1386 ps=1.5 w=0.42 l=0.15
X1859 v3_four_channel_output_load_integration_0/v3_four_channel_shared_support_integration_0/v3_four_channel_bias_reference_distribution_0/v3_four_channel_phase_distribution_0/v3_four_channel_output_collection_0/v3_four_channel_placement_0/v3_channel_selector_late_promotion_1/v3_selector_route_pilot_0/G3_MUX_NEG/a_76_199# V3R292 v3_four_channel_output_load_integration_0/v3_four_channel_shared_support_integration_0/v3_four_channel_bias_reference_distribution_0/v3_four_channel_phase_distribution_0/v3_four_channel_output_collection_0/v3_four_channel_placement_0/v3_channel_selector_late_promotion_1/v3_selector_route_pilot_0/G3_MUX_NEG/a_218_374# VDPWR sky130_fd_pr__pfet_01v8_hvt ad=0.3864 pd=2.68 as=0 ps=0 w=0.42 l=0.15
X1860 v3_four_channel_output_load_integration_0/v3_four_channel_shared_support_integration_0/v3_four_channel_bias_reference_distribution_0/v3_four_channel_phase_distribution_0/v3_four_channel_output_collection_0/v3_four_channel_placement_0/v3_channel_selector_late_promotion_1/v3_selector_route_pilot_0/G3_MUX_NEG/a_505_21# V3R220 VGND VGND sky130_fd_pr__nfet_01v8 ad=0.1092 pd=1.36 as=0 ps=0 w=0.42 l=0.15
X1861 v3_four_channel_output_load_integration_0/v3_four_channel_shared_support_integration_0/v3_four_channel_bias_reference_distribution_0/v3_four_channel_phase_distribution_0/v3_four_channel_output_collection_0/v3_four_channel_placement_0/v3_channel_selector_late_promotion_1/v3_selector_route_pilot_0/G3_MUX_NEG/a_439_47# V3R292 v3_four_channel_output_load_integration_0/v3_four_channel_shared_support_integration_0/v3_four_channel_bias_reference_distribution_0/v3_four_channel_phase_distribution_0/v3_four_channel_output_collection_0/v3_four_channel_placement_0/v3_channel_selector_late_promotion_1/v3_selector_route_pilot_0/G3_MUX_NEG/a_76_199# VGND sky130_fd_pr__nfet_01v8 ad=0 pd=0 as=0.1995 ps=1.79 w=0.42 l=0.15
X1862 v3_four_channel_output_load_integration_0/v3_four_channel_shared_support_integration_0/v3_four_channel_bias_reference_distribution_0/v3_four_channel_phase_distribution_0/v3_four_channel_output_collection_0/v3_four_channel_placement_0/v3_channel_selector_late_promotion_1/v3_selector_route_pilot_0/G3_MUX_NEG/a_535_374# V3R293 v3_four_channel_output_load_integration_0/v3_four_channel_shared_support_integration_0/v3_four_channel_bias_reference_distribution_0/v3_four_channel_phase_distribution_0/v3_four_channel_output_collection_0/v3_four_channel_placement_0/v3_channel_selector_late_promotion_1/v3_selector_route_pilot_0/G3_MUX_NEG/a_76_199# VDPWR sky130_fd_pr__pfet_01v8_hvt ad=0 pd=0 as=0 ps=0 w=0.42 l=0.15
X1863 v3_four_channel_output_load_integration_0/v3_four_channel_shared_support_integration_0/v3_four_channel_bias_reference_distribution_0/v3_four_channel_phase_distribution_0/v3_four_channel_output_collection_0/v3_four_channel_placement_0/v3_channel_selector_late_promotion_1/v3_selector_route_pilot_0/G3_MUX_NEG/a_76_199# V3R293 v3_four_channel_output_load_integration_0/v3_four_channel_shared_support_integration_0/v3_four_channel_bias_reference_distribution_0/v3_four_channel_phase_distribution_0/v3_four_channel_output_collection_0/v3_four_channel_placement_0/v3_channel_selector_late_promotion_1/v3_selector_route_pilot_0/G3_MUX_NEG/a_218_47# VGND sky130_fd_pr__nfet_01v8 ad=0 pd=0 as=0.1386 ps=1.5 w=0.42 l=0.15
X1864 v3_four_channel_output_load_integration_0/v3_four_channel_shared_support_integration_0/v3_four_channel_bias_reference_distribution_0/v3_four_channel_phase_distribution_0/v3_four_channel_output_collection_0/v3_four_channel_placement_0/v3_channel_selector_late_promotion_1/v3_selector_route_pilot_0/G3_MUX_NEG/a_218_47# V3R220 VGND VGND sky130_fd_pr__nfet_01v8 ad=0 pd=0 as=0 ps=0 w=0.42 l=0.15
X1865 VDPWR v3_four_channel_output_load_integration_0/v3_four_channel_shared_support_integration_0/v3_four_channel_bias_reference_distribution_0/v3_four_channel_phase_distribution_0/v3_four_channel_output_collection_0/v3_four_channel_placement_0/v3_channel_selector_late_promotion_1/v3_selector_route_pilot_0/G3_MUX_NEG/a_76_199# v3_four_channel_output_load_integration_0/v3_four_channel_shared_support_integration_0/v3_four_channel_bias_reference_distribution_0/v3_four_channel_phase_distribution_0/v3_four_channel_output_collection_0/v3_four_channel_placement_0/v3_channel_selector_late_promotion_1/v3_selector_route_pilot_0/G3_MUX_NEG/X VDPWR sky130_fd_pr__pfet_01v8_hvt ad=0 pd=0 as=0.26 ps=2.52 w=1 l=0.15
X1866 VGND v3_four_channel_output_load_integration_0/v3_four_channel_shared_support_integration_0/v3_four_channel_bias_reference_distribution_0/v3_four_channel_phase_distribution_0/v3_four_channel_output_collection_0/v3_four_channel_placement_0/v3_channel_selector_late_promotion_1/v3_selector_route_pilot_0/G3_MUX_NEG/a_76_199# v3_four_channel_output_load_integration_0/v3_four_channel_shared_support_integration_0/v3_four_channel_bias_reference_distribution_0/v3_four_channel_phase_distribution_0/v3_four_channel_output_collection_0/v3_four_channel_placement_0/v3_channel_selector_late_promotion_1/v3_selector_route_pilot_0/G3_MUX_NEG/X VGND sky130_fd_pr__nfet_01v8 ad=0 pd=0 as=0.169 ps=1.82 w=0.65 l=0.15
X1867 VDPWR v3_four_channel_output_load_integration_0/v3_four_channel_shared_support_integration_0/v3_four_channel_bias_reference_distribution_0/v3_four_channel_phase_distribution_0/v3_four_channel_output_collection_0/v3_four_channel_placement_0/v3_channel_selector_late_promotion_1/v3_selector_route_pilot_0/G3_LO_P_AND/B v3_four_channel_output_load_integration_0/v3_four_channel_shared_support_integration_0/v3_four_channel_bias_reference_distribution_0/v3_four_channel_phase_distribution_0/v3_four_channel_output_collection_0/v3_four_channel_placement_0/v3_channel_selector_late_promotion_1/v3_selector_route_pilot_0/G0_LO_P_AND/a_59_75# VDPWR sky130_fd_pr__pfet_01v8_hvt ad=0 pd=0 as=0.1134 ps=1.38 w=0.42 l=0.15
X1868 v3_four_channel_output_load_integration_0/v3_four_channel_shared_support_integration_0/v3_four_channel_bias_reference_distribution_0/v3_four_channel_phase_distribution_0/v3_four_channel_output_collection_0/v3_four_channel_placement_0/v3_channel_selector_late_promotion_1/v3_selector_route_pilot_0/group0_lo_p v3_four_channel_output_load_integration_0/v3_four_channel_shared_support_integration_0/v3_four_channel_bias_reference_distribution_0/v3_four_channel_phase_distribution_0/v3_four_channel_output_collection_0/v3_four_channel_placement_0/v3_channel_selector_late_promotion_1/v3_selector_route_pilot_0/G0_LO_P_AND/a_59_75# VDPWR VDPWR sky130_fd_pr__pfet_01v8_hvt ad=0.475 pd=2.95 as=0 ps=0 w=1 l=0.15
X1869 VGND v3_four_channel_output_load_integration_0/v3_four_channel_shared_support_integration_0/v3_four_channel_bias_reference_distribution_0/v3_four_channel_phase_distribution_0/v3_four_channel_output_collection_0/v3_four_channel_placement_0/v3_channel_selector_late_promotion_1/v3_selector_route_pilot_0/G3_LO_P_AND/B v3_four_channel_output_load_integration_0/v3_four_channel_shared_support_integration_0/v3_four_channel_bias_reference_distribution_0/v3_four_channel_phase_distribution_0/v3_four_channel_output_collection_0/v3_four_channel_placement_0/v3_channel_selector_late_promotion_1/v3_selector_route_pilot_0/G0_LO_P_AND/a_145_75# VGND sky130_fd_pr__nfet_01v8 ad=0 pd=0 as=0.1134 ps=1.38 w=0.42 l=0.15
X1870 v3_four_channel_output_load_integration_0/v3_four_channel_shared_support_integration_0/v3_four_channel_bias_reference_distribution_0/v3_four_channel_phase_distribution_0/v3_four_channel_output_collection_0/v3_four_channel_placement_0/v3_channel_selector_late_promotion_1/v3_selector_route_pilot_0/G0_LO_P_AND/a_59_75# v3_four_channel_output_load_integration_0/v3_four_channel_shared_support_integration_0/v3_four_channel_bias_reference_distribution_0/v3_four_channel_phase_distribution_0/v3_four_channel_output_collection_0/v3_four_channel_placement_0/v3_channel_selector_late_promotion_1/v3_selector_route_pilot_0/G0_MUX_AXIS/X VDPWR VDPWR sky130_fd_pr__pfet_01v8_hvt ad=0 pd=0 as=0 ps=0 w=0.42 l=0.15
X1871 v3_four_channel_output_load_integration_0/v3_four_channel_shared_support_integration_0/v3_four_channel_bias_reference_distribution_0/v3_four_channel_phase_distribution_0/v3_four_channel_output_collection_0/v3_four_channel_placement_0/v3_channel_selector_late_promotion_1/v3_selector_route_pilot_0/group0_lo_p v3_four_channel_output_load_integration_0/v3_four_channel_shared_support_integration_0/v3_four_channel_bias_reference_distribution_0/v3_four_channel_phase_distribution_0/v3_four_channel_output_collection_0/v3_four_channel_placement_0/v3_channel_selector_late_promotion_1/v3_selector_route_pilot_0/G0_LO_P_AND/a_59_75# VGND VGND sky130_fd_pr__nfet_01v8 ad=0.182 pd=1.86 as=0 ps=0 w=0.65 l=0.15
X1872 v3_four_channel_output_load_integration_0/v3_four_channel_shared_support_integration_0/v3_four_channel_bias_reference_distribution_0/v3_four_channel_phase_distribution_0/v3_four_channel_output_collection_0/v3_four_channel_placement_0/v3_channel_selector_late_promotion_1/v3_selector_route_pilot_0/G0_LO_P_AND/a_145_75# v3_four_channel_output_load_integration_0/v3_four_channel_shared_support_integration_0/v3_four_channel_bias_reference_distribution_0/v3_four_channel_phase_distribution_0/v3_four_channel_output_collection_0/v3_four_channel_placement_0/v3_channel_selector_late_promotion_1/v3_selector_route_pilot_0/G0_MUX_AXIS/X v3_four_channel_output_load_integration_0/v3_four_channel_shared_support_integration_0/v3_four_channel_bias_reference_distribution_0/v3_four_channel_phase_distribution_0/v3_four_channel_output_collection_0/v3_four_channel_placement_0/v3_channel_selector_late_promotion_1/v3_selector_route_pilot_0/G0_LO_P_AND/a_59_75# VGND sky130_fd_pr__nfet_01v8 ad=0 pd=0 as=0.1176 ps=1.4 w=0.42 l=0.15
X1873 VDPWR v3_four_channel_output_load_integration_0/v3_four_channel_shared_support_integration_0/v3_four_channel_bias_reference_distribution_0/v3_four_channel_phase_distribution_0/v3_four_channel_output_collection_0/v3_four_channel_placement_0/v3_channel_selector_late_promotion_1/v3_selector_route_pilot_0/G3_LO_P_AND/B v3_four_channel_output_load_integration_0/v3_four_channel_shared_support_integration_0/v3_four_channel_bias_reference_distribution_0/v3_four_channel_phase_distribution_0/v3_four_channel_output_collection_0/v3_four_channel_placement_0/v3_channel_selector_late_promotion_1/v3_selector_route_pilot_0/G3_LO_N_ANDNOT/a_207_413# VDPWR sky130_fd_pr__pfet_01v8_hvt ad=0 pd=0 as=0.1218 ps=1.42 w=0.42 l=0.15
X1874 v3_four_channel_output_load_integration_0/v3_four_channel_shared_support_integration_0/v3_four_channel_bias_reference_distribution_0/v3_four_channel_phase_distribution_0/v3_four_channel_output_collection_0/v3_four_channel_placement_0/v3_channel_selector_late_promotion_1/v3_selector_route_pilot_0/group3_lo_n v3_four_channel_output_load_integration_0/v3_four_channel_shared_support_integration_0/v3_four_channel_bias_reference_distribution_0/v3_four_channel_phase_distribution_0/v3_four_channel_output_collection_0/v3_four_channel_placement_0/v3_channel_selector_late_promotion_1/v3_selector_route_pilot_0/G3_LO_N_ANDNOT/a_207_413# VDPWR VDPWR sky130_fd_pr__pfet_01v8_hvt ad=0.26 pd=2.52 as=0 ps=0 w=1 l=0.15
X1875 v3_four_channel_output_load_integration_0/v3_four_channel_shared_support_integration_0/v3_four_channel_bias_reference_distribution_0/v3_four_channel_phase_distribution_0/v3_four_channel_output_collection_0/v3_four_channel_placement_0/v3_channel_selector_late_promotion_1/v3_selector_route_pilot_0/G3_LO_N_ANDNOT/a_297_47# v3_four_channel_output_load_integration_0/v3_four_channel_shared_support_integration_0/v3_four_channel_bias_reference_distribution_0/v3_four_channel_phase_distribution_0/v3_four_channel_output_collection_0/v3_four_channel_placement_0/v3_channel_selector_late_promotion_1/v3_selector_route_pilot_0/G3_LO_N_ANDNOT/a_27_413# v3_four_channel_output_load_integration_0/v3_four_channel_shared_support_integration_0/v3_four_channel_bias_reference_distribution_0/v3_four_channel_phase_distribution_0/v3_four_channel_output_collection_0/v3_four_channel_placement_0/v3_channel_selector_late_promotion_1/v3_selector_route_pilot_0/G3_LO_N_ANDNOT/a_207_413# VGND sky130_fd_pr__nfet_01v8 ad=0.1008 pd=1.32 as=0.1092 ps=1.36 w=0.42 l=0.15
X1876 v3_four_channel_output_load_integration_0/v3_four_channel_shared_support_integration_0/v3_four_channel_bias_reference_distribution_0/v3_four_channel_phase_distribution_0/v3_four_channel_output_collection_0/v3_four_channel_placement_0/v3_channel_selector_late_promotion_1/v3_selector_route_pilot_0/group3_lo_n v3_four_channel_output_load_integration_0/v3_four_channel_shared_support_integration_0/v3_four_channel_bias_reference_distribution_0/v3_four_channel_phase_distribution_0/v3_four_channel_output_collection_0/v3_four_channel_placement_0/v3_channel_selector_late_promotion_1/v3_selector_route_pilot_0/G3_LO_N_ANDNOT/a_207_413# VGND VGND sky130_fd_pr__nfet_01v8 ad=0.169 pd=1.82 as=0 ps=0 w=0.65 l=0.15
X1877 v3_four_channel_output_load_integration_0/v3_four_channel_shared_support_integration_0/v3_four_channel_bias_reference_distribution_0/v3_four_channel_phase_distribution_0/v3_four_channel_output_collection_0/v3_four_channel_placement_0/v3_channel_selector_late_promotion_1/v3_selector_route_pilot_0/G3_LO_N_ANDNOT/a_207_413# v3_four_channel_output_load_integration_0/v3_four_channel_shared_support_integration_0/v3_four_channel_bias_reference_distribution_0/v3_four_channel_phase_distribution_0/v3_four_channel_output_collection_0/v3_four_channel_placement_0/v3_channel_selector_late_promotion_1/v3_selector_route_pilot_0/G3_LO_N_ANDNOT/a_27_413# VDPWR VDPWR sky130_fd_pr__pfet_01v8_hvt ad=0 pd=0 as=0 ps=0 w=0.42 l=0.15
X1878 VDPWR v3_four_channel_output_load_integration_0/v3_four_channel_shared_support_integration_0/v3_four_channel_bias_reference_distribution_0/v3_four_channel_phase_distribution_0/v3_four_channel_output_collection_0/v3_four_channel_placement_0/v3_channel_selector_late_promotion_1/v3_selector_route_pilot_0/G3_MUX_AXIS/X v3_four_channel_output_load_integration_0/v3_four_channel_shared_support_integration_0/v3_four_channel_bias_reference_distribution_0/v3_four_channel_phase_distribution_0/v3_four_channel_output_collection_0/v3_four_channel_placement_0/v3_channel_selector_late_promotion_1/v3_selector_route_pilot_0/G3_LO_N_ANDNOT/a_27_413# VDPWR sky130_fd_pr__pfet_01v8_hvt ad=0 pd=0 as=0.1092 ps=1.36 w=0.42 l=0.15
X1879 VGND v3_four_channel_output_load_integration_0/v3_four_channel_shared_support_integration_0/v3_four_channel_bias_reference_distribution_0/v3_four_channel_phase_distribution_0/v3_four_channel_output_collection_0/v3_four_channel_placement_0/v3_channel_selector_late_promotion_1/v3_selector_route_pilot_0/G3_LO_P_AND/B v3_four_channel_output_load_integration_0/v3_four_channel_shared_support_integration_0/v3_four_channel_bias_reference_distribution_0/v3_four_channel_phase_distribution_0/v3_four_channel_output_collection_0/v3_four_channel_placement_0/v3_channel_selector_late_promotion_1/v3_selector_route_pilot_0/G3_LO_N_ANDNOT/a_297_47# VGND sky130_fd_pr__nfet_01v8 ad=0 pd=0 as=0 ps=0 w=0.42 l=0.15
X1880 v3_four_channel_output_load_integration_0/v3_four_channel_shared_support_integration_0/v3_four_channel_bias_reference_distribution_0/v3_four_channel_phase_distribution_0/v3_four_channel_output_collection_0/v3_four_channel_placement_0/v3_channel_selector_late_promotion_1/v3_selector_route_pilot_0/G3_LO_N_ANDNOT/a_27_413# v3_four_channel_output_load_integration_0/v3_four_channel_shared_support_integration_0/v3_four_channel_bias_reference_distribution_0/v3_four_channel_phase_distribution_0/v3_four_channel_output_collection_0/v3_four_channel_placement_0/v3_channel_selector_late_promotion_1/v3_selector_route_pilot_0/G3_MUX_AXIS/X VGND VGND sky130_fd_pr__nfet_01v8 ad=0.1092 pd=1.36 as=0 ps=0 w=0.42 l=0.15
X1881 VDPWR v3_four_channel_output_load_integration_0/v3_four_channel_shared_support_integration_0/v3_four_channel_bias_reference_distribution_0/v3_four_channel_phase_distribution_0/v3_four_channel_output_collection_0/v3_four_channel_placement_0/v3_channel_selector_late_promotion_1/v3_selector_route_pilot_0/G3_LO_P_AND/B v3_four_channel_output_load_integration_0/v3_four_channel_shared_support_integration_0/v3_four_channel_bias_reference_distribution_0/v3_four_channel_phase_distribution_0/v3_four_channel_output_collection_0/v3_four_channel_placement_0/v3_channel_selector_late_promotion_1/v3_selector_route_pilot_0/G2_LO_N_ANDNOT/a_207_413# VDPWR sky130_fd_pr__pfet_01v8_hvt ad=0 pd=0 as=0.1218 ps=1.42 w=0.42 l=0.15
X1882 v3_four_channel_output_load_integration_0/v3_four_channel_shared_support_integration_0/v3_four_channel_bias_reference_distribution_0/v3_four_channel_phase_distribution_0/v3_four_channel_output_collection_0/v3_four_channel_placement_0/v3_channel_selector_late_promotion_1/v3_selector_route_pilot_0/group2_lo_n v3_four_channel_output_load_integration_0/v3_four_channel_shared_support_integration_0/v3_four_channel_bias_reference_distribution_0/v3_four_channel_phase_distribution_0/v3_four_channel_output_collection_0/v3_four_channel_placement_0/v3_channel_selector_late_promotion_1/v3_selector_route_pilot_0/G2_LO_N_ANDNOT/a_207_413# VDPWR VDPWR sky130_fd_pr__pfet_01v8_hvt ad=0.26 pd=2.52 as=0 ps=0 w=1 l=0.15
X1883 v3_four_channel_output_load_integration_0/v3_four_channel_shared_support_integration_0/v3_four_channel_bias_reference_distribution_0/v3_four_channel_phase_distribution_0/v3_four_channel_output_collection_0/v3_four_channel_placement_0/v3_channel_selector_late_promotion_1/v3_selector_route_pilot_0/G2_LO_N_ANDNOT/a_297_47# v3_four_channel_output_load_integration_0/v3_four_channel_shared_support_integration_0/v3_four_channel_bias_reference_distribution_0/v3_four_channel_phase_distribution_0/v3_four_channel_output_collection_0/v3_four_channel_placement_0/v3_channel_selector_late_promotion_1/v3_selector_route_pilot_0/G2_LO_N_ANDNOT/a_27_413# v3_four_channel_output_load_integration_0/v3_four_channel_shared_support_integration_0/v3_four_channel_bias_reference_distribution_0/v3_four_channel_phase_distribution_0/v3_four_channel_output_collection_0/v3_four_channel_placement_0/v3_channel_selector_late_promotion_1/v3_selector_route_pilot_0/G2_LO_N_ANDNOT/a_207_413# VGND sky130_fd_pr__nfet_01v8 ad=0.1008 pd=1.32 as=0.1092 ps=1.36 w=0.42 l=0.15
X1884 v3_four_channel_output_load_integration_0/v3_four_channel_shared_support_integration_0/v3_four_channel_bias_reference_distribution_0/v3_four_channel_phase_distribution_0/v3_four_channel_output_collection_0/v3_four_channel_placement_0/v3_channel_selector_late_promotion_1/v3_selector_route_pilot_0/group2_lo_n v3_four_channel_output_load_integration_0/v3_four_channel_shared_support_integration_0/v3_four_channel_bias_reference_distribution_0/v3_four_channel_phase_distribution_0/v3_four_channel_output_collection_0/v3_four_channel_placement_0/v3_channel_selector_late_promotion_1/v3_selector_route_pilot_0/G2_LO_N_ANDNOT/a_207_413# VGND VGND sky130_fd_pr__nfet_01v8 ad=0.169 pd=1.82 as=0 ps=0 w=0.65 l=0.15
X1885 v3_four_channel_output_load_integration_0/v3_four_channel_shared_support_integration_0/v3_four_channel_bias_reference_distribution_0/v3_four_channel_phase_distribution_0/v3_four_channel_output_collection_0/v3_four_channel_placement_0/v3_channel_selector_late_promotion_1/v3_selector_route_pilot_0/G2_LO_N_ANDNOT/a_207_413# v3_four_channel_output_load_integration_0/v3_four_channel_shared_support_integration_0/v3_four_channel_bias_reference_distribution_0/v3_four_channel_phase_distribution_0/v3_four_channel_output_collection_0/v3_four_channel_placement_0/v3_channel_selector_late_promotion_1/v3_selector_route_pilot_0/G2_LO_N_ANDNOT/a_27_413# VDPWR VDPWR sky130_fd_pr__pfet_01v8_hvt ad=0 pd=0 as=0 ps=0 w=0.42 l=0.15
X1886 VDPWR v3_four_channel_output_load_integration_0/v3_four_channel_shared_support_integration_0/v3_four_channel_bias_reference_distribution_0/v3_four_channel_phase_distribution_0/v3_four_channel_output_collection_0/v3_four_channel_placement_0/v3_channel_selector_late_promotion_1/v3_selector_route_pilot_0/G2_MUX_AXIS/X v3_four_channel_output_load_integration_0/v3_four_channel_shared_support_integration_0/v3_four_channel_bias_reference_distribution_0/v3_four_channel_phase_distribution_0/v3_four_channel_output_collection_0/v3_four_channel_placement_0/v3_channel_selector_late_promotion_1/v3_selector_route_pilot_0/G2_LO_N_ANDNOT/a_27_413# VDPWR sky130_fd_pr__pfet_01v8_hvt ad=0 pd=0 as=0.1092 ps=1.36 w=0.42 l=0.15
X1887 VGND v3_four_channel_output_load_integration_0/v3_four_channel_shared_support_integration_0/v3_four_channel_bias_reference_distribution_0/v3_four_channel_phase_distribution_0/v3_four_channel_output_collection_0/v3_four_channel_placement_0/v3_channel_selector_late_promotion_1/v3_selector_route_pilot_0/G3_LO_P_AND/B v3_four_channel_output_load_integration_0/v3_four_channel_shared_support_integration_0/v3_four_channel_bias_reference_distribution_0/v3_four_channel_phase_distribution_0/v3_four_channel_output_collection_0/v3_four_channel_placement_0/v3_channel_selector_late_promotion_1/v3_selector_route_pilot_0/G2_LO_N_ANDNOT/a_297_47# VGND sky130_fd_pr__nfet_01v8 ad=0 pd=0 as=0 ps=0 w=0.42 l=0.15
X1888 v3_four_channel_output_load_integration_0/v3_four_channel_shared_support_integration_0/v3_four_channel_bias_reference_distribution_0/v3_four_channel_phase_distribution_0/v3_four_channel_output_collection_0/v3_four_channel_placement_0/v3_channel_selector_late_promotion_1/v3_selector_route_pilot_0/G2_LO_N_ANDNOT/a_27_413# v3_four_channel_output_load_integration_0/v3_four_channel_shared_support_integration_0/v3_four_channel_bias_reference_distribution_0/v3_four_channel_phase_distribution_0/v3_four_channel_output_collection_0/v3_four_channel_placement_0/v3_channel_selector_late_promotion_1/v3_selector_route_pilot_0/G2_MUX_AXIS/X VGND VGND sky130_fd_pr__nfet_01v8 ad=0.1092 pd=1.36 as=0 ps=0 w=0.42 l=0.15
X1889 VDPWR v3_four_channel_output_load_integration_0/v3_four_channel_shared_support_integration_0/v3_four_channel_bias_reference_distribution_0/v3_four_channel_phase_distribution_0/v3_four_channel_output_collection_0/v3_four_channel_placement_0/v3_channel_selector_late_promotion_1/v3_selector_route_pilot_0/G3_LO_P_AND/B v3_four_channel_output_load_integration_0/v3_four_channel_shared_support_integration_0/v3_four_channel_bias_reference_distribution_0/v3_four_channel_phase_distribution_0/v3_four_channel_output_collection_0/v3_four_channel_placement_0/v3_channel_selector_late_promotion_1/v3_selector_route_pilot_0/G0_LO_N_ANDNOT/a_207_413# VDPWR sky130_fd_pr__pfet_01v8_hvt ad=0 pd=0 as=0.1218 ps=1.42 w=0.42 l=0.15
X1890 v3_four_channel_output_load_integration_0/v3_four_channel_shared_support_integration_0/v3_four_channel_bias_reference_distribution_0/v3_four_channel_phase_distribution_0/v3_four_channel_output_collection_0/v3_four_channel_placement_0/v3_channel_selector_late_promotion_1/v3_selector_route_pilot_0/group0_lo_n v3_four_channel_output_load_integration_0/v3_four_channel_shared_support_integration_0/v3_four_channel_bias_reference_distribution_0/v3_four_channel_phase_distribution_0/v3_four_channel_output_collection_0/v3_four_channel_placement_0/v3_channel_selector_late_promotion_1/v3_selector_route_pilot_0/G0_LO_N_ANDNOT/a_207_413# VDPWR VDPWR sky130_fd_pr__pfet_01v8_hvt ad=0.26 pd=2.52 as=0 ps=0 w=1 l=0.15
X1891 v3_four_channel_output_load_integration_0/v3_four_channel_shared_support_integration_0/v3_four_channel_bias_reference_distribution_0/v3_four_channel_phase_distribution_0/v3_four_channel_output_collection_0/v3_four_channel_placement_0/v3_channel_selector_late_promotion_1/v3_selector_route_pilot_0/G0_LO_N_ANDNOT/a_297_47# v3_four_channel_output_load_integration_0/v3_four_channel_shared_support_integration_0/v3_four_channel_bias_reference_distribution_0/v3_four_channel_phase_distribution_0/v3_four_channel_output_collection_0/v3_four_channel_placement_0/v3_channel_selector_late_promotion_1/v3_selector_route_pilot_0/G0_LO_N_ANDNOT/a_27_413# v3_four_channel_output_load_integration_0/v3_four_channel_shared_support_integration_0/v3_four_channel_bias_reference_distribution_0/v3_four_channel_phase_distribution_0/v3_four_channel_output_collection_0/v3_four_channel_placement_0/v3_channel_selector_late_promotion_1/v3_selector_route_pilot_0/G0_LO_N_ANDNOT/a_207_413# VGND sky130_fd_pr__nfet_01v8 ad=0.1008 pd=1.32 as=0.1092 ps=1.36 w=0.42 l=0.15
X1892 v3_four_channel_output_load_integration_0/v3_four_channel_shared_support_integration_0/v3_four_channel_bias_reference_distribution_0/v3_four_channel_phase_distribution_0/v3_four_channel_output_collection_0/v3_four_channel_placement_0/v3_channel_selector_late_promotion_1/v3_selector_route_pilot_0/group0_lo_n v3_four_channel_output_load_integration_0/v3_four_channel_shared_support_integration_0/v3_four_channel_bias_reference_distribution_0/v3_four_channel_phase_distribution_0/v3_four_channel_output_collection_0/v3_four_channel_placement_0/v3_channel_selector_late_promotion_1/v3_selector_route_pilot_0/G0_LO_N_ANDNOT/a_207_413# VGND VGND sky130_fd_pr__nfet_01v8 ad=0.169 pd=1.82 as=0 ps=0 w=0.65 l=0.15
X1893 v3_four_channel_output_load_integration_0/v3_four_channel_shared_support_integration_0/v3_four_channel_bias_reference_distribution_0/v3_four_channel_phase_distribution_0/v3_four_channel_output_collection_0/v3_four_channel_placement_0/v3_channel_selector_late_promotion_1/v3_selector_route_pilot_0/G0_LO_N_ANDNOT/a_207_413# v3_four_channel_output_load_integration_0/v3_four_channel_shared_support_integration_0/v3_four_channel_bias_reference_distribution_0/v3_four_channel_phase_distribution_0/v3_four_channel_output_collection_0/v3_four_channel_placement_0/v3_channel_selector_late_promotion_1/v3_selector_route_pilot_0/G0_LO_N_ANDNOT/a_27_413# VDPWR VDPWR sky130_fd_pr__pfet_01v8_hvt ad=0 pd=0 as=0 ps=0 w=0.42 l=0.15
X1894 VDPWR v3_four_channel_output_load_integration_0/v3_four_channel_shared_support_integration_0/v3_four_channel_bias_reference_distribution_0/v3_four_channel_phase_distribution_0/v3_four_channel_output_collection_0/v3_four_channel_placement_0/v3_channel_selector_late_promotion_1/v3_selector_route_pilot_0/G0_MUX_AXIS/X v3_four_channel_output_load_integration_0/v3_four_channel_shared_support_integration_0/v3_four_channel_bias_reference_distribution_0/v3_four_channel_phase_distribution_0/v3_four_channel_output_collection_0/v3_four_channel_placement_0/v3_channel_selector_late_promotion_1/v3_selector_route_pilot_0/G0_LO_N_ANDNOT/a_27_413# VDPWR sky130_fd_pr__pfet_01v8_hvt ad=0 pd=0 as=0.1092 ps=1.36 w=0.42 l=0.15
X1895 VGND v3_four_channel_output_load_integration_0/v3_four_channel_shared_support_integration_0/v3_four_channel_bias_reference_distribution_0/v3_four_channel_phase_distribution_0/v3_four_channel_output_collection_0/v3_four_channel_placement_0/v3_channel_selector_late_promotion_1/v3_selector_route_pilot_0/G3_LO_P_AND/B v3_four_channel_output_load_integration_0/v3_four_channel_shared_support_integration_0/v3_four_channel_bias_reference_distribution_0/v3_four_channel_phase_distribution_0/v3_four_channel_output_collection_0/v3_four_channel_placement_0/v3_channel_selector_late_promotion_1/v3_selector_route_pilot_0/G0_LO_N_ANDNOT/a_297_47# VGND sky130_fd_pr__nfet_01v8 ad=0 pd=0 as=0 ps=0 w=0.42 l=0.15
X1896 v3_four_channel_output_load_integration_0/v3_four_channel_shared_support_integration_0/v3_four_channel_bias_reference_distribution_0/v3_four_channel_phase_distribution_0/v3_four_channel_output_collection_0/v3_four_channel_placement_0/v3_channel_selector_late_promotion_1/v3_selector_route_pilot_0/G0_LO_N_ANDNOT/a_27_413# v3_four_channel_output_load_integration_0/v3_four_channel_shared_support_integration_0/v3_four_channel_bias_reference_distribution_0/v3_four_channel_phase_distribution_0/v3_four_channel_output_collection_0/v3_four_channel_placement_0/v3_channel_selector_late_promotion_1/v3_selector_route_pilot_0/G0_MUX_AXIS/X VGND VGND sky130_fd_pr__nfet_01v8 ad=0.1092 pd=1.36 as=0 ps=0 w=0.42 l=0.15
X1897 VDPWR v3_four_channel_output_load_integration_0/v3_four_channel_shared_support_integration_0/v3_four_channel_bias_reference_distribution_0/v3_four_channel_phase_distribution_0/v3_four_channel_output_collection_0/v3_four_channel_placement_0/v3_channel_selector_late_promotion_1/v3_selector_route_pilot_0/G1_MUX_AXIS/a_505_21# v3_four_channel_output_load_integration_0/v3_four_channel_shared_support_integration_0/v3_four_channel_bias_reference_distribution_0/v3_four_channel_phase_distribution_0/v3_four_channel_output_collection_0/v3_four_channel_placement_0/v3_channel_selector_late_promotion_1/v3_selector_route_pilot_0/G1_MUX_AXIS/a_535_374# VDPWR sky130_fd_pr__pfet_01v8_hvt ad=0 pd=0 as=0.0882 ps=1.26 w=0.42 l=0.15
X1898 v3_four_channel_output_load_integration_0/v3_four_channel_shared_support_integration_0/v3_four_channel_bias_reference_distribution_0/v3_four_channel_phase_distribution_0/v3_four_channel_output_collection_0/v3_four_channel_placement_0/v3_channel_selector_late_promotion_1/v3_selector_route_pilot_0/G1_MUX_AXIS/a_505_21# V3R216 VDPWR VDPWR sky130_fd_pr__pfet_01v8_hvt ad=0.1176 pd=1.4 as=0 ps=0 w=0.42 l=0.15
X1899 v3_four_channel_output_load_integration_0/v3_four_channel_shared_support_integration_0/v3_four_channel_bias_reference_distribution_0/v3_four_channel_phase_distribution_0/v3_four_channel_output_collection_0/v3_four_channel_placement_0/v3_channel_selector_late_promotion_1/v3_selector_route_pilot_0/G1_MUX_AXIS/a_218_374# V3R216 VDPWR VDPWR sky130_fd_pr__pfet_01v8_hvt ad=0.1533 pd=1.57 as=0 ps=0 w=0.42 l=0.15
X1900 VGND v3_four_channel_output_load_integration_0/v3_four_channel_shared_support_integration_0/v3_four_channel_bias_reference_distribution_0/v3_four_channel_phase_distribution_0/v3_four_channel_output_collection_0/v3_four_channel_placement_0/v3_channel_selector_late_promotion_1/v3_selector_route_pilot_0/G1_MUX_AXIS/a_505_21# v3_four_channel_output_load_integration_0/v3_four_channel_shared_support_integration_0/v3_four_channel_bias_reference_distribution_0/v3_four_channel_phase_distribution_0/v3_four_channel_output_collection_0/v3_four_channel_placement_0/v3_channel_selector_late_promotion_1/v3_selector_route_pilot_0/G1_MUX_AXIS/a_439_47# VGND sky130_fd_pr__nfet_01v8 ad=0 pd=0 as=0.1386 ps=1.5 w=0.42 l=0.15
X1901 v3_four_channel_output_load_integration_0/v3_four_channel_shared_support_integration_0/v3_four_channel_bias_reference_distribution_0/v3_four_channel_phase_distribution_0/v3_four_channel_output_collection_0/v3_four_channel_placement_0/v3_channel_selector_late_promotion_1/v3_selector_route_pilot_0/G1_MUX_AXIS/a_76_199# v3_four_channel_output_load_integration_0/v3_four_channel_shared_support_integration_0/v3_four_channel_bias_reference_distribution_0/v3_four_channel_phase_distribution_0/v3_four_channel_output_collection_0/v3_four_channel_placement_0/v3_channel_selector_late_promotion_1/v3_selector_route_pilot_0/G1_MUX_POS/X v3_four_channel_output_load_integration_0/v3_four_channel_shared_support_integration_0/v3_four_channel_bias_reference_distribution_0/v3_four_channel_phase_distribution_0/v3_four_channel_output_collection_0/v3_four_channel_placement_0/v3_channel_selector_late_promotion_1/v3_selector_route_pilot_0/G1_MUX_AXIS/a_218_374# VDPWR sky130_fd_pr__pfet_01v8_hvt ad=0.3864 pd=2.68 as=0 ps=0 w=0.42 l=0.15
X1902 v3_four_channel_output_load_integration_0/v3_four_channel_shared_support_integration_0/v3_four_channel_bias_reference_distribution_0/v3_four_channel_phase_distribution_0/v3_four_channel_output_collection_0/v3_four_channel_placement_0/v3_channel_selector_late_promotion_1/v3_selector_route_pilot_0/G1_MUX_AXIS/a_505_21# V3R216 VGND VGND sky130_fd_pr__nfet_01v8 ad=0.1092 pd=1.36 as=0 ps=0 w=0.42 l=0.15
X1903 v3_four_channel_output_load_integration_0/v3_four_channel_shared_support_integration_0/v3_four_channel_bias_reference_distribution_0/v3_four_channel_phase_distribution_0/v3_four_channel_output_collection_0/v3_four_channel_placement_0/v3_channel_selector_late_promotion_1/v3_selector_route_pilot_0/G1_MUX_AXIS/a_439_47# v3_four_channel_output_load_integration_0/v3_four_channel_shared_support_integration_0/v3_four_channel_bias_reference_distribution_0/v3_four_channel_phase_distribution_0/v3_four_channel_output_collection_0/v3_four_channel_placement_0/v3_channel_selector_late_promotion_1/v3_selector_route_pilot_0/G1_MUX_POS/X v3_four_channel_output_load_integration_0/v3_four_channel_shared_support_integration_0/v3_four_channel_bias_reference_distribution_0/v3_four_channel_phase_distribution_0/v3_four_channel_output_collection_0/v3_four_channel_placement_0/v3_channel_selector_late_promotion_1/v3_selector_route_pilot_0/G1_MUX_AXIS/a_76_199# VGND sky130_fd_pr__nfet_01v8 ad=0 pd=0 as=0.1995 ps=1.79 w=0.42 l=0.15
X1904 v3_four_channel_output_load_integration_0/v3_four_channel_shared_support_integration_0/v3_four_channel_bias_reference_distribution_0/v3_four_channel_phase_distribution_0/v3_four_channel_output_collection_0/v3_four_channel_placement_0/v3_channel_selector_late_promotion_1/v3_selector_route_pilot_0/G1_MUX_AXIS/a_535_374# v3_four_channel_output_load_integration_0/v3_four_channel_shared_support_integration_0/v3_four_channel_bias_reference_distribution_0/v3_four_channel_phase_distribution_0/v3_four_channel_output_collection_0/v3_four_channel_placement_0/v3_channel_selector_late_promotion_1/v3_selector_route_pilot_0/G1_MUX_NEG/X v3_four_channel_output_load_integration_0/v3_four_channel_shared_support_integration_0/v3_four_channel_bias_reference_distribution_0/v3_four_channel_phase_distribution_0/v3_four_channel_output_collection_0/v3_four_channel_placement_0/v3_channel_selector_late_promotion_1/v3_selector_route_pilot_0/G1_MUX_AXIS/a_76_199# VDPWR sky130_fd_pr__pfet_01v8_hvt ad=0 pd=0 as=0 ps=0 w=0.42 l=0.15
X1905 v3_four_channel_output_load_integration_0/v3_four_channel_shared_support_integration_0/v3_four_channel_bias_reference_distribution_0/v3_four_channel_phase_distribution_0/v3_four_channel_output_collection_0/v3_four_channel_placement_0/v3_channel_selector_late_promotion_1/v3_selector_route_pilot_0/G1_MUX_AXIS/a_76_199# v3_four_channel_output_load_integration_0/v3_four_channel_shared_support_integration_0/v3_four_channel_bias_reference_distribution_0/v3_four_channel_phase_distribution_0/v3_four_channel_output_collection_0/v3_four_channel_placement_0/v3_channel_selector_late_promotion_1/v3_selector_route_pilot_0/G1_MUX_NEG/X v3_four_channel_output_load_integration_0/v3_four_channel_shared_support_integration_0/v3_four_channel_bias_reference_distribution_0/v3_four_channel_phase_distribution_0/v3_four_channel_output_collection_0/v3_four_channel_placement_0/v3_channel_selector_late_promotion_1/v3_selector_route_pilot_0/G1_MUX_AXIS/a_218_47# VGND sky130_fd_pr__nfet_01v8 ad=0 pd=0 as=0.1386 ps=1.5 w=0.42 l=0.15
X1906 v3_four_channel_output_load_integration_0/v3_four_channel_shared_support_integration_0/v3_four_channel_bias_reference_distribution_0/v3_four_channel_phase_distribution_0/v3_four_channel_output_collection_0/v3_four_channel_placement_0/v3_channel_selector_late_promotion_1/v3_selector_route_pilot_0/G1_MUX_AXIS/a_218_47# V3R216 VGND VGND sky130_fd_pr__nfet_01v8 ad=0 pd=0 as=0 ps=0 w=0.42 l=0.15
X1907 VDPWR v3_four_channel_output_load_integration_0/v3_four_channel_shared_support_integration_0/v3_four_channel_bias_reference_distribution_0/v3_four_channel_phase_distribution_0/v3_four_channel_output_collection_0/v3_four_channel_placement_0/v3_channel_selector_late_promotion_1/v3_selector_route_pilot_0/G1_MUX_AXIS/a_76_199# v3_four_channel_output_load_integration_0/v3_four_channel_shared_support_integration_0/v3_four_channel_bias_reference_distribution_0/v3_four_channel_phase_distribution_0/v3_four_channel_output_collection_0/v3_four_channel_placement_0/v3_channel_selector_late_promotion_1/v3_selector_route_pilot_0/G1_MUX_AXIS/X VDPWR sky130_fd_pr__pfet_01v8_hvt ad=0 pd=0 as=0.26 ps=2.52 w=1 l=0.15
X1908 VGND v3_four_channel_output_load_integration_0/v3_four_channel_shared_support_integration_0/v3_four_channel_bias_reference_distribution_0/v3_four_channel_phase_distribution_0/v3_four_channel_output_collection_0/v3_four_channel_placement_0/v3_channel_selector_late_promotion_1/v3_selector_route_pilot_0/G1_MUX_AXIS/a_76_199# v3_four_channel_output_load_integration_0/v3_four_channel_shared_support_integration_0/v3_four_channel_bias_reference_distribution_0/v3_four_channel_phase_distribution_0/v3_four_channel_output_collection_0/v3_four_channel_placement_0/v3_channel_selector_late_promotion_1/v3_selector_route_pilot_0/G1_MUX_AXIS/X VGND sky130_fd_pr__nfet_01v8 ad=0 pd=0 as=0.169 ps=1.82 w=0.65 l=0.15
X1909 VDPWR v3_four_channel_output_load_integration_0/v3_four_channel_shared_support_integration_0/v3_four_channel_bias_reference_distribution_0/v3_four_channel_phase_distribution_0/v3_four_channel_output_collection_0/v3_four_channel_placement_0/v3_channel_selector_late_promotion_1/v3_selector_route_pilot_0/G3_LO_P_AND/B v3_four_channel_output_load_integration_0/v3_four_channel_shared_support_integration_0/v3_four_channel_bias_reference_distribution_0/v3_four_channel_phase_distribution_0/v3_four_channel_output_collection_0/v3_four_channel_placement_0/v3_channel_selector_late_promotion_1/v3_selector_route_pilot_0/G1_LO_N_ANDNOT/a_207_413# VDPWR sky130_fd_pr__pfet_01v8_hvt ad=0 pd=0 as=0.1218 ps=1.42 w=0.42 l=0.15
X1910 v3_four_channel_output_load_integration_0/v3_four_channel_shared_support_integration_0/v3_four_channel_bias_reference_distribution_0/v3_four_channel_phase_distribution_0/v3_four_channel_output_collection_0/v3_four_channel_placement_0/v3_channel_selector_late_promotion_1/v3_selector_route_pilot_0/group1_lo_n v3_four_channel_output_load_integration_0/v3_four_channel_shared_support_integration_0/v3_four_channel_bias_reference_distribution_0/v3_four_channel_phase_distribution_0/v3_four_channel_output_collection_0/v3_four_channel_placement_0/v3_channel_selector_late_promotion_1/v3_selector_route_pilot_0/G1_LO_N_ANDNOT/a_207_413# VDPWR VDPWR sky130_fd_pr__pfet_01v8_hvt ad=0.26 pd=2.52 as=0 ps=0 w=1 l=0.15
X1911 v3_four_channel_output_load_integration_0/v3_four_channel_shared_support_integration_0/v3_four_channel_bias_reference_distribution_0/v3_four_channel_phase_distribution_0/v3_four_channel_output_collection_0/v3_four_channel_placement_0/v3_channel_selector_late_promotion_1/v3_selector_route_pilot_0/G1_LO_N_ANDNOT/a_297_47# v3_four_channel_output_load_integration_0/v3_four_channel_shared_support_integration_0/v3_four_channel_bias_reference_distribution_0/v3_four_channel_phase_distribution_0/v3_four_channel_output_collection_0/v3_four_channel_placement_0/v3_channel_selector_late_promotion_1/v3_selector_route_pilot_0/G1_LO_N_ANDNOT/a_27_413# v3_four_channel_output_load_integration_0/v3_four_channel_shared_support_integration_0/v3_four_channel_bias_reference_distribution_0/v3_four_channel_phase_distribution_0/v3_four_channel_output_collection_0/v3_four_channel_placement_0/v3_channel_selector_late_promotion_1/v3_selector_route_pilot_0/G1_LO_N_ANDNOT/a_207_413# VGND sky130_fd_pr__nfet_01v8 ad=0.1008 pd=1.32 as=0.1092 ps=1.36 w=0.42 l=0.15
X1912 v3_four_channel_output_load_integration_0/v3_four_channel_shared_support_integration_0/v3_four_channel_bias_reference_distribution_0/v3_four_channel_phase_distribution_0/v3_four_channel_output_collection_0/v3_four_channel_placement_0/v3_channel_selector_late_promotion_1/v3_selector_route_pilot_0/group1_lo_n v3_four_channel_output_load_integration_0/v3_four_channel_shared_support_integration_0/v3_four_channel_bias_reference_distribution_0/v3_four_channel_phase_distribution_0/v3_four_channel_output_collection_0/v3_four_channel_placement_0/v3_channel_selector_late_promotion_1/v3_selector_route_pilot_0/G1_LO_N_ANDNOT/a_207_413# VGND VGND sky130_fd_pr__nfet_01v8 ad=0.169 pd=1.82 as=0 ps=0 w=0.65 l=0.15
X1913 v3_four_channel_output_load_integration_0/v3_four_channel_shared_support_integration_0/v3_four_channel_bias_reference_distribution_0/v3_four_channel_phase_distribution_0/v3_four_channel_output_collection_0/v3_four_channel_placement_0/v3_channel_selector_late_promotion_1/v3_selector_route_pilot_0/G1_LO_N_ANDNOT/a_207_413# v3_four_channel_output_load_integration_0/v3_four_channel_shared_support_integration_0/v3_four_channel_bias_reference_distribution_0/v3_four_channel_phase_distribution_0/v3_four_channel_output_collection_0/v3_four_channel_placement_0/v3_channel_selector_late_promotion_1/v3_selector_route_pilot_0/G1_LO_N_ANDNOT/a_27_413# VDPWR VDPWR sky130_fd_pr__pfet_01v8_hvt ad=0 pd=0 as=0 ps=0 w=0.42 l=0.15
X1914 VDPWR v3_four_channel_output_load_integration_0/v3_four_channel_shared_support_integration_0/v3_four_channel_bias_reference_distribution_0/v3_four_channel_phase_distribution_0/v3_four_channel_output_collection_0/v3_four_channel_placement_0/v3_channel_selector_late_promotion_1/v3_selector_route_pilot_0/G1_MUX_AXIS/X v3_four_channel_output_load_integration_0/v3_four_channel_shared_support_integration_0/v3_four_channel_bias_reference_distribution_0/v3_four_channel_phase_distribution_0/v3_four_channel_output_collection_0/v3_four_channel_placement_0/v3_channel_selector_late_promotion_1/v3_selector_route_pilot_0/G1_LO_N_ANDNOT/a_27_413# VDPWR sky130_fd_pr__pfet_01v8_hvt ad=0 pd=0 as=0.1092 ps=1.36 w=0.42 l=0.15
X1915 VGND v3_four_channel_output_load_integration_0/v3_four_channel_shared_support_integration_0/v3_four_channel_bias_reference_distribution_0/v3_four_channel_phase_distribution_0/v3_four_channel_output_collection_0/v3_four_channel_placement_0/v3_channel_selector_late_promotion_1/v3_selector_route_pilot_0/G3_LO_P_AND/B v3_four_channel_output_load_integration_0/v3_four_channel_shared_support_integration_0/v3_four_channel_bias_reference_distribution_0/v3_four_channel_phase_distribution_0/v3_four_channel_output_collection_0/v3_four_channel_placement_0/v3_channel_selector_late_promotion_1/v3_selector_route_pilot_0/G1_LO_N_ANDNOT/a_297_47# VGND sky130_fd_pr__nfet_01v8 ad=0 pd=0 as=0 ps=0 w=0.42 l=0.15
X1916 v3_four_channel_output_load_integration_0/v3_four_channel_shared_support_integration_0/v3_four_channel_bias_reference_distribution_0/v3_four_channel_phase_distribution_0/v3_four_channel_output_collection_0/v3_four_channel_placement_0/v3_channel_selector_late_promotion_1/v3_selector_route_pilot_0/G1_LO_N_ANDNOT/a_27_413# v3_four_channel_output_load_integration_0/v3_four_channel_shared_support_integration_0/v3_four_channel_bias_reference_distribution_0/v3_four_channel_phase_distribution_0/v3_four_channel_output_collection_0/v3_four_channel_placement_0/v3_channel_selector_late_promotion_1/v3_selector_route_pilot_0/G1_MUX_AXIS/X VGND VGND sky130_fd_pr__nfet_01v8 ad=0.1092 pd=1.36 as=0 ps=0 w=0.42 l=0.15
X1917 VDPWR v3_four_channel_output_load_integration_0/v3_four_channel_shared_support_integration_0/v3_four_channel_bias_reference_distribution_0/v3_four_channel_phase_distribution_0/v3_four_channel_output_collection_0/v3_four_channel_placement_0/v3_channel_selector_late_promotion_1/v3_selector_route_pilot_0/G3_LO_P_AND/B v3_four_channel_output_load_integration_0/v3_four_channel_shared_support_integration_0/v3_four_channel_bias_reference_distribution_0/v3_four_channel_phase_distribution_0/v3_four_channel_output_collection_0/v3_four_channel_placement_0/v3_channel_selector_late_promotion_1/v3_selector_route_pilot_0/G3_LO_P_AND/a_59_75# VDPWR sky130_fd_pr__pfet_01v8_hvt ad=0 pd=0 as=0.1134 ps=1.38 w=0.42 l=0.15
X1918 v3_four_channel_output_load_integration_0/v3_four_channel_shared_support_integration_0/v3_four_channel_bias_reference_distribution_0/v3_four_channel_phase_distribution_0/v3_four_channel_output_collection_0/v3_four_channel_placement_0/v3_channel_selector_late_promotion_1/v3_selector_route_pilot_0/group3_lo_p v3_four_channel_output_load_integration_0/v3_four_channel_shared_support_integration_0/v3_four_channel_bias_reference_distribution_0/v3_four_channel_phase_distribution_0/v3_four_channel_output_collection_0/v3_four_channel_placement_0/v3_channel_selector_late_promotion_1/v3_selector_route_pilot_0/G3_LO_P_AND/a_59_75# VDPWR VDPWR sky130_fd_pr__pfet_01v8_hvt ad=0.475 pd=2.95 as=0 ps=0 w=1 l=0.15
X1919 VGND v3_four_channel_output_load_integration_0/v3_four_channel_shared_support_integration_0/v3_four_channel_bias_reference_distribution_0/v3_four_channel_phase_distribution_0/v3_four_channel_output_collection_0/v3_four_channel_placement_0/v3_channel_selector_late_promotion_1/v3_selector_route_pilot_0/G3_LO_P_AND/B v3_four_channel_output_load_integration_0/v3_four_channel_shared_support_integration_0/v3_four_channel_bias_reference_distribution_0/v3_four_channel_phase_distribution_0/v3_four_channel_output_collection_0/v3_four_channel_placement_0/v3_channel_selector_late_promotion_1/v3_selector_route_pilot_0/G3_LO_P_AND/a_145_75# VGND sky130_fd_pr__nfet_01v8 ad=0 pd=0 as=0.1134 ps=1.38 w=0.42 l=0.15
X1920 v3_four_channel_output_load_integration_0/v3_four_channel_shared_support_integration_0/v3_four_channel_bias_reference_distribution_0/v3_four_channel_phase_distribution_0/v3_four_channel_output_collection_0/v3_four_channel_placement_0/v3_channel_selector_late_promotion_1/v3_selector_route_pilot_0/G3_LO_P_AND/a_59_75# v3_four_channel_output_load_integration_0/v3_four_channel_shared_support_integration_0/v3_four_channel_bias_reference_distribution_0/v3_four_channel_phase_distribution_0/v3_four_channel_output_collection_0/v3_four_channel_placement_0/v3_channel_selector_late_promotion_1/v3_selector_route_pilot_0/G3_MUX_AXIS/X VDPWR VDPWR sky130_fd_pr__pfet_01v8_hvt ad=0 pd=0 as=0 ps=0 w=0.42 l=0.15
X1921 v3_four_channel_output_load_integration_0/v3_four_channel_shared_support_integration_0/v3_four_channel_bias_reference_distribution_0/v3_four_channel_phase_distribution_0/v3_four_channel_output_collection_0/v3_four_channel_placement_0/v3_channel_selector_late_promotion_1/v3_selector_route_pilot_0/group3_lo_p v3_four_channel_output_load_integration_0/v3_four_channel_shared_support_integration_0/v3_four_channel_bias_reference_distribution_0/v3_four_channel_phase_distribution_0/v3_four_channel_output_collection_0/v3_four_channel_placement_0/v3_channel_selector_late_promotion_1/v3_selector_route_pilot_0/G3_LO_P_AND/a_59_75# VGND VGND sky130_fd_pr__nfet_01v8 ad=0.182 pd=1.86 as=0 ps=0 w=0.65 l=0.15
X1922 v3_four_channel_output_load_integration_0/v3_four_channel_shared_support_integration_0/v3_four_channel_bias_reference_distribution_0/v3_four_channel_phase_distribution_0/v3_four_channel_output_collection_0/v3_four_channel_placement_0/v3_channel_selector_late_promotion_1/v3_selector_route_pilot_0/G3_LO_P_AND/a_145_75# v3_four_channel_output_load_integration_0/v3_four_channel_shared_support_integration_0/v3_four_channel_bias_reference_distribution_0/v3_four_channel_phase_distribution_0/v3_four_channel_output_collection_0/v3_four_channel_placement_0/v3_channel_selector_late_promotion_1/v3_selector_route_pilot_0/G3_MUX_AXIS/X v3_four_channel_output_load_integration_0/v3_four_channel_shared_support_integration_0/v3_four_channel_bias_reference_distribution_0/v3_four_channel_phase_distribution_0/v3_four_channel_output_collection_0/v3_four_channel_placement_0/v3_channel_selector_late_promotion_1/v3_selector_route_pilot_0/G3_LO_P_AND/a_59_75# VGND sky130_fd_pr__nfet_01v8 ad=0 pd=0 as=0.1176 ps=1.4 w=0.42 l=0.15
X1923 VDPWR v3_four_channel_output_load_integration_0/v3_four_channel_shared_support_integration_0/v3_four_channel_bias_reference_distribution_0/v3_four_channel_phase_distribution_0/v3_four_channel_output_collection_0/v3_four_channel_placement_0/v3_channel_selector_late_promotion_1/v3_selector_route_pilot_0/G2_MUX_POS/a_505_21# v3_four_channel_output_load_integration_0/v3_four_channel_shared_support_integration_0/v3_four_channel_bias_reference_distribution_0/v3_four_channel_phase_distribution_0/v3_four_channel_output_collection_0/v3_four_channel_placement_0/v3_channel_selector_late_promotion_1/v3_selector_route_pilot_0/G2_MUX_POS/a_535_374# VDPWR sky130_fd_pr__pfet_01v8_hvt ad=0 pd=0 as=0.0882 ps=1.26 w=0.42 l=0.15
X1924 v3_four_channel_output_load_integration_0/v3_four_channel_shared_support_integration_0/v3_four_channel_bias_reference_distribution_0/v3_four_channel_phase_distribution_0/v3_four_channel_output_collection_0/v3_four_channel_placement_0/v3_channel_selector_late_promotion_1/v3_selector_route_pilot_0/G2_MUX_POS/a_505_21# V3R218 VDPWR VDPWR sky130_fd_pr__pfet_01v8_hvt ad=0.1176 pd=1.4 as=0 ps=0 w=0.42 l=0.15
X1925 v3_four_channel_output_load_integration_0/v3_four_channel_shared_support_integration_0/v3_four_channel_bias_reference_distribution_0/v3_four_channel_phase_distribution_0/v3_four_channel_output_collection_0/v3_four_channel_placement_0/v3_channel_selector_late_promotion_1/v3_selector_route_pilot_0/G2_MUX_POS/a_218_374# V3R218 VDPWR VDPWR sky130_fd_pr__pfet_01v8_hvt ad=0.1533 pd=1.57 as=0 ps=0 w=0.42 l=0.15
X1926 VGND v3_four_channel_output_load_integration_0/v3_four_channel_shared_support_integration_0/v3_four_channel_bias_reference_distribution_0/v3_four_channel_phase_distribution_0/v3_four_channel_output_collection_0/v3_four_channel_placement_0/v3_channel_selector_late_promotion_1/v3_selector_route_pilot_0/G2_MUX_POS/a_505_21# v3_four_channel_output_load_integration_0/v3_four_channel_shared_support_integration_0/v3_four_channel_bias_reference_distribution_0/v3_four_channel_phase_distribution_0/v3_four_channel_output_collection_0/v3_four_channel_placement_0/v3_channel_selector_late_promotion_1/v3_selector_route_pilot_0/G2_MUX_POS/a_439_47# VGND sky130_fd_pr__nfet_01v8 ad=0 pd=0 as=0.1386 ps=1.5 w=0.42 l=0.15
X1927 v3_four_channel_output_load_integration_0/v3_four_channel_shared_support_integration_0/v3_four_channel_bias_reference_distribution_0/v3_four_channel_phase_distribution_0/v3_four_channel_output_collection_0/v3_four_channel_placement_0/v3_channel_selector_late_promotion_1/v3_selector_route_pilot_0/G2_MUX_POS/a_76_199# V3R290 v3_four_channel_output_load_integration_0/v3_four_channel_shared_support_integration_0/v3_four_channel_bias_reference_distribution_0/v3_four_channel_phase_distribution_0/v3_four_channel_output_collection_0/v3_four_channel_placement_0/v3_channel_selector_late_promotion_1/v3_selector_route_pilot_0/G2_MUX_POS/a_218_374# VDPWR sky130_fd_pr__pfet_01v8_hvt ad=0.3864 pd=2.68 as=0 ps=0 w=0.42 l=0.15
X1928 v3_four_channel_output_load_integration_0/v3_four_channel_shared_support_integration_0/v3_four_channel_bias_reference_distribution_0/v3_four_channel_phase_distribution_0/v3_four_channel_output_collection_0/v3_four_channel_placement_0/v3_channel_selector_late_promotion_1/v3_selector_route_pilot_0/G2_MUX_POS/a_505_21# V3R218 VGND VGND sky130_fd_pr__nfet_01v8 ad=0.1092 pd=1.36 as=0 ps=0 w=0.42 l=0.15
X1929 v3_four_channel_output_load_integration_0/v3_four_channel_shared_support_integration_0/v3_four_channel_bias_reference_distribution_0/v3_four_channel_phase_distribution_0/v3_four_channel_output_collection_0/v3_four_channel_placement_0/v3_channel_selector_late_promotion_1/v3_selector_route_pilot_0/G2_MUX_POS/a_439_47# V3R290 v3_four_channel_output_load_integration_0/v3_four_channel_shared_support_integration_0/v3_four_channel_bias_reference_distribution_0/v3_four_channel_phase_distribution_0/v3_four_channel_output_collection_0/v3_four_channel_placement_0/v3_channel_selector_late_promotion_1/v3_selector_route_pilot_0/G2_MUX_POS/a_76_199# VGND sky130_fd_pr__nfet_01v8 ad=0 pd=0 as=0.1995 ps=1.79 w=0.42 l=0.15
X1930 v3_four_channel_output_load_integration_0/v3_four_channel_shared_support_integration_0/v3_four_channel_bias_reference_distribution_0/v3_four_channel_phase_distribution_0/v3_four_channel_output_collection_0/v3_four_channel_placement_0/v3_channel_selector_late_promotion_1/v3_selector_route_pilot_0/G2_MUX_POS/a_535_374# V3R291 v3_four_channel_output_load_integration_0/v3_four_channel_shared_support_integration_0/v3_four_channel_bias_reference_distribution_0/v3_four_channel_phase_distribution_0/v3_four_channel_output_collection_0/v3_four_channel_placement_0/v3_channel_selector_late_promotion_1/v3_selector_route_pilot_0/G2_MUX_POS/a_76_199# VDPWR sky130_fd_pr__pfet_01v8_hvt ad=0 pd=0 as=0 ps=0 w=0.42 l=0.15
X1931 v3_four_channel_output_load_integration_0/v3_four_channel_shared_support_integration_0/v3_four_channel_bias_reference_distribution_0/v3_four_channel_phase_distribution_0/v3_four_channel_output_collection_0/v3_four_channel_placement_0/v3_channel_selector_late_promotion_1/v3_selector_route_pilot_0/G2_MUX_POS/a_76_199# V3R291 v3_four_channel_output_load_integration_0/v3_four_channel_shared_support_integration_0/v3_four_channel_bias_reference_distribution_0/v3_four_channel_phase_distribution_0/v3_four_channel_output_collection_0/v3_four_channel_placement_0/v3_channel_selector_late_promotion_1/v3_selector_route_pilot_0/G2_MUX_POS/a_218_47# VGND sky130_fd_pr__nfet_01v8 ad=0 pd=0 as=0.1386 ps=1.5 w=0.42 l=0.15
X1932 v3_four_channel_output_load_integration_0/v3_four_channel_shared_support_integration_0/v3_four_channel_bias_reference_distribution_0/v3_four_channel_phase_distribution_0/v3_four_channel_output_collection_0/v3_four_channel_placement_0/v3_channel_selector_late_promotion_1/v3_selector_route_pilot_0/G2_MUX_POS/a_218_47# V3R218 VGND VGND sky130_fd_pr__nfet_01v8 ad=0 pd=0 as=0 ps=0 w=0.42 l=0.15
X1933 VDPWR v3_four_channel_output_load_integration_0/v3_four_channel_shared_support_integration_0/v3_four_channel_bias_reference_distribution_0/v3_four_channel_phase_distribution_0/v3_four_channel_output_collection_0/v3_four_channel_placement_0/v3_channel_selector_late_promotion_1/v3_selector_route_pilot_0/G2_MUX_POS/a_76_199# v3_four_channel_output_load_integration_0/v3_four_channel_shared_support_integration_0/v3_four_channel_bias_reference_distribution_0/v3_four_channel_phase_distribution_0/v3_four_channel_output_collection_0/v3_four_channel_placement_0/v3_channel_selector_late_promotion_1/v3_selector_route_pilot_0/G2_MUX_POS/X VDPWR sky130_fd_pr__pfet_01v8_hvt ad=0 pd=0 as=0.26 ps=2.52 w=1 l=0.15
X1934 VGND v3_four_channel_output_load_integration_0/v3_four_channel_shared_support_integration_0/v3_four_channel_bias_reference_distribution_0/v3_four_channel_phase_distribution_0/v3_four_channel_output_collection_0/v3_four_channel_placement_0/v3_channel_selector_late_promotion_1/v3_selector_route_pilot_0/G2_MUX_POS/a_76_199# v3_four_channel_output_load_integration_0/v3_four_channel_shared_support_integration_0/v3_four_channel_bias_reference_distribution_0/v3_four_channel_phase_distribution_0/v3_four_channel_output_collection_0/v3_four_channel_placement_0/v3_channel_selector_late_promotion_1/v3_selector_route_pilot_0/G2_MUX_POS/X VGND sky130_fd_pr__nfet_01v8 ad=0 pd=0 as=0.169 ps=1.82 w=0.65 l=0.15
X1935 VDPWR v3_four_channel_output_load_integration_0/v3_four_channel_shared_support_integration_0/v3_four_channel_bias_reference_distribution_0/v3_four_channel_phase_distribution_0/v3_four_channel_output_collection_0/v3_four_channel_placement_0/v3_channel_selector_late_promotion_1/v3_selector_route_pilot_0/G2_MUX_NEG/a_505_21# v3_four_channel_output_load_integration_0/v3_four_channel_shared_support_integration_0/v3_four_channel_bias_reference_distribution_0/v3_four_channel_phase_distribution_0/v3_four_channel_output_collection_0/v3_four_channel_placement_0/v3_channel_selector_late_promotion_1/v3_selector_route_pilot_0/G2_MUX_NEG/a_535_374# VDPWR sky130_fd_pr__pfet_01v8_hvt ad=0 pd=0 as=0.0882 ps=1.26 w=0.42 l=0.15
X1936 v3_four_channel_output_load_integration_0/v3_four_channel_shared_support_integration_0/v3_four_channel_bias_reference_distribution_0/v3_four_channel_phase_distribution_0/v3_four_channel_output_collection_0/v3_four_channel_placement_0/v3_channel_selector_late_promotion_1/v3_selector_route_pilot_0/G2_MUX_NEG/a_505_21# V3R218 VDPWR VDPWR sky130_fd_pr__pfet_01v8_hvt ad=0.1176 pd=1.4 as=0 ps=0 w=0.42 l=0.15
X1937 v3_four_channel_output_load_integration_0/v3_four_channel_shared_support_integration_0/v3_four_channel_bias_reference_distribution_0/v3_four_channel_phase_distribution_0/v3_four_channel_output_collection_0/v3_four_channel_placement_0/v3_channel_selector_late_promotion_1/v3_selector_route_pilot_0/G2_MUX_NEG/a_218_374# V3R218 VDPWR VDPWR sky130_fd_pr__pfet_01v8_hvt ad=0.1533 pd=1.57 as=0 ps=0 w=0.42 l=0.15
X1938 VGND v3_four_channel_output_load_integration_0/v3_four_channel_shared_support_integration_0/v3_four_channel_bias_reference_distribution_0/v3_four_channel_phase_distribution_0/v3_four_channel_output_collection_0/v3_four_channel_placement_0/v3_channel_selector_late_promotion_1/v3_selector_route_pilot_0/G2_MUX_NEG/a_505_21# v3_four_channel_output_load_integration_0/v3_four_channel_shared_support_integration_0/v3_four_channel_bias_reference_distribution_0/v3_four_channel_phase_distribution_0/v3_four_channel_output_collection_0/v3_four_channel_placement_0/v3_channel_selector_late_promotion_1/v3_selector_route_pilot_0/G2_MUX_NEG/a_439_47# VGND sky130_fd_pr__nfet_01v8 ad=0 pd=0 as=0.1386 ps=1.5 w=0.42 l=0.15
X1939 v3_four_channel_output_load_integration_0/v3_four_channel_shared_support_integration_0/v3_four_channel_bias_reference_distribution_0/v3_four_channel_phase_distribution_0/v3_four_channel_output_collection_0/v3_four_channel_placement_0/v3_channel_selector_late_promotion_1/v3_selector_route_pilot_0/G2_MUX_NEG/a_76_199# V3R292 v3_four_channel_output_load_integration_0/v3_four_channel_shared_support_integration_0/v3_four_channel_bias_reference_distribution_0/v3_four_channel_phase_distribution_0/v3_four_channel_output_collection_0/v3_four_channel_placement_0/v3_channel_selector_late_promotion_1/v3_selector_route_pilot_0/G2_MUX_NEG/a_218_374# VDPWR sky130_fd_pr__pfet_01v8_hvt ad=0.3864 pd=2.68 as=0 ps=0 w=0.42 l=0.15
X1940 v3_four_channel_output_load_integration_0/v3_four_channel_shared_support_integration_0/v3_four_channel_bias_reference_distribution_0/v3_four_channel_phase_distribution_0/v3_four_channel_output_collection_0/v3_four_channel_placement_0/v3_channel_selector_late_promotion_1/v3_selector_route_pilot_0/G2_MUX_NEG/a_505_21# V3R218 VGND VGND sky130_fd_pr__nfet_01v8 ad=0.1092 pd=1.36 as=0 ps=0 w=0.42 l=0.15
X1941 v3_four_channel_output_load_integration_0/v3_four_channel_shared_support_integration_0/v3_four_channel_bias_reference_distribution_0/v3_four_channel_phase_distribution_0/v3_four_channel_output_collection_0/v3_four_channel_placement_0/v3_channel_selector_late_promotion_1/v3_selector_route_pilot_0/G2_MUX_NEG/a_439_47# V3R292 v3_four_channel_output_load_integration_0/v3_four_channel_shared_support_integration_0/v3_four_channel_bias_reference_distribution_0/v3_four_channel_phase_distribution_0/v3_four_channel_output_collection_0/v3_four_channel_placement_0/v3_channel_selector_late_promotion_1/v3_selector_route_pilot_0/G2_MUX_NEG/a_76_199# VGND sky130_fd_pr__nfet_01v8 ad=0 pd=0 as=0.1995 ps=1.79 w=0.42 l=0.15
X1942 v3_four_channel_output_load_integration_0/v3_four_channel_shared_support_integration_0/v3_four_channel_bias_reference_distribution_0/v3_four_channel_phase_distribution_0/v3_four_channel_output_collection_0/v3_four_channel_placement_0/v3_channel_selector_late_promotion_1/v3_selector_route_pilot_0/G2_MUX_NEG/a_535_374# V3R293 v3_four_channel_output_load_integration_0/v3_four_channel_shared_support_integration_0/v3_four_channel_bias_reference_distribution_0/v3_four_channel_phase_distribution_0/v3_four_channel_output_collection_0/v3_four_channel_placement_0/v3_channel_selector_late_promotion_1/v3_selector_route_pilot_0/G2_MUX_NEG/a_76_199# VDPWR sky130_fd_pr__pfet_01v8_hvt ad=0 pd=0 as=0 ps=0 w=0.42 l=0.15
X1943 v3_four_channel_output_load_integration_0/v3_four_channel_shared_support_integration_0/v3_four_channel_bias_reference_distribution_0/v3_four_channel_phase_distribution_0/v3_four_channel_output_collection_0/v3_four_channel_placement_0/v3_channel_selector_late_promotion_1/v3_selector_route_pilot_0/G2_MUX_NEG/a_76_199# V3R293 v3_four_channel_output_load_integration_0/v3_four_channel_shared_support_integration_0/v3_four_channel_bias_reference_distribution_0/v3_four_channel_phase_distribution_0/v3_four_channel_output_collection_0/v3_four_channel_placement_0/v3_channel_selector_late_promotion_1/v3_selector_route_pilot_0/G2_MUX_NEG/a_218_47# VGND sky130_fd_pr__nfet_01v8 ad=0 pd=0 as=0.1386 ps=1.5 w=0.42 l=0.15
X1944 v3_four_channel_output_load_integration_0/v3_four_channel_shared_support_integration_0/v3_four_channel_bias_reference_distribution_0/v3_four_channel_phase_distribution_0/v3_four_channel_output_collection_0/v3_four_channel_placement_0/v3_channel_selector_late_promotion_1/v3_selector_route_pilot_0/G2_MUX_NEG/a_218_47# V3R218 VGND VGND sky130_fd_pr__nfet_01v8 ad=0 pd=0 as=0 ps=0 w=0.42 l=0.15
X1945 VDPWR v3_four_channel_output_load_integration_0/v3_four_channel_shared_support_integration_0/v3_four_channel_bias_reference_distribution_0/v3_four_channel_phase_distribution_0/v3_four_channel_output_collection_0/v3_four_channel_placement_0/v3_channel_selector_late_promotion_1/v3_selector_route_pilot_0/G2_MUX_NEG/a_76_199# v3_four_channel_output_load_integration_0/v3_four_channel_shared_support_integration_0/v3_four_channel_bias_reference_distribution_0/v3_four_channel_phase_distribution_0/v3_four_channel_output_collection_0/v3_four_channel_placement_0/v3_channel_selector_late_promotion_1/v3_selector_route_pilot_0/G2_MUX_NEG/X VDPWR sky130_fd_pr__pfet_01v8_hvt ad=0 pd=0 as=0.26 ps=2.52 w=1 l=0.15
X1946 VGND v3_four_channel_output_load_integration_0/v3_four_channel_shared_support_integration_0/v3_four_channel_bias_reference_distribution_0/v3_four_channel_phase_distribution_0/v3_four_channel_output_collection_0/v3_four_channel_placement_0/v3_channel_selector_late_promotion_1/v3_selector_route_pilot_0/G2_MUX_NEG/a_76_199# v3_four_channel_output_load_integration_0/v3_four_channel_shared_support_integration_0/v3_four_channel_bias_reference_distribution_0/v3_four_channel_phase_distribution_0/v3_four_channel_output_collection_0/v3_four_channel_placement_0/v3_channel_selector_late_promotion_1/v3_selector_route_pilot_0/G2_MUX_NEG/X VGND sky130_fd_pr__nfet_01v8 ad=0 pd=0 as=0.169 ps=1.82 w=0.65 l=0.15
X1947 VDPWR v3_four_channel_output_load_integration_0/v3_four_channel_shared_support_integration_0/v3_four_channel_bias_reference_distribution_0/v3_four_channel_phase_distribution_0/v3_four_channel_output_collection_0/v3_four_channel_placement_0/v3_channel_selector_late_promotion_1/v3_selector_route_pilot_0/G0_MUX_AXIS/a_505_21# v3_four_channel_output_load_integration_0/v3_four_channel_shared_support_integration_0/v3_four_channel_bias_reference_distribution_0/v3_four_channel_phase_distribution_0/v3_four_channel_output_collection_0/v3_four_channel_placement_0/v3_channel_selector_late_promotion_1/v3_selector_route_pilot_0/G0_MUX_AXIS/a_535_374# VDPWR sky130_fd_pr__pfet_01v8_hvt ad=0 pd=0 as=0.0882 ps=1.26 w=0.42 l=0.15
X1948 v3_four_channel_output_load_integration_0/v3_four_channel_shared_support_integration_0/v3_four_channel_bias_reference_distribution_0/v3_four_channel_phase_distribution_0/v3_four_channel_output_collection_0/v3_four_channel_placement_0/v3_channel_selector_late_promotion_1/v3_selector_route_pilot_0/G0_MUX_AXIS/a_505_21# V3R214 VDPWR VDPWR sky130_fd_pr__pfet_01v8_hvt ad=0.1176 pd=1.4 as=0 ps=0 w=0.42 l=0.15
X1949 v3_four_channel_output_load_integration_0/v3_four_channel_shared_support_integration_0/v3_four_channel_bias_reference_distribution_0/v3_four_channel_phase_distribution_0/v3_four_channel_output_collection_0/v3_four_channel_placement_0/v3_channel_selector_late_promotion_1/v3_selector_route_pilot_0/G0_MUX_AXIS/a_218_374# V3R214 VDPWR VDPWR sky130_fd_pr__pfet_01v8_hvt ad=0.1533 pd=1.57 as=0 ps=0 w=0.42 l=0.15
X1950 VGND v3_four_channel_output_load_integration_0/v3_four_channel_shared_support_integration_0/v3_four_channel_bias_reference_distribution_0/v3_four_channel_phase_distribution_0/v3_four_channel_output_collection_0/v3_four_channel_placement_0/v3_channel_selector_late_promotion_1/v3_selector_route_pilot_0/G0_MUX_AXIS/a_505_21# v3_four_channel_output_load_integration_0/v3_four_channel_shared_support_integration_0/v3_four_channel_bias_reference_distribution_0/v3_four_channel_phase_distribution_0/v3_four_channel_output_collection_0/v3_four_channel_placement_0/v3_channel_selector_late_promotion_1/v3_selector_route_pilot_0/G0_MUX_AXIS/a_439_47# VGND sky130_fd_pr__nfet_01v8 ad=0 pd=0 as=0.1386 ps=1.5 w=0.42 l=0.15
X1951 v3_four_channel_output_load_integration_0/v3_four_channel_shared_support_integration_0/v3_four_channel_bias_reference_distribution_0/v3_four_channel_phase_distribution_0/v3_four_channel_output_collection_0/v3_four_channel_placement_0/v3_channel_selector_late_promotion_1/v3_selector_route_pilot_0/G0_MUX_AXIS/a_76_199# v3_four_channel_output_load_integration_0/v3_four_channel_shared_support_integration_0/v3_four_channel_bias_reference_distribution_0/v3_four_channel_phase_distribution_0/v3_four_channel_output_collection_0/v3_four_channel_placement_0/v3_channel_selector_late_promotion_1/v3_selector_route_pilot_0/G0_MUX_POS/X v3_four_channel_output_load_integration_0/v3_four_channel_shared_support_integration_0/v3_four_channel_bias_reference_distribution_0/v3_four_channel_phase_distribution_0/v3_four_channel_output_collection_0/v3_four_channel_placement_0/v3_channel_selector_late_promotion_1/v3_selector_route_pilot_0/G0_MUX_AXIS/a_218_374# VDPWR sky130_fd_pr__pfet_01v8_hvt ad=0.3864 pd=2.68 as=0 ps=0 w=0.42 l=0.15
X1952 v3_four_channel_output_load_integration_0/v3_four_channel_shared_support_integration_0/v3_four_channel_bias_reference_distribution_0/v3_four_channel_phase_distribution_0/v3_four_channel_output_collection_0/v3_four_channel_placement_0/v3_channel_selector_late_promotion_1/v3_selector_route_pilot_0/G0_MUX_AXIS/a_505_21# V3R214 VGND VGND sky130_fd_pr__nfet_01v8 ad=0.1092 pd=1.36 as=0 ps=0 w=0.42 l=0.15
X1953 v3_four_channel_output_load_integration_0/v3_four_channel_shared_support_integration_0/v3_four_channel_bias_reference_distribution_0/v3_four_channel_phase_distribution_0/v3_four_channel_output_collection_0/v3_four_channel_placement_0/v3_channel_selector_late_promotion_1/v3_selector_route_pilot_0/G0_MUX_AXIS/a_439_47# v3_four_channel_output_load_integration_0/v3_four_channel_shared_support_integration_0/v3_four_channel_bias_reference_distribution_0/v3_four_channel_phase_distribution_0/v3_four_channel_output_collection_0/v3_four_channel_placement_0/v3_channel_selector_late_promotion_1/v3_selector_route_pilot_0/G0_MUX_POS/X v3_four_channel_output_load_integration_0/v3_four_channel_shared_support_integration_0/v3_four_channel_bias_reference_distribution_0/v3_four_channel_phase_distribution_0/v3_four_channel_output_collection_0/v3_four_channel_placement_0/v3_channel_selector_late_promotion_1/v3_selector_route_pilot_0/G0_MUX_AXIS/a_76_199# VGND sky130_fd_pr__nfet_01v8 ad=0 pd=0 as=0.1995 ps=1.79 w=0.42 l=0.15
X1954 v3_four_channel_output_load_integration_0/v3_four_channel_shared_support_integration_0/v3_four_channel_bias_reference_distribution_0/v3_four_channel_phase_distribution_0/v3_four_channel_output_collection_0/v3_four_channel_placement_0/v3_channel_selector_late_promotion_1/v3_selector_route_pilot_0/G0_MUX_AXIS/a_535_374# v3_four_channel_output_load_integration_0/v3_four_channel_shared_support_integration_0/v3_four_channel_bias_reference_distribution_0/v3_four_channel_phase_distribution_0/v3_four_channel_output_collection_0/v3_four_channel_placement_0/v3_channel_selector_late_promotion_1/v3_selector_route_pilot_0/G0_MUX_NEG/X v3_four_channel_output_load_integration_0/v3_four_channel_shared_support_integration_0/v3_four_channel_bias_reference_distribution_0/v3_four_channel_phase_distribution_0/v3_four_channel_output_collection_0/v3_four_channel_placement_0/v3_channel_selector_late_promotion_1/v3_selector_route_pilot_0/G0_MUX_AXIS/a_76_199# VDPWR sky130_fd_pr__pfet_01v8_hvt ad=0 pd=0 as=0 ps=0 w=0.42 l=0.15
X1955 v3_four_channel_output_load_integration_0/v3_four_channel_shared_support_integration_0/v3_four_channel_bias_reference_distribution_0/v3_four_channel_phase_distribution_0/v3_four_channel_output_collection_0/v3_four_channel_placement_0/v3_channel_selector_late_promotion_1/v3_selector_route_pilot_0/G0_MUX_AXIS/a_76_199# v3_four_channel_output_load_integration_0/v3_four_channel_shared_support_integration_0/v3_four_channel_bias_reference_distribution_0/v3_four_channel_phase_distribution_0/v3_four_channel_output_collection_0/v3_four_channel_placement_0/v3_channel_selector_late_promotion_1/v3_selector_route_pilot_0/G0_MUX_NEG/X v3_four_channel_output_load_integration_0/v3_four_channel_shared_support_integration_0/v3_four_channel_bias_reference_distribution_0/v3_four_channel_phase_distribution_0/v3_four_channel_output_collection_0/v3_four_channel_placement_0/v3_channel_selector_late_promotion_1/v3_selector_route_pilot_0/G0_MUX_AXIS/a_218_47# VGND sky130_fd_pr__nfet_01v8 ad=0 pd=0 as=0.1386 ps=1.5 w=0.42 l=0.15
X1956 v3_four_channel_output_load_integration_0/v3_four_channel_shared_support_integration_0/v3_four_channel_bias_reference_distribution_0/v3_four_channel_phase_distribution_0/v3_four_channel_output_collection_0/v3_four_channel_placement_0/v3_channel_selector_late_promotion_1/v3_selector_route_pilot_0/G0_MUX_AXIS/a_218_47# V3R214 VGND VGND sky130_fd_pr__nfet_01v8 ad=0 pd=0 as=0 ps=0 w=0.42 l=0.15
X1957 VDPWR v3_four_channel_output_load_integration_0/v3_four_channel_shared_support_integration_0/v3_four_channel_bias_reference_distribution_0/v3_four_channel_phase_distribution_0/v3_four_channel_output_collection_0/v3_four_channel_placement_0/v3_channel_selector_late_promotion_1/v3_selector_route_pilot_0/G0_MUX_AXIS/a_76_199# v3_four_channel_output_load_integration_0/v3_four_channel_shared_support_integration_0/v3_four_channel_bias_reference_distribution_0/v3_four_channel_phase_distribution_0/v3_four_channel_output_collection_0/v3_four_channel_placement_0/v3_channel_selector_late_promotion_1/v3_selector_route_pilot_0/G0_MUX_AXIS/X VDPWR sky130_fd_pr__pfet_01v8_hvt ad=0 pd=0 as=0.26 ps=2.52 w=1 l=0.15
X1958 VGND v3_four_channel_output_load_integration_0/v3_four_channel_shared_support_integration_0/v3_four_channel_bias_reference_distribution_0/v3_four_channel_phase_distribution_0/v3_four_channel_output_collection_0/v3_four_channel_placement_0/v3_channel_selector_late_promotion_1/v3_selector_route_pilot_0/G0_MUX_AXIS/a_76_199# v3_four_channel_output_load_integration_0/v3_four_channel_shared_support_integration_0/v3_four_channel_bias_reference_distribution_0/v3_four_channel_phase_distribution_0/v3_four_channel_output_collection_0/v3_four_channel_placement_0/v3_channel_selector_late_promotion_1/v3_selector_route_pilot_0/G0_MUX_AXIS/X VGND sky130_fd_pr__nfet_01v8 ad=0 pd=0 as=0.169 ps=1.82 w=0.65 l=0.15
X1959 VDPWR v3_four_channel_output_load_integration_0/v3_four_channel_shared_support_integration_0/v3_four_channel_bias_reference_distribution_0/v3_four_channel_phase_distribution_0/v3_four_channel_output_collection_0/v3_four_channel_placement_0/v3_channel_selector_late_promotion_1/v3_selector_route_pilot_0/G3_LO_P_AND/B v3_four_channel_output_load_integration_0/v3_four_channel_shared_support_integration_0/v3_four_channel_bias_reference_distribution_0/v3_four_channel_phase_distribution_0/v3_four_channel_output_collection_0/v3_four_channel_placement_0/v3_channel_selector_late_promotion_1/v3_selector_route_pilot_0/G2_LO_P_AND/a_59_75# VDPWR sky130_fd_pr__pfet_01v8_hvt ad=0 pd=0 as=0.1134 ps=1.38 w=0.42 l=0.15
X1960 v3_four_channel_output_load_integration_0/v3_four_channel_shared_support_integration_0/v3_four_channel_bias_reference_distribution_0/v3_four_channel_phase_distribution_0/v3_four_channel_output_collection_0/v3_four_channel_placement_0/v3_channel_selector_late_promotion_1/v3_selector_route_pilot_0/group2_lo_p v3_four_channel_output_load_integration_0/v3_four_channel_shared_support_integration_0/v3_four_channel_bias_reference_distribution_0/v3_four_channel_phase_distribution_0/v3_four_channel_output_collection_0/v3_four_channel_placement_0/v3_channel_selector_late_promotion_1/v3_selector_route_pilot_0/G2_LO_P_AND/a_59_75# VDPWR VDPWR sky130_fd_pr__pfet_01v8_hvt ad=0.475 pd=2.95 as=0 ps=0 w=1 l=0.15
X1961 VGND v3_four_channel_output_load_integration_0/v3_four_channel_shared_support_integration_0/v3_four_channel_bias_reference_distribution_0/v3_four_channel_phase_distribution_0/v3_four_channel_output_collection_0/v3_four_channel_placement_0/v3_channel_selector_late_promotion_1/v3_selector_route_pilot_0/G3_LO_P_AND/B v3_four_channel_output_load_integration_0/v3_four_channel_shared_support_integration_0/v3_four_channel_bias_reference_distribution_0/v3_four_channel_phase_distribution_0/v3_four_channel_output_collection_0/v3_four_channel_placement_0/v3_channel_selector_late_promotion_1/v3_selector_route_pilot_0/G2_LO_P_AND/a_145_75# VGND sky130_fd_pr__nfet_01v8 ad=0 pd=0 as=0.1134 ps=1.38 w=0.42 l=0.15
X1962 v3_four_channel_output_load_integration_0/v3_four_channel_shared_support_integration_0/v3_four_channel_bias_reference_distribution_0/v3_four_channel_phase_distribution_0/v3_four_channel_output_collection_0/v3_four_channel_placement_0/v3_channel_selector_late_promotion_1/v3_selector_route_pilot_0/G2_LO_P_AND/a_59_75# v3_four_channel_output_load_integration_0/v3_four_channel_shared_support_integration_0/v3_four_channel_bias_reference_distribution_0/v3_four_channel_phase_distribution_0/v3_four_channel_output_collection_0/v3_four_channel_placement_0/v3_channel_selector_late_promotion_1/v3_selector_route_pilot_0/G2_MUX_AXIS/X VDPWR VDPWR sky130_fd_pr__pfet_01v8_hvt ad=0 pd=0 as=0 ps=0 w=0.42 l=0.15
X1963 v3_four_channel_output_load_integration_0/v3_four_channel_shared_support_integration_0/v3_four_channel_bias_reference_distribution_0/v3_four_channel_phase_distribution_0/v3_four_channel_output_collection_0/v3_four_channel_placement_0/v3_channel_selector_late_promotion_1/v3_selector_route_pilot_0/group2_lo_p v3_four_channel_output_load_integration_0/v3_four_channel_shared_support_integration_0/v3_four_channel_bias_reference_distribution_0/v3_four_channel_phase_distribution_0/v3_four_channel_output_collection_0/v3_four_channel_placement_0/v3_channel_selector_late_promotion_1/v3_selector_route_pilot_0/G2_LO_P_AND/a_59_75# VGND VGND sky130_fd_pr__nfet_01v8 ad=0.182 pd=1.86 as=0 ps=0 w=0.65 l=0.15
X1964 v3_four_channel_output_load_integration_0/v3_four_channel_shared_support_integration_0/v3_four_channel_bias_reference_distribution_0/v3_four_channel_phase_distribution_0/v3_four_channel_output_collection_0/v3_four_channel_placement_0/v3_channel_selector_late_promotion_1/v3_selector_route_pilot_0/G2_LO_P_AND/a_145_75# v3_four_channel_output_load_integration_0/v3_four_channel_shared_support_integration_0/v3_four_channel_bias_reference_distribution_0/v3_four_channel_phase_distribution_0/v3_four_channel_output_collection_0/v3_four_channel_placement_0/v3_channel_selector_late_promotion_1/v3_selector_route_pilot_0/G2_MUX_AXIS/X v3_four_channel_output_load_integration_0/v3_four_channel_shared_support_integration_0/v3_four_channel_bias_reference_distribution_0/v3_four_channel_phase_distribution_0/v3_four_channel_output_collection_0/v3_four_channel_placement_0/v3_channel_selector_late_promotion_1/v3_selector_route_pilot_0/G2_LO_P_AND/a_59_75# VGND sky130_fd_pr__nfet_01v8 ad=0 pd=0 as=0.1176 ps=1.4 w=0.42 l=0.15
X1965 v3_four_channel_output_load_integration_0/v3_four_channel_shared_support_integration_0/v3_four_channel_bias_reference_distribution_0/v3_four_channel_phase_distribution_0/v3_four_channel_output_collection_0/v3_four_channel_placement_0/v3_channel_selector_late_promotion_2/v3_channel_input_bias_late_promotion_0/a_4678_23422# v3_four_channel_output_load_integration_0/v3_four_channel_shared_support_integration_0/v3_four_channel_bias_reference_distribution_0/v3_four_channel_phase_distribution_0/v3_four_channel_output_collection_0/v3_four_channel_placement_0/v3_channel_selector_late_promotion_2/v3_selector_route_pilot_0/group3_lo_p v3_four_channel_output_load_integration_0/combined_n VGND sky130_fd_pr__nfet_01v8 ad=0.6206 pd=6.02 as=0 ps=0 w=0.65 l=0.15
X1966 v3_four_channel_output_load_integration_0/combined_n v3_four_channel_output_load_integration_0/v3_four_channel_shared_support_integration_0/v3_four_channel_bias_reference_distribution_0/v3_four_channel_phase_distribution_0/v3_four_channel_output_collection_0/v3_four_channel_placement_0/v3_channel_selector_late_promotion_2/v3_selector_route_pilot_0/group3_lo_p v3_four_channel_output_load_integration_0/v3_four_channel_shared_support_integration_0/v3_four_channel_bias_reference_distribution_0/v3_four_channel_phase_distribution_0/v3_four_channel_output_collection_0/v3_four_channel_placement_0/v3_channel_selector_late_promotion_2/v3_channel_input_bias_late_promotion_0/a_4254_6978# VGND sky130_fd_pr__nfet_01v8 ad=0 pd=0 as=0.6206 ps=6.02 w=0.65 l=0.15
X1967 v3_four_channel_output_load_integration_0/v3_four_channel_shared_support_integration_0/v3_four_channel_bias_reference_distribution_0/v3_four_channel_phase_distribution_0/v3_four_channel_output_collection_0/v3_four_channel_placement_0/v3_channel_selector_late_promotion_2/v3_channel_input_bias_late_promotion_0/a_4678_23422# v3_four_channel_output_load_integration_0/v3_four_channel_shared_support_integration_0/v3_vcm_support_block_0/ref v3_four_channel_output_load_integration_0/v3_four_channel_shared_support_integration_0/v3_four_channel_bias_reference_distribution_0/v3_four_channel_phase_distribution_0/v3_four_channel_output_collection_0/v3_four_channel_placement_0/v3_channel_selector_late_promotion_2/v3_channel_input_bias_late_promotion_0/a_4382_21688# VGND sky130_fd_pr__nfet_01v8 ad=0 pd=0 as=1.9575 ps=15.24 w=0.84 l=0.6
X1968 v3_four_channel_output_load_integration_0/combined_n v3_four_channel_output_load_integration_0/v3_four_channel_shared_support_integration_0/v3_four_channel_bias_reference_distribution_0/v3_four_channel_phase_distribution_0/v3_four_channel_output_collection_0/v3_four_channel_placement_0/v3_channel_selector_late_promotion_2/v3_selector_route_pilot_0/group3_lo_n v3_four_channel_output_load_integration_0/v3_four_channel_shared_support_integration_0/v3_four_channel_bias_reference_distribution_0/v3_four_channel_phase_distribution_0/v3_four_channel_output_collection_0/v3_four_channel_placement_0/v3_channel_selector_late_promotion_2/v3_channel_input_bias_late_promotion_0/a_7038_22978# VGND sky130_fd_pr__nfet_01v8 ad=0 pd=0 as=0.6206 ps=6.02 w=0.65 l=0.15
X1969 v3_four_channel_output_load_integration_0/combined_n v3_four_channel_output_load_integration_0/v3_four_channel_shared_support_integration_0/v3_four_channel_bias_reference_distribution_0/v3_four_channel_phase_distribution_0/v3_four_channel_output_collection_0/v3_four_channel_placement_0/v3_channel_selector_late_promotion_2/v3_selector_route_pilot_0/group3_lo_p v3_four_channel_output_load_integration_0/v3_four_channel_shared_support_integration_0/v3_four_channel_bias_reference_distribution_0/v3_four_channel_phase_distribution_0/v3_four_channel_output_collection_0/v3_four_channel_placement_0/v3_channel_selector_late_promotion_2/v3_channel_input_bias_late_promotion_0/a_7038_6978# VGND sky130_fd_pr__nfet_01v8 ad=0 pd=0 as=0.6206 ps=6.02 w=0.65 l=0.15
X1970 v3_four_channel_output_load_integration_0/v3_four_channel_shared_support_integration_0/v3_four_channel_bias_reference_distribution_0/v3_four_channel_phase_distribution_0/v3_four_channel_output_collection_0/v3_four_channel_placement_0/v3_channel_selector_late_promotion_2/v3_channel_input_bias_late_promotion_0/a_7462_11422# V3I001 v3_four_channel_output_load_integration_0/v3_four_channel_shared_support_integration_0/v3_four_channel_bias_reference_distribution_0/v3_four_channel_phase_distribution_0/v3_four_channel_output_collection_0/v3_four_channel_placement_0/v3_channel_selector_late_promotion_2/v3_channel_input_bias_late_promotion_0/a_7216_10978# VGND sky130_fd_pr__nfet_01v8 ad=0.6206 pd=6.02 as=1.9575 ps=15.24 w=0.84 l=0.6
X1971 v3_four_channel_output_load_integration_0/v3_four_channel_shared_support_integration_0/v3_four_channel_bias_reference_distribution_0/v3_four_channel_phase_distribution_0/v3_four_channel_output_collection_0/v3_four_channel_placement_0/v3_channel_selector_late_promotion_2/v3_channel_input_bias_late_promotion_0/a_7462_11422# v3_four_channel_output_load_integration_0/v3_four_channel_shared_support_integration_0/v3_four_channel_bias_reference_distribution_0/v3_four_channel_phase_distribution_0/v3_four_channel_output_collection_0/v3_four_channel_placement_0/v3_channel_selector_late_promotion_2/v3_selector_route_pilot_0/group2_lo_n v3_four_channel_output_load_integration_0/combined_n VGND sky130_fd_pr__nfet_01v8 ad=0 pd=0 as=0 ps=0 w=0.65 l=0.15
X1972 v3_four_channel_output_load_integration_0/v3_four_channel_shared_support_integration_0/v3_four_channel_bias_reference_distribution_0/v3_four_channel_phase_distribution_0/v3_four_channel_output_collection_0/v3_four_channel_placement_0/v3_channel_selector_late_promotion_2/v3_channel_input_bias_late_promotion_0/a_5774_21688# V3I001 v3_four_channel_output_load_integration_0/v3_four_channel_shared_support_integration_0/v3_four_channel_bias_reference_distribution_0/v3_four_channel_phase_distribution_0/v3_four_channel_output_collection_0/v3_four_channel_placement_0/v3_channel_selector_late_promotion_2/v3_channel_input_bias_late_promotion_0/a_5646_22978# VGND sky130_fd_pr__nfet_01v8 ad=1.9575 pd=15.24 as=0.6206 ps=6.02 w=0.84 l=0.6
X1973 VGND v3_four_channel_output_load_integration_0/v3_four_channel_shared_support_integration_0/v3_tail_bias_support_block_0/vbias v3_four_channel_output_load_integration_0/v3_four_channel_shared_support_integration_0/v3_four_channel_bias_reference_distribution_0/v3_four_channel_phase_distribution_0/v3_four_channel_output_collection_0/v3_four_channel_placement_0/v3_channel_selector_late_promotion_2/v3_channel_input_bias_late_promotion_0/a_5774_17688# VGND sky130_fd_pr__nfet_01v8 ad=0 pd=0 as=1.9575 ps=15.24 w=5.07 l=1
X1974 v3_four_channel_output_load_integration_0/v3_four_channel_shared_support_integration_0/v3_four_channel_bias_reference_distribution_0/v3_four_channel_phase_distribution_0/v3_four_channel_output_collection_0/v3_four_channel_placement_0/v3_channel_selector_late_promotion_2/v3_channel_input_bias_late_promotion_0/a_6070_7422# V3I001 v3_four_channel_output_load_integration_0/v3_four_channel_shared_support_integration_0/v3_four_channel_bias_reference_distribution_0/v3_four_channel_phase_distribution_0/v3_four_channel_output_collection_0/v3_four_channel_placement_0/v3_channel_selector_late_promotion_2/v3_channel_input_bias_late_promotion_0/a_5824_6978# VGND sky130_fd_pr__nfet_01v8 ad=0.6206 pd=6.02 as=1.9575 ps=15.24 w=0.84 l=0.6
X1975 v3_four_channel_output_load_integration_0/v3_four_channel_shared_support_integration_0/v3_four_channel_bias_reference_distribution_0/v3_four_channel_phase_distribution_0/v3_four_channel_output_collection_0/v3_four_channel_placement_0/v3_channel_selector_late_promotion_2/v3_channel_input_bias_late_promotion_0/a_6070_7422# v3_four_channel_output_load_integration_0/v3_four_channel_shared_support_integration_0/v3_four_channel_bias_reference_distribution_0/v3_four_channel_phase_distribution_0/v3_four_channel_output_collection_0/v3_four_channel_placement_0/v3_channel_selector_late_promotion_2/v3_selector_route_pilot_0/group3_lo_n v3_four_channel_output_load_integration_0/combined_n VGND sky130_fd_pr__nfet_01v8 ad=0 pd=0 as=0 ps=0 w=0.65 l=0.15
X1976 v3_four_channel_output_load_integration_0/v3_four_channel_shared_support_integration_0/v3_vcm_support_block_0/ref V3I001 VGND sky130_fd_pr__res_xhigh_po_0p35 l=17.36
X1977 v3_four_channel_output_load_integration_0/v3_four_channel_shared_support_integration_0/v3_four_channel_bias_reference_distribution_0/v3_four_channel_phase_distribution_0/v3_four_channel_output_collection_0/v3_four_channel_placement_0/v3_channel_selector_late_promotion_2/v3_channel_input_bias_late_promotion_0/a_7462_23422# v3_four_channel_output_load_integration_0/v3_four_channel_shared_support_integration_0/v3_vcm_support_block_0/ref v3_four_channel_output_load_integration_0/v3_four_channel_shared_support_integration_0/v3_four_channel_bias_reference_distribution_0/v3_four_channel_phase_distribution_0/v3_four_channel_output_collection_0/v3_four_channel_placement_0/v3_channel_selector_late_promotion_2/v3_channel_input_bias_late_promotion_0/a_7166_21688# VGND sky130_fd_pr__nfet_01v8 ad=0.6206 pd=6.02 as=1.9575 ps=15.24 w=0.84 l=0.6
X1978 v3_four_channel_output_load_integration_0/v3_four_channel_shared_support_integration_0/v3_four_channel_bias_reference_distribution_0/v3_four_channel_phase_distribution_0/v3_four_channel_output_collection_0/v3_four_channel_placement_0/v3_channel_selector_late_promotion_2/v3_channel_input_bias_late_promotion_0/a_7462_23422# v3_four_channel_output_load_integration_0/v3_four_channel_shared_support_integration_0/v3_four_channel_bias_reference_distribution_0/v3_four_channel_phase_distribution_0/v3_four_channel_output_collection_0/v3_four_channel_placement_0/v3_channel_selector_late_promotion_2/v3_selector_route_pilot_0/group3_lo_p v3_four_channel_output_load_integration_0/combined_n VGND sky130_fd_pr__nfet_01v8 ad=0 pd=0 as=0 ps=0 w=0.65 l=0.15
X1979 VGND v3_four_channel_output_load_integration_0/v3_four_channel_shared_support_integration_0/v3_tail_bias_support_block_0/vbias v3_four_channel_output_load_integration_0/v3_four_channel_shared_support_integration_0/v3_four_channel_bias_reference_distribution_0/v3_four_channel_phase_distribution_0/v3_four_channel_output_collection_0/v3_four_channel_placement_0/v3_channel_selector_late_promotion_2/v3_channel_input_bias_late_promotion_0/a_4382_21688# VGND sky130_fd_pr__nfet_01v8 ad=0 pd=0 as=0 ps=0 w=5.07 l=1
X1980 VGND v3_four_channel_output_load_integration_0/v3_four_channel_shared_support_integration_0/v3_tail_bias_support_block_0/vbias v3_four_channel_output_load_integration_0/v3_four_channel_shared_support_integration_0/v3_four_channel_bias_reference_distribution_0/v3_four_channel_phase_distribution_0/v3_four_channel_output_collection_0/v3_four_channel_placement_0/v3_channel_selector_late_promotion_2/v3_channel_input_bias_late_promotion_0/a_5774_13688# VGND sky130_fd_pr__nfet_01v8 ad=0 pd=0 as=1.9575 ps=15.24 w=5.07 l=1
X1981 VGND v3_four_channel_output_load_integration_0/v3_four_channel_shared_support_integration_0/v3_tail_bias_support_block_0/vbias v3_four_channel_output_load_integration_0/v3_four_channel_shared_support_integration_0/v3_four_channel_bias_reference_distribution_0/v3_four_channel_phase_distribution_0/v3_four_channel_output_collection_0/v3_four_channel_placement_0/v3_channel_selector_late_promotion_2/v3_channel_input_bias_late_promotion_0/a_7166_17688# VGND sky130_fd_pr__nfet_01v8 ad=0 pd=0 as=1.9575 ps=15.24 w=5.07 l=1
X1982 VGND VGND VGND VGND sky130_fd_pr__nfet_01v8 ad=0 pd=0 as=0 ps=0 w=0.65 l=0.15
X1983 v3_four_channel_output_load_integration_0/combined_p v3_four_channel_output_load_integration_0/v3_four_channel_shared_support_integration_0/v3_four_channel_bias_reference_distribution_0/v3_four_channel_phase_distribution_0/v3_four_channel_output_collection_0/v3_four_channel_placement_0/v3_channel_selector_late_promotion_2/v3_selector_route_pilot_0/group3_lo_p v3_four_channel_output_load_integration_0/v3_four_channel_shared_support_integration_0/v3_four_channel_bias_reference_distribution_0/v3_four_channel_phase_distribution_0/v3_four_channel_output_collection_0/v3_four_channel_placement_0/v3_channel_selector_late_promotion_2/v3_channel_input_bias_late_promotion_0/a_5646_18978# VGND sky130_fd_pr__nfet_01v8 ad=0 pd=0 as=0.6206 ps=6.02 w=0.65 l=0.15
X1984 VGND VGND VGND VGND sky130_fd_pr__nfet_01v8 ad=0 pd=0 as=0 ps=0 w=0.65 l=0.15
X1985 v3_four_channel_output_load_integration_0/v3_four_channel_shared_support_integration_0/v3_four_channel_bias_reference_distribution_0/v3_four_channel_phase_distribution_0/v3_four_channel_output_collection_0/v3_four_channel_placement_0/v3_channel_selector_late_promotion_2/v3_channel_input_bias_late_promotion_0/a_6070_19422# v3_four_channel_output_load_integration_0/v3_four_channel_shared_support_integration_0/v3_four_channel_bias_reference_distribution_0/v3_four_channel_phase_distribution_0/v3_four_channel_output_collection_0/v3_four_channel_placement_0/v3_channel_selector_late_promotion_2/v3_selector_route_pilot_0/group3_lo_n v3_four_channel_output_load_integration_0/combined_p VGND sky130_fd_pr__nfet_01v8 ad=0.6206 pd=6.02 as=0 ps=0 w=0.65 l=0.15
X1986 VGND VGND VGND VGND sky130_fd_pr__nfet_01v8 ad=0 pd=0 as=0 ps=0 w=0.65 l=0.15
X1987 v3_four_channel_output_load_integration_0/combined_p v3_four_channel_output_load_integration_0/v3_four_channel_shared_support_integration_0/v3_four_channel_bias_reference_distribution_0/v3_four_channel_phase_distribution_0/v3_four_channel_output_collection_0/v3_four_channel_placement_0/v3_channel_selector_late_promotion_2/v3_selector_route_pilot_0/group2_lo_p v3_four_channel_output_load_integration_0/v3_four_channel_shared_support_integration_0/v3_four_channel_bias_reference_distribution_0/v3_four_channel_phase_distribution_0/v3_four_channel_output_collection_0/v3_four_channel_placement_0/v3_channel_selector_late_promotion_2/v3_channel_input_bias_late_promotion_0/a_4254_18978# VGND sky130_fd_pr__nfet_01v8 ad=0 pd=0 as=0.6206 ps=6.02 w=0.65 l=0.15
X1988 v3_four_channel_output_load_integration_0/v3_four_channel_shared_support_integration_0/v3_four_channel_bias_reference_distribution_0/v3_four_channel_phase_distribution_0/v3_four_channel_output_collection_0/v3_four_channel_placement_0/v3_channel_selector_late_promotion_2/v3_channel_input_bias_late_promotion_0/a_7216_14978# v3_four_channel_output_load_integration_0/v3_four_channel_shared_support_integration_0/v3_tail_bias_support_block_0/vbias VGND VGND sky130_fd_pr__nfet_01v8 ad=1.9575 pd=15.24 as=0 ps=0 w=5.07 l=1
X1989 VGND VGND VGND VGND sky130_fd_pr__nfet_01v8 ad=0 pd=0 as=0 ps=0 w=0.65 l=0.15
X1990 VGND VGND VGND VGND sky130_fd_pr__nfet_01v8 ad=0 pd=0 as=0 ps=0 w=0.65 l=0.15
X1991 v3_four_channel_output_load_integration_0/v3_four_channel_shared_support_integration_0/v3_four_channel_bias_reference_distribution_0/v3_four_channel_phase_distribution_0/v3_four_channel_output_collection_0/v3_four_channel_placement_0/v3_channel_selector_late_promotion_2/v3_channel_input_bias_late_promotion_0/a_4382_17688# V3I001 v3_four_channel_output_load_integration_0/v3_four_channel_shared_support_integration_0/v3_four_channel_bias_reference_distribution_0/v3_four_channel_phase_distribution_0/v3_four_channel_output_collection_0/v3_four_channel_placement_0/v3_channel_selector_late_promotion_2/v3_channel_input_bias_late_promotion_0/a_4254_18978# VGND sky130_fd_pr__nfet_01v8 ad=1.9575 pd=15.24 as=0 ps=0 w=0.84 l=0.6
X1992 v3_four_channel_output_load_integration_0/v3_four_channel_shared_support_integration_0/v3_four_channel_bias_reference_distribution_0/v3_four_channel_phase_distribution_0/v3_four_channel_output_collection_0/v3_four_channel_placement_0/v3_channel_selector_late_promotion_2/v3_channel_input_bias_late_promotion_0/a_4678_19422# v3_four_channel_output_load_integration_0/v3_four_channel_shared_support_integration_0/v3_four_channel_bias_reference_distribution_0/v3_four_channel_phase_distribution_0/v3_four_channel_output_collection_0/v3_four_channel_placement_0/v3_channel_selector_late_promotion_2/v3_selector_route_pilot_0/group2_lo_n v3_four_channel_output_load_integration_0/combined_p VGND sky130_fd_pr__nfet_01v8 ad=0.6206 pd=6.02 as=0 ps=0 w=0.65 l=0.15
X1993 v3_four_channel_output_load_integration_0/combined_p v3_four_channel_output_load_integration_0/v3_four_channel_shared_support_integration_0/v3_four_channel_bias_reference_distribution_0/v3_four_channel_phase_distribution_0/v3_four_channel_output_collection_0/v3_four_channel_placement_0/v3_channel_selector_late_promotion_2/v3_selector_route_pilot_0/group0_lo_p v3_four_channel_output_load_integration_0/v3_four_channel_shared_support_integration_0/v3_four_channel_bias_reference_distribution_0/v3_four_channel_phase_distribution_0/v3_four_channel_output_collection_0/v3_four_channel_placement_0/v3_channel_selector_late_promotion_2/v3_channel_input_bias_late_promotion_0/a_5646_14978# VGND sky130_fd_pr__nfet_01v8 ad=0 pd=0 as=0.6206 ps=6.02 w=0.65 l=0.15
X1994 v3_four_channel_output_load_integration_0/combined_p v3_four_channel_output_load_integration_0/v3_four_channel_shared_support_integration_0/v3_four_channel_bias_reference_distribution_0/v3_four_channel_phase_distribution_0/v3_four_channel_output_collection_0/v3_four_channel_placement_0/v3_channel_selector_late_promotion_2/v3_selector_route_pilot_0/group2_lo_p v3_four_channel_output_load_integration_0/v3_four_channel_shared_support_integration_0/v3_four_channel_bias_reference_distribution_0/v3_four_channel_phase_distribution_0/v3_four_channel_output_collection_0/v3_four_channel_placement_0/v3_channel_selector_late_promotion_2/v3_channel_input_bias_late_promotion_0/a_7038_18978# VGND sky130_fd_pr__nfet_01v8 ad=0 pd=0 as=0.6206 ps=6.02 w=0.65 l=0.15
X1995 VGND VGND VGND VGND sky130_fd_pr__nfet_01v8 ad=0 pd=0 as=0 ps=0 w=5.07 l=1
X1996 v3_four_channel_output_load_integration_0/v3_four_channel_shared_support_integration_0/v3_four_channel_bias_reference_distribution_0/v3_four_channel_phase_distribution_0/v3_four_channel_output_collection_0/v3_four_channel_placement_0/v3_channel_selector_late_promotion_2/v3_channel_input_bias_late_promotion_0/a_6070_15422# v3_four_channel_output_load_integration_0/v3_four_channel_shared_support_integration_0/v3_four_channel_bias_reference_distribution_0/v3_four_channel_phase_distribution_0/v3_four_channel_output_collection_0/v3_four_channel_placement_0/v3_channel_selector_late_promotion_2/v3_selector_route_pilot_0/group0_lo_n v3_four_channel_output_load_integration_0/combined_p VGND sky130_fd_pr__nfet_01v8 ad=0.6206 pd=6.02 as=0 ps=0 w=0.65 l=0.15
X1997 v3_four_channel_output_load_integration_0/v3_four_channel_shared_support_integration_0/v3_four_channel_bias_reference_distribution_0/v3_four_channel_phase_distribution_0/v3_four_channel_output_collection_0/v3_four_channel_placement_0/v3_channel_selector_late_promotion_2/v3_channel_input_bias_late_promotion_0/a_7166_17688# V3I001 v3_four_channel_output_load_integration_0/v3_four_channel_shared_support_integration_0/v3_four_channel_bias_reference_distribution_0/v3_four_channel_phase_distribution_0/v3_four_channel_output_collection_0/v3_four_channel_placement_0/v3_channel_selector_late_promotion_2/v3_channel_input_bias_late_promotion_0/a_7038_18978# VGND sky130_fd_pr__nfet_01v8 ad=0 pd=0 as=0 ps=0 w=0.84 l=0.6
X1998 v3_four_channel_output_load_integration_0/combined_n v3_four_channel_output_load_integration_0/v3_four_channel_shared_support_integration_0/v3_four_channel_bias_reference_distribution_0/v3_four_channel_phase_distribution_0/v3_four_channel_output_collection_0/v3_four_channel_placement_0/v3_channel_selector_late_promotion_2/v3_selector_route_pilot_0/group3_lo_n v3_four_channel_output_load_integration_0/v3_four_channel_shared_support_integration_0/v3_four_channel_bias_reference_distribution_0/v3_four_channel_phase_distribution_0/v3_four_channel_output_collection_0/v3_four_channel_placement_0/v3_channel_selector_late_promotion_2/v3_channel_input_bias_late_promotion_0/a_5646_18978# VGND sky130_fd_pr__nfet_01v8 ad=0 pd=0 as=0 ps=0 w=0.65 l=0.15
X1999 VGND v3_four_channel_output_load_integration_0/v3_four_channel_shared_support_integration_0/v3_tail_bias_support_block_0/vbias v3_four_channel_output_load_integration_0/v3_four_channel_shared_support_integration_0/v3_four_channel_bias_reference_distribution_0/v3_four_channel_phase_distribution_0/v3_four_channel_output_collection_0/v3_four_channel_placement_0/v3_channel_selector_late_promotion_2/v3_channel_input_bias_late_promotion_0/a_5774_21688# VGND sky130_fd_pr__nfet_01v8 ad=0 pd=0 as=0 ps=0 w=5.07 l=1
X2000 v3_four_channel_output_load_integration_0/v3_four_channel_shared_support_integration_0/v3_four_channel_bias_reference_distribution_0/v3_four_channel_phase_distribution_0/v3_four_channel_output_collection_0/v3_four_channel_placement_0/v3_channel_selector_late_promotion_2/v3_channel_input_bias_late_promotion_0/a_6070_19422# v3_four_channel_output_load_integration_0/v3_four_channel_shared_support_integration_0/v3_vcm_support_block_0/ref v3_four_channel_output_load_integration_0/v3_four_channel_shared_support_integration_0/v3_four_channel_bias_reference_distribution_0/v3_four_channel_phase_distribution_0/v3_four_channel_output_collection_0/v3_four_channel_placement_0/v3_channel_selector_late_promotion_2/v3_channel_input_bias_late_promotion_0/a_5774_17688# VGND sky130_fd_pr__nfet_01v8 ad=0 pd=0 as=0 ps=0 w=0.84 l=0.6
X2001 VGND VGND VGND VGND sky130_fd_pr__nfet_01v8 ad=0 pd=0 as=0 ps=0 w=5.07 l=1
X2002 v3_four_channel_output_load_integration_0/combined_p v3_four_channel_output_load_integration_0/v3_four_channel_shared_support_integration_0/v3_four_channel_bias_reference_distribution_0/v3_four_channel_phase_distribution_0/v3_four_channel_output_collection_0/v3_four_channel_placement_0/v3_channel_selector_late_promotion_2/v3_selector_route_pilot_0/group1_lo_p v3_four_channel_output_load_integration_0/v3_four_channel_shared_support_integration_0/v3_four_channel_bias_reference_distribution_0/v3_four_channel_phase_distribution_0/v3_four_channel_output_collection_0/v3_four_channel_placement_0/v3_channel_selector_late_promotion_2/v3_channel_input_bias_late_promotion_0/a_4254_14978# VGND sky130_fd_pr__nfet_01v8 ad=0 pd=0 as=0.6206 ps=6.02 w=0.65 l=0.15
X2003 v3_four_channel_output_load_integration_0/v3_four_channel_shared_support_integration_0/v3_four_channel_bias_reference_distribution_0/v3_four_channel_phase_distribution_0/v3_four_channel_output_collection_0/v3_four_channel_placement_0/v3_channel_selector_late_promotion_2/v3_channel_input_bias_late_promotion_0/a_6070_19422# v3_four_channel_output_load_integration_0/v3_four_channel_shared_support_integration_0/v3_four_channel_bias_reference_distribution_0/v3_four_channel_phase_distribution_0/v3_four_channel_output_collection_0/v3_four_channel_placement_0/v3_channel_selector_late_promotion_2/v3_selector_route_pilot_0/group3_lo_p v3_four_channel_output_load_integration_0/combined_n VGND sky130_fd_pr__nfet_01v8 ad=0 pd=0 as=0 ps=0 w=0.65 l=0.15
X2004 VGND VGND VGND VGND sky130_fd_pr__nfet_01v8 ad=0 pd=0 as=0 ps=0 w=0.65 l=0.15
X2005 v3_four_channel_output_load_integration_0/v3_four_channel_shared_support_integration_0/v3_four_channel_bias_reference_distribution_0/v3_four_channel_phase_distribution_0/v3_four_channel_output_collection_0/v3_four_channel_placement_0/v3_channel_selector_late_promotion_2/v3_channel_input_bias_late_promotion_0/a_5824_10978# v3_four_channel_output_load_integration_0/v3_four_channel_shared_support_integration_0/v3_tail_bias_support_block_0/vbias VGND VGND sky130_fd_pr__nfet_01v8 ad=1.9575 pd=15.24 as=0 ps=0 w=5.07 l=1
X2006 v3_four_channel_output_load_integration_0/v3_four_channel_shared_support_integration_0/v3_four_channel_bias_reference_distribution_0/v3_four_channel_phase_distribution_0/v3_four_channel_output_collection_0/v3_four_channel_placement_0/v3_channel_selector_late_promotion_2/v3_channel_input_bias_late_promotion_0/a_4382_13688# V3I001 v3_four_channel_output_load_integration_0/v3_four_channel_shared_support_integration_0/v3_four_channel_bias_reference_distribution_0/v3_four_channel_phase_distribution_0/v3_four_channel_output_collection_0/v3_four_channel_placement_0/v3_channel_selector_late_promotion_2/v3_channel_input_bias_late_promotion_0/a_4254_14978# VGND sky130_fd_pr__nfet_01v8 ad=1.9575 pd=15.24 as=0 ps=0 w=0.84 l=0.6
X2007 v3_four_channel_output_load_integration_0/v3_four_channel_shared_support_integration_0/v3_four_channel_bias_reference_distribution_0/v3_four_channel_phase_distribution_0/v3_four_channel_output_collection_0/v3_four_channel_placement_0/v3_channel_selector_late_promotion_2/v3_channel_input_bias_late_promotion_0/a_4678_15422# v3_four_channel_output_load_integration_0/v3_four_channel_shared_support_integration_0/v3_four_channel_bias_reference_distribution_0/v3_four_channel_phase_distribution_0/v3_four_channel_output_collection_0/v3_four_channel_placement_0/v3_channel_selector_late_promotion_2/v3_selector_route_pilot_0/group1_lo_n v3_four_channel_output_load_integration_0/combined_p VGND sky130_fd_pr__nfet_01v8 ad=0.6206 pd=6.02 as=0 ps=0 w=0.65 l=0.15
X2008 v3_four_channel_output_load_integration_0/combined_n v3_four_channel_output_load_integration_0/v3_four_channel_shared_support_integration_0/v3_four_channel_bias_reference_distribution_0/v3_four_channel_phase_distribution_0/v3_four_channel_output_collection_0/v3_four_channel_placement_0/v3_channel_selector_late_promotion_2/v3_selector_route_pilot_0/group2_lo_n v3_four_channel_output_load_integration_0/v3_four_channel_shared_support_integration_0/v3_four_channel_bias_reference_distribution_0/v3_four_channel_phase_distribution_0/v3_four_channel_output_collection_0/v3_four_channel_placement_0/v3_channel_selector_late_promotion_2/v3_channel_input_bias_late_promotion_0/a_4254_18978# VGND sky130_fd_pr__nfet_01v8 ad=0 pd=0 as=0 ps=0 w=0.65 l=0.15
X2009 v3_four_channel_output_load_integration_0/combined_p v3_four_channel_output_load_integration_0/v3_four_channel_shared_support_integration_0/v3_four_channel_bias_reference_distribution_0/v3_four_channel_phase_distribution_0/v3_four_channel_output_collection_0/v3_four_channel_placement_0/v3_channel_selector_late_promotion_2/v3_selector_route_pilot_0/group3_lo_n v3_four_channel_output_load_integration_0/v3_four_channel_shared_support_integration_0/v3_four_channel_bias_reference_distribution_0/v3_four_channel_phase_distribution_0/v3_four_channel_output_collection_0/v3_four_channel_placement_0/v3_channel_selector_late_promotion_2/v3_channel_input_bias_late_promotion_0/a_5646_10978# VGND sky130_fd_pr__nfet_01v8 ad=0 pd=0 as=0.6206 ps=6.02 w=0.65 l=0.15
X2010 v3_four_channel_output_load_integration_0/combined_p v3_four_channel_output_load_integration_0/v3_four_channel_shared_support_integration_0/v3_four_channel_bias_reference_distribution_0/v3_four_channel_phase_distribution_0/v3_four_channel_output_collection_0/v3_four_channel_placement_0/v3_channel_selector_late_promotion_2/v3_selector_route_pilot_0/group1_lo_n v3_four_channel_output_load_integration_0/v3_four_channel_shared_support_integration_0/v3_four_channel_bias_reference_distribution_0/v3_four_channel_phase_distribution_0/v3_four_channel_output_collection_0/v3_four_channel_placement_0/v3_channel_selector_late_promotion_2/v3_channel_input_bias_late_promotion_0/a_7038_14978# VGND sky130_fd_pr__nfet_01v8 ad=0 pd=0 as=0.6206 ps=6.02 w=0.65 l=0.15
X2011 v3_four_channel_output_load_integration_0/v3_four_channel_shared_support_integration_0/v3_four_channel_bias_reference_distribution_0/v3_four_channel_phase_distribution_0/v3_four_channel_output_collection_0/v3_four_channel_placement_0/v3_channel_selector_late_promotion_2/v3_channel_input_bias_late_promotion_0/a_7462_19422# v3_four_channel_output_load_integration_0/v3_four_channel_shared_support_integration_0/v3_four_channel_bias_reference_distribution_0/v3_four_channel_phase_distribution_0/v3_four_channel_output_collection_0/v3_four_channel_placement_0/v3_channel_selector_late_promotion_2/v3_selector_route_pilot_0/group2_lo_n v3_four_channel_output_load_integration_0/combined_p VGND sky130_fd_pr__nfet_01v8 ad=0.6206 pd=6.02 as=0 ps=0 w=0.65 l=0.15
X2012 v3_four_channel_output_load_integration_0/v3_four_channel_shared_support_integration_0/v3_four_channel_bias_reference_distribution_0/v3_four_channel_phase_distribution_0/v3_four_channel_output_collection_0/v3_four_channel_placement_0/v3_channel_selector_late_promotion_2/v3_channel_input_bias_late_promotion_0/a_4678_7422# v3_four_channel_output_load_integration_0/v3_four_channel_shared_support_integration_0/v3_four_channel_bias_reference_distribution_0/v3_four_channel_phase_distribution_0/v3_four_channel_output_collection_0/v3_four_channel_placement_0/v3_channel_selector_late_promotion_2/v3_selector_route_pilot_0/group3_lo_p v3_four_channel_output_load_integration_0/combined_p VGND sky130_fd_pr__nfet_01v8 ad=0.6206 pd=6.02 as=0 ps=0 w=0.65 l=0.15
X2013 v3_four_channel_output_load_integration_0/v3_four_channel_shared_support_integration_0/v3_four_channel_bias_reference_distribution_0/v3_four_channel_phase_distribution_0/v3_four_channel_output_collection_0/v3_four_channel_placement_0/v3_channel_selector_late_promotion_2/v3_channel_input_bias_late_promotion_0/a_6070_11422# v3_four_channel_output_load_integration_0/v3_four_channel_shared_support_integration_0/v3_four_channel_bias_reference_distribution_0/v3_four_channel_phase_distribution_0/v3_four_channel_output_collection_0/v3_four_channel_placement_0/v3_channel_selector_late_promotion_2/v3_selector_route_pilot_0/group3_lo_p v3_four_channel_output_load_integration_0/combined_p VGND sky130_fd_pr__nfet_01v8 ad=0.6206 pd=6.02 as=0 ps=0 w=0.65 l=0.15
X2014 v3_four_channel_output_load_integration_0/v3_four_channel_shared_support_integration_0/v3_four_channel_bias_reference_distribution_0/v3_four_channel_phase_distribution_0/v3_four_channel_output_collection_0/v3_four_channel_placement_0/v3_channel_selector_late_promotion_2/v3_channel_input_bias_late_promotion_0/a_7216_10978# v3_four_channel_output_load_integration_0/v3_four_channel_shared_support_integration_0/v3_tail_bias_support_block_0/vbias VGND VGND sky130_fd_pr__nfet_01v8 ad=0 pd=0 as=0 ps=0 w=5.07 l=1
X2015 v3_four_channel_output_load_integration_0/v3_four_channel_shared_support_integration_0/v3_four_channel_bias_reference_distribution_0/v3_four_channel_phase_distribution_0/v3_four_channel_output_collection_0/v3_four_channel_placement_0/v3_channel_selector_late_promotion_2/v3_channel_input_bias_late_promotion_0/a_7216_14978# v3_four_channel_output_load_integration_0/v3_four_channel_shared_support_integration_0/v3_vcm_support_block_0/ref v3_four_channel_output_load_integration_0/v3_four_channel_shared_support_integration_0/v3_four_channel_bias_reference_distribution_0/v3_four_channel_phase_distribution_0/v3_four_channel_output_collection_0/v3_four_channel_placement_0/v3_channel_selector_late_promotion_2/v3_channel_input_bias_late_promotion_0/a_7038_14978# VGND sky130_fd_pr__nfet_01v8 ad=0 pd=0 as=0 ps=0 w=0.84 l=0.6
X2016 v3_four_channel_output_load_integration_0/v3_four_channel_shared_support_integration_0/v3_four_channel_bias_reference_distribution_0/v3_four_channel_phase_distribution_0/v3_four_channel_output_collection_0/v3_four_channel_placement_0/v3_channel_selector_late_promotion_2/v3_channel_input_bias_late_promotion_0/a_4678_19422# v3_four_channel_output_load_integration_0/v3_four_channel_shared_support_integration_0/v3_vcm_support_block_0/ref v3_four_channel_output_load_integration_0/v3_four_channel_shared_support_integration_0/v3_four_channel_bias_reference_distribution_0/v3_four_channel_phase_distribution_0/v3_four_channel_output_collection_0/v3_four_channel_placement_0/v3_channel_selector_late_promotion_2/v3_channel_input_bias_late_promotion_0/a_4382_17688# VGND sky130_fd_pr__nfet_01v8 ad=0 pd=0 as=0 ps=0 w=0.84 l=0.6
X2017 v3_four_channel_output_load_integration_0/v3_four_channel_shared_support_integration_0/v3_four_channel_bias_reference_distribution_0/v3_four_channel_phase_distribution_0/v3_four_channel_output_collection_0/v3_four_channel_placement_0/v3_channel_selector_late_promotion_2/v3_channel_input_bias_late_promotion_0/a_4678_19422# v3_four_channel_output_load_integration_0/v3_four_channel_shared_support_integration_0/v3_four_channel_bias_reference_distribution_0/v3_four_channel_phase_distribution_0/v3_four_channel_output_collection_0/v3_four_channel_placement_0/v3_channel_selector_late_promotion_2/v3_selector_route_pilot_0/group2_lo_p v3_four_channel_output_load_integration_0/combined_n VGND sky130_fd_pr__nfet_01v8 ad=0 pd=0 as=0 ps=0 w=0.65 l=0.15
X2018 v3_four_channel_output_load_integration_0/combined_n v3_four_channel_output_load_integration_0/v3_four_channel_shared_support_integration_0/v3_four_channel_bias_reference_distribution_0/v3_four_channel_phase_distribution_0/v3_four_channel_output_collection_0/v3_four_channel_placement_0/v3_channel_selector_late_promotion_2/v3_selector_route_pilot_0/group0_lo_n v3_four_channel_output_load_integration_0/v3_four_channel_shared_support_integration_0/v3_four_channel_bias_reference_distribution_0/v3_four_channel_phase_distribution_0/v3_four_channel_output_collection_0/v3_four_channel_placement_0/v3_channel_selector_late_promotion_2/v3_channel_input_bias_late_promotion_0/a_5646_14978# VGND sky130_fd_pr__nfet_01v8 ad=0 pd=0 as=0 ps=0 w=0.65 l=0.15
X2019 v3_four_channel_output_load_integration_0/combined_n v3_four_channel_output_load_integration_0/v3_four_channel_shared_support_integration_0/v3_four_channel_bias_reference_distribution_0/v3_four_channel_phase_distribution_0/v3_four_channel_output_collection_0/v3_four_channel_placement_0/v3_channel_selector_late_promotion_2/v3_selector_route_pilot_0/group2_lo_n v3_four_channel_output_load_integration_0/v3_four_channel_shared_support_integration_0/v3_four_channel_bias_reference_distribution_0/v3_four_channel_phase_distribution_0/v3_four_channel_output_collection_0/v3_four_channel_placement_0/v3_channel_selector_late_promotion_2/v3_channel_input_bias_late_promotion_0/a_7038_18978# VGND sky130_fd_pr__nfet_01v8 ad=0 pd=0 as=0 ps=0 w=0.65 l=0.15
X2020 v3_four_channel_output_load_integration_0/v3_four_channel_shared_support_integration_0/v3_four_channel_bias_reference_distribution_0/v3_four_channel_phase_distribution_0/v3_four_channel_output_collection_0/v3_four_channel_placement_0/v3_channel_selector_late_promotion_2/v3_channel_input_bias_late_promotion_0/a_7462_7422# v3_four_channel_output_load_integration_0/v3_four_channel_shared_support_integration_0/v3_four_channel_bias_reference_distribution_0/v3_four_channel_phase_distribution_0/v3_four_channel_output_collection_0/v3_four_channel_placement_0/v3_channel_selector_late_promotion_2/v3_selector_route_pilot_0/group3_lo_p v3_four_channel_output_load_integration_0/combined_p VGND sky130_fd_pr__nfet_01v8 ad=0.6206 pd=6.02 as=0 ps=0 w=0.65 l=0.15
X2021 VGND v3_four_channel_output_load_integration_0/v3_four_channel_shared_support_integration_0/v3_tail_bias_support_block_0/vbias v3_four_channel_output_load_integration_0/v3_four_channel_shared_support_integration_0/v3_four_channel_bias_reference_distribution_0/v3_four_channel_phase_distribution_0/v3_four_channel_output_collection_0/v3_four_channel_placement_0/v3_channel_selector_late_promotion_2/v3_channel_input_bias_late_promotion_0/a_7166_21688# VGND sky130_fd_pr__nfet_01v8 ad=0 pd=0 as=0 ps=0 w=5.07 l=1
X2022 v3_four_channel_output_load_integration_0/v3_four_channel_shared_support_integration_0/v3_four_channel_bias_reference_distribution_0/v3_four_channel_phase_distribution_0/v3_four_channel_output_collection_0/v3_four_channel_placement_0/v3_channel_selector_late_promotion_2/v3_channel_input_bias_late_promotion_0/a_6070_15422# v3_four_channel_output_load_integration_0/v3_four_channel_shared_support_integration_0/v3_vcm_support_block_0/ref v3_four_channel_output_load_integration_0/v3_four_channel_shared_support_integration_0/v3_four_channel_bias_reference_distribution_0/v3_four_channel_phase_distribution_0/v3_four_channel_output_collection_0/v3_four_channel_placement_0/v3_channel_selector_late_promotion_2/v3_channel_input_bias_late_promotion_0/a_5774_13688# VGND sky130_fd_pr__nfet_01v8 ad=0 pd=0 as=0 ps=0 w=0.84 l=0.6
X2023 v3_four_channel_output_load_integration_0/combined_p v3_four_channel_output_load_integration_0/v3_four_channel_shared_support_integration_0/v3_four_channel_bias_reference_distribution_0/v3_four_channel_phase_distribution_0/v3_four_channel_output_collection_0/v3_four_channel_placement_0/v3_channel_selector_late_promotion_2/v3_selector_route_pilot_0/group2_lo_n v3_four_channel_output_load_integration_0/v3_four_channel_shared_support_integration_0/v3_four_channel_bias_reference_distribution_0/v3_four_channel_phase_distribution_0/v3_four_channel_output_collection_0/v3_four_channel_placement_0/v3_channel_selector_late_promotion_2/v3_channel_input_bias_late_promotion_0/a_4254_10978# VGND sky130_fd_pr__nfet_01v8 ad=0 pd=0 as=0.6206 ps=6.02 w=0.65 l=0.15
X2024 v3_four_channel_output_load_integration_0/v3_four_channel_shared_support_integration_0/v3_four_channel_bias_reference_distribution_0/v3_four_channel_phase_distribution_0/v3_four_channel_output_collection_0/v3_four_channel_placement_0/v3_channel_selector_late_promotion_2/v3_channel_input_bias_late_promotion_0/a_6070_15422# v3_four_channel_output_load_integration_0/v3_four_channel_shared_support_integration_0/v3_four_channel_bias_reference_distribution_0/v3_four_channel_phase_distribution_0/v3_four_channel_output_collection_0/v3_four_channel_placement_0/v3_channel_selector_late_promotion_2/v3_selector_route_pilot_0/group0_lo_p v3_four_channel_output_load_integration_0/combined_n VGND sky130_fd_pr__nfet_01v8 ad=0 pd=0 as=0 ps=0 w=0.65 l=0.15
X2025 v3_four_channel_output_load_integration_0/v3_four_channel_shared_support_integration_0/v3_four_channel_bias_reference_distribution_0/v3_four_channel_phase_distribution_0/v3_four_channel_output_collection_0/v3_four_channel_placement_0/v3_channel_selector_late_promotion_2/v3_channel_input_bias_late_promotion_0/a_5824_6978# v3_four_channel_output_load_integration_0/v3_four_channel_shared_support_integration_0/v3_vcm_support_block_0/ref v3_four_channel_output_load_integration_0/v3_four_channel_shared_support_integration_0/v3_four_channel_bias_reference_distribution_0/v3_four_channel_phase_distribution_0/v3_four_channel_output_collection_0/v3_four_channel_placement_0/v3_channel_selector_late_promotion_2/v3_channel_input_bias_late_promotion_0/a_5646_6978# VGND sky130_fd_pr__nfet_01v8 ad=0 pd=0 as=0.6206 ps=6.02 w=0.84 l=0.6
X2026 v3_four_channel_output_load_integration_0/v3_four_channel_shared_support_integration_0/v3_four_channel_bias_reference_distribution_0/v3_four_channel_phase_distribution_0/v3_four_channel_output_collection_0/v3_four_channel_placement_0/v3_channel_selector_late_promotion_2/v3_channel_input_bias_late_promotion_0/a_5774_17688# V3I001 v3_four_channel_output_load_integration_0/v3_four_channel_shared_support_integration_0/v3_four_channel_bias_reference_distribution_0/v3_four_channel_phase_distribution_0/v3_four_channel_output_collection_0/v3_four_channel_placement_0/v3_channel_selector_late_promotion_2/v3_channel_input_bias_late_promotion_0/a_5646_18978# VGND sky130_fd_pr__nfet_01v8 ad=0 pd=0 as=0 ps=0 w=0.84 l=0.6
X2027 v3_four_channel_output_load_integration_0/combined_p v3_four_channel_output_load_integration_0/v3_four_channel_shared_support_integration_0/v3_four_channel_bias_reference_distribution_0/v3_four_channel_phase_distribution_0/v3_four_channel_output_collection_0/v3_four_channel_placement_0/v3_channel_selector_late_promotion_2/v3_selector_route_pilot_0/group3_lo_p v3_four_channel_output_load_integration_0/v3_four_channel_shared_support_integration_0/v3_four_channel_bias_reference_distribution_0/v3_four_channel_phase_distribution_0/v3_four_channel_output_collection_0/v3_four_channel_placement_0/v3_channel_selector_late_promotion_2/v3_channel_input_bias_late_promotion_0/a_5646_22978# VGND sky130_fd_pr__nfet_01v8 ad=0 pd=0 as=0 ps=0 w=0.65 l=0.15
X2028 v3_four_channel_output_load_integration_0/v3_four_channel_shared_support_integration_0/v3_four_channel_bias_reference_distribution_0/v3_four_channel_phase_distribution_0/v3_four_channel_output_collection_0/v3_four_channel_placement_0/v3_channel_selector_late_promotion_2/v3_channel_input_bias_late_promotion_0/a_5824_6978# v3_four_channel_output_load_integration_0/v3_four_channel_shared_support_integration_0/v3_tail_bias_support_block_0/vbias VGND VGND sky130_fd_pr__nfet_01v8 ad=0 pd=0 as=0 ps=0 w=5.07 l=1
X2029 v3_four_channel_output_load_integration_0/v3_four_channel_shared_support_integration_0/v3_four_channel_bias_reference_distribution_0/v3_four_channel_phase_distribution_0/v3_four_channel_output_collection_0/v3_four_channel_placement_0/v3_channel_selector_late_promotion_2/v3_channel_input_bias_late_promotion_0/a_4432_10978# v3_four_channel_output_load_integration_0/v3_four_channel_shared_support_integration_0/v3_vcm_support_block_0/ref v3_four_channel_output_load_integration_0/v3_four_channel_shared_support_integration_0/v3_four_channel_bias_reference_distribution_0/v3_four_channel_phase_distribution_0/v3_four_channel_output_collection_0/v3_four_channel_placement_0/v3_channel_selector_late_promotion_2/v3_channel_input_bias_late_promotion_0/a_4254_10978# VGND sky130_fd_pr__nfet_01v8 ad=1.9575 pd=15.24 as=0 ps=0 w=0.84 l=0.6
X2030 v3_four_channel_output_load_integration_0/v3_four_channel_shared_support_integration_0/v3_four_channel_bias_reference_distribution_0/v3_four_channel_phase_distribution_0/v3_four_channel_output_collection_0/v3_four_channel_placement_0/v3_channel_selector_late_promotion_2/v3_channel_input_bias_late_promotion_0/a_4678_11422# v3_four_channel_output_load_integration_0/v3_four_channel_shared_support_integration_0/v3_four_channel_bias_reference_distribution_0/v3_four_channel_phase_distribution_0/v3_four_channel_output_collection_0/v3_four_channel_placement_0/v3_channel_selector_late_promotion_2/v3_selector_route_pilot_0/group2_lo_p v3_four_channel_output_load_integration_0/combined_p VGND sky130_fd_pr__nfet_01v8 ad=0.6206 pd=6.02 as=0 ps=0 w=0.65 l=0.15
X2031 v3_four_channel_output_load_integration_0/v3_four_channel_shared_support_integration_0/v3_four_channel_bias_reference_distribution_0/v3_four_channel_phase_distribution_0/v3_four_channel_output_collection_0/v3_four_channel_placement_0/v3_channel_selector_late_promotion_2/v3_channel_input_bias_late_promotion_0/a_6070_23422# v3_four_channel_output_load_integration_0/v3_four_channel_shared_support_integration_0/v3_four_channel_bias_reference_distribution_0/v3_four_channel_phase_distribution_0/v3_four_channel_output_collection_0/v3_four_channel_placement_0/v3_channel_selector_late_promotion_2/v3_selector_route_pilot_0/group3_lo_n v3_four_channel_output_load_integration_0/combined_p VGND sky130_fd_pr__nfet_01v8 ad=0.6206 pd=6.02 as=0 ps=0 w=0.65 l=0.15
X2032 v3_four_channel_output_load_integration_0/combined_n v3_four_channel_output_load_integration_0/v3_four_channel_shared_support_integration_0/v3_four_channel_bias_reference_distribution_0/v3_four_channel_phase_distribution_0/v3_four_channel_output_collection_0/v3_four_channel_placement_0/v3_channel_selector_late_promotion_2/v3_selector_route_pilot_0/group1_lo_n v3_four_channel_output_load_integration_0/v3_four_channel_shared_support_integration_0/v3_four_channel_bias_reference_distribution_0/v3_four_channel_phase_distribution_0/v3_four_channel_output_collection_0/v3_four_channel_placement_0/v3_channel_selector_late_promotion_2/v3_channel_input_bias_late_promotion_0/a_4254_14978# VGND sky130_fd_pr__nfet_01v8 ad=0 pd=0 as=0 ps=0 w=0.65 l=0.15
X2033 v3_four_channel_output_load_integration_0/combined_p v3_four_channel_output_load_integration_0/v3_four_channel_shared_support_integration_0/v3_four_channel_bias_reference_distribution_0/v3_four_channel_phase_distribution_0/v3_four_channel_output_collection_0/v3_four_channel_placement_0/v3_channel_selector_late_promotion_2/v3_selector_route_pilot_0/group2_lo_n v3_four_channel_output_load_integration_0/v3_four_channel_shared_support_integration_0/v3_four_channel_bias_reference_distribution_0/v3_four_channel_phase_distribution_0/v3_four_channel_output_collection_0/v3_four_channel_placement_0/v3_channel_selector_late_promotion_2/v3_channel_input_bias_late_promotion_0/a_7038_10978# VGND sky130_fd_pr__nfet_01v8 ad=0 pd=0 as=0.6206 ps=6.02 w=0.65 l=0.15
X2034 v3_four_channel_output_load_integration_0/v3_four_channel_shared_support_integration_0/v3_four_channel_bias_reference_distribution_0/v3_four_channel_phase_distribution_0/v3_four_channel_output_collection_0/v3_four_channel_placement_0/v3_channel_selector_late_promotion_2/v3_channel_input_bias_late_promotion_0/a_7462_15422# v3_four_channel_output_load_integration_0/v3_four_channel_shared_support_integration_0/v3_four_channel_bias_reference_distribution_0/v3_four_channel_phase_distribution_0/v3_four_channel_output_collection_0/v3_four_channel_placement_0/v3_channel_selector_late_promotion_2/v3_selector_route_pilot_0/group1_lo_p v3_four_channel_output_load_integration_0/combined_p VGND sky130_fd_pr__nfet_01v8 ad=0.6206 pd=6.02 as=0 ps=0 w=0.65 l=0.15
X2035 VGND VGND VGND VGND sky130_fd_pr__nfet_01v8 ad=0 pd=0 as=0 ps=0 w=5.07 l=1
X2036 v3_four_channel_output_load_integration_0/v3_four_channel_shared_support_integration_0/v3_four_channel_bias_reference_distribution_0/v3_four_channel_phase_distribution_0/v3_four_channel_output_collection_0/v3_four_channel_placement_0/v3_channel_selector_late_promotion_2/v3_channel_input_bias_late_promotion_0/a_7216_6978# v3_four_channel_output_load_integration_0/v3_four_channel_shared_support_integration_0/v3_tail_bias_support_block_0/vbias VGND VGND sky130_fd_pr__nfet_01v8 ad=1.9575 pd=15.24 as=0 ps=0 w=5.07 l=1
X2037 v3_four_channel_output_load_integration_0/v3_four_channel_shared_support_integration_0/v3_four_channel_bias_reference_distribution_0/v3_four_channel_phase_distribution_0/v3_four_channel_output_collection_0/v3_four_channel_placement_0/v3_channel_selector_late_promotion_2/v3_channel_input_bias_late_promotion_0/a_7216_10978# v3_four_channel_output_load_integration_0/v3_four_channel_shared_support_integration_0/v3_vcm_support_block_0/ref v3_four_channel_output_load_integration_0/v3_four_channel_shared_support_integration_0/v3_four_channel_bias_reference_distribution_0/v3_four_channel_phase_distribution_0/v3_four_channel_output_collection_0/v3_four_channel_placement_0/v3_channel_selector_late_promotion_2/v3_channel_input_bias_late_promotion_0/a_7038_10978# VGND sky130_fd_pr__nfet_01v8 ad=0 pd=0 as=0 ps=0 w=0.84 l=0.6
X2038 v3_four_channel_output_load_integration_0/v3_four_channel_shared_support_integration_0/v3_four_channel_bias_reference_distribution_0/v3_four_channel_phase_distribution_0/v3_four_channel_output_collection_0/v3_four_channel_placement_0/v3_channel_selector_late_promotion_2/v3_channel_input_bias_late_promotion_0/a_4678_15422# v3_four_channel_output_load_integration_0/v3_four_channel_shared_support_integration_0/v3_vcm_support_block_0/ref v3_four_channel_output_load_integration_0/v3_four_channel_shared_support_integration_0/v3_four_channel_bias_reference_distribution_0/v3_four_channel_phase_distribution_0/v3_four_channel_output_collection_0/v3_four_channel_placement_0/v3_channel_selector_late_promotion_2/v3_channel_input_bias_late_promotion_0/a_4382_13688# VGND sky130_fd_pr__nfet_01v8 ad=0 pd=0 as=0 ps=0 w=0.84 l=0.6
X2039 v3_four_channel_output_load_integration_0/v3_four_channel_shared_support_integration_0/v3_four_channel_bias_reference_distribution_0/v3_four_channel_phase_distribution_0/v3_four_channel_output_collection_0/v3_four_channel_placement_0/v3_channel_selector_late_promotion_2/v3_channel_input_bias_late_promotion_0/a_4678_15422# v3_four_channel_output_load_integration_0/v3_four_channel_shared_support_integration_0/v3_four_channel_bias_reference_distribution_0/v3_four_channel_phase_distribution_0/v3_four_channel_output_collection_0/v3_four_channel_placement_0/v3_channel_selector_late_promotion_2/v3_selector_route_pilot_0/group1_lo_p v3_four_channel_output_load_integration_0/combined_n VGND sky130_fd_pr__nfet_01v8 ad=0 pd=0 as=0 ps=0 w=0.65 l=0.15
X2040 v3_four_channel_output_load_integration_0/combined_p v3_four_channel_output_load_integration_0/v3_four_channel_shared_support_integration_0/v3_four_channel_bias_reference_distribution_0/v3_four_channel_phase_distribution_0/v3_four_channel_output_collection_0/v3_four_channel_placement_0/v3_channel_selector_late_promotion_2/v3_selector_route_pilot_0/group3_lo_p v3_four_channel_output_load_integration_0/v3_four_channel_shared_support_integration_0/v3_four_channel_bias_reference_distribution_0/v3_four_channel_phase_distribution_0/v3_four_channel_output_collection_0/v3_four_channel_placement_0/v3_channel_selector_late_promotion_2/v3_channel_input_bias_late_promotion_0/a_4254_22978# VGND sky130_fd_pr__nfet_01v8 ad=0 pd=0 as=0.6206 ps=6.02 w=0.65 l=0.15
X2041 v3_four_channel_output_load_integration_0/v3_four_channel_shared_support_integration_0/v3_four_channel_bias_reference_distribution_0/v3_four_channel_phase_distribution_0/v3_four_channel_output_collection_0/v3_four_channel_placement_0/v3_channel_selector_late_promotion_2/v3_channel_input_bias_late_promotion_0/a_7462_19422# v3_four_channel_output_load_integration_0/v3_four_channel_shared_support_integration_0/v3_vcm_support_block_0/ref v3_four_channel_output_load_integration_0/v3_four_channel_shared_support_integration_0/v3_four_channel_bias_reference_distribution_0/v3_four_channel_phase_distribution_0/v3_four_channel_output_collection_0/v3_four_channel_placement_0/v3_channel_selector_late_promotion_2/v3_channel_input_bias_late_promotion_0/a_7166_17688# VGND sky130_fd_pr__nfet_01v8 ad=0 pd=0 as=0 ps=0 w=0.84 l=0.6
X2042 v3_four_channel_output_load_integration_0/combined_n v3_four_channel_output_load_integration_0/v3_four_channel_shared_support_integration_0/v3_four_channel_bias_reference_distribution_0/v3_four_channel_phase_distribution_0/v3_four_channel_output_collection_0/v3_four_channel_placement_0/v3_channel_selector_late_promotion_2/v3_selector_route_pilot_0/group3_lo_p v3_four_channel_output_load_integration_0/v3_four_channel_shared_support_integration_0/v3_four_channel_bias_reference_distribution_0/v3_four_channel_phase_distribution_0/v3_four_channel_output_collection_0/v3_four_channel_placement_0/v3_channel_selector_late_promotion_2/v3_channel_input_bias_late_promotion_0/a_5646_10978# VGND sky130_fd_pr__nfet_01v8 ad=0 pd=0 as=0 ps=0 w=0.65 l=0.15
X2043 v3_four_channel_output_load_integration_0/combined_n v3_four_channel_output_load_integration_0/v3_four_channel_shared_support_integration_0/v3_four_channel_bias_reference_distribution_0/v3_four_channel_phase_distribution_0/v3_four_channel_output_collection_0/v3_four_channel_placement_0/v3_channel_selector_late_promotion_2/v3_selector_route_pilot_0/group1_lo_p v3_four_channel_output_load_integration_0/v3_four_channel_shared_support_integration_0/v3_four_channel_bias_reference_distribution_0/v3_four_channel_phase_distribution_0/v3_four_channel_output_collection_0/v3_four_channel_placement_0/v3_channel_selector_late_promotion_2/v3_channel_input_bias_late_promotion_0/a_7038_14978# VGND sky130_fd_pr__nfet_01v8 ad=0 pd=0 as=0 ps=0 w=0.65 l=0.15
X2044 v3_four_channel_output_load_integration_0/v3_four_channel_shared_support_integration_0/v3_four_channel_bias_reference_distribution_0/v3_four_channel_phase_distribution_0/v3_four_channel_output_collection_0/v3_four_channel_placement_0/v3_channel_selector_late_promotion_2/v3_channel_input_bias_late_promotion_0/a_7462_19422# v3_four_channel_output_load_integration_0/v3_four_channel_shared_support_integration_0/v3_four_channel_bias_reference_distribution_0/v3_four_channel_phase_distribution_0/v3_four_channel_output_collection_0/v3_four_channel_placement_0/v3_channel_selector_late_promotion_2/v3_selector_route_pilot_0/group2_lo_p v3_four_channel_output_load_integration_0/combined_n VGND sky130_fd_pr__nfet_01v8 ad=0 pd=0 as=0 ps=0 w=0.65 l=0.15
X2045 v3_four_channel_output_load_integration_0/v3_four_channel_shared_support_integration_0/v3_four_channel_bias_reference_distribution_0/v3_four_channel_phase_distribution_0/v3_four_channel_output_collection_0/v3_four_channel_placement_0/v3_channel_selector_late_promotion_2/v3_channel_input_bias_late_promotion_0/a_4678_7422# V3I001 v3_four_channel_output_load_integration_0/v3_four_channel_shared_support_integration_0/v3_four_channel_bias_reference_distribution_0/v3_four_channel_phase_distribution_0/v3_four_channel_output_collection_0/v3_four_channel_placement_0/v3_channel_selector_late_promotion_2/v3_channel_input_bias_late_promotion_0/a_4432_6978# VGND sky130_fd_pr__nfet_01v8 ad=0 pd=0 as=1.9575 ps=15.24 w=0.84 l=0.6
X2046 v3_four_channel_output_load_integration_0/combined_p v3_four_channel_output_load_integration_0/v3_four_channel_shared_support_integration_0/v3_four_channel_bias_reference_distribution_0/v3_four_channel_phase_distribution_0/v3_four_channel_output_collection_0/v3_four_channel_placement_0/v3_channel_selector_late_promotion_2/v3_selector_route_pilot_0/group3_lo_n v3_four_channel_output_load_integration_0/v3_four_channel_shared_support_integration_0/v3_four_channel_bias_reference_distribution_0/v3_four_channel_phase_distribution_0/v3_four_channel_output_collection_0/v3_four_channel_placement_0/v3_channel_selector_late_promotion_2/v3_channel_input_bias_late_promotion_0/a_5646_6978# VGND sky130_fd_pr__nfet_01v8 ad=0 pd=0 as=0 ps=0 w=0.65 l=0.15
X2047 v3_four_channel_output_load_integration_0/v3_four_channel_shared_support_integration_0/v3_four_channel_bias_reference_distribution_0/v3_four_channel_phase_distribution_0/v3_four_channel_output_collection_0/v3_four_channel_placement_0/v3_channel_selector_late_promotion_2/v3_channel_input_bias_late_promotion_0/a_4678_7422# v3_four_channel_output_load_integration_0/v3_four_channel_shared_support_integration_0/v3_four_channel_bias_reference_distribution_0/v3_four_channel_phase_distribution_0/v3_four_channel_output_collection_0/v3_four_channel_placement_0/v3_channel_selector_late_promotion_2/v3_selector_route_pilot_0/group3_lo_n v3_four_channel_output_load_integration_0/combined_n VGND sky130_fd_pr__nfet_01v8 ad=0 pd=0 as=0 ps=0 w=0.65 l=0.15
X2048 v3_four_channel_output_load_integration_0/v3_four_channel_shared_support_integration_0/v3_four_channel_bias_reference_distribution_0/v3_four_channel_phase_distribution_0/v3_four_channel_output_collection_0/v3_four_channel_placement_0/v3_channel_selector_late_promotion_2/v3_channel_input_bias_late_promotion_0/a_6070_11422# V3I001 v3_four_channel_output_load_integration_0/v3_four_channel_shared_support_integration_0/v3_four_channel_bias_reference_distribution_0/v3_four_channel_phase_distribution_0/v3_four_channel_output_collection_0/v3_four_channel_placement_0/v3_channel_selector_late_promotion_2/v3_channel_input_bias_late_promotion_0/a_5824_10978# VGND sky130_fd_pr__nfet_01v8 ad=0 pd=0 as=0 ps=0 w=0.84 l=0.6
X2049 v3_four_channel_output_load_integration_0/v3_four_channel_shared_support_integration_0/v3_four_channel_bias_reference_distribution_0/v3_four_channel_phase_distribution_0/v3_four_channel_output_collection_0/v3_four_channel_placement_0/v3_channel_selector_late_promotion_2/v3_channel_input_bias_late_promotion_0/a_6070_11422# v3_four_channel_output_load_integration_0/v3_four_channel_shared_support_integration_0/v3_four_channel_bias_reference_distribution_0/v3_four_channel_phase_distribution_0/v3_four_channel_output_collection_0/v3_four_channel_placement_0/v3_channel_selector_late_promotion_2/v3_selector_route_pilot_0/group3_lo_n v3_four_channel_output_load_integration_0/combined_n VGND sky130_fd_pr__nfet_01v8 ad=0 pd=0 as=0 ps=0 w=0.65 l=0.15
X2050 v3_four_channel_output_load_integration_0/v3_four_channel_shared_support_integration_0/v3_four_channel_bias_reference_distribution_0/v3_four_channel_phase_distribution_0/v3_four_channel_output_collection_0/v3_four_channel_placement_0/v3_channel_selector_late_promotion_2/v3_channel_input_bias_late_promotion_0/a_4382_21688# V3I001 v3_four_channel_output_load_integration_0/v3_four_channel_shared_support_integration_0/v3_four_channel_bias_reference_distribution_0/v3_four_channel_phase_distribution_0/v3_four_channel_output_collection_0/v3_four_channel_placement_0/v3_channel_selector_late_promotion_2/v3_channel_input_bias_late_promotion_0/a_4254_22978# VGND sky130_fd_pr__nfet_01v8 ad=0 pd=0 as=0 ps=0 w=0.84 l=0.6
X2051 v3_four_channel_output_load_integration_0/v3_four_channel_shared_support_integration_0/v3_four_channel_bias_reference_distribution_0/v3_four_channel_phase_distribution_0/v3_four_channel_output_collection_0/v3_four_channel_placement_0/v3_channel_selector_late_promotion_2/v3_channel_input_bias_late_promotion_0/a_4678_23422# v3_four_channel_output_load_integration_0/v3_four_channel_shared_support_integration_0/v3_four_channel_bias_reference_distribution_0/v3_four_channel_phase_distribution_0/v3_four_channel_output_collection_0/v3_four_channel_placement_0/v3_channel_selector_late_promotion_2/v3_selector_route_pilot_0/group3_lo_n v3_four_channel_output_load_integration_0/combined_p VGND sky130_fd_pr__nfet_01v8 ad=0 pd=0 as=0 ps=0 w=0.65 l=0.15
X2052 v3_four_channel_output_load_integration_0/combined_p v3_four_channel_output_load_integration_0/v3_four_channel_shared_support_integration_0/v3_four_channel_bias_reference_distribution_0/v3_four_channel_phase_distribution_0/v3_four_channel_output_collection_0/v3_four_channel_placement_0/v3_channel_selector_late_promotion_2/v3_selector_route_pilot_0/group3_lo_n v3_four_channel_output_load_integration_0/v3_four_channel_shared_support_integration_0/v3_four_channel_bias_reference_distribution_0/v3_four_channel_phase_distribution_0/v3_four_channel_output_collection_0/v3_four_channel_placement_0/v3_channel_selector_late_promotion_2/v3_channel_input_bias_late_promotion_0/a_4254_6978# VGND sky130_fd_pr__nfet_01v8 ad=0 pd=0 as=0 ps=0 w=0.65 l=0.15
X2053 v3_four_channel_output_load_integration_0/v3_four_channel_shared_support_integration_0/v3_four_channel_bias_reference_distribution_0/v3_four_channel_phase_distribution_0/v3_four_channel_output_collection_0/v3_four_channel_placement_0/v3_channel_selector_late_promotion_2/v3_channel_input_bias_late_promotion_0/a_5774_13688# V3I001 v3_four_channel_output_load_integration_0/v3_four_channel_shared_support_integration_0/v3_four_channel_bias_reference_distribution_0/v3_four_channel_phase_distribution_0/v3_four_channel_output_collection_0/v3_four_channel_placement_0/v3_channel_selector_late_promotion_2/v3_channel_input_bias_late_promotion_0/a_5646_14978# VGND sky130_fd_pr__nfet_01v8 ad=0 pd=0 as=0 ps=0 w=0.84 l=0.6
X2054 v3_four_channel_output_load_integration_0/combined_p v3_four_channel_output_load_integration_0/v3_four_channel_shared_support_integration_0/v3_four_channel_bias_reference_distribution_0/v3_four_channel_phase_distribution_0/v3_four_channel_output_collection_0/v3_four_channel_placement_0/v3_channel_selector_late_promotion_2/v3_selector_route_pilot_0/group3_lo_p v3_four_channel_output_load_integration_0/v3_four_channel_shared_support_integration_0/v3_four_channel_bias_reference_distribution_0/v3_four_channel_phase_distribution_0/v3_four_channel_output_collection_0/v3_four_channel_placement_0/v3_channel_selector_late_promotion_2/v3_channel_input_bias_late_promotion_0/a_7038_22978# VGND sky130_fd_pr__nfet_01v8 ad=0 pd=0 as=0 ps=0 w=0.65 l=0.15
X2055 v3_four_channel_output_load_integration_0/v3_four_channel_shared_support_integration_0/v3_four_channel_bias_reference_distribution_0/v3_four_channel_phase_distribution_0/v3_four_channel_output_collection_0/v3_four_channel_placement_0/v3_channel_selector_late_promotion_2/v3_channel_input_bias_late_promotion_0/a_7462_7422# V3I001 v3_four_channel_output_load_integration_0/v3_four_channel_shared_support_integration_0/v3_four_channel_bias_reference_distribution_0/v3_four_channel_phase_distribution_0/v3_four_channel_output_collection_0/v3_four_channel_placement_0/v3_channel_selector_late_promotion_2/v3_channel_input_bias_late_promotion_0/a_7216_6978# VGND sky130_fd_pr__nfet_01v8 ad=0 pd=0 as=0 ps=0 w=0.84 l=0.6
X2056 v3_four_channel_output_load_integration_0/v3_four_channel_shared_support_integration_0/v3_four_channel_bias_reference_distribution_0/v3_four_channel_phase_distribution_0/v3_four_channel_output_collection_0/v3_four_channel_placement_0/v3_channel_selector_late_promotion_2/v3_channel_input_bias_late_promotion_0/a_4432_10978# v3_four_channel_output_load_integration_0/v3_four_channel_shared_support_integration_0/v3_tail_bias_support_block_0/vbias VGND VGND sky130_fd_pr__nfet_01v8 ad=0 pd=0 as=0 ps=0 w=5.07 l=1
X2057 v3_four_channel_output_load_integration_0/v3_four_channel_shared_support_integration_0/v3_four_channel_bias_reference_distribution_0/v3_four_channel_phase_distribution_0/v3_four_channel_output_collection_0/v3_four_channel_placement_0/v3_channel_selector_late_promotion_2/v3_channel_input_bias_late_promotion_0/a_7462_7422# v3_four_channel_output_load_integration_0/v3_four_channel_shared_support_integration_0/v3_four_channel_bias_reference_distribution_0/v3_four_channel_phase_distribution_0/v3_four_channel_output_collection_0/v3_four_channel_placement_0/v3_channel_selector_late_promotion_2/v3_selector_route_pilot_0/group3_lo_n v3_four_channel_output_load_integration_0/combined_n VGND sky130_fd_pr__nfet_01v8 ad=0 pd=0 as=0 ps=0 w=0.65 l=0.15
X2058 VGND v3_four_channel_output_load_integration_0/v3_four_channel_shared_support_integration_0/v3_tail_bias_support_block_0/vbias v3_four_channel_output_load_integration_0/v3_four_channel_shared_support_integration_0/v3_four_channel_bias_reference_distribution_0/v3_four_channel_phase_distribution_0/v3_four_channel_output_collection_0/v3_four_channel_placement_0/v3_channel_selector_late_promotion_2/v3_channel_input_bias_late_promotion_0/a_4382_17688# VGND sky130_fd_pr__nfet_01v8 ad=0 pd=0 as=0 ps=0 w=5.07 l=1
X2059 v3_four_channel_output_load_integration_0/combined_p v3_four_channel_output_load_integration_0/v3_four_channel_shared_support_integration_0/v3_four_channel_bias_reference_distribution_0/v3_four_channel_phase_distribution_0/v3_four_channel_output_collection_0/v3_four_channel_placement_0/v3_channel_selector_late_promotion_2/v3_selector_route_pilot_0/group3_lo_n v3_four_channel_output_load_integration_0/v3_four_channel_shared_support_integration_0/v3_four_channel_bias_reference_distribution_0/v3_four_channel_phase_distribution_0/v3_four_channel_output_collection_0/v3_four_channel_placement_0/v3_channel_selector_late_promotion_2/v3_channel_input_bias_late_promotion_0/a_7038_6978# VGND sky130_fd_pr__nfet_01v8 ad=0 pd=0 as=0 ps=0 w=0.65 l=0.15
X2060 v3_four_channel_output_load_integration_0/combined_n v3_four_channel_output_load_integration_0/v3_four_channel_shared_support_integration_0/v3_four_channel_bias_reference_distribution_0/v3_four_channel_phase_distribution_0/v3_four_channel_output_collection_0/v3_four_channel_placement_0/v3_channel_selector_late_promotion_2/v3_selector_route_pilot_0/group2_lo_p v3_four_channel_output_load_integration_0/v3_four_channel_shared_support_integration_0/v3_four_channel_bias_reference_distribution_0/v3_four_channel_phase_distribution_0/v3_four_channel_output_collection_0/v3_four_channel_placement_0/v3_channel_selector_late_promotion_2/v3_channel_input_bias_late_promotion_0/a_4254_10978# VGND sky130_fd_pr__nfet_01v8 ad=0 pd=0 as=0 ps=0 w=0.65 l=0.15
X2061 v3_four_channel_output_load_integration_0/v3_four_channel_shared_support_integration_0/v3_four_channel_bias_reference_distribution_0/v3_four_channel_phase_distribution_0/v3_four_channel_output_collection_0/v3_four_channel_placement_0/v3_channel_selector_late_promotion_2/v3_channel_input_bias_late_promotion_0/a_7462_11422# v3_four_channel_output_load_integration_0/v3_four_channel_shared_support_integration_0/v3_four_channel_bias_reference_distribution_0/v3_four_channel_phase_distribution_0/v3_four_channel_output_collection_0/v3_four_channel_placement_0/v3_channel_selector_late_promotion_2/v3_selector_route_pilot_0/group2_lo_p v3_four_channel_output_load_integration_0/combined_p VGND sky130_fd_pr__nfet_01v8 ad=0 pd=0 as=0 ps=0 w=0.65 l=0.15
X2062 v3_four_channel_output_load_integration_0/v3_four_channel_shared_support_integration_0/v3_four_channel_bias_reference_distribution_0/v3_four_channel_phase_distribution_0/v3_four_channel_output_collection_0/v3_four_channel_placement_0/v3_channel_selector_late_promotion_2/v3_channel_input_bias_late_promotion_0/a_7166_21688# V3I001 v3_four_channel_output_load_integration_0/v3_four_channel_shared_support_integration_0/v3_four_channel_bias_reference_distribution_0/v3_four_channel_phase_distribution_0/v3_four_channel_output_collection_0/v3_four_channel_placement_0/v3_channel_selector_late_promotion_2/v3_channel_input_bias_late_promotion_0/a_7038_22978# VGND sky130_fd_pr__nfet_01v8 ad=0 pd=0 as=0 ps=0 w=0.84 l=0.6
X2063 v3_four_channel_output_load_integration_0/combined_n v3_four_channel_output_load_integration_0/v3_four_channel_shared_support_integration_0/v3_four_channel_bias_reference_distribution_0/v3_four_channel_phase_distribution_0/v3_four_channel_output_collection_0/v3_four_channel_placement_0/v3_channel_selector_late_promotion_2/v3_selector_route_pilot_0/group3_lo_n v3_four_channel_output_load_integration_0/v3_four_channel_shared_support_integration_0/v3_four_channel_bias_reference_distribution_0/v3_four_channel_phase_distribution_0/v3_four_channel_output_collection_0/v3_four_channel_placement_0/v3_channel_selector_late_promotion_2/v3_channel_input_bias_late_promotion_0/a_5646_22978# VGND sky130_fd_pr__nfet_01v8 ad=0 pd=0 as=0 ps=0 w=0.65 l=0.15
X2064 v3_four_channel_output_load_integration_0/v3_four_channel_shared_support_integration_0/v3_four_channel_bias_reference_distribution_0/v3_four_channel_phase_distribution_0/v3_four_channel_output_collection_0/v3_four_channel_placement_0/v3_channel_selector_late_promotion_2/v3_channel_input_bias_late_promotion_0/a_4678_11422# V3I001 v3_four_channel_output_load_integration_0/v3_four_channel_shared_support_integration_0/v3_four_channel_bias_reference_distribution_0/v3_four_channel_phase_distribution_0/v3_four_channel_output_collection_0/v3_four_channel_placement_0/v3_channel_selector_late_promotion_2/v3_channel_input_bias_late_promotion_0/a_4432_10978# VGND sky130_fd_pr__nfet_01v8 ad=0 pd=0 as=0 ps=0 w=0.84 l=0.6
X2065 v3_four_channel_output_load_integration_0/v3_four_channel_shared_support_integration_0/v3_four_channel_bias_reference_distribution_0/v3_four_channel_phase_distribution_0/v3_four_channel_output_collection_0/v3_four_channel_placement_0/v3_channel_selector_late_promotion_2/v3_channel_input_bias_late_promotion_0/a_6070_23422# v3_four_channel_output_load_integration_0/v3_four_channel_shared_support_integration_0/v3_vcm_support_block_0/ref v3_four_channel_output_load_integration_0/v3_four_channel_shared_support_integration_0/v3_four_channel_bias_reference_distribution_0/v3_four_channel_phase_distribution_0/v3_four_channel_output_collection_0/v3_four_channel_placement_0/v3_channel_selector_late_promotion_2/v3_channel_input_bias_late_promotion_0/a_5774_21688# VGND sky130_fd_pr__nfet_01v8 ad=0 pd=0 as=0 ps=0 w=0.84 l=0.6
X2066 v3_four_channel_output_load_integration_0/v3_four_channel_shared_support_integration_0/v3_four_channel_bias_reference_distribution_0/v3_four_channel_phase_distribution_0/v3_four_channel_output_collection_0/v3_four_channel_placement_0/v3_channel_selector_late_promotion_2/v3_channel_input_bias_late_promotion_0/a_6070_23422# v3_four_channel_output_load_integration_0/v3_four_channel_shared_support_integration_0/v3_four_channel_bias_reference_distribution_0/v3_four_channel_phase_distribution_0/v3_four_channel_output_collection_0/v3_four_channel_placement_0/v3_channel_selector_late_promotion_2/v3_selector_route_pilot_0/group3_lo_p v3_four_channel_output_load_integration_0/combined_n VGND sky130_fd_pr__nfet_01v8 ad=0 pd=0 as=0 ps=0 w=0.65 l=0.15
X2067 v3_four_channel_output_load_integration_0/v3_four_channel_shared_support_integration_0/v3_four_channel_bias_reference_distribution_0/v3_four_channel_phase_distribution_0/v3_four_channel_output_collection_0/v3_four_channel_placement_0/v3_channel_selector_late_promotion_2/v3_channel_input_bias_late_promotion_0/a_4678_11422# v3_four_channel_output_load_integration_0/v3_four_channel_shared_support_integration_0/v3_four_channel_bias_reference_distribution_0/v3_four_channel_phase_distribution_0/v3_four_channel_output_collection_0/v3_four_channel_placement_0/v3_channel_selector_late_promotion_2/v3_selector_route_pilot_0/group2_lo_n v3_four_channel_output_load_integration_0/combined_n VGND sky130_fd_pr__nfet_01v8 ad=0 pd=0 as=0 ps=0 w=0.65 l=0.15
X2068 v3_four_channel_output_load_integration_0/v3_four_channel_shared_support_integration_0/v3_four_channel_bias_reference_distribution_0/v3_four_channel_phase_distribution_0/v3_four_channel_output_collection_0/v3_four_channel_placement_0/v3_channel_selector_late_promotion_2/v3_channel_input_bias_late_promotion_0/a_7462_15422# V3I001 v3_four_channel_output_load_integration_0/v3_four_channel_shared_support_integration_0/v3_four_channel_bias_reference_distribution_0/v3_four_channel_phase_distribution_0/v3_four_channel_output_collection_0/v3_four_channel_placement_0/v3_channel_selector_late_promotion_2/v3_channel_input_bias_late_promotion_0/a_7216_14978# VGND sky130_fd_pr__nfet_01v8 ad=0 pd=0 as=0 ps=0 w=0.84 l=0.6
X2069 v3_four_channel_output_load_integration_0/v3_four_channel_shared_support_integration_0/v3_four_channel_bias_reference_distribution_0/v3_four_channel_phase_distribution_0/v3_four_channel_output_collection_0/v3_four_channel_placement_0/v3_channel_selector_late_promotion_2/v3_channel_input_bias_late_promotion_0/a_6070_7422# v3_four_channel_output_load_integration_0/v3_four_channel_shared_support_integration_0/v3_four_channel_bias_reference_distribution_0/v3_four_channel_phase_distribution_0/v3_four_channel_output_collection_0/v3_four_channel_placement_0/v3_channel_selector_late_promotion_2/v3_selector_route_pilot_0/group3_lo_p v3_four_channel_output_load_integration_0/combined_p VGND sky130_fd_pr__nfet_01v8 ad=0 pd=0 as=0 ps=0 w=0.65 l=0.15
X2070 v3_four_channel_output_load_integration_0/combined_n v3_four_channel_output_load_integration_0/v3_four_channel_shared_support_integration_0/v3_four_channel_bias_reference_distribution_0/v3_four_channel_phase_distribution_0/v3_four_channel_output_collection_0/v3_four_channel_placement_0/v3_channel_selector_late_promotion_2/v3_selector_route_pilot_0/group2_lo_p v3_four_channel_output_load_integration_0/v3_four_channel_shared_support_integration_0/v3_four_channel_bias_reference_distribution_0/v3_four_channel_phase_distribution_0/v3_four_channel_output_collection_0/v3_four_channel_placement_0/v3_channel_selector_late_promotion_2/v3_channel_input_bias_late_promotion_0/a_7038_10978# VGND sky130_fd_pr__nfet_01v8 ad=0 pd=0 as=0 ps=0 w=0.65 l=0.15
X2071 v3_four_channel_output_load_integration_0/v3_four_channel_shared_support_integration_0/v3_four_channel_bias_reference_distribution_0/v3_four_channel_phase_distribution_0/v3_four_channel_output_collection_0/v3_four_channel_placement_0/v3_channel_selector_late_promotion_2/v3_channel_input_bias_late_promotion_0/a_7462_15422# v3_four_channel_output_load_integration_0/v3_four_channel_shared_support_integration_0/v3_four_channel_bias_reference_distribution_0/v3_four_channel_phase_distribution_0/v3_four_channel_output_collection_0/v3_four_channel_placement_0/v3_channel_selector_late_promotion_2/v3_selector_route_pilot_0/group1_lo_n v3_four_channel_output_load_integration_0/combined_n VGND sky130_fd_pr__nfet_01v8 ad=0 pd=0 as=0 ps=0 w=0.65 l=0.15
X2072 v3_four_channel_output_load_integration_0/v3_four_channel_shared_support_integration_0/v3_four_channel_bias_reference_distribution_0/v3_four_channel_phase_distribution_0/v3_four_channel_output_collection_0/v3_four_channel_placement_0/v3_channel_selector_late_promotion_2/v3_channel_input_bias_late_promotion_0/a_4432_6978# v3_four_channel_output_load_integration_0/v3_four_channel_shared_support_integration_0/v3_vcm_support_block_0/ref v3_four_channel_output_load_integration_0/v3_four_channel_shared_support_integration_0/v3_four_channel_bias_reference_distribution_0/v3_four_channel_phase_distribution_0/v3_four_channel_output_collection_0/v3_four_channel_placement_0/v3_channel_selector_late_promotion_2/v3_channel_input_bias_late_promotion_0/a_4254_6978# VGND sky130_fd_pr__nfet_01v8 ad=0 pd=0 as=0 ps=0 w=0.84 l=0.6
X2073 v3_four_channel_output_load_integration_0/v3_four_channel_shared_support_integration_0/v3_four_channel_bias_reference_distribution_0/v3_four_channel_phase_distribution_0/v3_four_channel_output_collection_0/v3_four_channel_placement_0/v3_channel_selector_late_promotion_2/v3_channel_input_bias_late_promotion_0/a_5824_10978# v3_four_channel_output_load_integration_0/v3_four_channel_shared_support_integration_0/v3_vcm_support_block_0/ref v3_four_channel_output_load_integration_0/v3_four_channel_shared_support_integration_0/v3_four_channel_bias_reference_distribution_0/v3_four_channel_phase_distribution_0/v3_four_channel_output_collection_0/v3_four_channel_placement_0/v3_channel_selector_late_promotion_2/v3_channel_input_bias_late_promotion_0/a_5646_10978# VGND sky130_fd_pr__nfet_01v8 ad=0 pd=0 as=0 ps=0 w=0.84 l=0.6
X2074 v3_four_channel_output_load_integration_0/combined_n v3_four_channel_output_load_integration_0/v3_four_channel_shared_support_integration_0/v3_four_channel_bias_reference_distribution_0/v3_four_channel_phase_distribution_0/v3_four_channel_output_collection_0/v3_four_channel_placement_0/v3_channel_selector_late_promotion_2/v3_selector_route_pilot_0/group3_lo_n v3_four_channel_output_load_integration_0/v3_four_channel_shared_support_integration_0/v3_four_channel_bias_reference_distribution_0/v3_four_channel_phase_distribution_0/v3_four_channel_output_collection_0/v3_four_channel_placement_0/v3_channel_selector_late_promotion_2/v3_channel_input_bias_late_promotion_0/a_4254_22978# VGND sky130_fd_pr__nfet_01v8 ad=0 pd=0 as=0 ps=0 w=0.65 l=0.15
X2075 v3_four_channel_output_load_integration_0/v3_four_channel_shared_support_integration_0/v3_four_channel_bias_reference_distribution_0/v3_four_channel_phase_distribution_0/v3_four_channel_output_collection_0/v3_four_channel_placement_0/v3_channel_selector_late_promotion_2/v3_channel_input_bias_late_promotion_0/a_7462_23422# v3_four_channel_output_load_integration_0/v3_four_channel_shared_support_integration_0/v3_four_channel_bias_reference_distribution_0/v3_four_channel_phase_distribution_0/v3_four_channel_output_collection_0/v3_four_channel_placement_0/v3_channel_selector_late_promotion_2/v3_selector_route_pilot_0/group3_lo_n v3_four_channel_output_load_integration_0/combined_p VGND sky130_fd_pr__nfet_01v8 ad=0 pd=0 as=0 ps=0 w=0.65 l=0.15
X2076 v3_four_channel_output_load_integration_0/v3_four_channel_shared_support_integration_0/v3_four_channel_bias_reference_distribution_0/v3_four_channel_phase_distribution_0/v3_four_channel_output_collection_0/v3_four_channel_placement_0/v3_channel_selector_late_promotion_2/v3_channel_input_bias_late_promotion_0/a_4432_6978# v3_four_channel_output_load_integration_0/v3_four_channel_shared_support_integration_0/v3_tail_bias_support_block_0/vbias VGND VGND sky130_fd_pr__nfet_01v8 ad=0 pd=0 as=0 ps=0 w=5.07 l=1
X2077 v3_four_channel_output_load_integration_0/v3_four_channel_shared_support_integration_0/v3_four_channel_bias_reference_distribution_0/v3_four_channel_phase_distribution_0/v3_four_channel_output_collection_0/v3_four_channel_placement_0/v3_channel_selector_late_promotion_2/v3_channel_input_bias_late_promotion_0/a_7216_6978# v3_four_channel_output_load_integration_0/v3_four_channel_shared_support_integration_0/v3_vcm_support_block_0/ref v3_four_channel_output_load_integration_0/v3_four_channel_shared_support_integration_0/v3_four_channel_bias_reference_distribution_0/v3_four_channel_phase_distribution_0/v3_four_channel_output_collection_0/v3_four_channel_placement_0/v3_channel_selector_late_promotion_2/v3_channel_input_bias_late_promotion_0/a_7038_6978# VGND sky130_fd_pr__nfet_01v8 ad=0 pd=0 as=0 ps=0 w=0.84 l=0.6
X2078 v3_four_channel_output_load_integration_0/combined_n v3_four_channel_output_load_integration_0/v3_four_channel_shared_support_integration_0/v3_four_channel_bias_reference_distribution_0/v3_four_channel_phase_distribution_0/v3_four_channel_output_collection_0/v3_four_channel_placement_0/v3_channel_selector_late_promotion_2/v3_selector_route_pilot_0/group3_lo_p v3_four_channel_output_load_integration_0/v3_four_channel_shared_support_integration_0/v3_four_channel_bias_reference_distribution_0/v3_four_channel_phase_distribution_0/v3_four_channel_output_collection_0/v3_four_channel_placement_0/v3_channel_selector_late_promotion_2/v3_channel_input_bias_late_promotion_0/a_5646_6978# VGND sky130_fd_pr__nfet_01v8 ad=0 pd=0 as=0 ps=0 w=0.65 l=0.15
X2079 VGND v3_four_channel_output_load_integration_0/v3_four_channel_shared_support_integration_0/v3_tail_bias_support_block_0/vbias v3_four_channel_output_load_integration_0/v3_four_channel_shared_support_integration_0/v3_four_channel_bias_reference_distribution_0/v3_four_channel_phase_distribution_0/v3_four_channel_output_collection_0/v3_four_channel_placement_0/v3_channel_selector_late_promotion_2/v3_channel_input_bias_late_promotion_0/a_4382_13688# VGND sky130_fd_pr__nfet_01v8 ad=0 pd=0 as=0 ps=0 w=5.07 l=1
X2080 VDPWR v3_four_channel_output_load_integration_0/v3_four_channel_shared_support_integration_0/v3_four_channel_bias_reference_distribution_0/v3_four_channel_phase_distribution_0/v3_four_channel_output_collection_0/v3_four_channel_placement_0/v3_channel_selector_late_promotion_2/v3_selector_route_pilot_0/G1_MUX_POS/a_505_21# v3_four_channel_output_load_integration_0/v3_four_channel_shared_support_integration_0/v3_four_channel_bias_reference_distribution_0/v3_four_channel_phase_distribution_0/v3_four_channel_output_collection_0/v3_four_channel_placement_0/v3_channel_selector_late_promotion_2/v3_selector_route_pilot_0/G1_MUX_POS/a_535_374# VDPWR sky130_fd_pr__pfet_01v8_hvt ad=0 pd=0 as=0.0882 ps=1.26 w=0.42 l=0.15
X2081 v3_four_channel_output_load_integration_0/v3_four_channel_shared_support_integration_0/v3_four_channel_bias_reference_distribution_0/v3_four_channel_phase_distribution_0/v3_four_channel_output_collection_0/v3_four_channel_placement_0/v3_channel_selector_late_promotion_2/v3_selector_route_pilot_0/G1_MUX_POS/a_505_21# V3R207 VDPWR VDPWR sky130_fd_pr__pfet_01v8_hvt ad=0.1176 pd=1.4 as=0 ps=0 w=0.42 l=0.15
X2082 v3_four_channel_output_load_integration_0/v3_four_channel_shared_support_integration_0/v3_four_channel_bias_reference_distribution_0/v3_four_channel_phase_distribution_0/v3_four_channel_output_collection_0/v3_four_channel_placement_0/v3_channel_selector_late_promotion_2/v3_selector_route_pilot_0/G1_MUX_POS/a_218_374# V3R207 VDPWR VDPWR sky130_fd_pr__pfet_01v8_hvt ad=0.1533 pd=1.57 as=0 ps=0 w=0.42 l=0.15
X2083 VGND v3_four_channel_output_load_integration_0/v3_four_channel_shared_support_integration_0/v3_four_channel_bias_reference_distribution_0/v3_four_channel_phase_distribution_0/v3_four_channel_output_collection_0/v3_four_channel_placement_0/v3_channel_selector_late_promotion_2/v3_selector_route_pilot_0/G1_MUX_POS/a_505_21# v3_four_channel_output_load_integration_0/v3_four_channel_shared_support_integration_0/v3_four_channel_bias_reference_distribution_0/v3_four_channel_phase_distribution_0/v3_four_channel_output_collection_0/v3_four_channel_placement_0/v3_channel_selector_late_promotion_2/v3_selector_route_pilot_0/G1_MUX_POS/a_439_47# VGND sky130_fd_pr__nfet_01v8 ad=0 pd=0 as=0.1386 ps=1.5 w=0.42 l=0.15
X2084 v3_four_channel_output_load_integration_0/v3_four_channel_shared_support_integration_0/v3_four_channel_bias_reference_distribution_0/v3_four_channel_phase_distribution_0/v3_four_channel_output_collection_0/v3_four_channel_placement_0/v3_channel_selector_late_promotion_2/v3_selector_route_pilot_0/G1_MUX_POS/a_76_199# V3R290 v3_four_channel_output_load_integration_0/v3_four_channel_shared_support_integration_0/v3_four_channel_bias_reference_distribution_0/v3_four_channel_phase_distribution_0/v3_four_channel_output_collection_0/v3_four_channel_placement_0/v3_channel_selector_late_promotion_2/v3_selector_route_pilot_0/G1_MUX_POS/a_218_374# VDPWR sky130_fd_pr__pfet_01v8_hvt ad=0.3864 pd=2.68 as=0 ps=0 w=0.42 l=0.15
X2085 v3_four_channel_output_load_integration_0/v3_four_channel_shared_support_integration_0/v3_four_channel_bias_reference_distribution_0/v3_four_channel_phase_distribution_0/v3_four_channel_output_collection_0/v3_four_channel_placement_0/v3_channel_selector_late_promotion_2/v3_selector_route_pilot_0/G1_MUX_POS/a_505_21# V3R207 VGND VGND sky130_fd_pr__nfet_01v8 ad=0.1092 pd=1.36 as=0 ps=0 w=0.42 l=0.15
X2086 v3_four_channel_output_load_integration_0/v3_four_channel_shared_support_integration_0/v3_four_channel_bias_reference_distribution_0/v3_four_channel_phase_distribution_0/v3_four_channel_output_collection_0/v3_four_channel_placement_0/v3_channel_selector_late_promotion_2/v3_selector_route_pilot_0/G1_MUX_POS/a_439_47# V3R290 v3_four_channel_output_load_integration_0/v3_four_channel_shared_support_integration_0/v3_four_channel_bias_reference_distribution_0/v3_four_channel_phase_distribution_0/v3_four_channel_output_collection_0/v3_four_channel_placement_0/v3_channel_selector_late_promotion_2/v3_selector_route_pilot_0/G1_MUX_POS/a_76_199# VGND sky130_fd_pr__nfet_01v8 ad=0 pd=0 as=0.1995 ps=1.79 w=0.42 l=0.15
X2087 v3_four_channel_output_load_integration_0/v3_four_channel_shared_support_integration_0/v3_four_channel_bias_reference_distribution_0/v3_four_channel_phase_distribution_0/v3_four_channel_output_collection_0/v3_four_channel_placement_0/v3_channel_selector_late_promotion_2/v3_selector_route_pilot_0/G1_MUX_POS/a_535_374# V3R291 v3_four_channel_output_load_integration_0/v3_four_channel_shared_support_integration_0/v3_four_channel_bias_reference_distribution_0/v3_four_channel_phase_distribution_0/v3_four_channel_output_collection_0/v3_four_channel_placement_0/v3_channel_selector_late_promotion_2/v3_selector_route_pilot_0/G1_MUX_POS/a_76_199# VDPWR sky130_fd_pr__pfet_01v8_hvt ad=0 pd=0 as=0 ps=0 w=0.42 l=0.15
X2088 v3_four_channel_output_load_integration_0/v3_four_channel_shared_support_integration_0/v3_four_channel_bias_reference_distribution_0/v3_four_channel_phase_distribution_0/v3_four_channel_output_collection_0/v3_four_channel_placement_0/v3_channel_selector_late_promotion_2/v3_selector_route_pilot_0/G1_MUX_POS/a_76_199# V3R291 v3_four_channel_output_load_integration_0/v3_four_channel_shared_support_integration_0/v3_four_channel_bias_reference_distribution_0/v3_four_channel_phase_distribution_0/v3_four_channel_output_collection_0/v3_four_channel_placement_0/v3_channel_selector_late_promotion_2/v3_selector_route_pilot_0/G1_MUX_POS/a_218_47# VGND sky130_fd_pr__nfet_01v8 ad=0 pd=0 as=0.1386 ps=1.5 w=0.42 l=0.15
X2089 v3_four_channel_output_load_integration_0/v3_four_channel_shared_support_integration_0/v3_four_channel_bias_reference_distribution_0/v3_four_channel_phase_distribution_0/v3_four_channel_output_collection_0/v3_four_channel_placement_0/v3_channel_selector_late_promotion_2/v3_selector_route_pilot_0/G1_MUX_POS/a_218_47# V3R207 VGND VGND sky130_fd_pr__nfet_01v8 ad=0 pd=0 as=0 ps=0 w=0.42 l=0.15
X2090 VDPWR v3_four_channel_output_load_integration_0/v3_four_channel_shared_support_integration_0/v3_four_channel_bias_reference_distribution_0/v3_four_channel_phase_distribution_0/v3_four_channel_output_collection_0/v3_four_channel_placement_0/v3_channel_selector_late_promotion_2/v3_selector_route_pilot_0/G1_MUX_POS/a_76_199# v3_four_channel_output_load_integration_0/v3_four_channel_shared_support_integration_0/v3_four_channel_bias_reference_distribution_0/v3_four_channel_phase_distribution_0/v3_four_channel_output_collection_0/v3_four_channel_placement_0/v3_channel_selector_late_promotion_2/v3_selector_route_pilot_0/G1_MUX_POS/X VDPWR sky130_fd_pr__pfet_01v8_hvt ad=0 pd=0 as=0.26 ps=2.52 w=1 l=0.15
X2091 VGND v3_four_channel_output_load_integration_0/v3_four_channel_shared_support_integration_0/v3_four_channel_bias_reference_distribution_0/v3_four_channel_phase_distribution_0/v3_four_channel_output_collection_0/v3_four_channel_placement_0/v3_channel_selector_late_promotion_2/v3_selector_route_pilot_0/G1_MUX_POS/a_76_199# v3_four_channel_output_load_integration_0/v3_four_channel_shared_support_integration_0/v3_four_channel_bias_reference_distribution_0/v3_four_channel_phase_distribution_0/v3_four_channel_output_collection_0/v3_four_channel_placement_0/v3_channel_selector_late_promotion_2/v3_selector_route_pilot_0/G1_MUX_POS/X VGND sky130_fd_pr__nfet_01v8 ad=0 pd=0 as=0.169 ps=1.82 w=0.65 l=0.15
X2092 VDPWR v3_four_channel_output_load_integration_0/v3_four_channel_shared_support_integration_0/v3_four_channel_bias_reference_distribution_0/v3_four_channel_phase_distribution_0/v3_four_channel_output_collection_0/v3_four_channel_placement_0/v3_channel_selector_late_promotion_2/v3_selector_route_pilot_0/G3_MUX_AXIS/a_505_21# v3_four_channel_output_load_integration_0/v3_four_channel_shared_support_integration_0/v3_four_channel_bias_reference_distribution_0/v3_four_channel_phase_distribution_0/v3_four_channel_output_collection_0/v3_four_channel_placement_0/v3_channel_selector_late_promotion_2/v3_selector_route_pilot_0/G3_MUX_AXIS/a_535_374# VDPWR sky130_fd_pr__pfet_01v8_hvt ad=0 pd=0 as=0.0882 ps=1.26 w=0.42 l=0.15
X2093 v3_four_channel_output_load_integration_0/v3_four_channel_shared_support_integration_0/v3_four_channel_bias_reference_distribution_0/v3_four_channel_phase_distribution_0/v3_four_channel_output_collection_0/v3_four_channel_placement_0/v3_channel_selector_late_promotion_2/v3_selector_route_pilot_0/G3_MUX_AXIS/a_505_21# V3R212 VDPWR VDPWR sky130_fd_pr__pfet_01v8_hvt ad=0.1176 pd=1.4 as=0 ps=0 w=0.42 l=0.15
X2094 v3_four_channel_output_load_integration_0/v3_four_channel_shared_support_integration_0/v3_four_channel_bias_reference_distribution_0/v3_four_channel_phase_distribution_0/v3_four_channel_output_collection_0/v3_four_channel_placement_0/v3_channel_selector_late_promotion_2/v3_selector_route_pilot_0/G3_MUX_AXIS/a_218_374# V3R212 VDPWR VDPWR sky130_fd_pr__pfet_01v8_hvt ad=0.1533 pd=1.57 as=0 ps=0 w=0.42 l=0.15
X2095 VGND v3_four_channel_output_load_integration_0/v3_four_channel_shared_support_integration_0/v3_four_channel_bias_reference_distribution_0/v3_four_channel_phase_distribution_0/v3_four_channel_output_collection_0/v3_four_channel_placement_0/v3_channel_selector_late_promotion_2/v3_selector_route_pilot_0/G3_MUX_AXIS/a_505_21# v3_four_channel_output_load_integration_0/v3_four_channel_shared_support_integration_0/v3_four_channel_bias_reference_distribution_0/v3_four_channel_phase_distribution_0/v3_four_channel_output_collection_0/v3_four_channel_placement_0/v3_channel_selector_late_promotion_2/v3_selector_route_pilot_0/G3_MUX_AXIS/a_439_47# VGND sky130_fd_pr__nfet_01v8 ad=0 pd=0 as=0.1386 ps=1.5 w=0.42 l=0.15
X2096 v3_four_channel_output_load_integration_0/v3_four_channel_shared_support_integration_0/v3_four_channel_bias_reference_distribution_0/v3_four_channel_phase_distribution_0/v3_four_channel_output_collection_0/v3_four_channel_placement_0/v3_channel_selector_late_promotion_2/v3_selector_route_pilot_0/G3_MUX_AXIS/a_76_199# v3_four_channel_output_load_integration_0/v3_four_channel_shared_support_integration_0/v3_four_channel_bias_reference_distribution_0/v3_four_channel_phase_distribution_0/v3_four_channel_output_collection_0/v3_four_channel_placement_0/v3_channel_selector_late_promotion_2/v3_selector_route_pilot_0/G3_MUX_POS/X v3_four_channel_output_load_integration_0/v3_four_channel_shared_support_integration_0/v3_four_channel_bias_reference_distribution_0/v3_four_channel_phase_distribution_0/v3_four_channel_output_collection_0/v3_four_channel_placement_0/v3_channel_selector_late_promotion_2/v3_selector_route_pilot_0/G3_MUX_AXIS/a_218_374# VDPWR sky130_fd_pr__pfet_01v8_hvt ad=0.3864 pd=2.68 as=0 ps=0 w=0.42 l=0.15
X2097 v3_four_channel_output_load_integration_0/v3_four_channel_shared_support_integration_0/v3_four_channel_bias_reference_distribution_0/v3_four_channel_phase_distribution_0/v3_four_channel_output_collection_0/v3_four_channel_placement_0/v3_channel_selector_late_promotion_2/v3_selector_route_pilot_0/G3_MUX_AXIS/a_505_21# V3R212 VGND VGND sky130_fd_pr__nfet_01v8 ad=0.1092 pd=1.36 as=0 ps=0 w=0.42 l=0.15
X2098 v3_four_channel_output_load_integration_0/v3_four_channel_shared_support_integration_0/v3_four_channel_bias_reference_distribution_0/v3_four_channel_phase_distribution_0/v3_four_channel_output_collection_0/v3_four_channel_placement_0/v3_channel_selector_late_promotion_2/v3_selector_route_pilot_0/G3_MUX_AXIS/a_439_47# v3_four_channel_output_load_integration_0/v3_four_channel_shared_support_integration_0/v3_four_channel_bias_reference_distribution_0/v3_four_channel_phase_distribution_0/v3_four_channel_output_collection_0/v3_four_channel_placement_0/v3_channel_selector_late_promotion_2/v3_selector_route_pilot_0/G3_MUX_POS/X v3_four_channel_output_load_integration_0/v3_four_channel_shared_support_integration_0/v3_four_channel_bias_reference_distribution_0/v3_four_channel_phase_distribution_0/v3_four_channel_output_collection_0/v3_four_channel_placement_0/v3_channel_selector_late_promotion_2/v3_selector_route_pilot_0/G3_MUX_AXIS/a_76_199# VGND sky130_fd_pr__nfet_01v8 ad=0 pd=0 as=0.1995 ps=1.79 w=0.42 l=0.15
X2099 v3_four_channel_output_load_integration_0/v3_four_channel_shared_support_integration_0/v3_four_channel_bias_reference_distribution_0/v3_four_channel_phase_distribution_0/v3_four_channel_output_collection_0/v3_four_channel_placement_0/v3_channel_selector_late_promotion_2/v3_selector_route_pilot_0/G3_MUX_AXIS/a_535_374# v3_four_channel_output_load_integration_0/v3_four_channel_shared_support_integration_0/v3_four_channel_bias_reference_distribution_0/v3_four_channel_phase_distribution_0/v3_four_channel_output_collection_0/v3_four_channel_placement_0/v3_channel_selector_late_promotion_2/v3_selector_route_pilot_0/G3_MUX_NEG/X v3_four_channel_output_load_integration_0/v3_four_channel_shared_support_integration_0/v3_four_channel_bias_reference_distribution_0/v3_four_channel_phase_distribution_0/v3_four_channel_output_collection_0/v3_four_channel_placement_0/v3_channel_selector_late_promotion_2/v3_selector_route_pilot_0/G3_MUX_AXIS/a_76_199# VDPWR sky130_fd_pr__pfet_01v8_hvt ad=0 pd=0 as=0 ps=0 w=0.42 l=0.15
X2100 v3_four_channel_output_load_integration_0/v3_four_channel_shared_support_integration_0/v3_four_channel_bias_reference_distribution_0/v3_four_channel_phase_distribution_0/v3_four_channel_output_collection_0/v3_four_channel_placement_0/v3_channel_selector_late_promotion_2/v3_selector_route_pilot_0/G3_MUX_AXIS/a_76_199# v3_four_channel_output_load_integration_0/v3_four_channel_shared_support_integration_0/v3_four_channel_bias_reference_distribution_0/v3_four_channel_phase_distribution_0/v3_four_channel_output_collection_0/v3_four_channel_placement_0/v3_channel_selector_late_promotion_2/v3_selector_route_pilot_0/G3_MUX_NEG/X v3_four_channel_output_load_integration_0/v3_four_channel_shared_support_integration_0/v3_four_channel_bias_reference_distribution_0/v3_four_channel_phase_distribution_0/v3_four_channel_output_collection_0/v3_four_channel_placement_0/v3_channel_selector_late_promotion_2/v3_selector_route_pilot_0/G3_MUX_AXIS/a_218_47# VGND sky130_fd_pr__nfet_01v8 ad=0 pd=0 as=0.1386 ps=1.5 w=0.42 l=0.15
X2101 v3_four_channel_output_load_integration_0/v3_four_channel_shared_support_integration_0/v3_four_channel_bias_reference_distribution_0/v3_four_channel_phase_distribution_0/v3_four_channel_output_collection_0/v3_four_channel_placement_0/v3_channel_selector_late_promotion_2/v3_selector_route_pilot_0/G3_MUX_AXIS/a_218_47# V3R212 VGND VGND sky130_fd_pr__nfet_01v8 ad=0 pd=0 as=0 ps=0 w=0.42 l=0.15
X2102 VDPWR v3_four_channel_output_load_integration_0/v3_four_channel_shared_support_integration_0/v3_four_channel_bias_reference_distribution_0/v3_four_channel_phase_distribution_0/v3_four_channel_output_collection_0/v3_four_channel_placement_0/v3_channel_selector_late_promotion_2/v3_selector_route_pilot_0/G3_MUX_AXIS/a_76_199# v3_four_channel_output_load_integration_0/v3_four_channel_shared_support_integration_0/v3_four_channel_bias_reference_distribution_0/v3_four_channel_phase_distribution_0/v3_four_channel_output_collection_0/v3_four_channel_placement_0/v3_channel_selector_late_promotion_2/v3_selector_route_pilot_0/G3_MUX_AXIS/X VDPWR sky130_fd_pr__pfet_01v8_hvt ad=0 pd=0 as=0.26 ps=2.52 w=1 l=0.15
X2103 VGND v3_four_channel_output_load_integration_0/v3_four_channel_shared_support_integration_0/v3_four_channel_bias_reference_distribution_0/v3_four_channel_phase_distribution_0/v3_four_channel_output_collection_0/v3_four_channel_placement_0/v3_channel_selector_late_promotion_2/v3_selector_route_pilot_0/G3_MUX_AXIS/a_76_199# v3_four_channel_output_load_integration_0/v3_four_channel_shared_support_integration_0/v3_four_channel_bias_reference_distribution_0/v3_four_channel_phase_distribution_0/v3_four_channel_output_collection_0/v3_four_channel_placement_0/v3_channel_selector_late_promotion_2/v3_selector_route_pilot_0/G3_MUX_AXIS/X VGND sky130_fd_pr__nfet_01v8 ad=0 pd=0 as=0.169 ps=1.82 w=0.65 l=0.15
X2104 VDPWR V3R069 v3_four_channel_output_load_integration_0/v3_four_channel_shared_support_integration_0/v3_four_channel_bias_reference_distribution_0/v3_four_channel_phase_distribution_0/v3_four_channel_output_collection_0/v3_four_channel_placement_0/v3_channel_selector_late_promotion_2/v3_selector_route_pilot_0/ENABLE_ANDNOT/a_207_413# VDPWR sky130_fd_pr__pfet_01v8_hvt ad=0 pd=0 as=0.1218 ps=1.42 w=0.42 l=0.15
X2105 v3_four_channel_output_load_integration_0/v3_four_channel_shared_support_integration_0/v3_four_channel_bias_reference_distribution_0/v3_four_channel_phase_distribution_0/v3_four_channel_output_collection_0/v3_four_channel_placement_0/v3_channel_selector_late_promotion_2/v3_selector_route_pilot_0/G3_LO_P_AND/B v3_four_channel_output_load_integration_0/v3_four_channel_shared_support_integration_0/v3_four_channel_bias_reference_distribution_0/v3_four_channel_phase_distribution_0/v3_four_channel_output_collection_0/v3_four_channel_placement_0/v3_channel_selector_late_promotion_2/v3_selector_route_pilot_0/ENABLE_ANDNOT/a_207_413# VDPWR VDPWR sky130_fd_pr__pfet_01v8_hvt ad=0.26 pd=2.52 as=0 ps=0 w=1 l=0.15
X2106 v3_four_channel_output_load_integration_0/v3_four_channel_shared_support_integration_0/v3_four_channel_bias_reference_distribution_0/v3_four_channel_phase_distribution_0/v3_four_channel_output_collection_0/v3_four_channel_placement_0/v3_channel_selector_late_promotion_2/v3_selector_route_pilot_0/ENABLE_ANDNOT/a_297_47# v3_four_channel_output_load_integration_0/v3_four_channel_shared_support_integration_0/v3_four_channel_bias_reference_distribution_0/v3_four_channel_phase_distribution_0/v3_four_channel_output_collection_0/v3_four_channel_placement_0/v3_channel_selector_late_promotion_2/v3_selector_route_pilot_0/ENABLE_ANDNOT/a_27_413# v3_four_channel_output_load_integration_0/v3_four_channel_shared_support_integration_0/v3_four_channel_bias_reference_distribution_0/v3_four_channel_phase_distribution_0/v3_four_channel_output_collection_0/v3_four_channel_placement_0/v3_channel_selector_late_promotion_2/v3_selector_route_pilot_0/ENABLE_ANDNOT/a_207_413# VGND sky130_fd_pr__nfet_01v8 ad=0.1008 pd=1.32 as=0.1092 ps=1.36 w=0.42 l=0.15
X2107 v3_four_channel_output_load_integration_0/v3_four_channel_shared_support_integration_0/v3_four_channel_bias_reference_distribution_0/v3_four_channel_phase_distribution_0/v3_four_channel_output_collection_0/v3_four_channel_placement_0/v3_channel_selector_late_promotion_2/v3_selector_route_pilot_0/G3_LO_P_AND/B v3_four_channel_output_load_integration_0/v3_four_channel_shared_support_integration_0/v3_four_channel_bias_reference_distribution_0/v3_four_channel_phase_distribution_0/v3_four_channel_output_collection_0/v3_four_channel_placement_0/v3_channel_selector_late_promotion_2/v3_selector_route_pilot_0/ENABLE_ANDNOT/a_207_413# VGND VGND sky130_fd_pr__nfet_01v8 ad=0.169 pd=1.82 as=0 ps=0 w=0.65 l=0.15
X2108 v3_four_channel_output_load_integration_0/v3_four_channel_shared_support_integration_0/v3_four_channel_bias_reference_distribution_0/v3_four_channel_phase_distribution_0/v3_four_channel_output_collection_0/v3_four_channel_placement_0/v3_channel_selector_late_promotion_2/v3_selector_route_pilot_0/ENABLE_ANDNOT/a_207_413# v3_four_channel_output_load_integration_0/v3_four_channel_shared_support_integration_0/v3_four_channel_bias_reference_distribution_0/v3_four_channel_phase_distribution_0/v3_four_channel_output_collection_0/v3_four_channel_placement_0/v3_channel_selector_late_promotion_2/v3_selector_route_pilot_0/ENABLE_ANDNOT/a_27_413# VDPWR VDPWR sky130_fd_pr__pfet_01v8_hvt ad=0 pd=0 as=0 ps=0 w=0.42 l=0.15
X2109 VDPWR V3R238 v3_four_channel_output_load_integration_0/v3_four_channel_shared_support_integration_0/v3_four_channel_bias_reference_distribution_0/v3_four_channel_phase_distribution_0/v3_four_channel_output_collection_0/v3_four_channel_placement_0/v3_channel_selector_late_promotion_2/v3_selector_route_pilot_0/ENABLE_ANDNOT/a_27_413# VDPWR sky130_fd_pr__pfet_01v8_hvt ad=0 pd=0 as=0.1092 ps=1.36 w=0.42 l=0.15
X2110 VGND V3R069 v3_four_channel_output_load_integration_0/v3_four_channel_shared_support_integration_0/v3_four_channel_bias_reference_distribution_0/v3_four_channel_phase_distribution_0/v3_four_channel_output_collection_0/v3_four_channel_placement_0/v3_channel_selector_late_promotion_2/v3_selector_route_pilot_0/ENABLE_ANDNOT/a_297_47# VGND sky130_fd_pr__nfet_01v8 ad=0 pd=0 as=0 ps=0 w=0.42 l=0.15
X2111 v3_four_channel_output_load_integration_0/v3_four_channel_shared_support_integration_0/v3_four_channel_bias_reference_distribution_0/v3_four_channel_phase_distribution_0/v3_four_channel_output_collection_0/v3_four_channel_placement_0/v3_channel_selector_late_promotion_2/v3_selector_route_pilot_0/ENABLE_ANDNOT/a_27_413# V3R238 VGND VGND sky130_fd_pr__nfet_01v8 ad=0.1092 pd=1.36 as=0 ps=0 w=0.42 l=0.15
X2112 VDPWR v3_four_channel_output_load_integration_0/v3_four_channel_shared_support_integration_0/v3_four_channel_bias_reference_distribution_0/v3_four_channel_phase_distribution_0/v3_four_channel_output_collection_0/v3_four_channel_placement_0/v3_channel_selector_late_promotion_2/v3_selector_route_pilot_0/G1_MUX_NEG/a_505_21# v3_four_channel_output_load_integration_0/v3_four_channel_shared_support_integration_0/v3_four_channel_bias_reference_distribution_0/v3_four_channel_phase_distribution_0/v3_four_channel_output_collection_0/v3_four_channel_placement_0/v3_channel_selector_late_promotion_2/v3_selector_route_pilot_0/G1_MUX_NEG/a_535_374# VDPWR sky130_fd_pr__pfet_01v8_hvt ad=0 pd=0 as=0.0882 ps=1.26 w=0.42 l=0.15
X2113 v3_four_channel_output_load_integration_0/v3_four_channel_shared_support_integration_0/v3_four_channel_bias_reference_distribution_0/v3_four_channel_phase_distribution_0/v3_four_channel_output_collection_0/v3_four_channel_placement_0/v3_channel_selector_late_promotion_2/v3_selector_route_pilot_0/G1_MUX_NEG/a_505_21# V3R207 VDPWR VDPWR sky130_fd_pr__pfet_01v8_hvt ad=0.1176 pd=1.4 as=0 ps=0 w=0.42 l=0.15
X2114 v3_four_channel_output_load_integration_0/v3_four_channel_shared_support_integration_0/v3_four_channel_bias_reference_distribution_0/v3_four_channel_phase_distribution_0/v3_four_channel_output_collection_0/v3_four_channel_placement_0/v3_channel_selector_late_promotion_2/v3_selector_route_pilot_0/G1_MUX_NEG/a_218_374# V3R207 VDPWR VDPWR sky130_fd_pr__pfet_01v8_hvt ad=0.1533 pd=1.57 as=0 ps=0 w=0.42 l=0.15
X2115 VGND v3_four_channel_output_load_integration_0/v3_four_channel_shared_support_integration_0/v3_four_channel_bias_reference_distribution_0/v3_four_channel_phase_distribution_0/v3_four_channel_output_collection_0/v3_four_channel_placement_0/v3_channel_selector_late_promotion_2/v3_selector_route_pilot_0/G1_MUX_NEG/a_505_21# v3_four_channel_output_load_integration_0/v3_four_channel_shared_support_integration_0/v3_four_channel_bias_reference_distribution_0/v3_four_channel_phase_distribution_0/v3_four_channel_output_collection_0/v3_four_channel_placement_0/v3_channel_selector_late_promotion_2/v3_selector_route_pilot_0/G1_MUX_NEG/a_439_47# VGND sky130_fd_pr__nfet_01v8 ad=0 pd=0 as=0.1386 ps=1.5 w=0.42 l=0.15
X2116 v3_four_channel_output_load_integration_0/v3_four_channel_shared_support_integration_0/v3_four_channel_bias_reference_distribution_0/v3_four_channel_phase_distribution_0/v3_four_channel_output_collection_0/v3_four_channel_placement_0/v3_channel_selector_late_promotion_2/v3_selector_route_pilot_0/G1_MUX_NEG/a_76_199# V3R292 v3_four_channel_output_load_integration_0/v3_four_channel_shared_support_integration_0/v3_four_channel_bias_reference_distribution_0/v3_four_channel_phase_distribution_0/v3_four_channel_output_collection_0/v3_four_channel_placement_0/v3_channel_selector_late_promotion_2/v3_selector_route_pilot_0/G1_MUX_NEG/a_218_374# VDPWR sky130_fd_pr__pfet_01v8_hvt ad=0.3864 pd=2.68 as=0 ps=0 w=0.42 l=0.15
X2117 v3_four_channel_output_load_integration_0/v3_four_channel_shared_support_integration_0/v3_four_channel_bias_reference_distribution_0/v3_four_channel_phase_distribution_0/v3_four_channel_output_collection_0/v3_four_channel_placement_0/v3_channel_selector_late_promotion_2/v3_selector_route_pilot_0/G1_MUX_NEG/a_505_21# V3R207 VGND VGND sky130_fd_pr__nfet_01v8 ad=0.1092 pd=1.36 as=0 ps=0 w=0.42 l=0.15
X2118 v3_four_channel_output_load_integration_0/v3_four_channel_shared_support_integration_0/v3_four_channel_bias_reference_distribution_0/v3_four_channel_phase_distribution_0/v3_four_channel_output_collection_0/v3_four_channel_placement_0/v3_channel_selector_late_promotion_2/v3_selector_route_pilot_0/G1_MUX_NEG/a_439_47# V3R292 v3_four_channel_output_load_integration_0/v3_four_channel_shared_support_integration_0/v3_four_channel_bias_reference_distribution_0/v3_four_channel_phase_distribution_0/v3_four_channel_output_collection_0/v3_four_channel_placement_0/v3_channel_selector_late_promotion_2/v3_selector_route_pilot_0/G1_MUX_NEG/a_76_199# VGND sky130_fd_pr__nfet_01v8 ad=0 pd=0 as=0.1995 ps=1.79 w=0.42 l=0.15
X2119 v3_four_channel_output_load_integration_0/v3_four_channel_shared_support_integration_0/v3_four_channel_bias_reference_distribution_0/v3_four_channel_phase_distribution_0/v3_four_channel_output_collection_0/v3_four_channel_placement_0/v3_channel_selector_late_promotion_2/v3_selector_route_pilot_0/G1_MUX_NEG/a_535_374# V3R293 v3_four_channel_output_load_integration_0/v3_four_channel_shared_support_integration_0/v3_four_channel_bias_reference_distribution_0/v3_four_channel_phase_distribution_0/v3_four_channel_output_collection_0/v3_four_channel_placement_0/v3_channel_selector_late_promotion_2/v3_selector_route_pilot_0/G1_MUX_NEG/a_76_199# VDPWR sky130_fd_pr__pfet_01v8_hvt ad=0 pd=0 as=0 ps=0 w=0.42 l=0.15
X2120 v3_four_channel_output_load_integration_0/v3_four_channel_shared_support_integration_0/v3_four_channel_bias_reference_distribution_0/v3_four_channel_phase_distribution_0/v3_four_channel_output_collection_0/v3_four_channel_placement_0/v3_channel_selector_late_promotion_2/v3_selector_route_pilot_0/G1_MUX_NEG/a_76_199# V3R293 v3_four_channel_output_load_integration_0/v3_four_channel_shared_support_integration_0/v3_four_channel_bias_reference_distribution_0/v3_four_channel_phase_distribution_0/v3_four_channel_output_collection_0/v3_four_channel_placement_0/v3_channel_selector_late_promotion_2/v3_selector_route_pilot_0/G1_MUX_NEG/a_218_47# VGND sky130_fd_pr__nfet_01v8 ad=0 pd=0 as=0.1386 ps=1.5 w=0.42 l=0.15
X2121 v3_four_channel_output_load_integration_0/v3_four_channel_shared_support_integration_0/v3_four_channel_bias_reference_distribution_0/v3_four_channel_phase_distribution_0/v3_four_channel_output_collection_0/v3_four_channel_placement_0/v3_channel_selector_late_promotion_2/v3_selector_route_pilot_0/G1_MUX_NEG/a_218_47# V3R207 VGND VGND sky130_fd_pr__nfet_01v8 ad=0 pd=0 as=0 ps=0 w=0.42 l=0.15
X2122 VDPWR v3_four_channel_output_load_integration_0/v3_four_channel_shared_support_integration_0/v3_four_channel_bias_reference_distribution_0/v3_four_channel_phase_distribution_0/v3_four_channel_output_collection_0/v3_four_channel_placement_0/v3_channel_selector_late_promotion_2/v3_selector_route_pilot_0/G1_MUX_NEG/a_76_199# v3_four_channel_output_load_integration_0/v3_four_channel_shared_support_integration_0/v3_four_channel_bias_reference_distribution_0/v3_four_channel_phase_distribution_0/v3_four_channel_output_collection_0/v3_four_channel_placement_0/v3_channel_selector_late_promotion_2/v3_selector_route_pilot_0/G1_MUX_NEG/X VDPWR sky130_fd_pr__pfet_01v8_hvt ad=0 pd=0 as=0.26 ps=2.52 w=1 l=0.15
X2123 VGND v3_four_channel_output_load_integration_0/v3_four_channel_shared_support_integration_0/v3_four_channel_bias_reference_distribution_0/v3_four_channel_phase_distribution_0/v3_four_channel_output_collection_0/v3_four_channel_placement_0/v3_channel_selector_late_promotion_2/v3_selector_route_pilot_0/G1_MUX_NEG/a_76_199# v3_four_channel_output_load_integration_0/v3_four_channel_shared_support_integration_0/v3_four_channel_bias_reference_distribution_0/v3_four_channel_phase_distribution_0/v3_four_channel_output_collection_0/v3_four_channel_placement_0/v3_channel_selector_late_promotion_2/v3_selector_route_pilot_0/G1_MUX_NEG/X VGND sky130_fd_pr__nfet_01v8 ad=0 pd=0 as=0.169 ps=1.82 w=0.65 l=0.15
X2124 VDPWR v3_four_channel_output_load_integration_0/v3_four_channel_shared_support_integration_0/v3_four_channel_bias_reference_distribution_0/v3_four_channel_phase_distribution_0/v3_four_channel_output_collection_0/v3_four_channel_placement_0/v3_channel_selector_late_promotion_2/v3_selector_route_pilot_0/G3_LO_P_AND/B v3_four_channel_output_load_integration_0/v3_four_channel_shared_support_integration_0/v3_four_channel_bias_reference_distribution_0/v3_four_channel_phase_distribution_0/v3_four_channel_output_collection_0/v3_four_channel_placement_0/v3_channel_selector_late_promotion_2/v3_selector_route_pilot_0/G1_LO_P_AND/a_59_75# VDPWR sky130_fd_pr__pfet_01v8_hvt ad=0 pd=0 as=0.1134 ps=1.38 w=0.42 l=0.15
X2125 v3_four_channel_output_load_integration_0/v3_four_channel_shared_support_integration_0/v3_four_channel_bias_reference_distribution_0/v3_four_channel_phase_distribution_0/v3_four_channel_output_collection_0/v3_four_channel_placement_0/v3_channel_selector_late_promotion_2/v3_selector_route_pilot_0/group1_lo_p v3_four_channel_output_load_integration_0/v3_four_channel_shared_support_integration_0/v3_four_channel_bias_reference_distribution_0/v3_four_channel_phase_distribution_0/v3_four_channel_output_collection_0/v3_four_channel_placement_0/v3_channel_selector_late_promotion_2/v3_selector_route_pilot_0/G1_LO_P_AND/a_59_75# VDPWR VDPWR sky130_fd_pr__pfet_01v8_hvt ad=0.475 pd=2.95 as=0 ps=0 w=1 l=0.15
X2126 VGND v3_four_channel_output_load_integration_0/v3_four_channel_shared_support_integration_0/v3_four_channel_bias_reference_distribution_0/v3_four_channel_phase_distribution_0/v3_four_channel_output_collection_0/v3_four_channel_placement_0/v3_channel_selector_late_promotion_2/v3_selector_route_pilot_0/G3_LO_P_AND/B v3_four_channel_output_load_integration_0/v3_four_channel_shared_support_integration_0/v3_four_channel_bias_reference_distribution_0/v3_four_channel_phase_distribution_0/v3_four_channel_output_collection_0/v3_four_channel_placement_0/v3_channel_selector_late_promotion_2/v3_selector_route_pilot_0/G1_LO_P_AND/a_145_75# VGND sky130_fd_pr__nfet_01v8 ad=0 pd=0 as=0.1134 ps=1.38 w=0.42 l=0.15
X2127 v3_four_channel_output_load_integration_0/v3_four_channel_shared_support_integration_0/v3_four_channel_bias_reference_distribution_0/v3_four_channel_phase_distribution_0/v3_four_channel_output_collection_0/v3_four_channel_placement_0/v3_channel_selector_late_promotion_2/v3_selector_route_pilot_0/G1_LO_P_AND/a_59_75# v3_four_channel_output_load_integration_0/v3_four_channel_shared_support_integration_0/v3_four_channel_bias_reference_distribution_0/v3_four_channel_phase_distribution_0/v3_four_channel_output_collection_0/v3_four_channel_placement_0/v3_channel_selector_late_promotion_2/v3_selector_route_pilot_0/G1_MUX_AXIS/X VDPWR VDPWR sky130_fd_pr__pfet_01v8_hvt ad=0 pd=0 as=0 ps=0 w=0.42 l=0.15
X2128 v3_four_channel_output_load_integration_0/v3_four_channel_shared_support_integration_0/v3_four_channel_bias_reference_distribution_0/v3_four_channel_phase_distribution_0/v3_four_channel_output_collection_0/v3_four_channel_placement_0/v3_channel_selector_late_promotion_2/v3_selector_route_pilot_0/group1_lo_p v3_four_channel_output_load_integration_0/v3_four_channel_shared_support_integration_0/v3_four_channel_bias_reference_distribution_0/v3_four_channel_phase_distribution_0/v3_four_channel_output_collection_0/v3_four_channel_placement_0/v3_channel_selector_late_promotion_2/v3_selector_route_pilot_0/G1_LO_P_AND/a_59_75# VGND VGND sky130_fd_pr__nfet_01v8 ad=0.182 pd=1.86 as=0 ps=0 w=0.65 l=0.15
X2129 v3_four_channel_output_load_integration_0/v3_four_channel_shared_support_integration_0/v3_four_channel_bias_reference_distribution_0/v3_four_channel_phase_distribution_0/v3_four_channel_output_collection_0/v3_four_channel_placement_0/v3_channel_selector_late_promotion_2/v3_selector_route_pilot_0/G1_LO_P_AND/a_145_75# v3_four_channel_output_load_integration_0/v3_four_channel_shared_support_integration_0/v3_four_channel_bias_reference_distribution_0/v3_four_channel_phase_distribution_0/v3_four_channel_output_collection_0/v3_four_channel_placement_0/v3_channel_selector_late_promotion_2/v3_selector_route_pilot_0/G1_MUX_AXIS/X v3_four_channel_output_load_integration_0/v3_four_channel_shared_support_integration_0/v3_four_channel_bias_reference_distribution_0/v3_four_channel_phase_distribution_0/v3_four_channel_output_collection_0/v3_four_channel_placement_0/v3_channel_selector_late_promotion_2/v3_selector_route_pilot_0/G1_LO_P_AND/a_59_75# VGND sky130_fd_pr__nfet_01v8 ad=0 pd=0 as=0.1176 ps=1.4 w=0.42 l=0.15
X2130 VDPWR v3_four_channel_output_load_integration_0/v3_four_channel_shared_support_integration_0/v3_four_channel_bias_reference_distribution_0/v3_four_channel_phase_distribution_0/v3_four_channel_output_collection_0/v3_four_channel_placement_0/v3_channel_selector_late_promotion_2/v3_selector_route_pilot_0/G0_MUX_POS/a_505_21# v3_four_channel_output_load_integration_0/v3_four_channel_shared_support_integration_0/v3_four_channel_bias_reference_distribution_0/v3_four_channel_phase_distribution_0/v3_four_channel_output_collection_0/v3_four_channel_placement_0/v3_channel_selector_late_promotion_2/v3_selector_route_pilot_0/G0_MUX_POS/a_535_374# VDPWR sky130_fd_pr__pfet_01v8_hvt ad=0 pd=0 as=0.0882 ps=1.26 w=0.42 l=0.15
X2131 v3_four_channel_output_load_integration_0/v3_four_channel_shared_support_integration_0/v3_four_channel_bias_reference_distribution_0/v3_four_channel_phase_distribution_0/v3_four_channel_output_collection_0/v3_four_channel_placement_0/v3_channel_selector_late_promotion_2/v3_selector_route_pilot_0/G0_MUX_POS/a_505_21# V3R236 VDPWR VDPWR sky130_fd_pr__pfet_01v8_hvt ad=0.1176 pd=1.4 as=0 ps=0 w=0.42 l=0.15
X2132 v3_four_channel_output_load_integration_0/v3_four_channel_shared_support_integration_0/v3_four_channel_bias_reference_distribution_0/v3_four_channel_phase_distribution_0/v3_four_channel_output_collection_0/v3_four_channel_placement_0/v3_channel_selector_late_promotion_2/v3_selector_route_pilot_0/G0_MUX_POS/a_218_374# V3R236 VDPWR VDPWR sky130_fd_pr__pfet_01v8_hvt ad=0.1533 pd=1.57 as=0 ps=0 w=0.42 l=0.15
X2133 VGND v3_four_channel_output_load_integration_0/v3_four_channel_shared_support_integration_0/v3_four_channel_bias_reference_distribution_0/v3_four_channel_phase_distribution_0/v3_four_channel_output_collection_0/v3_four_channel_placement_0/v3_channel_selector_late_promotion_2/v3_selector_route_pilot_0/G0_MUX_POS/a_505_21# v3_four_channel_output_load_integration_0/v3_four_channel_shared_support_integration_0/v3_four_channel_bias_reference_distribution_0/v3_four_channel_phase_distribution_0/v3_four_channel_output_collection_0/v3_four_channel_placement_0/v3_channel_selector_late_promotion_2/v3_selector_route_pilot_0/G0_MUX_POS/a_439_47# VGND sky130_fd_pr__nfet_01v8 ad=0 pd=0 as=0.1386 ps=1.5 w=0.42 l=0.15
X2134 v3_four_channel_output_load_integration_0/v3_four_channel_shared_support_integration_0/v3_four_channel_bias_reference_distribution_0/v3_four_channel_phase_distribution_0/v3_four_channel_output_collection_0/v3_four_channel_placement_0/v3_channel_selector_late_promotion_2/v3_selector_route_pilot_0/G0_MUX_POS/a_76_199# V3R290 v3_four_channel_output_load_integration_0/v3_four_channel_shared_support_integration_0/v3_four_channel_bias_reference_distribution_0/v3_four_channel_phase_distribution_0/v3_four_channel_output_collection_0/v3_four_channel_placement_0/v3_channel_selector_late_promotion_2/v3_selector_route_pilot_0/G0_MUX_POS/a_218_374# VDPWR sky130_fd_pr__pfet_01v8_hvt ad=0.3864 pd=2.68 as=0 ps=0 w=0.42 l=0.15
X2135 v3_four_channel_output_load_integration_0/v3_four_channel_shared_support_integration_0/v3_four_channel_bias_reference_distribution_0/v3_four_channel_phase_distribution_0/v3_four_channel_output_collection_0/v3_four_channel_placement_0/v3_channel_selector_late_promotion_2/v3_selector_route_pilot_0/G0_MUX_POS/a_505_21# V3R236 VGND VGND sky130_fd_pr__nfet_01v8 ad=0.1092 pd=1.36 as=0 ps=0 w=0.42 l=0.15
X2136 v3_four_channel_output_load_integration_0/v3_four_channel_shared_support_integration_0/v3_four_channel_bias_reference_distribution_0/v3_four_channel_phase_distribution_0/v3_four_channel_output_collection_0/v3_four_channel_placement_0/v3_channel_selector_late_promotion_2/v3_selector_route_pilot_0/G0_MUX_POS/a_439_47# V3R290 v3_four_channel_output_load_integration_0/v3_four_channel_shared_support_integration_0/v3_four_channel_bias_reference_distribution_0/v3_four_channel_phase_distribution_0/v3_four_channel_output_collection_0/v3_four_channel_placement_0/v3_channel_selector_late_promotion_2/v3_selector_route_pilot_0/G0_MUX_POS/a_76_199# VGND sky130_fd_pr__nfet_01v8 ad=0 pd=0 as=0.1995 ps=1.79 w=0.42 l=0.15
X2137 v3_four_channel_output_load_integration_0/v3_four_channel_shared_support_integration_0/v3_four_channel_bias_reference_distribution_0/v3_four_channel_phase_distribution_0/v3_four_channel_output_collection_0/v3_four_channel_placement_0/v3_channel_selector_late_promotion_2/v3_selector_route_pilot_0/G0_MUX_POS/a_535_374# V3R291 v3_four_channel_output_load_integration_0/v3_four_channel_shared_support_integration_0/v3_four_channel_bias_reference_distribution_0/v3_four_channel_phase_distribution_0/v3_four_channel_output_collection_0/v3_four_channel_placement_0/v3_channel_selector_late_promotion_2/v3_selector_route_pilot_0/G0_MUX_POS/a_76_199# VDPWR sky130_fd_pr__pfet_01v8_hvt ad=0 pd=0 as=0 ps=0 w=0.42 l=0.15
X2138 v3_four_channel_output_load_integration_0/v3_four_channel_shared_support_integration_0/v3_four_channel_bias_reference_distribution_0/v3_four_channel_phase_distribution_0/v3_four_channel_output_collection_0/v3_four_channel_placement_0/v3_channel_selector_late_promotion_2/v3_selector_route_pilot_0/G0_MUX_POS/a_76_199# V3R291 v3_four_channel_output_load_integration_0/v3_four_channel_shared_support_integration_0/v3_four_channel_bias_reference_distribution_0/v3_four_channel_phase_distribution_0/v3_four_channel_output_collection_0/v3_four_channel_placement_0/v3_channel_selector_late_promotion_2/v3_selector_route_pilot_0/G0_MUX_POS/a_218_47# VGND sky130_fd_pr__nfet_01v8 ad=0 pd=0 as=0.1386 ps=1.5 w=0.42 l=0.15
X2139 v3_four_channel_output_load_integration_0/v3_four_channel_shared_support_integration_0/v3_four_channel_bias_reference_distribution_0/v3_four_channel_phase_distribution_0/v3_four_channel_output_collection_0/v3_four_channel_placement_0/v3_channel_selector_late_promotion_2/v3_selector_route_pilot_0/G0_MUX_POS/a_218_47# V3R236 VGND VGND sky130_fd_pr__nfet_01v8 ad=0 pd=0 as=0 ps=0 w=0.42 l=0.15
X2140 VDPWR v3_four_channel_output_load_integration_0/v3_four_channel_shared_support_integration_0/v3_four_channel_bias_reference_distribution_0/v3_four_channel_phase_distribution_0/v3_four_channel_output_collection_0/v3_four_channel_placement_0/v3_channel_selector_late_promotion_2/v3_selector_route_pilot_0/G0_MUX_POS/a_76_199# v3_four_channel_output_load_integration_0/v3_four_channel_shared_support_integration_0/v3_four_channel_bias_reference_distribution_0/v3_four_channel_phase_distribution_0/v3_four_channel_output_collection_0/v3_four_channel_placement_0/v3_channel_selector_late_promotion_2/v3_selector_route_pilot_0/G0_MUX_POS/X VDPWR sky130_fd_pr__pfet_01v8_hvt ad=0 pd=0 as=0.26 ps=2.52 w=1 l=0.15
X2141 VGND v3_four_channel_output_load_integration_0/v3_four_channel_shared_support_integration_0/v3_four_channel_bias_reference_distribution_0/v3_four_channel_phase_distribution_0/v3_four_channel_output_collection_0/v3_four_channel_placement_0/v3_channel_selector_late_promotion_2/v3_selector_route_pilot_0/G0_MUX_POS/a_76_199# v3_four_channel_output_load_integration_0/v3_four_channel_shared_support_integration_0/v3_four_channel_bias_reference_distribution_0/v3_four_channel_phase_distribution_0/v3_four_channel_output_collection_0/v3_four_channel_placement_0/v3_channel_selector_late_promotion_2/v3_selector_route_pilot_0/G0_MUX_POS/X VGND sky130_fd_pr__nfet_01v8 ad=0 pd=0 as=0.169 ps=1.82 w=0.65 l=0.15
X2142 VDPWR v3_four_channel_output_load_integration_0/v3_four_channel_shared_support_integration_0/v3_four_channel_bias_reference_distribution_0/v3_four_channel_phase_distribution_0/v3_four_channel_output_collection_0/v3_four_channel_placement_0/v3_channel_selector_late_promotion_2/v3_selector_route_pilot_0/G0_MUX_NEG/a_505_21# v3_four_channel_output_load_integration_0/v3_four_channel_shared_support_integration_0/v3_four_channel_bias_reference_distribution_0/v3_four_channel_phase_distribution_0/v3_four_channel_output_collection_0/v3_four_channel_placement_0/v3_channel_selector_late_promotion_2/v3_selector_route_pilot_0/G0_MUX_NEG/a_535_374# VDPWR sky130_fd_pr__pfet_01v8_hvt ad=0 pd=0 as=0.0882 ps=1.26 w=0.42 l=0.15
X2143 v3_four_channel_output_load_integration_0/v3_four_channel_shared_support_integration_0/v3_four_channel_bias_reference_distribution_0/v3_four_channel_phase_distribution_0/v3_four_channel_output_collection_0/v3_four_channel_placement_0/v3_channel_selector_late_promotion_2/v3_selector_route_pilot_0/G0_MUX_NEG/a_505_21# V3R236 VDPWR VDPWR sky130_fd_pr__pfet_01v8_hvt ad=0.1176 pd=1.4 as=0 ps=0 w=0.42 l=0.15
X2144 v3_four_channel_output_load_integration_0/v3_four_channel_shared_support_integration_0/v3_four_channel_bias_reference_distribution_0/v3_four_channel_phase_distribution_0/v3_four_channel_output_collection_0/v3_four_channel_placement_0/v3_channel_selector_late_promotion_2/v3_selector_route_pilot_0/G0_MUX_NEG/a_218_374# V3R236 VDPWR VDPWR sky130_fd_pr__pfet_01v8_hvt ad=0.1533 pd=1.57 as=0 ps=0 w=0.42 l=0.15
X2145 VGND v3_four_channel_output_load_integration_0/v3_four_channel_shared_support_integration_0/v3_four_channel_bias_reference_distribution_0/v3_four_channel_phase_distribution_0/v3_four_channel_output_collection_0/v3_four_channel_placement_0/v3_channel_selector_late_promotion_2/v3_selector_route_pilot_0/G0_MUX_NEG/a_505_21# v3_four_channel_output_load_integration_0/v3_four_channel_shared_support_integration_0/v3_four_channel_bias_reference_distribution_0/v3_four_channel_phase_distribution_0/v3_four_channel_output_collection_0/v3_four_channel_placement_0/v3_channel_selector_late_promotion_2/v3_selector_route_pilot_0/G0_MUX_NEG/a_439_47# VGND sky130_fd_pr__nfet_01v8 ad=0 pd=0 as=0.1386 ps=1.5 w=0.42 l=0.15
X2146 v3_four_channel_output_load_integration_0/v3_four_channel_shared_support_integration_0/v3_four_channel_bias_reference_distribution_0/v3_four_channel_phase_distribution_0/v3_four_channel_output_collection_0/v3_four_channel_placement_0/v3_channel_selector_late_promotion_2/v3_selector_route_pilot_0/G0_MUX_NEG/a_76_199# V3R292 v3_four_channel_output_load_integration_0/v3_four_channel_shared_support_integration_0/v3_four_channel_bias_reference_distribution_0/v3_four_channel_phase_distribution_0/v3_four_channel_output_collection_0/v3_four_channel_placement_0/v3_channel_selector_late_promotion_2/v3_selector_route_pilot_0/G0_MUX_NEG/a_218_374# VDPWR sky130_fd_pr__pfet_01v8_hvt ad=0.3864 pd=2.68 as=0 ps=0 w=0.42 l=0.15
X2147 v3_four_channel_output_load_integration_0/v3_four_channel_shared_support_integration_0/v3_four_channel_bias_reference_distribution_0/v3_four_channel_phase_distribution_0/v3_four_channel_output_collection_0/v3_four_channel_placement_0/v3_channel_selector_late_promotion_2/v3_selector_route_pilot_0/G0_MUX_NEG/a_505_21# V3R236 VGND VGND sky130_fd_pr__nfet_01v8 ad=0.1092 pd=1.36 as=0 ps=0 w=0.42 l=0.15
X2148 v3_four_channel_output_load_integration_0/v3_four_channel_shared_support_integration_0/v3_four_channel_bias_reference_distribution_0/v3_four_channel_phase_distribution_0/v3_four_channel_output_collection_0/v3_four_channel_placement_0/v3_channel_selector_late_promotion_2/v3_selector_route_pilot_0/G0_MUX_NEG/a_439_47# V3R292 v3_four_channel_output_load_integration_0/v3_four_channel_shared_support_integration_0/v3_four_channel_bias_reference_distribution_0/v3_four_channel_phase_distribution_0/v3_four_channel_output_collection_0/v3_four_channel_placement_0/v3_channel_selector_late_promotion_2/v3_selector_route_pilot_0/G0_MUX_NEG/a_76_199# VGND sky130_fd_pr__nfet_01v8 ad=0 pd=0 as=0.1995 ps=1.79 w=0.42 l=0.15
X2149 v3_four_channel_output_load_integration_0/v3_four_channel_shared_support_integration_0/v3_four_channel_bias_reference_distribution_0/v3_four_channel_phase_distribution_0/v3_four_channel_output_collection_0/v3_four_channel_placement_0/v3_channel_selector_late_promotion_2/v3_selector_route_pilot_0/G0_MUX_NEG/a_535_374# V3R293 v3_four_channel_output_load_integration_0/v3_four_channel_shared_support_integration_0/v3_four_channel_bias_reference_distribution_0/v3_four_channel_phase_distribution_0/v3_four_channel_output_collection_0/v3_four_channel_placement_0/v3_channel_selector_late_promotion_2/v3_selector_route_pilot_0/G0_MUX_NEG/a_76_199# VDPWR sky130_fd_pr__pfet_01v8_hvt ad=0 pd=0 as=0 ps=0 w=0.42 l=0.15
X2150 v3_four_channel_output_load_integration_0/v3_four_channel_shared_support_integration_0/v3_four_channel_bias_reference_distribution_0/v3_four_channel_phase_distribution_0/v3_four_channel_output_collection_0/v3_four_channel_placement_0/v3_channel_selector_late_promotion_2/v3_selector_route_pilot_0/G0_MUX_NEG/a_76_199# V3R293 v3_four_channel_output_load_integration_0/v3_four_channel_shared_support_integration_0/v3_four_channel_bias_reference_distribution_0/v3_four_channel_phase_distribution_0/v3_four_channel_output_collection_0/v3_four_channel_placement_0/v3_channel_selector_late_promotion_2/v3_selector_route_pilot_0/G0_MUX_NEG/a_218_47# VGND sky130_fd_pr__nfet_01v8 ad=0 pd=0 as=0.1386 ps=1.5 w=0.42 l=0.15
X2151 v3_four_channel_output_load_integration_0/v3_four_channel_shared_support_integration_0/v3_four_channel_bias_reference_distribution_0/v3_four_channel_phase_distribution_0/v3_four_channel_output_collection_0/v3_four_channel_placement_0/v3_channel_selector_late_promotion_2/v3_selector_route_pilot_0/G0_MUX_NEG/a_218_47# V3R236 VGND VGND sky130_fd_pr__nfet_01v8 ad=0 pd=0 as=0 ps=0 w=0.42 l=0.15
X2152 VDPWR v3_four_channel_output_load_integration_0/v3_four_channel_shared_support_integration_0/v3_four_channel_bias_reference_distribution_0/v3_four_channel_phase_distribution_0/v3_four_channel_output_collection_0/v3_four_channel_placement_0/v3_channel_selector_late_promotion_2/v3_selector_route_pilot_0/G0_MUX_NEG/a_76_199# v3_four_channel_output_load_integration_0/v3_four_channel_shared_support_integration_0/v3_four_channel_bias_reference_distribution_0/v3_four_channel_phase_distribution_0/v3_four_channel_output_collection_0/v3_four_channel_placement_0/v3_channel_selector_late_promotion_2/v3_selector_route_pilot_0/G0_MUX_NEG/X VDPWR sky130_fd_pr__pfet_01v8_hvt ad=0 pd=0 as=0.26 ps=2.52 w=1 l=0.15
X2153 VGND v3_four_channel_output_load_integration_0/v3_four_channel_shared_support_integration_0/v3_four_channel_bias_reference_distribution_0/v3_four_channel_phase_distribution_0/v3_four_channel_output_collection_0/v3_four_channel_placement_0/v3_channel_selector_late_promotion_2/v3_selector_route_pilot_0/G0_MUX_NEG/a_76_199# v3_four_channel_output_load_integration_0/v3_four_channel_shared_support_integration_0/v3_four_channel_bias_reference_distribution_0/v3_four_channel_phase_distribution_0/v3_four_channel_output_collection_0/v3_four_channel_placement_0/v3_channel_selector_late_promotion_2/v3_selector_route_pilot_0/G0_MUX_NEG/X VGND sky130_fd_pr__nfet_01v8 ad=0 pd=0 as=0.169 ps=1.82 w=0.65 l=0.15
X2154 VDPWR v3_four_channel_output_load_integration_0/v3_four_channel_shared_support_integration_0/v3_four_channel_bias_reference_distribution_0/v3_four_channel_phase_distribution_0/v3_four_channel_output_collection_0/v3_four_channel_placement_0/v3_channel_selector_late_promotion_2/v3_selector_route_pilot_0/G2_MUX_AXIS/a_505_21# v3_four_channel_output_load_integration_0/v3_four_channel_shared_support_integration_0/v3_four_channel_bias_reference_distribution_0/v3_four_channel_phase_distribution_0/v3_four_channel_output_collection_0/v3_four_channel_placement_0/v3_channel_selector_late_promotion_2/v3_selector_route_pilot_0/G2_MUX_AXIS/a_535_374# VDPWR sky130_fd_pr__pfet_01v8_hvt ad=0 pd=0 as=0.0882 ps=1.26 w=0.42 l=0.15
X2155 v3_four_channel_output_load_integration_0/v3_four_channel_shared_support_integration_0/v3_four_channel_bias_reference_distribution_0/v3_four_channel_phase_distribution_0/v3_four_channel_output_collection_0/v3_four_channel_placement_0/v3_channel_selector_late_promotion_2/v3_selector_route_pilot_0/G2_MUX_AXIS/a_505_21# V3R210 VDPWR VDPWR sky130_fd_pr__pfet_01v8_hvt ad=0.1176 pd=1.4 as=0 ps=0 w=0.42 l=0.15
X2156 v3_four_channel_output_load_integration_0/v3_four_channel_shared_support_integration_0/v3_four_channel_bias_reference_distribution_0/v3_four_channel_phase_distribution_0/v3_four_channel_output_collection_0/v3_four_channel_placement_0/v3_channel_selector_late_promotion_2/v3_selector_route_pilot_0/G2_MUX_AXIS/a_218_374# V3R210 VDPWR VDPWR sky130_fd_pr__pfet_01v8_hvt ad=0.1533 pd=1.57 as=0 ps=0 w=0.42 l=0.15
X2157 VGND v3_four_channel_output_load_integration_0/v3_four_channel_shared_support_integration_0/v3_four_channel_bias_reference_distribution_0/v3_four_channel_phase_distribution_0/v3_four_channel_output_collection_0/v3_four_channel_placement_0/v3_channel_selector_late_promotion_2/v3_selector_route_pilot_0/G2_MUX_AXIS/a_505_21# v3_four_channel_output_load_integration_0/v3_four_channel_shared_support_integration_0/v3_four_channel_bias_reference_distribution_0/v3_four_channel_phase_distribution_0/v3_four_channel_output_collection_0/v3_four_channel_placement_0/v3_channel_selector_late_promotion_2/v3_selector_route_pilot_0/G2_MUX_AXIS/a_439_47# VGND sky130_fd_pr__nfet_01v8 ad=0 pd=0 as=0.1386 ps=1.5 w=0.42 l=0.15
X2158 v3_four_channel_output_load_integration_0/v3_four_channel_shared_support_integration_0/v3_four_channel_bias_reference_distribution_0/v3_four_channel_phase_distribution_0/v3_four_channel_output_collection_0/v3_four_channel_placement_0/v3_channel_selector_late_promotion_2/v3_selector_route_pilot_0/G2_MUX_AXIS/a_76_199# v3_four_channel_output_load_integration_0/v3_four_channel_shared_support_integration_0/v3_four_channel_bias_reference_distribution_0/v3_four_channel_phase_distribution_0/v3_four_channel_output_collection_0/v3_four_channel_placement_0/v3_channel_selector_late_promotion_2/v3_selector_route_pilot_0/G2_MUX_POS/X v3_four_channel_output_load_integration_0/v3_four_channel_shared_support_integration_0/v3_four_channel_bias_reference_distribution_0/v3_four_channel_phase_distribution_0/v3_four_channel_output_collection_0/v3_four_channel_placement_0/v3_channel_selector_late_promotion_2/v3_selector_route_pilot_0/G2_MUX_AXIS/a_218_374# VDPWR sky130_fd_pr__pfet_01v8_hvt ad=0.3864 pd=2.68 as=0 ps=0 w=0.42 l=0.15
X2159 v3_four_channel_output_load_integration_0/v3_four_channel_shared_support_integration_0/v3_four_channel_bias_reference_distribution_0/v3_four_channel_phase_distribution_0/v3_four_channel_output_collection_0/v3_four_channel_placement_0/v3_channel_selector_late_promotion_2/v3_selector_route_pilot_0/G2_MUX_AXIS/a_505_21# V3R210 VGND VGND sky130_fd_pr__nfet_01v8 ad=0.1092 pd=1.36 as=0 ps=0 w=0.42 l=0.15
X2160 v3_four_channel_output_load_integration_0/v3_four_channel_shared_support_integration_0/v3_four_channel_bias_reference_distribution_0/v3_four_channel_phase_distribution_0/v3_four_channel_output_collection_0/v3_four_channel_placement_0/v3_channel_selector_late_promotion_2/v3_selector_route_pilot_0/G2_MUX_AXIS/a_439_47# v3_four_channel_output_load_integration_0/v3_four_channel_shared_support_integration_0/v3_four_channel_bias_reference_distribution_0/v3_four_channel_phase_distribution_0/v3_four_channel_output_collection_0/v3_four_channel_placement_0/v3_channel_selector_late_promotion_2/v3_selector_route_pilot_0/G2_MUX_POS/X v3_four_channel_output_load_integration_0/v3_four_channel_shared_support_integration_0/v3_four_channel_bias_reference_distribution_0/v3_four_channel_phase_distribution_0/v3_four_channel_output_collection_0/v3_four_channel_placement_0/v3_channel_selector_late_promotion_2/v3_selector_route_pilot_0/G2_MUX_AXIS/a_76_199# VGND sky130_fd_pr__nfet_01v8 ad=0 pd=0 as=0.1995 ps=1.79 w=0.42 l=0.15
X2161 v3_four_channel_output_load_integration_0/v3_four_channel_shared_support_integration_0/v3_four_channel_bias_reference_distribution_0/v3_four_channel_phase_distribution_0/v3_four_channel_output_collection_0/v3_four_channel_placement_0/v3_channel_selector_late_promotion_2/v3_selector_route_pilot_0/G2_MUX_AXIS/a_535_374# v3_four_channel_output_load_integration_0/v3_four_channel_shared_support_integration_0/v3_four_channel_bias_reference_distribution_0/v3_four_channel_phase_distribution_0/v3_four_channel_output_collection_0/v3_four_channel_placement_0/v3_channel_selector_late_promotion_2/v3_selector_route_pilot_0/G2_MUX_NEG/X v3_four_channel_output_load_integration_0/v3_four_channel_shared_support_integration_0/v3_four_channel_bias_reference_distribution_0/v3_four_channel_phase_distribution_0/v3_four_channel_output_collection_0/v3_four_channel_placement_0/v3_channel_selector_late_promotion_2/v3_selector_route_pilot_0/G2_MUX_AXIS/a_76_199# VDPWR sky130_fd_pr__pfet_01v8_hvt ad=0 pd=0 as=0 ps=0 w=0.42 l=0.15
X2162 v3_four_channel_output_load_integration_0/v3_four_channel_shared_support_integration_0/v3_four_channel_bias_reference_distribution_0/v3_four_channel_phase_distribution_0/v3_four_channel_output_collection_0/v3_four_channel_placement_0/v3_channel_selector_late_promotion_2/v3_selector_route_pilot_0/G2_MUX_AXIS/a_76_199# v3_four_channel_output_load_integration_0/v3_four_channel_shared_support_integration_0/v3_four_channel_bias_reference_distribution_0/v3_four_channel_phase_distribution_0/v3_four_channel_output_collection_0/v3_four_channel_placement_0/v3_channel_selector_late_promotion_2/v3_selector_route_pilot_0/G2_MUX_NEG/X v3_four_channel_output_load_integration_0/v3_four_channel_shared_support_integration_0/v3_four_channel_bias_reference_distribution_0/v3_four_channel_phase_distribution_0/v3_four_channel_output_collection_0/v3_four_channel_placement_0/v3_channel_selector_late_promotion_2/v3_selector_route_pilot_0/G2_MUX_AXIS/a_218_47# VGND sky130_fd_pr__nfet_01v8 ad=0 pd=0 as=0.1386 ps=1.5 w=0.42 l=0.15
X2163 v3_four_channel_output_load_integration_0/v3_four_channel_shared_support_integration_0/v3_four_channel_bias_reference_distribution_0/v3_four_channel_phase_distribution_0/v3_four_channel_output_collection_0/v3_four_channel_placement_0/v3_channel_selector_late_promotion_2/v3_selector_route_pilot_0/G2_MUX_AXIS/a_218_47# V3R210 VGND VGND sky130_fd_pr__nfet_01v8 ad=0 pd=0 as=0 ps=0 w=0.42 l=0.15
X2164 VDPWR v3_four_channel_output_load_integration_0/v3_four_channel_shared_support_integration_0/v3_four_channel_bias_reference_distribution_0/v3_four_channel_phase_distribution_0/v3_four_channel_output_collection_0/v3_four_channel_placement_0/v3_channel_selector_late_promotion_2/v3_selector_route_pilot_0/G2_MUX_AXIS/a_76_199# v3_four_channel_output_load_integration_0/v3_four_channel_shared_support_integration_0/v3_four_channel_bias_reference_distribution_0/v3_four_channel_phase_distribution_0/v3_four_channel_output_collection_0/v3_four_channel_placement_0/v3_channel_selector_late_promotion_2/v3_selector_route_pilot_0/G2_MUX_AXIS/X VDPWR sky130_fd_pr__pfet_01v8_hvt ad=0 pd=0 as=0.26 ps=2.52 w=1 l=0.15
X2165 VGND v3_four_channel_output_load_integration_0/v3_four_channel_shared_support_integration_0/v3_four_channel_bias_reference_distribution_0/v3_four_channel_phase_distribution_0/v3_four_channel_output_collection_0/v3_four_channel_placement_0/v3_channel_selector_late_promotion_2/v3_selector_route_pilot_0/G2_MUX_AXIS/a_76_199# v3_four_channel_output_load_integration_0/v3_four_channel_shared_support_integration_0/v3_four_channel_bias_reference_distribution_0/v3_four_channel_phase_distribution_0/v3_four_channel_output_collection_0/v3_four_channel_placement_0/v3_channel_selector_late_promotion_2/v3_selector_route_pilot_0/G2_MUX_AXIS/X VGND sky130_fd_pr__nfet_01v8 ad=0 pd=0 as=0.169 ps=1.82 w=0.65 l=0.15
X2166 VDPWR v3_four_channel_output_load_integration_0/v3_four_channel_shared_support_integration_0/v3_four_channel_bias_reference_distribution_0/v3_four_channel_phase_distribution_0/v3_four_channel_output_collection_0/v3_four_channel_placement_0/v3_channel_selector_late_promotion_2/v3_selector_route_pilot_0/G3_MUX_POS/a_505_21# v3_four_channel_output_load_integration_0/v3_four_channel_shared_support_integration_0/v3_four_channel_bias_reference_distribution_0/v3_four_channel_phase_distribution_0/v3_four_channel_output_collection_0/v3_four_channel_placement_0/v3_channel_selector_late_promotion_2/v3_selector_route_pilot_0/G3_MUX_POS/a_535_374# VDPWR sky130_fd_pr__pfet_01v8_hvt ad=0 pd=0 as=0.0882 ps=1.26 w=0.42 l=0.15
X2167 v3_four_channel_output_load_integration_0/v3_four_channel_shared_support_integration_0/v3_four_channel_bias_reference_distribution_0/v3_four_channel_phase_distribution_0/v3_four_channel_output_collection_0/v3_four_channel_placement_0/v3_channel_selector_late_promotion_2/v3_selector_route_pilot_0/G3_MUX_POS/a_505_21# V3R211 VDPWR VDPWR sky130_fd_pr__pfet_01v8_hvt ad=0.1176 pd=1.4 as=0 ps=0 w=0.42 l=0.15
X2168 v3_four_channel_output_load_integration_0/v3_four_channel_shared_support_integration_0/v3_four_channel_bias_reference_distribution_0/v3_four_channel_phase_distribution_0/v3_four_channel_output_collection_0/v3_four_channel_placement_0/v3_channel_selector_late_promotion_2/v3_selector_route_pilot_0/G3_MUX_POS/a_218_374# V3R211 VDPWR VDPWR sky130_fd_pr__pfet_01v8_hvt ad=0.1533 pd=1.57 as=0 ps=0 w=0.42 l=0.15
X2169 VGND v3_four_channel_output_load_integration_0/v3_four_channel_shared_support_integration_0/v3_four_channel_bias_reference_distribution_0/v3_four_channel_phase_distribution_0/v3_four_channel_output_collection_0/v3_four_channel_placement_0/v3_channel_selector_late_promotion_2/v3_selector_route_pilot_0/G3_MUX_POS/a_505_21# v3_four_channel_output_load_integration_0/v3_four_channel_shared_support_integration_0/v3_four_channel_bias_reference_distribution_0/v3_four_channel_phase_distribution_0/v3_four_channel_output_collection_0/v3_four_channel_placement_0/v3_channel_selector_late_promotion_2/v3_selector_route_pilot_0/G3_MUX_POS/a_439_47# VGND sky130_fd_pr__nfet_01v8 ad=0 pd=0 as=0.1386 ps=1.5 w=0.42 l=0.15
X2170 v3_four_channel_output_load_integration_0/v3_four_channel_shared_support_integration_0/v3_four_channel_bias_reference_distribution_0/v3_four_channel_phase_distribution_0/v3_four_channel_output_collection_0/v3_four_channel_placement_0/v3_channel_selector_late_promotion_2/v3_selector_route_pilot_0/G3_MUX_POS/a_76_199# V3R290 v3_four_channel_output_load_integration_0/v3_four_channel_shared_support_integration_0/v3_four_channel_bias_reference_distribution_0/v3_four_channel_phase_distribution_0/v3_four_channel_output_collection_0/v3_four_channel_placement_0/v3_channel_selector_late_promotion_2/v3_selector_route_pilot_0/G3_MUX_POS/a_218_374# VDPWR sky130_fd_pr__pfet_01v8_hvt ad=0.3864 pd=2.68 as=0 ps=0 w=0.42 l=0.15
X2171 v3_four_channel_output_load_integration_0/v3_four_channel_shared_support_integration_0/v3_four_channel_bias_reference_distribution_0/v3_four_channel_phase_distribution_0/v3_four_channel_output_collection_0/v3_four_channel_placement_0/v3_channel_selector_late_promotion_2/v3_selector_route_pilot_0/G3_MUX_POS/a_505_21# V3R211 VGND VGND sky130_fd_pr__nfet_01v8 ad=0.1092 pd=1.36 as=0 ps=0 w=0.42 l=0.15
X2172 v3_four_channel_output_load_integration_0/v3_four_channel_shared_support_integration_0/v3_four_channel_bias_reference_distribution_0/v3_four_channel_phase_distribution_0/v3_four_channel_output_collection_0/v3_four_channel_placement_0/v3_channel_selector_late_promotion_2/v3_selector_route_pilot_0/G3_MUX_POS/a_439_47# V3R290 v3_four_channel_output_load_integration_0/v3_four_channel_shared_support_integration_0/v3_four_channel_bias_reference_distribution_0/v3_four_channel_phase_distribution_0/v3_four_channel_output_collection_0/v3_four_channel_placement_0/v3_channel_selector_late_promotion_2/v3_selector_route_pilot_0/G3_MUX_POS/a_76_199# VGND sky130_fd_pr__nfet_01v8 ad=0 pd=0 as=0.1995 ps=1.79 w=0.42 l=0.15
X2173 v3_four_channel_output_load_integration_0/v3_four_channel_shared_support_integration_0/v3_four_channel_bias_reference_distribution_0/v3_four_channel_phase_distribution_0/v3_four_channel_output_collection_0/v3_four_channel_placement_0/v3_channel_selector_late_promotion_2/v3_selector_route_pilot_0/G3_MUX_POS/a_535_374# V3R291 v3_four_channel_output_load_integration_0/v3_four_channel_shared_support_integration_0/v3_four_channel_bias_reference_distribution_0/v3_four_channel_phase_distribution_0/v3_four_channel_output_collection_0/v3_four_channel_placement_0/v3_channel_selector_late_promotion_2/v3_selector_route_pilot_0/G3_MUX_POS/a_76_199# VDPWR sky130_fd_pr__pfet_01v8_hvt ad=0 pd=0 as=0 ps=0 w=0.42 l=0.15
X2174 v3_four_channel_output_load_integration_0/v3_four_channel_shared_support_integration_0/v3_four_channel_bias_reference_distribution_0/v3_four_channel_phase_distribution_0/v3_four_channel_output_collection_0/v3_four_channel_placement_0/v3_channel_selector_late_promotion_2/v3_selector_route_pilot_0/G3_MUX_POS/a_76_199# V3R291 v3_four_channel_output_load_integration_0/v3_four_channel_shared_support_integration_0/v3_four_channel_bias_reference_distribution_0/v3_four_channel_phase_distribution_0/v3_four_channel_output_collection_0/v3_four_channel_placement_0/v3_channel_selector_late_promotion_2/v3_selector_route_pilot_0/G3_MUX_POS/a_218_47# VGND sky130_fd_pr__nfet_01v8 ad=0 pd=0 as=0.1386 ps=1.5 w=0.42 l=0.15
X2175 v3_four_channel_output_load_integration_0/v3_four_channel_shared_support_integration_0/v3_four_channel_bias_reference_distribution_0/v3_four_channel_phase_distribution_0/v3_four_channel_output_collection_0/v3_four_channel_placement_0/v3_channel_selector_late_promotion_2/v3_selector_route_pilot_0/G3_MUX_POS/a_218_47# V3R211 VGND VGND sky130_fd_pr__nfet_01v8 ad=0 pd=0 as=0 ps=0 w=0.42 l=0.15
X2176 VDPWR v3_four_channel_output_load_integration_0/v3_four_channel_shared_support_integration_0/v3_four_channel_bias_reference_distribution_0/v3_four_channel_phase_distribution_0/v3_four_channel_output_collection_0/v3_four_channel_placement_0/v3_channel_selector_late_promotion_2/v3_selector_route_pilot_0/G3_MUX_POS/a_76_199# v3_four_channel_output_load_integration_0/v3_four_channel_shared_support_integration_0/v3_four_channel_bias_reference_distribution_0/v3_four_channel_phase_distribution_0/v3_four_channel_output_collection_0/v3_four_channel_placement_0/v3_channel_selector_late_promotion_2/v3_selector_route_pilot_0/G3_MUX_POS/X VDPWR sky130_fd_pr__pfet_01v8_hvt ad=0 pd=0 as=0.26 ps=2.52 w=1 l=0.15
X2177 VGND v3_four_channel_output_load_integration_0/v3_four_channel_shared_support_integration_0/v3_four_channel_bias_reference_distribution_0/v3_four_channel_phase_distribution_0/v3_four_channel_output_collection_0/v3_four_channel_placement_0/v3_channel_selector_late_promotion_2/v3_selector_route_pilot_0/G3_MUX_POS/a_76_199# v3_four_channel_output_load_integration_0/v3_four_channel_shared_support_integration_0/v3_four_channel_bias_reference_distribution_0/v3_four_channel_phase_distribution_0/v3_four_channel_output_collection_0/v3_four_channel_placement_0/v3_channel_selector_late_promotion_2/v3_selector_route_pilot_0/G3_MUX_POS/X VGND sky130_fd_pr__nfet_01v8 ad=0 pd=0 as=0.169 ps=1.82 w=0.65 l=0.15
X2178 VDPWR v3_four_channel_output_load_integration_0/v3_four_channel_shared_support_integration_0/v3_four_channel_bias_reference_distribution_0/v3_four_channel_phase_distribution_0/v3_four_channel_output_collection_0/v3_four_channel_placement_0/v3_channel_selector_late_promotion_2/v3_selector_route_pilot_0/G3_MUX_NEG/a_505_21# v3_four_channel_output_load_integration_0/v3_four_channel_shared_support_integration_0/v3_four_channel_bias_reference_distribution_0/v3_four_channel_phase_distribution_0/v3_four_channel_output_collection_0/v3_four_channel_placement_0/v3_channel_selector_late_promotion_2/v3_selector_route_pilot_0/G3_MUX_NEG/a_535_374# VDPWR sky130_fd_pr__pfet_01v8_hvt ad=0 pd=0 as=0.0882 ps=1.26 w=0.42 l=0.15
X2179 v3_four_channel_output_load_integration_0/v3_four_channel_shared_support_integration_0/v3_four_channel_bias_reference_distribution_0/v3_four_channel_phase_distribution_0/v3_four_channel_output_collection_0/v3_four_channel_placement_0/v3_channel_selector_late_promotion_2/v3_selector_route_pilot_0/G3_MUX_NEG/a_505_21# V3R211 VDPWR VDPWR sky130_fd_pr__pfet_01v8_hvt ad=0.1176 pd=1.4 as=0 ps=0 w=0.42 l=0.15
X2180 v3_four_channel_output_load_integration_0/v3_four_channel_shared_support_integration_0/v3_four_channel_bias_reference_distribution_0/v3_four_channel_phase_distribution_0/v3_four_channel_output_collection_0/v3_four_channel_placement_0/v3_channel_selector_late_promotion_2/v3_selector_route_pilot_0/G3_MUX_NEG/a_218_374# V3R211 VDPWR VDPWR sky130_fd_pr__pfet_01v8_hvt ad=0.1533 pd=1.57 as=0 ps=0 w=0.42 l=0.15
X2181 VGND v3_four_channel_output_load_integration_0/v3_four_channel_shared_support_integration_0/v3_four_channel_bias_reference_distribution_0/v3_four_channel_phase_distribution_0/v3_four_channel_output_collection_0/v3_four_channel_placement_0/v3_channel_selector_late_promotion_2/v3_selector_route_pilot_0/G3_MUX_NEG/a_505_21# v3_four_channel_output_load_integration_0/v3_four_channel_shared_support_integration_0/v3_four_channel_bias_reference_distribution_0/v3_four_channel_phase_distribution_0/v3_four_channel_output_collection_0/v3_four_channel_placement_0/v3_channel_selector_late_promotion_2/v3_selector_route_pilot_0/G3_MUX_NEG/a_439_47# VGND sky130_fd_pr__nfet_01v8 ad=0 pd=0 as=0.1386 ps=1.5 w=0.42 l=0.15
X2182 v3_four_channel_output_load_integration_0/v3_four_channel_shared_support_integration_0/v3_four_channel_bias_reference_distribution_0/v3_four_channel_phase_distribution_0/v3_four_channel_output_collection_0/v3_four_channel_placement_0/v3_channel_selector_late_promotion_2/v3_selector_route_pilot_0/G3_MUX_NEG/a_76_199# V3R292 v3_four_channel_output_load_integration_0/v3_four_channel_shared_support_integration_0/v3_four_channel_bias_reference_distribution_0/v3_four_channel_phase_distribution_0/v3_four_channel_output_collection_0/v3_four_channel_placement_0/v3_channel_selector_late_promotion_2/v3_selector_route_pilot_0/G3_MUX_NEG/a_218_374# VDPWR sky130_fd_pr__pfet_01v8_hvt ad=0.3864 pd=2.68 as=0 ps=0 w=0.42 l=0.15
X2183 v3_four_channel_output_load_integration_0/v3_four_channel_shared_support_integration_0/v3_four_channel_bias_reference_distribution_0/v3_four_channel_phase_distribution_0/v3_four_channel_output_collection_0/v3_four_channel_placement_0/v3_channel_selector_late_promotion_2/v3_selector_route_pilot_0/G3_MUX_NEG/a_505_21# V3R211 VGND VGND sky130_fd_pr__nfet_01v8 ad=0.1092 pd=1.36 as=0 ps=0 w=0.42 l=0.15
X2184 v3_four_channel_output_load_integration_0/v3_four_channel_shared_support_integration_0/v3_four_channel_bias_reference_distribution_0/v3_four_channel_phase_distribution_0/v3_four_channel_output_collection_0/v3_four_channel_placement_0/v3_channel_selector_late_promotion_2/v3_selector_route_pilot_0/G3_MUX_NEG/a_439_47# V3R292 v3_four_channel_output_load_integration_0/v3_four_channel_shared_support_integration_0/v3_four_channel_bias_reference_distribution_0/v3_four_channel_phase_distribution_0/v3_four_channel_output_collection_0/v3_four_channel_placement_0/v3_channel_selector_late_promotion_2/v3_selector_route_pilot_0/G3_MUX_NEG/a_76_199# VGND sky130_fd_pr__nfet_01v8 ad=0 pd=0 as=0.1995 ps=1.79 w=0.42 l=0.15
X2185 v3_four_channel_output_load_integration_0/v3_four_channel_shared_support_integration_0/v3_four_channel_bias_reference_distribution_0/v3_four_channel_phase_distribution_0/v3_four_channel_output_collection_0/v3_four_channel_placement_0/v3_channel_selector_late_promotion_2/v3_selector_route_pilot_0/G3_MUX_NEG/a_535_374# V3R293 v3_four_channel_output_load_integration_0/v3_four_channel_shared_support_integration_0/v3_four_channel_bias_reference_distribution_0/v3_four_channel_phase_distribution_0/v3_four_channel_output_collection_0/v3_four_channel_placement_0/v3_channel_selector_late_promotion_2/v3_selector_route_pilot_0/G3_MUX_NEG/a_76_199# VDPWR sky130_fd_pr__pfet_01v8_hvt ad=0 pd=0 as=0 ps=0 w=0.42 l=0.15
X2186 v3_four_channel_output_load_integration_0/v3_four_channel_shared_support_integration_0/v3_four_channel_bias_reference_distribution_0/v3_four_channel_phase_distribution_0/v3_four_channel_output_collection_0/v3_four_channel_placement_0/v3_channel_selector_late_promotion_2/v3_selector_route_pilot_0/G3_MUX_NEG/a_76_199# V3R293 v3_four_channel_output_load_integration_0/v3_four_channel_shared_support_integration_0/v3_four_channel_bias_reference_distribution_0/v3_four_channel_phase_distribution_0/v3_four_channel_output_collection_0/v3_four_channel_placement_0/v3_channel_selector_late_promotion_2/v3_selector_route_pilot_0/G3_MUX_NEG/a_218_47# VGND sky130_fd_pr__nfet_01v8 ad=0 pd=0 as=0.1386 ps=1.5 w=0.42 l=0.15
X2187 v3_four_channel_output_load_integration_0/v3_four_channel_shared_support_integration_0/v3_four_channel_bias_reference_distribution_0/v3_four_channel_phase_distribution_0/v3_four_channel_output_collection_0/v3_four_channel_placement_0/v3_channel_selector_late_promotion_2/v3_selector_route_pilot_0/G3_MUX_NEG/a_218_47# V3R211 VGND VGND sky130_fd_pr__nfet_01v8 ad=0 pd=0 as=0 ps=0 w=0.42 l=0.15
X2188 VDPWR v3_four_channel_output_load_integration_0/v3_four_channel_shared_support_integration_0/v3_four_channel_bias_reference_distribution_0/v3_four_channel_phase_distribution_0/v3_four_channel_output_collection_0/v3_four_channel_placement_0/v3_channel_selector_late_promotion_2/v3_selector_route_pilot_0/G3_MUX_NEG/a_76_199# v3_four_channel_output_load_integration_0/v3_four_channel_shared_support_integration_0/v3_four_channel_bias_reference_distribution_0/v3_four_channel_phase_distribution_0/v3_four_channel_output_collection_0/v3_four_channel_placement_0/v3_channel_selector_late_promotion_2/v3_selector_route_pilot_0/G3_MUX_NEG/X VDPWR sky130_fd_pr__pfet_01v8_hvt ad=0 pd=0 as=0.26 ps=2.52 w=1 l=0.15
X2189 VGND v3_four_channel_output_load_integration_0/v3_four_channel_shared_support_integration_0/v3_four_channel_bias_reference_distribution_0/v3_four_channel_phase_distribution_0/v3_four_channel_output_collection_0/v3_four_channel_placement_0/v3_channel_selector_late_promotion_2/v3_selector_route_pilot_0/G3_MUX_NEG/a_76_199# v3_four_channel_output_load_integration_0/v3_four_channel_shared_support_integration_0/v3_four_channel_bias_reference_distribution_0/v3_four_channel_phase_distribution_0/v3_four_channel_output_collection_0/v3_four_channel_placement_0/v3_channel_selector_late_promotion_2/v3_selector_route_pilot_0/G3_MUX_NEG/X VGND sky130_fd_pr__nfet_01v8 ad=0 pd=0 as=0.169 ps=1.82 w=0.65 l=0.15
X2190 VDPWR v3_four_channel_output_load_integration_0/v3_four_channel_shared_support_integration_0/v3_four_channel_bias_reference_distribution_0/v3_four_channel_phase_distribution_0/v3_four_channel_output_collection_0/v3_four_channel_placement_0/v3_channel_selector_late_promotion_2/v3_selector_route_pilot_0/G3_LO_P_AND/B v3_four_channel_output_load_integration_0/v3_four_channel_shared_support_integration_0/v3_four_channel_bias_reference_distribution_0/v3_four_channel_phase_distribution_0/v3_four_channel_output_collection_0/v3_four_channel_placement_0/v3_channel_selector_late_promotion_2/v3_selector_route_pilot_0/G0_LO_P_AND/a_59_75# VDPWR sky130_fd_pr__pfet_01v8_hvt ad=0 pd=0 as=0.1134 ps=1.38 w=0.42 l=0.15
X2191 v3_four_channel_output_load_integration_0/v3_four_channel_shared_support_integration_0/v3_four_channel_bias_reference_distribution_0/v3_four_channel_phase_distribution_0/v3_four_channel_output_collection_0/v3_four_channel_placement_0/v3_channel_selector_late_promotion_2/v3_selector_route_pilot_0/group0_lo_p v3_four_channel_output_load_integration_0/v3_four_channel_shared_support_integration_0/v3_four_channel_bias_reference_distribution_0/v3_four_channel_phase_distribution_0/v3_four_channel_output_collection_0/v3_four_channel_placement_0/v3_channel_selector_late_promotion_2/v3_selector_route_pilot_0/G0_LO_P_AND/a_59_75# VDPWR VDPWR sky130_fd_pr__pfet_01v8_hvt ad=0.475 pd=2.95 as=0 ps=0 w=1 l=0.15
X2192 VGND v3_four_channel_output_load_integration_0/v3_four_channel_shared_support_integration_0/v3_four_channel_bias_reference_distribution_0/v3_four_channel_phase_distribution_0/v3_four_channel_output_collection_0/v3_four_channel_placement_0/v3_channel_selector_late_promotion_2/v3_selector_route_pilot_0/G3_LO_P_AND/B v3_four_channel_output_load_integration_0/v3_four_channel_shared_support_integration_0/v3_four_channel_bias_reference_distribution_0/v3_four_channel_phase_distribution_0/v3_four_channel_output_collection_0/v3_four_channel_placement_0/v3_channel_selector_late_promotion_2/v3_selector_route_pilot_0/G0_LO_P_AND/a_145_75# VGND sky130_fd_pr__nfet_01v8 ad=0 pd=0 as=0.1134 ps=1.38 w=0.42 l=0.15
X2193 v3_four_channel_output_load_integration_0/v3_four_channel_shared_support_integration_0/v3_four_channel_bias_reference_distribution_0/v3_four_channel_phase_distribution_0/v3_four_channel_output_collection_0/v3_four_channel_placement_0/v3_channel_selector_late_promotion_2/v3_selector_route_pilot_0/G0_LO_P_AND/a_59_75# v3_four_channel_output_load_integration_0/v3_four_channel_shared_support_integration_0/v3_four_channel_bias_reference_distribution_0/v3_four_channel_phase_distribution_0/v3_four_channel_output_collection_0/v3_four_channel_placement_0/v3_channel_selector_late_promotion_2/v3_selector_route_pilot_0/G0_MUX_AXIS/X VDPWR VDPWR sky130_fd_pr__pfet_01v8_hvt ad=0 pd=0 as=0 ps=0 w=0.42 l=0.15
X2194 v3_four_channel_output_load_integration_0/v3_four_channel_shared_support_integration_0/v3_four_channel_bias_reference_distribution_0/v3_four_channel_phase_distribution_0/v3_four_channel_output_collection_0/v3_four_channel_placement_0/v3_channel_selector_late_promotion_2/v3_selector_route_pilot_0/group0_lo_p v3_four_channel_output_load_integration_0/v3_four_channel_shared_support_integration_0/v3_four_channel_bias_reference_distribution_0/v3_four_channel_phase_distribution_0/v3_four_channel_output_collection_0/v3_four_channel_placement_0/v3_channel_selector_late_promotion_2/v3_selector_route_pilot_0/G0_LO_P_AND/a_59_75# VGND VGND sky130_fd_pr__nfet_01v8 ad=0.182 pd=1.86 as=0 ps=0 w=0.65 l=0.15
X2195 v3_four_channel_output_load_integration_0/v3_four_channel_shared_support_integration_0/v3_four_channel_bias_reference_distribution_0/v3_four_channel_phase_distribution_0/v3_four_channel_output_collection_0/v3_four_channel_placement_0/v3_channel_selector_late_promotion_2/v3_selector_route_pilot_0/G0_LO_P_AND/a_145_75# v3_four_channel_output_load_integration_0/v3_four_channel_shared_support_integration_0/v3_four_channel_bias_reference_distribution_0/v3_four_channel_phase_distribution_0/v3_four_channel_output_collection_0/v3_four_channel_placement_0/v3_channel_selector_late_promotion_2/v3_selector_route_pilot_0/G0_MUX_AXIS/X v3_four_channel_output_load_integration_0/v3_four_channel_shared_support_integration_0/v3_four_channel_bias_reference_distribution_0/v3_four_channel_phase_distribution_0/v3_four_channel_output_collection_0/v3_four_channel_placement_0/v3_channel_selector_late_promotion_2/v3_selector_route_pilot_0/G0_LO_P_AND/a_59_75# VGND sky130_fd_pr__nfet_01v8 ad=0 pd=0 as=0.1176 ps=1.4 w=0.42 l=0.15
X2196 VDPWR v3_four_channel_output_load_integration_0/v3_four_channel_shared_support_integration_0/v3_four_channel_bias_reference_distribution_0/v3_four_channel_phase_distribution_0/v3_four_channel_output_collection_0/v3_four_channel_placement_0/v3_channel_selector_late_promotion_2/v3_selector_route_pilot_0/G3_LO_P_AND/B v3_four_channel_output_load_integration_0/v3_four_channel_shared_support_integration_0/v3_four_channel_bias_reference_distribution_0/v3_four_channel_phase_distribution_0/v3_four_channel_output_collection_0/v3_four_channel_placement_0/v3_channel_selector_late_promotion_2/v3_selector_route_pilot_0/G3_LO_N_ANDNOT/a_207_413# VDPWR sky130_fd_pr__pfet_01v8_hvt ad=0 pd=0 as=0.1218 ps=1.42 w=0.42 l=0.15
X2197 v3_four_channel_output_load_integration_0/v3_four_channel_shared_support_integration_0/v3_four_channel_bias_reference_distribution_0/v3_four_channel_phase_distribution_0/v3_four_channel_output_collection_0/v3_four_channel_placement_0/v3_channel_selector_late_promotion_2/v3_selector_route_pilot_0/group3_lo_n v3_four_channel_output_load_integration_0/v3_four_channel_shared_support_integration_0/v3_four_channel_bias_reference_distribution_0/v3_four_channel_phase_distribution_0/v3_four_channel_output_collection_0/v3_four_channel_placement_0/v3_channel_selector_late_promotion_2/v3_selector_route_pilot_0/G3_LO_N_ANDNOT/a_207_413# VDPWR VDPWR sky130_fd_pr__pfet_01v8_hvt ad=0.26 pd=2.52 as=0 ps=0 w=1 l=0.15
X2198 v3_four_channel_output_load_integration_0/v3_four_channel_shared_support_integration_0/v3_four_channel_bias_reference_distribution_0/v3_four_channel_phase_distribution_0/v3_four_channel_output_collection_0/v3_four_channel_placement_0/v3_channel_selector_late_promotion_2/v3_selector_route_pilot_0/G3_LO_N_ANDNOT/a_297_47# v3_four_channel_output_load_integration_0/v3_four_channel_shared_support_integration_0/v3_four_channel_bias_reference_distribution_0/v3_four_channel_phase_distribution_0/v3_four_channel_output_collection_0/v3_four_channel_placement_0/v3_channel_selector_late_promotion_2/v3_selector_route_pilot_0/G3_LO_N_ANDNOT/a_27_413# v3_four_channel_output_load_integration_0/v3_four_channel_shared_support_integration_0/v3_four_channel_bias_reference_distribution_0/v3_four_channel_phase_distribution_0/v3_four_channel_output_collection_0/v3_four_channel_placement_0/v3_channel_selector_late_promotion_2/v3_selector_route_pilot_0/G3_LO_N_ANDNOT/a_207_413# VGND sky130_fd_pr__nfet_01v8 ad=0.1008 pd=1.32 as=0.1092 ps=1.36 w=0.42 l=0.15
X2199 v3_four_channel_output_load_integration_0/v3_four_channel_shared_support_integration_0/v3_four_channel_bias_reference_distribution_0/v3_four_channel_phase_distribution_0/v3_four_channel_output_collection_0/v3_four_channel_placement_0/v3_channel_selector_late_promotion_2/v3_selector_route_pilot_0/group3_lo_n v3_four_channel_output_load_integration_0/v3_four_channel_shared_support_integration_0/v3_four_channel_bias_reference_distribution_0/v3_four_channel_phase_distribution_0/v3_four_channel_output_collection_0/v3_four_channel_placement_0/v3_channel_selector_late_promotion_2/v3_selector_route_pilot_0/G3_LO_N_ANDNOT/a_207_413# VGND VGND sky130_fd_pr__nfet_01v8 ad=0.169 pd=1.82 as=0 ps=0 w=0.65 l=0.15
X2200 v3_four_channel_output_load_integration_0/v3_four_channel_shared_support_integration_0/v3_four_channel_bias_reference_distribution_0/v3_four_channel_phase_distribution_0/v3_four_channel_output_collection_0/v3_four_channel_placement_0/v3_channel_selector_late_promotion_2/v3_selector_route_pilot_0/G3_LO_N_ANDNOT/a_207_413# v3_four_channel_output_load_integration_0/v3_four_channel_shared_support_integration_0/v3_four_channel_bias_reference_distribution_0/v3_four_channel_phase_distribution_0/v3_four_channel_output_collection_0/v3_four_channel_placement_0/v3_channel_selector_late_promotion_2/v3_selector_route_pilot_0/G3_LO_N_ANDNOT/a_27_413# VDPWR VDPWR sky130_fd_pr__pfet_01v8_hvt ad=0 pd=0 as=0 ps=0 w=0.42 l=0.15
X2201 VDPWR v3_four_channel_output_load_integration_0/v3_four_channel_shared_support_integration_0/v3_four_channel_bias_reference_distribution_0/v3_four_channel_phase_distribution_0/v3_four_channel_output_collection_0/v3_four_channel_placement_0/v3_channel_selector_late_promotion_2/v3_selector_route_pilot_0/G3_MUX_AXIS/X v3_four_channel_output_load_integration_0/v3_four_channel_shared_support_integration_0/v3_four_channel_bias_reference_distribution_0/v3_four_channel_phase_distribution_0/v3_four_channel_output_collection_0/v3_four_channel_placement_0/v3_channel_selector_late_promotion_2/v3_selector_route_pilot_0/G3_LO_N_ANDNOT/a_27_413# VDPWR sky130_fd_pr__pfet_01v8_hvt ad=0 pd=0 as=0.1092 ps=1.36 w=0.42 l=0.15
X2202 VGND v3_four_channel_output_load_integration_0/v3_four_channel_shared_support_integration_0/v3_four_channel_bias_reference_distribution_0/v3_four_channel_phase_distribution_0/v3_four_channel_output_collection_0/v3_four_channel_placement_0/v3_channel_selector_late_promotion_2/v3_selector_route_pilot_0/G3_LO_P_AND/B v3_four_channel_output_load_integration_0/v3_four_channel_shared_support_integration_0/v3_four_channel_bias_reference_distribution_0/v3_four_channel_phase_distribution_0/v3_four_channel_output_collection_0/v3_four_channel_placement_0/v3_channel_selector_late_promotion_2/v3_selector_route_pilot_0/G3_LO_N_ANDNOT/a_297_47# VGND sky130_fd_pr__nfet_01v8 ad=0 pd=0 as=0 ps=0 w=0.42 l=0.15
X2203 v3_four_channel_output_load_integration_0/v3_four_channel_shared_support_integration_0/v3_four_channel_bias_reference_distribution_0/v3_four_channel_phase_distribution_0/v3_four_channel_output_collection_0/v3_four_channel_placement_0/v3_channel_selector_late_promotion_2/v3_selector_route_pilot_0/G3_LO_N_ANDNOT/a_27_413# v3_four_channel_output_load_integration_0/v3_four_channel_shared_support_integration_0/v3_four_channel_bias_reference_distribution_0/v3_four_channel_phase_distribution_0/v3_four_channel_output_collection_0/v3_four_channel_placement_0/v3_channel_selector_late_promotion_2/v3_selector_route_pilot_0/G3_MUX_AXIS/X VGND VGND sky130_fd_pr__nfet_01v8 ad=0.1092 pd=1.36 as=0 ps=0 w=0.42 l=0.15
X2204 VDPWR v3_four_channel_output_load_integration_0/v3_four_channel_shared_support_integration_0/v3_four_channel_bias_reference_distribution_0/v3_four_channel_phase_distribution_0/v3_four_channel_output_collection_0/v3_four_channel_placement_0/v3_channel_selector_late_promotion_2/v3_selector_route_pilot_0/G3_LO_P_AND/B v3_four_channel_output_load_integration_0/v3_four_channel_shared_support_integration_0/v3_four_channel_bias_reference_distribution_0/v3_four_channel_phase_distribution_0/v3_four_channel_output_collection_0/v3_four_channel_placement_0/v3_channel_selector_late_promotion_2/v3_selector_route_pilot_0/G2_LO_N_ANDNOT/a_207_413# VDPWR sky130_fd_pr__pfet_01v8_hvt ad=0 pd=0 as=0.1218 ps=1.42 w=0.42 l=0.15
X2205 v3_four_channel_output_load_integration_0/v3_four_channel_shared_support_integration_0/v3_four_channel_bias_reference_distribution_0/v3_four_channel_phase_distribution_0/v3_four_channel_output_collection_0/v3_four_channel_placement_0/v3_channel_selector_late_promotion_2/v3_selector_route_pilot_0/group2_lo_n v3_four_channel_output_load_integration_0/v3_four_channel_shared_support_integration_0/v3_four_channel_bias_reference_distribution_0/v3_four_channel_phase_distribution_0/v3_four_channel_output_collection_0/v3_four_channel_placement_0/v3_channel_selector_late_promotion_2/v3_selector_route_pilot_0/G2_LO_N_ANDNOT/a_207_413# VDPWR VDPWR sky130_fd_pr__pfet_01v8_hvt ad=0.26 pd=2.52 as=0 ps=0 w=1 l=0.15
X2206 v3_four_channel_output_load_integration_0/v3_four_channel_shared_support_integration_0/v3_four_channel_bias_reference_distribution_0/v3_four_channel_phase_distribution_0/v3_four_channel_output_collection_0/v3_four_channel_placement_0/v3_channel_selector_late_promotion_2/v3_selector_route_pilot_0/G2_LO_N_ANDNOT/a_297_47# v3_four_channel_output_load_integration_0/v3_four_channel_shared_support_integration_0/v3_four_channel_bias_reference_distribution_0/v3_four_channel_phase_distribution_0/v3_four_channel_output_collection_0/v3_four_channel_placement_0/v3_channel_selector_late_promotion_2/v3_selector_route_pilot_0/G2_LO_N_ANDNOT/a_27_413# v3_four_channel_output_load_integration_0/v3_four_channel_shared_support_integration_0/v3_four_channel_bias_reference_distribution_0/v3_four_channel_phase_distribution_0/v3_four_channel_output_collection_0/v3_four_channel_placement_0/v3_channel_selector_late_promotion_2/v3_selector_route_pilot_0/G2_LO_N_ANDNOT/a_207_413# VGND sky130_fd_pr__nfet_01v8 ad=0.1008 pd=1.32 as=0.1092 ps=1.36 w=0.42 l=0.15
X2207 v3_four_channel_output_load_integration_0/v3_four_channel_shared_support_integration_0/v3_four_channel_bias_reference_distribution_0/v3_four_channel_phase_distribution_0/v3_four_channel_output_collection_0/v3_four_channel_placement_0/v3_channel_selector_late_promotion_2/v3_selector_route_pilot_0/group2_lo_n v3_four_channel_output_load_integration_0/v3_four_channel_shared_support_integration_0/v3_four_channel_bias_reference_distribution_0/v3_four_channel_phase_distribution_0/v3_four_channel_output_collection_0/v3_four_channel_placement_0/v3_channel_selector_late_promotion_2/v3_selector_route_pilot_0/G2_LO_N_ANDNOT/a_207_413# VGND VGND sky130_fd_pr__nfet_01v8 ad=0.169 pd=1.82 as=0 ps=0 w=0.65 l=0.15
X2208 v3_four_channel_output_load_integration_0/v3_four_channel_shared_support_integration_0/v3_four_channel_bias_reference_distribution_0/v3_four_channel_phase_distribution_0/v3_four_channel_output_collection_0/v3_four_channel_placement_0/v3_channel_selector_late_promotion_2/v3_selector_route_pilot_0/G2_LO_N_ANDNOT/a_207_413# v3_four_channel_output_load_integration_0/v3_four_channel_shared_support_integration_0/v3_four_channel_bias_reference_distribution_0/v3_four_channel_phase_distribution_0/v3_four_channel_output_collection_0/v3_four_channel_placement_0/v3_channel_selector_late_promotion_2/v3_selector_route_pilot_0/G2_LO_N_ANDNOT/a_27_413# VDPWR VDPWR sky130_fd_pr__pfet_01v8_hvt ad=0 pd=0 as=0 ps=0 w=0.42 l=0.15
X2209 VDPWR v3_four_channel_output_load_integration_0/v3_four_channel_shared_support_integration_0/v3_four_channel_bias_reference_distribution_0/v3_four_channel_phase_distribution_0/v3_four_channel_output_collection_0/v3_four_channel_placement_0/v3_channel_selector_late_promotion_2/v3_selector_route_pilot_0/G2_MUX_AXIS/X v3_four_channel_output_load_integration_0/v3_four_channel_shared_support_integration_0/v3_four_channel_bias_reference_distribution_0/v3_four_channel_phase_distribution_0/v3_four_channel_output_collection_0/v3_four_channel_placement_0/v3_channel_selector_late_promotion_2/v3_selector_route_pilot_0/G2_LO_N_ANDNOT/a_27_413# VDPWR sky130_fd_pr__pfet_01v8_hvt ad=0 pd=0 as=0.1092 ps=1.36 w=0.42 l=0.15
X2210 VGND v3_four_channel_output_load_integration_0/v3_four_channel_shared_support_integration_0/v3_four_channel_bias_reference_distribution_0/v3_four_channel_phase_distribution_0/v3_four_channel_output_collection_0/v3_four_channel_placement_0/v3_channel_selector_late_promotion_2/v3_selector_route_pilot_0/G3_LO_P_AND/B v3_four_channel_output_load_integration_0/v3_four_channel_shared_support_integration_0/v3_four_channel_bias_reference_distribution_0/v3_four_channel_phase_distribution_0/v3_four_channel_output_collection_0/v3_four_channel_placement_0/v3_channel_selector_late_promotion_2/v3_selector_route_pilot_0/G2_LO_N_ANDNOT/a_297_47# VGND sky130_fd_pr__nfet_01v8 ad=0 pd=0 as=0 ps=0 w=0.42 l=0.15
X2211 v3_four_channel_output_load_integration_0/v3_four_channel_shared_support_integration_0/v3_four_channel_bias_reference_distribution_0/v3_four_channel_phase_distribution_0/v3_four_channel_output_collection_0/v3_four_channel_placement_0/v3_channel_selector_late_promotion_2/v3_selector_route_pilot_0/G2_LO_N_ANDNOT/a_27_413# v3_four_channel_output_load_integration_0/v3_four_channel_shared_support_integration_0/v3_four_channel_bias_reference_distribution_0/v3_four_channel_phase_distribution_0/v3_four_channel_output_collection_0/v3_four_channel_placement_0/v3_channel_selector_late_promotion_2/v3_selector_route_pilot_0/G2_MUX_AXIS/X VGND VGND sky130_fd_pr__nfet_01v8 ad=0.1092 pd=1.36 as=0 ps=0 w=0.42 l=0.15
X2212 VDPWR v3_four_channel_output_load_integration_0/v3_four_channel_shared_support_integration_0/v3_four_channel_bias_reference_distribution_0/v3_four_channel_phase_distribution_0/v3_four_channel_output_collection_0/v3_four_channel_placement_0/v3_channel_selector_late_promotion_2/v3_selector_route_pilot_0/G3_LO_P_AND/B v3_four_channel_output_load_integration_0/v3_four_channel_shared_support_integration_0/v3_four_channel_bias_reference_distribution_0/v3_four_channel_phase_distribution_0/v3_four_channel_output_collection_0/v3_four_channel_placement_0/v3_channel_selector_late_promotion_2/v3_selector_route_pilot_0/G0_LO_N_ANDNOT/a_207_413# VDPWR sky130_fd_pr__pfet_01v8_hvt ad=0 pd=0 as=0.1218 ps=1.42 w=0.42 l=0.15
X2213 v3_four_channel_output_load_integration_0/v3_four_channel_shared_support_integration_0/v3_four_channel_bias_reference_distribution_0/v3_four_channel_phase_distribution_0/v3_four_channel_output_collection_0/v3_four_channel_placement_0/v3_channel_selector_late_promotion_2/v3_selector_route_pilot_0/group0_lo_n v3_four_channel_output_load_integration_0/v3_four_channel_shared_support_integration_0/v3_four_channel_bias_reference_distribution_0/v3_four_channel_phase_distribution_0/v3_four_channel_output_collection_0/v3_four_channel_placement_0/v3_channel_selector_late_promotion_2/v3_selector_route_pilot_0/G0_LO_N_ANDNOT/a_207_413# VDPWR VDPWR sky130_fd_pr__pfet_01v8_hvt ad=0.26 pd=2.52 as=0 ps=0 w=1 l=0.15
X2214 v3_four_channel_output_load_integration_0/v3_four_channel_shared_support_integration_0/v3_four_channel_bias_reference_distribution_0/v3_four_channel_phase_distribution_0/v3_four_channel_output_collection_0/v3_four_channel_placement_0/v3_channel_selector_late_promotion_2/v3_selector_route_pilot_0/G0_LO_N_ANDNOT/a_297_47# v3_four_channel_output_load_integration_0/v3_four_channel_shared_support_integration_0/v3_four_channel_bias_reference_distribution_0/v3_four_channel_phase_distribution_0/v3_four_channel_output_collection_0/v3_four_channel_placement_0/v3_channel_selector_late_promotion_2/v3_selector_route_pilot_0/G0_LO_N_ANDNOT/a_27_413# v3_four_channel_output_load_integration_0/v3_four_channel_shared_support_integration_0/v3_four_channel_bias_reference_distribution_0/v3_four_channel_phase_distribution_0/v3_four_channel_output_collection_0/v3_four_channel_placement_0/v3_channel_selector_late_promotion_2/v3_selector_route_pilot_0/G0_LO_N_ANDNOT/a_207_413# VGND sky130_fd_pr__nfet_01v8 ad=0.1008 pd=1.32 as=0.1092 ps=1.36 w=0.42 l=0.15
X2215 v3_four_channel_output_load_integration_0/v3_four_channel_shared_support_integration_0/v3_four_channel_bias_reference_distribution_0/v3_four_channel_phase_distribution_0/v3_four_channel_output_collection_0/v3_four_channel_placement_0/v3_channel_selector_late_promotion_2/v3_selector_route_pilot_0/group0_lo_n v3_four_channel_output_load_integration_0/v3_four_channel_shared_support_integration_0/v3_four_channel_bias_reference_distribution_0/v3_four_channel_phase_distribution_0/v3_four_channel_output_collection_0/v3_four_channel_placement_0/v3_channel_selector_late_promotion_2/v3_selector_route_pilot_0/G0_LO_N_ANDNOT/a_207_413# VGND VGND sky130_fd_pr__nfet_01v8 ad=0.169 pd=1.82 as=0 ps=0 w=0.65 l=0.15
X2216 v3_four_channel_output_load_integration_0/v3_four_channel_shared_support_integration_0/v3_four_channel_bias_reference_distribution_0/v3_four_channel_phase_distribution_0/v3_four_channel_output_collection_0/v3_four_channel_placement_0/v3_channel_selector_late_promotion_2/v3_selector_route_pilot_0/G0_LO_N_ANDNOT/a_207_413# v3_four_channel_output_load_integration_0/v3_four_channel_shared_support_integration_0/v3_four_channel_bias_reference_distribution_0/v3_four_channel_phase_distribution_0/v3_four_channel_output_collection_0/v3_four_channel_placement_0/v3_channel_selector_late_promotion_2/v3_selector_route_pilot_0/G0_LO_N_ANDNOT/a_27_413# VDPWR VDPWR sky130_fd_pr__pfet_01v8_hvt ad=0 pd=0 as=0 ps=0 w=0.42 l=0.15
X2217 VDPWR v3_four_channel_output_load_integration_0/v3_four_channel_shared_support_integration_0/v3_four_channel_bias_reference_distribution_0/v3_four_channel_phase_distribution_0/v3_four_channel_output_collection_0/v3_four_channel_placement_0/v3_channel_selector_late_promotion_2/v3_selector_route_pilot_0/G0_MUX_AXIS/X v3_four_channel_output_load_integration_0/v3_four_channel_shared_support_integration_0/v3_four_channel_bias_reference_distribution_0/v3_four_channel_phase_distribution_0/v3_four_channel_output_collection_0/v3_four_channel_placement_0/v3_channel_selector_late_promotion_2/v3_selector_route_pilot_0/G0_LO_N_ANDNOT/a_27_413# VDPWR sky130_fd_pr__pfet_01v8_hvt ad=0 pd=0 as=0.1092 ps=1.36 w=0.42 l=0.15
X2218 VGND v3_four_channel_output_load_integration_0/v3_four_channel_shared_support_integration_0/v3_four_channel_bias_reference_distribution_0/v3_four_channel_phase_distribution_0/v3_four_channel_output_collection_0/v3_four_channel_placement_0/v3_channel_selector_late_promotion_2/v3_selector_route_pilot_0/G3_LO_P_AND/B v3_four_channel_output_load_integration_0/v3_four_channel_shared_support_integration_0/v3_four_channel_bias_reference_distribution_0/v3_four_channel_phase_distribution_0/v3_four_channel_output_collection_0/v3_four_channel_placement_0/v3_channel_selector_late_promotion_2/v3_selector_route_pilot_0/G0_LO_N_ANDNOT/a_297_47# VGND sky130_fd_pr__nfet_01v8 ad=0 pd=0 as=0 ps=0 w=0.42 l=0.15
X2219 v3_four_channel_output_load_integration_0/v3_four_channel_shared_support_integration_0/v3_four_channel_bias_reference_distribution_0/v3_four_channel_phase_distribution_0/v3_four_channel_output_collection_0/v3_four_channel_placement_0/v3_channel_selector_late_promotion_2/v3_selector_route_pilot_0/G0_LO_N_ANDNOT/a_27_413# v3_four_channel_output_load_integration_0/v3_four_channel_shared_support_integration_0/v3_four_channel_bias_reference_distribution_0/v3_four_channel_phase_distribution_0/v3_four_channel_output_collection_0/v3_four_channel_placement_0/v3_channel_selector_late_promotion_2/v3_selector_route_pilot_0/G0_MUX_AXIS/X VGND VGND sky130_fd_pr__nfet_01v8 ad=0.1092 pd=1.36 as=0 ps=0 w=0.42 l=0.15
X2220 VDPWR v3_four_channel_output_load_integration_0/v3_four_channel_shared_support_integration_0/v3_four_channel_bias_reference_distribution_0/v3_four_channel_phase_distribution_0/v3_four_channel_output_collection_0/v3_four_channel_placement_0/v3_channel_selector_late_promotion_2/v3_selector_route_pilot_0/G1_MUX_AXIS/a_505_21# v3_four_channel_output_load_integration_0/v3_four_channel_shared_support_integration_0/v3_four_channel_bias_reference_distribution_0/v3_four_channel_phase_distribution_0/v3_four_channel_output_collection_0/v3_four_channel_placement_0/v3_channel_selector_late_promotion_2/v3_selector_route_pilot_0/G1_MUX_AXIS/a_535_374# VDPWR sky130_fd_pr__pfet_01v8_hvt ad=0 pd=0 as=0.0882 ps=1.26 w=0.42 l=0.15
X2221 v3_four_channel_output_load_integration_0/v3_four_channel_shared_support_integration_0/v3_four_channel_bias_reference_distribution_0/v3_four_channel_phase_distribution_0/v3_four_channel_output_collection_0/v3_four_channel_placement_0/v3_channel_selector_late_promotion_2/v3_selector_route_pilot_0/G1_MUX_AXIS/a_505_21# V3R208 VDPWR VDPWR sky130_fd_pr__pfet_01v8_hvt ad=0.1176 pd=1.4 as=0 ps=0 w=0.42 l=0.15
X2222 v3_four_channel_output_load_integration_0/v3_four_channel_shared_support_integration_0/v3_four_channel_bias_reference_distribution_0/v3_four_channel_phase_distribution_0/v3_four_channel_output_collection_0/v3_four_channel_placement_0/v3_channel_selector_late_promotion_2/v3_selector_route_pilot_0/G1_MUX_AXIS/a_218_374# V3R208 VDPWR VDPWR sky130_fd_pr__pfet_01v8_hvt ad=0.1533 pd=1.57 as=0 ps=0 w=0.42 l=0.15
X2223 VGND v3_four_channel_output_load_integration_0/v3_four_channel_shared_support_integration_0/v3_four_channel_bias_reference_distribution_0/v3_four_channel_phase_distribution_0/v3_four_channel_output_collection_0/v3_four_channel_placement_0/v3_channel_selector_late_promotion_2/v3_selector_route_pilot_0/G1_MUX_AXIS/a_505_21# v3_four_channel_output_load_integration_0/v3_four_channel_shared_support_integration_0/v3_four_channel_bias_reference_distribution_0/v3_four_channel_phase_distribution_0/v3_four_channel_output_collection_0/v3_four_channel_placement_0/v3_channel_selector_late_promotion_2/v3_selector_route_pilot_0/G1_MUX_AXIS/a_439_47# VGND sky130_fd_pr__nfet_01v8 ad=0 pd=0 as=0.1386 ps=1.5 w=0.42 l=0.15
X2224 v3_four_channel_output_load_integration_0/v3_four_channel_shared_support_integration_0/v3_four_channel_bias_reference_distribution_0/v3_four_channel_phase_distribution_0/v3_four_channel_output_collection_0/v3_four_channel_placement_0/v3_channel_selector_late_promotion_2/v3_selector_route_pilot_0/G1_MUX_AXIS/a_76_199# v3_four_channel_output_load_integration_0/v3_four_channel_shared_support_integration_0/v3_four_channel_bias_reference_distribution_0/v3_four_channel_phase_distribution_0/v3_four_channel_output_collection_0/v3_four_channel_placement_0/v3_channel_selector_late_promotion_2/v3_selector_route_pilot_0/G1_MUX_POS/X v3_four_channel_output_load_integration_0/v3_four_channel_shared_support_integration_0/v3_four_channel_bias_reference_distribution_0/v3_four_channel_phase_distribution_0/v3_four_channel_output_collection_0/v3_four_channel_placement_0/v3_channel_selector_late_promotion_2/v3_selector_route_pilot_0/G1_MUX_AXIS/a_218_374# VDPWR sky130_fd_pr__pfet_01v8_hvt ad=0.3864 pd=2.68 as=0 ps=0 w=0.42 l=0.15
X2225 v3_four_channel_output_load_integration_0/v3_four_channel_shared_support_integration_0/v3_four_channel_bias_reference_distribution_0/v3_four_channel_phase_distribution_0/v3_four_channel_output_collection_0/v3_four_channel_placement_0/v3_channel_selector_late_promotion_2/v3_selector_route_pilot_0/G1_MUX_AXIS/a_505_21# V3R208 VGND VGND sky130_fd_pr__nfet_01v8 ad=0.1092 pd=1.36 as=0 ps=0 w=0.42 l=0.15
X2226 v3_four_channel_output_load_integration_0/v3_four_channel_shared_support_integration_0/v3_four_channel_bias_reference_distribution_0/v3_four_channel_phase_distribution_0/v3_four_channel_output_collection_0/v3_four_channel_placement_0/v3_channel_selector_late_promotion_2/v3_selector_route_pilot_0/G1_MUX_AXIS/a_439_47# v3_four_channel_output_load_integration_0/v3_four_channel_shared_support_integration_0/v3_four_channel_bias_reference_distribution_0/v3_four_channel_phase_distribution_0/v3_four_channel_output_collection_0/v3_four_channel_placement_0/v3_channel_selector_late_promotion_2/v3_selector_route_pilot_0/G1_MUX_POS/X v3_four_channel_output_load_integration_0/v3_four_channel_shared_support_integration_0/v3_four_channel_bias_reference_distribution_0/v3_four_channel_phase_distribution_0/v3_four_channel_output_collection_0/v3_four_channel_placement_0/v3_channel_selector_late_promotion_2/v3_selector_route_pilot_0/G1_MUX_AXIS/a_76_199# VGND sky130_fd_pr__nfet_01v8 ad=0 pd=0 as=0.1995 ps=1.79 w=0.42 l=0.15
X2227 v3_four_channel_output_load_integration_0/v3_four_channel_shared_support_integration_0/v3_four_channel_bias_reference_distribution_0/v3_four_channel_phase_distribution_0/v3_four_channel_output_collection_0/v3_four_channel_placement_0/v3_channel_selector_late_promotion_2/v3_selector_route_pilot_0/G1_MUX_AXIS/a_535_374# v3_four_channel_output_load_integration_0/v3_four_channel_shared_support_integration_0/v3_four_channel_bias_reference_distribution_0/v3_four_channel_phase_distribution_0/v3_four_channel_output_collection_0/v3_four_channel_placement_0/v3_channel_selector_late_promotion_2/v3_selector_route_pilot_0/G1_MUX_NEG/X v3_four_channel_output_load_integration_0/v3_four_channel_shared_support_integration_0/v3_four_channel_bias_reference_distribution_0/v3_four_channel_phase_distribution_0/v3_four_channel_output_collection_0/v3_four_channel_placement_0/v3_channel_selector_late_promotion_2/v3_selector_route_pilot_0/G1_MUX_AXIS/a_76_199# VDPWR sky130_fd_pr__pfet_01v8_hvt ad=0 pd=0 as=0 ps=0 w=0.42 l=0.15
X2228 v3_four_channel_output_load_integration_0/v3_four_channel_shared_support_integration_0/v3_four_channel_bias_reference_distribution_0/v3_four_channel_phase_distribution_0/v3_four_channel_output_collection_0/v3_four_channel_placement_0/v3_channel_selector_late_promotion_2/v3_selector_route_pilot_0/G1_MUX_AXIS/a_76_199# v3_four_channel_output_load_integration_0/v3_four_channel_shared_support_integration_0/v3_four_channel_bias_reference_distribution_0/v3_four_channel_phase_distribution_0/v3_four_channel_output_collection_0/v3_four_channel_placement_0/v3_channel_selector_late_promotion_2/v3_selector_route_pilot_0/G1_MUX_NEG/X v3_four_channel_output_load_integration_0/v3_four_channel_shared_support_integration_0/v3_four_channel_bias_reference_distribution_0/v3_four_channel_phase_distribution_0/v3_four_channel_output_collection_0/v3_four_channel_placement_0/v3_channel_selector_late_promotion_2/v3_selector_route_pilot_0/G1_MUX_AXIS/a_218_47# VGND sky130_fd_pr__nfet_01v8 ad=0 pd=0 as=0.1386 ps=1.5 w=0.42 l=0.15
X2229 v3_four_channel_output_load_integration_0/v3_four_channel_shared_support_integration_0/v3_four_channel_bias_reference_distribution_0/v3_four_channel_phase_distribution_0/v3_four_channel_output_collection_0/v3_four_channel_placement_0/v3_channel_selector_late_promotion_2/v3_selector_route_pilot_0/G1_MUX_AXIS/a_218_47# V3R208 VGND VGND sky130_fd_pr__nfet_01v8 ad=0 pd=0 as=0 ps=0 w=0.42 l=0.15
X2230 VDPWR v3_four_channel_output_load_integration_0/v3_four_channel_shared_support_integration_0/v3_four_channel_bias_reference_distribution_0/v3_four_channel_phase_distribution_0/v3_four_channel_output_collection_0/v3_four_channel_placement_0/v3_channel_selector_late_promotion_2/v3_selector_route_pilot_0/G1_MUX_AXIS/a_76_199# v3_four_channel_output_load_integration_0/v3_four_channel_shared_support_integration_0/v3_four_channel_bias_reference_distribution_0/v3_four_channel_phase_distribution_0/v3_four_channel_output_collection_0/v3_four_channel_placement_0/v3_channel_selector_late_promotion_2/v3_selector_route_pilot_0/G1_MUX_AXIS/X VDPWR sky130_fd_pr__pfet_01v8_hvt ad=0 pd=0 as=0.26 ps=2.52 w=1 l=0.15
X2231 VGND v3_four_channel_output_load_integration_0/v3_four_channel_shared_support_integration_0/v3_four_channel_bias_reference_distribution_0/v3_four_channel_phase_distribution_0/v3_four_channel_output_collection_0/v3_four_channel_placement_0/v3_channel_selector_late_promotion_2/v3_selector_route_pilot_0/G1_MUX_AXIS/a_76_199# v3_four_channel_output_load_integration_0/v3_four_channel_shared_support_integration_0/v3_four_channel_bias_reference_distribution_0/v3_four_channel_phase_distribution_0/v3_four_channel_output_collection_0/v3_four_channel_placement_0/v3_channel_selector_late_promotion_2/v3_selector_route_pilot_0/G1_MUX_AXIS/X VGND sky130_fd_pr__nfet_01v8 ad=0 pd=0 as=0.169 ps=1.82 w=0.65 l=0.15
X2232 VDPWR v3_four_channel_output_load_integration_0/v3_four_channel_shared_support_integration_0/v3_four_channel_bias_reference_distribution_0/v3_four_channel_phase_distribution_0/v3_four_channel_output_collection_0/v3_four_channel_placement_0/v3_channel_selector_late_promotion_2/v3_selector_route_pilot_0/G3_LO_P_AND/B v3_four_channel_output_load_integration_0/v3_four_channel_shared_support_integration_0/v3_four_channel_bias_reference_distribution_0/v3_four_channel_phase_distribution_0/v3_four_channel_output_collection_0/v3_four_channel_placement_0/v3_channel_selector_late_promotion_2/v3_selector_route_pilot_0/G1_LO_N_ANDNOT/a_207_413# VDPWR sky130_fd_pr__pfet_01v8_hvt ad=0 pd=0 as=0.1218 ps=1.42 w=0.42 l=0.15
X2233 v3_four_channel_output_load_integration_0/v3_four_channel_shared_support_integration_0/v3_four_channel_bias_reference_distribution_0/v3_four_channel_phase_distribution_0/v3_four_channel_output_collection_0/v3_four_channel_placement_0/v3_channel_selector_late_promotion_2/v3_selector_route_pilot_0/group1_lo_n v3_four_channel_output_load_integration_0/v3_four_channel_shared_support_integration_0/v3_four_channel_bias_reference_distribution_0/v3_four_channel_phase_distribution_0/v3_four_channel_output_collection_0/v3_four_channel_placement_0/v3_channel_selector_late_promotion_2/v3_selector_route_pilot_0/G1_LO_N_ANDNOT/a_207_413# VDPWR VDPWR sky130_fd_pr__pfet_01v8_hvt ad=0.26 pd=2.52 as=0 ps=0 w=1 l=0.15
X2234 v3_four_channel_output_load_integration_0/v3_four_channel_shared_support_integration_0/v3_four_channel_bias_reference_distribution_0/v3_four_channel_phase_distribution_0/v3_four_channel_output_collection_0/v3_four_channel_placement_0/v3_channel_selector_late_promotion_2/v3_selector_route_pilot_0/G1_LO_N_ANDNOT/a_297_47# v3_four_channel_output_load_integration_0/v3_four_channel_shared_support_integration_0/v3_four_channel_bias_reference_distribution_0/v3_four_channel_phase_distribution_0/v3_four_channel_output_collection_0/v3_four_channel_placement_0/v3_channel_selector_late_promotion_2/v3_selector_route_pilot_0/G1_LO_N_ANDNOT/a_27_413# v3_four_channel_output_load_integration_0/v3_four_channel_shared_support_integration_0/v3_four_channel_bias_reference_distribution_0/v3_four_channel_phase_distribution_0/v3_four_channel_output_collection_0/v3_four_channel_placement_0/v3_channel_selector_late_promotion_2/v3_selector_route_pilot_0/G1_LO_N_ANDNOT/a_207_413# VGND sky130_fd_pr__nfet_01v8 ad=0.1008 pd=1.32 as=0.1092 ps=1.36 w=0.42 l=0.15
X2235 v3_four_channel_output_load_integration_0/v3_four_channel_shared_support_integration_0/v3_four_channel_bias_reference_distribution_0/v3_four_channel_phase_distribution_0/v3_four_channel_output_collection_0/v3_four_channel_placement_0/v3_channel_selector_late_promotion_2/v3_selector_route_pilot_0/group1_lo_n v3_four_channel_output_load_integration_0/v3_four_channel_shared_support_integration_0/v3_four_channel_bias_reference_distribution_0/v3_four_channel_phase_distribution_0/v3_four_channel_output_collection_0/v3_four_channel_placement_0/v3_channel_selector_late_promotion_2/v3_selector_route_pilot_0/G1_LO_N_ANDNOT/a_207_413# VGND VGND sky130_fd_pr__nfet_01v8 ad=0.169 pd=1.82 as=0 ps=0 w=0.65 l=0.15
X2236 v3_four_channel_output_load_integration_0/v3_four_channel_shared_support_integration_0/v3_four_channel_bias_reference_distribution_0/v3_four_channel_phase_distribution_0/v3_four_channel_output_collection_0/v3_four_channel_placement_0/v3_channel_selector_late_promotion_2/v3_selector_route_pilot_0/G1_LO_N_ANDNOT/a_207_413# v3_four_channel_output_load_integration_0/v3_four_channel_shared_support_integration_0/v3_four_channel_bias_reference_distribution_0/v3_four_channel_phase_distribution_0/v3_four_channel_output_collection_0/v3_four_channel_placement_0/v3_channel_selector_late_promotion_2/v3_selector_route_pilot_0/G1_LO_N_ANDNOT/a_27_413# VDPWR VDPWR sky130_fd_pr__pfet_01v8_hvt ad=0 pd=0 as=0 ps=0 w=0.42 l=0.15
X2237 VDPWR v3_four_channel_output_load_integration_0/v3_four_channel_shared_support_integration_0/v3_four_channel_bias_reference_distribution_0/v3_four_channel_phase_distribution_0/v3_four_channel_output_collection_0/v3_four_channel_placement_0/v3_channel_selector_late_promotion_2/v3_selector_route_pilot_0/G1_MUX_AXIS/X v3_four_channel_output_load_integration_0/v3_four_channel_shared_support_integration_0/v3_four_channel_bias_reference_distribution_0/v3_four_channel_phase_distribution_0/v3_four_channel_output_collection_0/v3_four_channel_placement_0/v3_channel_selector_late_promotion_2/v3_selector_route_pilot_0/G1_LO_N_ANDNOT/a_27_413# VDPWR sky130_fd_pr__pfet_01v8_hvt ad=0 pd=0 as=0.1092 ps=1.36 w=0.42 l=0.15
X2238 VGND v3_four_channel_output_load_integration_0/v3_four_channel_shared_support_integration_0/v3_four_channel_bias_reference_distribution_0/v3_four_channel_phase_distribution_0/v3_four_channel_output_collection_0/v3_four_channel_placement_0/v3_channel_selector_late_promotion_2/v3_selector_route_pilot_0/G3_LO_P_AND/B v3_four_channel_output_load_integration_0/v3_four_channel_shared_support_integration_0/v3_four_channel_bias_reference_distribution_0/v3_four_channel_phase_distribution_0/v3_four_channel_output_collection_0/v3_four_channel_placement_0/v3_channel_selector_late_promotion_2/v3_selector_route_pilot_0/G1_LO_N_ANDNOT/a_297_47# VGND sky130_fd_pr__nfet_01v8 ad=0 pd=0 as=0 ps=0 w=0.42 l=0.15
X2239 v3_four_channel_output_load_integration_0/v3_four_channel_shared_support_integration_0/v3_four_channel_bias_reference_distribution_0/v3_four_channel_phase_distribution_0/v3_four_channel_output_collection_0/v3_four_channel_placement_0/v3_channel_selector_late_promotion_2/v3_selector_route_pilot_0/G1_LO_N_ANDNOT/a_27_413# v3_four_channel_output_load_integration_0/v3_four_channel_shared_support_integration_0/v3_four_channel_bias_reference_distribution_0/v3_four_channel_phase_distribution_0/v3_four_channel_output_collection_0/v3_four_channel_placement_0/v3_channel_selector_late_promotion_2/v3_selector_route_pilot_0/G1_MUX_AXIS/X VGND VGND sky130_fd_pr__nfet_01v8 ad=0.1092 pd=1.36 as=0 ps=0 w=0.42 l=0.15
X2240 VDPWR v3_four_channel_output_load_integration_0/v3_four_channel_shared_support_integration_0/v3_four_channel_bias_reference_distribution_0/v3_four_channel_phase_distribution_0/v3_four_channel_output_collection_0/v3_four_channel_placement_0/v3_channel_selector_late_promotion_2/v3_selector_route_pilot_0/G3_LO_P_AND/B v3_four_channel_output_load_integration_0/v3_four_channel_shared_support_integration_0/v3_four_channel_bias_reference_distribution_0/v3_four_channel_phase_distribution_0/v3_four_channel_output_collection_0/v3_four_channel_placement_0/v3_channel_selector_late_promotion_2/v3_selector_route_pilot_0/G3_LO_P_AND/a_59_75# VDPWR sky130_fd_pr__pfet_01v8_hvt ad=0 pd=0 as=0.1134 ps=1.38 w=0.42 l=0.15
X2241 v3_four_channel_output_load_integration_0/v3_four_channel_shared_support_integration_0/v3_four_channel_bias_reference_distribution_0/v3_four_channel_phase_distribution_0/v3_four_channel_output_collection_0/v3_four_channel_placement_0/v3_channel_selector_late_promotion_2/v3_selector_route_pilot_0/group3_lo_p v3_four_channel_output_load_integration_0/v3_four_channel_shared_support_integration_0/v3_four_channel_bias_reference_distribution_0/v3_four_channel_phase_distribution_0/v3_four_channel_output_collection_0/v3_four_channel_placement_0/v3_channel_selector_late_promotion_2/v3_selector_route_pilot_0/G3_LO_P_AND/a_59_75# VDPWR VDPWR sky130_fd_pr__pfet_01v8_hvt ad=0.475 pd=2.95 as=0 ps=0 w=1 l=0.15
X2242 VGND v3_four_channel_output_load_integration_0/v3_four_channel_shared_support_integration_0/v3_four_channel_bias_reference_distribution_0/v3_four_channel_phase_distribution_0/v3_four_channel_output_collection_0/v3_four_channel_placement_0/v3_channel_selector_late_promotion_2/v3_selector_route_pilot_0/G3_LO_P_AND/B v3_four_channel_output_load_integration_0/v3_four_channel_shared_support_integration_0/v3_four_channel_bias_reference_distribution_0/v3_four_channel_phase_distribution_0/v3_four_channel_output_collection_0/v3_four_channel_placement_0/v3_channel_selector_late_promotion_2/v3_selector_route_pilot_0/G3_LO_P_AND/a_145_75# VGND sky130_fd_pr__nfet_01v8 ad=0 pd=0 as=0.1134 ps=1.38 w=0.42 l=0.15
X2243 v3_four_channel_output_load_integration_0/v3_four_channel_shared_support_integration_0/v3_four_channel_bias_reference_distribution_0/v3_four_channel_phase_distribution_0/v3_four_channel_output_collection_0/v3_four_channel_placement_0/v3_channel_selector_late_promotion_2/v3_selector_route_pilot_0/G3_LO_P_AND/a_59_75# v3_four_channel_output_load_integration_0/v3_four_channel_shared_support_integration_0/v3_four_channel_bias_reference_distribution_0/v3_four_channel_phase_distribution_0/v3_four_channel_output_collection_0/v3_four_channel_placement_0/v3_channel_selector_late_promotion_2/v3_selector_route_pilot_0/G3_MUX_AXIS/X VDPWR VDPWR sky130_fd_pr__pfet_01v8_hvt ad=0 pd=0 as=0 ps=0 w=0.42 l=0.15
X2244 v3_four_channel_output_load_integration_0/v3_four_channel_shared_support_integration_0/v3_four_channel_bias_reference_distribution_0/v3_four_channel_phase_distribution_0/v3_four_channel_output_collection_0/v3_four_channel_placement_0/v3_channel_selector_late_promotion_2/v3_selector_route_pilot_0/group3_lo_p v3_four_channel_output_load_integration_0/v3_four_channel_shared_support_integration_0/v3_four_channel_bias_reference_distribution_0/v3_four_channel_phase_distribution_0/v3_four_channel_output_collection_0/v3_four_channel_placement_0/v3_channel_selector_late_promotion_2/v3_selector_route_pilot_0/G3_LO_P_AND/a_59_75# VGND VGND sky130_fd_pr__nfet_01v8 ad=0.182 pd=1.86 as=0 ps=0 w=0.65 l=0.15
X2245 v3_four_channel_output_load_integration_0/v3_four_channel_shared_support_integration_0/v3_four_channel_bias_reference_distribution_0/v3_four_channel_phase_distribution_0/v3_four_channel_output_collection_0/v3_four_channel_placement_0/v3_channel_selector_late_promotion_2/v3_selector_route_pilot_0/G3_LO_P_AND/a_145_75# v3_four_channel_output_load_integration_0/v3_four_channel_shared_support_integration_0/v3_four_channel_bias_reference_distribution_0/v3_four_channel_phase_distribution_0/v3_four_channel_output_collection_0/v3_four_channel_placement_0/v3_channel_selector_late_promotion_2/v3_selector_route_pilot_0/G3_MUX_AXIS/X v3_four_channel_output_load_integration_0/v3_four_channel_shared_support_integration_0/v3_four_channel_bias_reference_distribution_0/v3_four_channel_phase_distribution_0/v3_four_channel_output_collection_0/v3_four_channel_placement_0/v3_channel_selector_late_promotion_2/v3_selector_route_pilot_0/G3_LO_P_AND/a_59_75# VGND sky130_fd_pr__nfet_01v8 ad=0 pd=0 as=0.1176 ps=1.4 w=0.42 l=0.15
X2246 VDPWR v3_four_channel_output_load_integration_0/v3_four_channel_shared_support_integration_0/v3_four_channel_bias_reference_distribution_0/v3_four_channel_phase_distribution_0/v3_four_channel_output_collection_0/v3_four_channel_placement_0/v3_channel_selector_late_promotion_2/v3_selector_route_pilot_0/G2_MUX_POS/a_505_21# v3_four_channel_output_load_integration_0/v3_four_channel_shared_support_integration_0/v3_four_channel_bias_reference_distribution_0/v3_four_channel_phase_distribution_0/v3_four_channel_output_collection_0/v3_four_channel_placement_0/v3_channel_selector_late_promotion_2/v3_selector_route_pilot_0/G2_MUX_POS/a_535_374# VDPWR sky130_fd_pr__pfet_01v8_hvt ad=0 pd=0 as=0.0882 ps=1.26 w=0.42 l=0.15
X2247 v3_four_channel_output_load_integration_0/v3_four_channel_shared_support_integration_0/v3_four_channel_bias_reference_distribution_0/v3_four_channel_phase_distribution_0/v3_four_channel_output_collection_0/v3_four_channel_placement_0/v3_channel_selector_late_promotion_2/v3_selector_route_pilot_0/G2_MUX_POS/a_505_21# V3R209 VDPWR VDPWR sky130_fd_pr__pfet_01v8_hvt ad=0.1176 pd=1.4 as=0 ps=0 w=0.42 l=0.15
X2248 v3_four_channel_output_load_integration_0/v3_four_channel_shared_support_integration_0/v3_four_channel_bias_reference_distribution_0/v3_four_channel_phase_distribution_0/v3_four_channel_output_collection_0/v3_four_channel_placement_0/v3_channel_selector_late_promotion_2/v3_selector_route_pilot_0/G2_MUX_POS/a_218_374# V3R209 VDPWR VDPWR sky130_fd_pr__pfet_01v8_hvt ad=0.1533 pd=1.57 as=0 ps=0 w=0.42 l=0.15
X2249 VGND v3_four_channel_output_load_integration_0/v3_four_channel_shared_support_integration_0/v3_four_channel_bias_reference_distribution_0/v3_four_channel_phase_distribution_0/v3_four_channel_output_collection_0/v3_four_channel_placement_0/v3_channel_selector_late_promotion_2/v3_selector_route_pilot_0/G2_MUX_POS/a_505_21# v3_four_channel_output_load_integration_0/v3_four_channel_shared_support_integration_0/v3_four_channel_bias_reference_distribution_0/v3_four_channel_phase_distribution_0/v3_four_channel_output_collection_0/v3_four_channel_placement_0/v3_channel_selector_late_promotion_2/v3_selector_route_pilot_0/G2_MUX_POS/a_439_47# VGND sky130_fd_pr__nfet_01v8 ad=0 pd=0 as=0.1386 ps=1.5 w=0.42 l=0.15
X2250 v3_four_channel_output_load_integration_0/v3_four_channel_shared_support_integration_0/v3_four_channel_bias_reference_distribution_0/v3_four_channel_phase_distribution_0/v3_four_channel_output_collection_0/v3_four_channel_placement_0/v3_channel_selector_late_promotion_2/v3_selector_route_pilot_0/G2_MUX_POS/a_76_199# V3R290 v3_four_channel_output_load_integration_0/v3_four_channel_shared_support_integration_0/v3_four_channel_bias_reference_distribution_0/v3_four_channel_phase_distribution_0/v3_four_channel_output_collection_0/v3_four_channel_placement_0/v3_channel_selector_late_promotion_2/v3_selector_route_pilot_0/G2_MUX_POS/a_218_374# VDPWR sky130_fd_pr__pfet_01v8_hvt ad=0.3864 pd=2.68 as=0 ps=0 w=0.42 l=0.15
X2251 v3_four_channel_output_load_integration_0/v3_four_channel_shared_support_integration_0/v3_four_channel_bias_reference_distribution_0/v3_four_channel_phase_distribution_0/v3_four_channel_output_collection_0/v3_four_channel_placement_0/v3_channel_selector_late_promotion_2/v3_selector_route_pilot_0/G2_MUX_POS/a_505_21# V3R209 VGND VGND sky130_fd_pr__nfet_01v8 ad=0.1092 pd=1.36 as=0 ps=0 w=0.42 l=0.15
X2252 v3_four_channel_output_load_integration_0/v3_four_channel_shared_support_integration_0/v3_four_channel_bias_reference_distribution_0/v3_four_channel_phase_distribution_0/v3_four_channel_output_collection_0/v3_four_channel_placement_0/v3_channel_selector_late_promotion_2/v3_selector_route_pilot_0/G2_MUX_POS/a_439_47# V3R290 v3_four_channel_output_load_integration_0/v3_four_channel_shared_support_integration_0/v3_four_channel_bias_reference_distribution_0/v3_four_channel_phase_distribution_0/v3_four_channel_output_collection_0/v3_four_channel_placement_0/v3_channel_selector_late_promotion_2/v3_selector_route_pilot_0/G2_MUX_POS/a_76_199# VGND sky130_fd_pr__nfet_01v8 ad=0 pd=0 as=0.1995 ps=1.79 w=0.42 l=0.15
X2253 v3_four_channel_output_load_integration_0/v3_four_channel_shared_support_integration_0/v3_four_channel_bias_reference_distribution_0/v3_four_channel_phase_distribution_0/v3_four_channel_output_collection_0/v3_four_channel_placement_0/v3_channel_selector_late_promotion_2/v3_selector_route_pilot_0/G2_MUX_POS/a_535_374# V3R291 v3_four_channel_output_load_integration_0/v3_four_channel_shared_support_integration_0/v3_four_channel_bias_reference_distribution_0/v3_four_channel_phase_distribution_0/v3_four_channel_output_collection_0/v3_four_channel_placement_0/v3_channel_selector_late_promotion_2/v3_selector_route_pilot_0/G2_MUX_POS/a_76_199# VDPWR sky130_fd_pr__pfet_01v8_hvt ad=0 pd=0 as=0 ps=0 w=0.42 l=0.15
X2254 v3_four_channel_output_load_integration_0/v3_four_channel_shared_support_integration_0/v3_four_channel_bias_reference_distribution_0/v3_four_channel_phase_distribution_0/v3_four_channel_output_collection_0/v3_four_channel_placement_0/v3_channel_selector_late_promotion_2/v3_selector_route_pilot_0/G2_MUX_POS/a_76_199# V3R291 v3_four_channel_output_load_integration_0/v3_four_channel_shared_support_integration_0/v3_four_channel_bias_reference_distribution_0/v3_four_channel_phase_distribution_0/v3_four_channel_output_collection_0/v3_four_channel_placement_0/v3_channel_selector_late_promotion_2/v3_selector_route_pilot_0/G2_MUX_POS/a_218_47# VGND sky130_fd_pr__nfet_01v8 ad=0 pd=0 as=0.1386 ps=1.5 w=0.42 l=0.15
X2255 v3_four_channel_output_load_integration_0/v3_four_channel_shared_support_integration_0/v3_four_channel_bias_reference_distribution_0/v3_four_channel_phase_distribution_0/v3_four_channel_output_collection_0/v3_four_channel_placement_0/v3_channel_selector_late_promotion_2/v3_selector_route_pilot_0/G2_MUX_POS/a_218_47# V3R209 VGND VGND sky130_fd_pr__nfet_01v8 ad=0 pd=0 as=0 ps=0 w=0.42 l=0.15
X2256 VDPWR v3_four_channel_output_load_integration_0/v3_four_channel_shared_support_integration_0/v3_four_channel_bias_reference_distribution_0/v3_four_channel_phase_distribution_0/v3_four_channel_output_collection_0/v3_four_channel_placement_0/v3_channel_selector_late_promotion_2/v3_selector_route_pilot_0/G2_MUX_POS/a_76_199# v3_four_channel_output_load_integration_0/v3_four_channel_shared_support_integration_0/v3_four_channel_bias_reference_distribution_0/v3_four_channel_phase_distribution_0/v3_four_channel_output_collection_0/v3_four_channel_placement_0/v3_channel_selector_late_promotion_2/v3_selector_route_pilot_0/G2_MUX_POS/X VDPWR sky130_fd_pr__pfet_01v8_hvt ad=0 pd=0 as=0.26 ps=2.52 w=1 l=0.15
X2257 VGND v3_four_channel_output_load_integration_0/v3_four_channel_shared_support_integration_0/v3_four_channel_bias_reference_distribution_0/v3_four_channel_phase_distribution_0/v3_four_channel_output_collection_0/v3_four_channel_placement_0/v3_channel_selector_late_promotion_2/v3_selector_route_pilot_0/G2_MUX_POS/a_76_199# v3_four_channel_output_load_integration_0/v3_four_channel_shared_support_integration_0/v3_four_channel_bias_reference_distribution_0/v3_four_channel_phase_distribution_0/v3_four_channel_output_collection_0/v3_four_channel_placement_0/v3_channel_selector_late_promotion_2/v3_selector_route_pilot_0/G2_MUX_POS/X VGND sky130_fd_pr__nfet_01v8 ad=0 pd=0 as=0.169 ps=1.82 w=0.65 l=0.15
X2258 VDPWR v3_four_channel_output_load_integration_0/v3_four_channel_shared_support_integration_0/v3_four_channel_bias_reference_distribution_0/v3_four_channel_phase_distribution_0/v3_four_channel_output_collection_0/v3_four_channel_placement_0/v3_channel_selector_late_promotion_2/v3_selector_route_pilot_0/G2_MUX_NEG/a_505_21# v3_four_channel_output_load_integration_0/v3_four_channel_shared_support_integration_0/v3_four_channel_bias_reference_distribution_0/v3_four_channel_phase_distribution_0/v3_four_channel_output_collection_0/v3_four_channel_placement_0/v3_channel_selector_late_promotion_2/v3_selector_route_pilot_0/G2_MUX_NEG/a_535_374# VDPWR sky130_fd_pr__pfet_01v8_hvt ad=0 pd=0 as=0.0882 ps=1.26 w=0.42 l=0.15
X2259 v3_four_channel_output_load_integration_0/v3_four_channel_shared_support_integration_0/v3_four_channel_bias_reference_distribution_0/v3_four_channel_phase_distribution_0/v3_four_channel_output_collection_0/v3_four_channel_placement_0/v3_channel_selector_late_promotion_2/v3_selector_route_pilot_0/G2_MUX_NEG/a_505_21# V3R209 VDPWR VDPWR sky130_fd_pr__pfet_01v8_hvt ad=0.1176 pd=1.4 as=0 ps=0 w=0.42 l=0.15
X2260 v3_four_channel_output_load_integration_0/v3_four_channel_shared_support_integration_0/v3_four_channel_bias_reference_distribution_0/v3_four_channel_phase_distribution_0/v3_four_channel_output_collection_0/v3_four_channel_placement_0/v3_channel_selector_late_promotion_2/v3_selector_route_pilot_0/G2_MUX_NEG/a_218_374# V3R209 VDPWR VDPWR sky130_fd_pr__pfet_01v8_hvt ad=0.1533 pd=1.57 as=0 ps=0 w=0.42 l=0.15
X2261 VGND v3_four_channel_output_load_integration_0/v3_four_channel_shared_support_integration_0/v3_four_channel_bias_reference_distribution_0/v3_four_channel_phase_distribution_0/v3_four_channel_output_collection_0/v3_four_channel_placement_0/v3_channel_selector_late_promotion_2/v3_selector_route_pilot_0/G2_MUX_NEG/a_505_21# v3_four_channel_output_load_integration_0/v3_four_channel_shared_support_integration_0/v3_four_channel_bias_reference_distribution_0/v3_four_channel_phase_distribution_0/v3_four_channel_output_collection_0/v3_four_channel_placement_0/v3_channel_selector_late_promotion_2/v3_selector_route_pilot_0/G2_MUX_NEG/a_439_47# VGND sky130_fd_pr__nfet_01v8 ad=0 pd=0 as=0.1386 ps=1.5 w=0.42 l=0.15
X2262 v3_four_channel_output_load_integration_0/v3_four_channel_shared_support_integration_0/v3_four_channel_bias_reference_distribution_0/v3_four_channel_phase_distribution_0/v3_four_channel_output_collection_0/v3_four_channel_placement_0/v3_channel_selector_late_promotion_2/v3_selector_route_pilot_0/G2_MUX_NEG/a_76_199# V3R292 v3_four_channel_output_load_integration_0/v3_four_channel_shared_support_integration_0/v3_four_channel_bias_reference_distribution_0/v3_four_channel_phase_distribution_0/v3_four_channel_output_collection_0/v3_four_channel_placement_0/v3_channel_selector_late_promotion_2/v3_selector_route_pilot_0/G2_MUX_NEG/a_218_374# VDPWR sky130_fd_pr__pfet_01v8_hvt ad=0.3864 pd=2.68 as=0 ps=0 w=0.42 l=0.15
X2263 v3_four_channel_output_load_integration_0/v3_four_channel_shared_support_integration_0/v3_four_channel_bias_reference_distribution_0/v3_four_channel_phase_distribution_0/v3_four_channel_output_collection_0/v3_four_channel_placement_0/v3_channel_selector_late_promotion_2/v3_selector_route_pilot_0/G2_MUX_NEG/a_505_21# V3R209 VGND VGND sky130_fd_pr__nfet_01v8 ad=0.1092 pd=1.36 as=0 ps=0 w=0.42 l=0.15
X2264 v3_four_channel_output_load_integration_0/v3_four_channel_shared_support_integration_0/v3_four_channel_bias_reference_distribution_0/v3_four_channel_phase_distribution_0/v3_four_channel_output_collection_0/v3_four_channel_placement_0/v3_channel_selector_late_promotion_2/v3_selector_route_pilot_0/G2_MUX_NEG/a_439_47# V3R292 v3_four_channel_output_load_integration_0/v3_four_channel_shared_support_integration_0/v3_four_channel_bias_reference_distribution_0/v3_four_channel_phase_distribution_0/v3_four_channel_output_collection_0/v3_four_channel_placement_0/v3_channel_selector_late_promotion_2/v3_selector_route_pilot_0/G2_MUX_NEG/a_76_199# VGND sky130_fd_pr__nfet_01v8 ad=0 pd=0 as=0.1995 ps=1.79 w=0.42 l=0.15
X2265 v3_four_channel_output_load_integration_0/v3_four_channel_shared_support_integration_0/v3_four_channel_bias_reference_distribution_0/v3_four_channel_phase_distribution_0/v3_four_channel_output_collection_0/v3_four_channel_placement_0/v3_channel_selector_late_promotion_2/v3_selector_route_pilot_0/G2_MUX_NEG/a_535_374# V3R293 v3_four_channel_output_load_integration_0/v3_four_channel_shared_support_integration_0/v3_four_channel_bias_reference_distribution_0/v3_four_channel_phase_distribution_0/v3_four_channel_output_collection_0/v3_four_channel_placement_0/v3_channel_selector_late_promotion_2/v3_selector_route_pilot_0/G2_MUX_NEG/a_76_199# VDPWR sky130_fd_pr__pfet_01v8_hvt ad=0 pd=0 as=0 ps=0 w=0.42 l=0.15
X2266 v3_four_channel_output_load_integration_0/v3_four_channel_shared_support_integration_0/v3_four_channel_bias_reference_distribution_0/v3_four_channel_phase_distribution_0/v3_four_channel_output_collection_0/v3_four_channel_placement_0/v3_channel_selector_late_promotion_2/v3_selector_route_pilot_0/G2_MUX_NEG/a_76_199# V3R293 v3_four_channel_output_load_integration_0/v3_four_channel_shared_support_integration_0/v3_four_channel_bias_reference_distribution_0/v3_four_channel_phase_distribution_0/v3_four_channel_output_collection_0/v3_four_channel_placement_0/v3_channel_selector_late_promotion_2/v3_selector_route_pilot_0/G2_MUX_NEG/a_218_47# VGND sky130_fd_pr__nfet_01v8 ad=0 pd=0 as=0.1386 ps=1.5 w=0.42 l=0.15
X2267 v3_four_channel_output_load_integration_0/v3_four_channel_shared_support_integration_0/v3_four_channel_bias_reference_distribution_0/v3_four_channel_phase_distribution_0/v3_four_channel_output_collection_0/v3_four_channel_placement_0/v3_channel_selector_late_promotion_2/v3_selector_route_pilot_0/G2_MUX_NEG/a_218_47# V3R209 VGND VGND sky130_fd_pr__nfet_01v8 ad=0 pd=0 as=0 ps=0 w=0.42 l=0.15
X2268 VDPWR v3_four_channel_output_load_integration_0/v3_four_channel_shared_support_integration_0/v3_four_channel_bias_reference_distribution_0/v3_four_channel_phase_distribution_0/v3_four_channel_output_collection_0/v3_four_channel_placement_0/v3_channel_selector_late_promotion_2/v3_selector_route_pilot_0/G2_MUX_NEG/a_76_199# v3_four_channel_output_load_integration_0/v3_four_channel_shared_support_integration_0/v3_four_channel_bias_reference_distribution_0/v3_four_channel_phase_distribution_0/v3_four_channel_output_collection_0/v3_four_channel_placement_0/v3_channel_selector_late_promotion_2/v3_selector_route_pilot_0/G2_MUX_NEG/X VDPWR sky130_fd_pr__pfet_01v8_hvt ad=0 pd=0 as=0.26 ps=2.52 w=1 l=0.15
X2269 VGND v3_four_channel_output_load_integration_0/v3_four_channel_shared_support_integration_0/v3_four_channel_bias_reference_distribution_0/v3_four_channel_phase_distribution_0/v3_four_channel_output_collection_0/v3_four_channel_placement_0/v3_channel_selector_late_promotion_2/v3_selector_route_pilot_0/G2_MUX_NEG/a_76_199# v3_four_channel_output_load_integration_0/v3_four_channel_shared_support_integration_0/v3_four_channel_bias_reference_distribution_0/v3_four_channel_phase_distribution_0/v3_four_channel_output_collection_0/v3_four_channel_placement_0/v3_channel_selector_late_promotion_2/v3_selector_route_pilot_0/G2_MUX_NEG/X VGND sky130_fd_pr__nfet_01v8 ad=0 pd=0 as=0.169 ps=1.82 w=0.65 l=0.15
X2270 VDPWR v3_four_channel_output_load_integration_0/v3_four_channel_shared_support_integration_0/v3_four_channel_bias_reference_distribution_0/v3_four_channel_phase_distribution_0/v3_four_channel_output_collection_0/v3_four_channel_placement_0/v3_channel_selector_late_promotion_2/v3_selector_route_pilot_0/G0_MUX_AXIS/a_505_21# v3_four_channel_output_load_integration_0/v3_four_channel_shared_support_integration_0/v3_four_channel_bias_reference_distribution_0/v3_four_channel_phase_distribution_0/v3_four_channel_output_collection_0/v3_four_channel_placement_0/v3_channel_selector_late_promotion_2/v3_selector_route_pilot_0/G0_MUX_AXIS/a_535_374# VDPWR sky130_fd_pr__pfet_01v8_hvt ad=0 pd=0 as=0.0882 ps=1.26 w=0.42 l=0.15
X2271 v3_four_channel_output_load_integration_0/v3_four_channel_shared_support_integration_0/v3_four_channel_bias_reference_distribution_0/v3_four_channel_phase_distribution_0/v3_four_channel_output_collection_0/v3_four_channel_placement_0/v3_channel_selector_late_promotion_2/v3_selector_route_pilot_0/G0_MUX_AXIS/a_505_21# V3R237 VDPWR VDPWR sky130_fd_pr__pfet_01v8_hvt ad=0.1176 pd=1.4 as=0 ps=0 w=0.42 l=0.15
X2272 v3_four_channel_output_load_integration_0/v3_four_channel_shared_support_integration_0/v3_four_channel_bias_reference_distribution_0/v3_four_channel_phase_distribution_0/v3_four_channel_output_collection_0/v3_four_channel_placement_0/v3_channel_selector_late_promotion_2/v3_selector_route_pilot_0/G0_MUX_AXIS/a_218_374# V3R237 VDPWR VDPWR sky130_fd_pr__pfet_01v8_hvt ad=0.1533 pd=1.57 as=0 ps=0 w=0.42 l=0.15
X2273 VGND v3_four_channel_output_load_integration_0/v3_four_channel_shared_support_integration_0/v3_four_channel_bias_reference_distribution_0/v3_four_channel_phase_distribution_0/v3_four_channel_output_collection_0/v3_four_channel_placement_0/v3_channel_selector_late_promotion_2/v3_selector_route_pilot_0/G0_MUX_AXIS/a_505_21# v3_four_channel_output_load_integration_0/v3_four_channel_shared_support_integration_0/v3_four_channel_bias_reference_distribution_0/v3_four_channel_phase_distribution_0/v3_four_channel_output_collection_0/v3_four_channel_placement_0/v3_channel_selector_late_promotion_2/v3_selector_route_pilot_0/G0_MUX_AXIS/a_439_47# VGND sky130_fd_pr__nfet_01v8 ad=0 pd=0 as=0.1386 ps=1.5 w=0.42 l=0.15
X2274 v3_four_channel_output_load_integration_0/v3_four_channel_shared_support_integration_0/v3_four_channel_bias_reference_distribution_0/v3_four_channel_phase_distribution_0/v3_four_channel_output_collection_0/v3_four_channel_placement_0/v3_channel_selector_late_promotion_2/v3_selector_route_pilot_0/G0_MUX_AXIS/a_76_199# v3_four_channel_output_load_integration_0/v3_four_channel_shared_support_integration_0/v3_four_channel_bias_reference_distribution_0/v3_four_channel_phase_distribution_0/v3_four_channel_output_collection_0/v3_four_channel_placement_0/v3_channel_selector_late_promotion_2/v3_selector_route_pilot_0/G0_MUX_POS/X v3_four_channel_output_load_integration_0/v3_four_channel_shared_support_integration_0/v3_four_channel_bias_reference_distribution_0/v3_four_channel_phase_distribution_0/v3_four_channel_output_collection_0/v3_four_channel_placement_0/v3_channel_selector_late_promotion_2/v3_selector_route_pilot_0/G0_MUX_AXIS/a_218_374# VDPWR sky130_fd_pr__pfet_01v8_hvt ad=0.3864 pd=2.68 as=0 ps=0 w=0.42 l=0.15
X2275 v3_four_channel_output_load_integration_0/v3_four_channel_shared_support_integration_0/v3_four_channel_bias_reference_distribution_0/v3_four_channel_phase_distribution_0/v3_four_channel_output_collection_0/v3_four_channel_placement_0/v3_channel_selector_late_promotion_2/v3_selector_route_pilot_0/G0_MUX_AXIS/a_505_21# V3R237 VGND VGND sky130_fd_pr__nfet_01v8 ad=0.1092 pd=1.36 as=0 ps=0 w=0.42 l=0.15
X2276 v3_four_channel_output_load_integration_0/v3_four_channel_shared_support_integration_0/v3_four_channel_bias_reference_distribution_0/v3_four_channel_phase_distribution_0/v3_four_channel_output_collection_0/v3_four_channel_placement_0/v3_channel_selector_late_promotion_2/v3_selector_route_pilot_0/G0_MUX_AXIS/a_439_47# v3_four_channel_output_load_integration_0/v3_four_channel_shared_support_integration_0/v3_four_channel_bias_reference_distribution_0/v3_four_channel_phase_distribution_0/v3_four_channel_output_collection_0/v3_four_channel_placement_0/v3_channel_selector_late_promotion_2/v3_selector_route_pilot_0/G0_MUX_POS/X v3_four_channel_output_load_integration_0/v3_four_channel_shared_support_integration_0/v3_four_channel_bias_reference_distribution_0/v3_four_channel_phase_distribution_0/v3_four_channel_output_collection_0/v3_four_channel_placement_0/v3_channel_selector_late_promotion_2/v3_selector_route_pilot_0/G0_MUX_AXIS/a_76_199# VGND sky130_fd_pr__nfet_01v8 ad=0 pd=0 as=0.1995 ps=1.79 w=0.42 l=0.15
X2277 v3_four_channel_output_load_integration_0/v3_four_channel_shared_support_integration_0/v3_four_channel_bias_reference_distribution_0/v3_four_channel_phase_distribution_0/v3_four_channel_output_collection_0/v3_four_channel_placement_0/v3_channel_selector_late_promotion_2/v3_selector_route_pilot_0/G0_MUX_AXIS/a_535_374# v3_four_channel_output_load_integration_0/v3_four_channel_shared_support_integration_0/v3_four_channel_bias_reference_distribution_0/v3_four_channel_phase_distribution_0/v3_four_channel_output_collection_0/v3_four_channel_placement_0/v3_channel_selector_late_promotion_2/v3_selector_route_pilot_0/G0_MUX_NEG/X v3_four_channel_output_load_integration_0/v3_four_channel_shared_support_integration_0/v3_four_channel_bias_reference_distribution_0/v3_four_channel_phase_distribution_0/v3_four_channel_output_collection_0/v3_four_channel_placement_0/v3_channel_selector_late_promotion_2/v3_selector_route_pilot_0/G0_MUX_AXIS/a_76_199# VDPWR sky130_fd_pr__pfet_01v8_hvt ad=0 pd=0 as=0 ps=0 w=0.42 l=0.15
X2278 v3_four_channel_output_load_integration_0/v3_four_channel_shared_support_integration_0/v3_four_channel_bias_reference_distribution_0/v3_four_channel_phase_distribution_0/v3_four_channel_output_collection_0/v3_four_channel_placement_0/v3_channel_selector_late_promotion_2/v3_selector_route_pilot_0/G0_MUX_AXIS/a_76_199# v3_four_channel_output_load_integration_0/v3_four_channel_shared_support_integration_0/v3_four_channel_bias_reference_distribution_0/v3_four_channel_phase_distribution_0/v3_four_channel_output_collection_0/v3_four_channel_placement_0/v3_channel_selector_late_promotion_2/v3_selector_route_pilot_0/G0_MUX_NEG/X v3_four_channel_output_load_integration_0/v3_four_channel_shared_support_integration_0/v3_four_channel_bias_reference_distribution_0/v3_four_channel_phase_distribution_0/v3_four_channel_output_collection_0/v3_four_channel_placement_0/v3_channel_selector_late_promotion_2/v3_selector_route_pilot_0/G0_MUX_AXIS/a_218_47# VGND sky130_fd_pr__nfet_01v8 ad=0 pd=0 as=0.1386 ps=1.5 w=0.42 l=0.15
X2279 v3_four_channel_output_load_integration_0/v3_four_channel_shared_support_integration_0/v3_four_channel_bias_reference_distribution_0/v3_four_channel_phase_distribution_0/v3_four_channel_output_collection_0/v3_four_channel_placement_0/v3_channel_selector_late_promotion_2/v3_selector_route_pilot_0/G0_MUX_AXIS/a_218_47# V3R237 VGND VGND sky130_fd_pr__nfet_01v8 ad=0 pd=0 as=0 ps=0 w=0.42 l=0.15
X2280 VDPWR v3_four_channel_output_load_integration_0/v3_four_channel_shared_support_integration_0/v3_four_channel_bias_reference_distribution_0/v3_four_channel_phase_distribution_0/v3_four_channel_output_collection_0/v3_four_channel_placement_0/v3_channel_selector_late_promotion_2/v3_selector_route_pilot_0/G0_MUX_AXIS/a_76_199# v3_four_channel_output_load_integration_0/v3_four_channel_shared_support_integration_0/v3_four_channel_bias_reference_distribution_0/v3_four_channel_phase_distribution_0/v3_four_channel_output_collection_0/v3_four_channel_placement_0/v3_channel_selector_late_promotion_2/v3_selector_route_pilot_0/G0_MUX_AXIS/X VDPWR sky130_fd_pr__pfet_01v8_hvt ad=0 pd=0 as=0.26 ps=2.52 w=1 l=0.15
X2281 VGND v3_four_channel_output_load_integration_0/v3_four_channel_shared_support_integration_0/v3_four_channel_bias_reference_distribution_0/v3_four_channel_phase_distribution_0/v3_four_channel_output_collection_0/v3_four_channel_placement_0/v3_channel_selector_late_promotion_2/v3_selector_route_pilot_0/G0_MUX_AXIS/a_76_199# v3_four_channel_output_load_integration_0/v3_four_channel_shared_support_integration_0/v3_four_channel_bias_reference_distribution_0/v3_four_channel_phase_distribution_0/v3_four_channel_output_collection_0/v3_four_channel_placement_0/v3_channel_selector_late_promotion_2/v3_selector_route_pilot_0/G0_MUX_AXIS/X VGND sky130_fd_pr__nfet_01v8 ad=0 pd=0 as=0.169 ps=1.82 w=0.65 l=0.15
X2282 VDPWR v3_four_channel_output_load_integration_0/v3_four_channel_shared_support_integration_0/v3_four_channel_bias_reference_distribution_0/v3_four_channel_phase_distribution_0/v3_four_channel_output_collection_0/v3_four_channel_placement_0/v3_channel_selector_late_promotion_2/v3_selector_route_pilot_0/G3_LO_P_AND/B v3_four_channel_output_load_integration_0/v3_four_channel_shared_support_integration_0/v3_four_channel_bias_reference_distribution_0/v3_four_channel_phase_distribution_0/v3_four_channel_output_collection_0/v3_four_channel_placement_0/v3_channel_selector_late_promotion_2/v3_selector_route_pilot_0/G2_LO_P_AND/a_59_75# VDPWR sky130_fd_pr__pfet_01v8_hvt ad=0 pd=0 as=0.1134 ps=1.38 w=0.42 l=0.15
X2283 v3_four_channel_output_load_integration_0/v3_four_channel_shared_support_integration_0/v3_four_channel_bias_reference_distribution_0/v3_four_channel_phase_distribution_0/v3_four_channel_output_collection_0/v3_four_channel_placement_0/v3_channel_selector_late_promotion_2/v3_selector_route_pilot_0/group2_lo_p v3_four_channel_output_load_integration_0/v3_four_channel_shared_support_integration_0/v3_four_channel_bias_reference_distribution_0/v3_four_channel_phase_distribution_0/v3_four_channel_output_collection_0/v3_four_channel_placement_0/v3_channel_selector_late_promotion_2/v3_selector_route_pilot_0/G2_LO_P_AND/a_59_75# VDPWR VDPWR sky130_fd_pr__pfet_01v8_hvt ad=0.475 pd=2.95 as=0 ps=0 w=1 l=0.15
X2284 VGND v3_four_channel_output_load_integration_0/v3_four_channel_shared_support_integration_0/v3_four_channel_bias_reference_distribution_0/v3_four_channel_phase_distribution_0/v3_four_channel_output_collection_0/v3_four_channel_placement_0/v3_channel_selector_late_promotion_2/v3_selector_route_pilot_0/G3_LO_P_AND/B v3_four_channel_output_load_integration_0/v3_four_channel_shared_support_integration_0/v3_four_channel_bias_reference_distribution_0/v3_four_channel_phase_distribution_0/v3_four_channel_output_collection_0/v3_four_channel_placement_0/v3_channel_selector_late_promotion_2/v3_selector_route_pilot_0/G2_LO_P_AND/a_145_75# VGND sky130_fd_pr__nfet_01v8 ad=0 pd=0 as=0.1134 ps=1.38 w=0.42 l=0.15
X2285 v3_four_channel_output_load_integration_0/v3_four_channel_shared_support_integration_0/v3_four_channel_bias_reference_distribution_0/v3_four_channel_phase_distribution_0/v3_four_channel_output_collection_0/v3_four_channel_placement_0/v3_channel_selector_late_promotion_2/v3_selector_route_pilot_0/G2_LO_P_AND/a_59_75# v3_four_channel_output_load_integration_0/v3_four_channel_shared_support_integration_0/v3_four_channel_bias_reference_distribution_0/v3_four_channel_phase_distribution_0/v3_four_channel_output_collection_0/v3_four_channel_placement_0/v3_channel_selector_late_promotion_2/v3_selector_route_pilot_0/G2_MUX_AXIS/X VDPWR VDPWR sky130_fd_pr__pfet_01v8_hvt ad=0 pd=0 as=0 ps=0 w=0.42 l=0.15
X2286 v3_four_channel_output_load_integration_0/v3_four_channel_shared_support_integration_0/v3_four_channel_bias_reference_distribution_0/v3_four_channel_phase_distribution_0/v3_four_channel_output_collection_0/v3_four_channel_placement_0/v3_channel_selector_late_promotion_2/v3_selector_route_pilot_0/group2_lo_p v3_four_channel_output_load_integration_0/v3_four_channel_shared_support_integration_0/v3_four_channel_bias_reference_distribution_0/v3_four_channel_phase_distribution_0/v3_four_channel_output_collection_0/v3_four_channel_placement_0/v3_channel_selector_late_promotion_2/v3_selector_route_pilot_0/G2_LO_P_AND/a_59_75# VGND VGND sky130_fd_pr__nfet_01v8 ad=0.182 pd=1.86 as=0 ps=0 w=0.65 l=0.15
X2287 v3_four_channel_output_load_integration_0/v3_four_channel_shared_support_integration_0/v3_four_channel_bias_reference_distribution_0/v3_four_channel_phase_distribution_0/v3_four_channel_output_collection_0/v3_four_channel_placement_0/v3_channel_selector_late_promotion_2/v3_selector_route_pilot_0/G2_LO_P_AND/a_145_75# v3_four_channel_output_load_integration_0/v3_four_channel_shared_support_integration_0/v3_four_channel_bias_reference_distribution_0/v3_four_channel_phase_distribution_0/v3_four_channel_output_collection_0/v3_four_channel_placement_0/v3_channel_selector_late_promotion_2/v3_selector_route_pilot_0/G2_MUX_AXIS/X v3_four_channel_output_load_integration_0/v3_four_channel_shared_support_integration_0/v3_four_channel_bias_reference_distribution_0/v3_four_channel_phase_distribution_0/v3_four_channel_output_collection_0/v3_four_channel_placement_0/v3_channel_selector_late_promotion_2/v3_selector_route_pilot_0/G2_LO_P_AND/a_59_75# VGND sky130_fd_pr__nfet_01v8 ad=0 pd=0 as=0.1176 ps=1.4 w=0.42 l=0.15
X2288 v3_four_channel_output_load_integration_0/v3_four_channel_shared_support_integration_0/v3_four_channel_bias_reference_distribution_0/v3_four_channel_phase_distribution_0/v3_four_channel_output_collection_0/v3_four_channel_placement_0/v3_channel_selector_late_promotion_3/v3_channel_input_bias_late_promotion_0/a_4678_23422# v3_four_channel_output_load_integration_0/v3_four_channel_shared_support_integration_0/v3_four_channel_bias_reference_distribution_0/v3_four_channel_phase_distribution_0/v3_four_channel_output_collection_0/v3_four_channel_placement_0/v3_channel_selector_late_promotion_3/v3_selector_route_pilot_0/group3_lo_p v3_four_channel_output_load_integration_0/combined_n VGND sky130_fd_pr__nfet_01v8 ad=0.6206 pd=6.02 as=0 ps=0 w=0.65 l=0.15
X2289 v3_four_channel_output_load_integration_0/combined_n v3_four_channel_output_load_integration_0/v3_four_channel_shared_support_integration_0/v3_four_channel_bias_reference_distribution_0/v3_four_channel_phase_distribution_0/v3_four_channel_output_collection_0/v3_four_channel_placement_0/v3_channel_selector_late_promotion_3/v3_selector_route_pilot_0/group3_lo_p v3_four_channel_output_load_integration_0/v3_four_channel_shared_support_integration_0/v3_four_channel_bias_reference_distribution_0/v3_four_channel_phase_distribution_0/v3_four_channel_output_collection_0/v3_four_channel_placement_0/v3_channel_selector_late_promotion_3/v3_channel_input_bias_late_promotion_0/a_4254_6978# VGND sky130_fd_pr__nfet_01v8 ad=0 pd=0 as=0.6206 ps=6.02 w=0.65 l=0.15
X2290 v3_four_channel_output_load_integration_0/v3_four_channel_shared_support_integration_0/v3_four_channel_bias_reference_distribution_0/v3_four_channel_phase_distribution_0/v3_four_channel_output_collection_0/v3_four_channel_placement_0/v3_channel_selector_late_promotion_3/v3_channel_input_bias_late_promotion_0/a_4678_23422# v3_four_channel_output_load_integration_0/v3_four_channel_shared_support_integration_0/v3_vcm_support_block_0/ref v3_four_channel_output_load_integration_0/v3_four_channel_shared_support_integration_0/v3_four_channel_bias_reference_distribution_0/v3_four_channel_phase_distribution_0/v3_four_channel_output_collection_0/v3_four_channel_placement_0/v3_channel_selector_late_promotion_3/v3_channel_input_bias_late_promotion_0/a_4382_21688# VGND sky130_fd_pr__nfet_01v8 ad=0 pd=0 as=1.9575 ps=15.24 w=0.84 l=0.6
X2291 v3_four_channel_output_load_integration_0/combined_n v3_four_channel_output_load_integration_0/v3_four_channel_shared_support_integration_0/v3_four_channel_bias_reference_distribution_0/v3_four_channel_phase_distribution_0/v3_four_channel_output_collection_0/v3_four_channel_placement_0/v3_channel_selector_late_promotion_3/v3_selector_route_pilot_0/group3_lo_n v3_four_channel_output_load_integration_0/v3_four_channel_shared_support_integration_0/v3_four_channel_bias_reference_distribution_0/v3_four_channel_phase_distribution_0/v3_four_channel_output_collection_0/v3_four_channel_placement_0/v3_channel_selector_late_promotion_3/v3_channel_input_bias_late_promotion_0/a_7038_22978# VGND sky130_fd_pr__nfet_01v8 ad=0 pd=0 as=0.6206 ps=6.02 w=0.65 l=0.15
X2292 v3_four_channel_output_load_integration_0/combined_n v3_four_channel_output_load_integration_0/v3_four_channel_shared_support_integration_0/v3_four_channel_bias_reference_distribution_0/v3_four_channel_phase_distribution_0/v3_four_channel_output_collection_0/v3_four_channel_placement_0/v3_channel_selector_late_promotion_3/v3_selector_route_pilot_0/group3_lo_p v3_four_channel_output_load_integration_0/v3_four_channel_shared_support_integration_0/v3_four_channel_bias_reference_distribution_0/v3_four_channel_phase_distribution_0/v3_four_channel_output_collection_0/v3_four_channel_placement_0/v3_channel_selector_late_promotion_3/v3_channel_input_bias_late_promotion_0/a_7038_6978# VGND sky130_fd_pr__nfet_01v8 ad=0 pd=0 as=0.6206 ps=6.02 w=0.65 l=0.15
X2293 v3_four_channel_output_load_integration_0/v3_four_channel_shared_support_integration_0/v3_four_channel_bias_reference_distribution_0/v3_four_channel_phase_distribution_0/v3_four_channel_output_collection_0/v3_four_channel_placement_0/v3_channel_selector_late_promotion_3/v3_channel_input_bias_late_promotion_0/a_7462_11422# V3I000 v3_four_channel_output_load_integration_0/v3_four_channel_shared_support_integration_0/v3_four_channel_bias_reference_distribution_0/v3_four_channel_phase_distribution_0/v3_four_channel_output_collection_0/v3_four_channel_placement_0/v3_channel_selector_late_promotion_3/v3_channel_input_bias_late_promotion_0/a_7216_10978# VGND sky130_fd_pr__nfet_01v8 ad=0.6206 pd=6.02 as=1.9575 ps=15.24 w=0.84 l=0.6
X2294 v3_four_channel_output_load_integration_0/v3_four_channel_shared_support_integration_0/v3_four_channel_bias_reference_distribution_0/v3_four_channel_phase_distribution_0/v3_four_channel_output_collection_0/v3_four_channel_placement_0/v3_channel_selector_late_promotion_3/v3_channel_input_bias_late_promotion_0/a_7462_11422# v3_four_channel_output_load_integration_0/v3_four_channel_shared_support_integration_0/v3_four_channel_bias_reference_distribution_0/v3_four_channel_phase_distribution_0/v3_four_channel_output_collection_0/v3_four_channel_placement_0/v3_channel_selector_late_promotion_3/v3_selector_route_pilot_0/group2_lo_n v3_four_channel_output_load_integration_0/combined_n VGND sky130_fd_pr__nfet_01v8 ad=0 pd=0 as=0 ps=0 w=0.65 l=0.15
X2295 v3_four_channel_output_load_integration_0/v3_four_channel_shared_support_integration_0/v3_four_channel_bias_reference_distribution_0/v3_four_channel_phase_distribution_0/v3_four_channel_output_collection_0/v3_four_channel_placement_0/v3_channel_selector_late_promotion_3/v3_channel_input_bias_late_promotion_0/a_5774_21688# V3I000 v3_four_channel_output_load_integration_0/v3_four_channel_shared_support_integration_0/v3_four_channel_bias_reference_distribution_0/v3_four_channel_phase_distribution_0/v3_four_channel_output_collection_0/v3_four_channel_placement_0/v3_channel_selector_late_promotion_3/v3_channel_input_bias_late_promotion_0/a_5646_22978# VGND sky130_fd_pr__nfet_01v8 ad=1.9575 pd=15.24 as=0.6206 ps=6.02 w=0.84 l=0.6
X2296 VGND v3_four_channel_output_load_integration_0/v3_four_channel_shared_support_integration_0/v3_tail_bias_support_block_0/vbias v3_four_channel_output_load_integration_0/v3_four_channel_shared_support_integration_0/v3_four_channel_bias_reference_distribution_0/v3_four_channel_phase_distribution_0/v3_four_channel_output_collection_0/v3_four_channel_placement_0/v3_channel_selector_late_promotion_3/v3_channel_input_bias_late_promotion_0/a_5774_17688# VGND sky130_fd_pr__nfet_01v8 ad=0 pd=0 as=1.9575 ps=15.24 w=5.07 l=1
X2297 v3_four_channel_output_load_integration_0/v3_four_channel_shared_support_integration_0/v3_four_channel_bias_reference_distribution_0/v3_four_channel_phase_distribution_0/v3_four_channel_output_collection_0/v3_four_channel_placement_0/v3_channel_selector_late_promotion_3/v3_channel_input_bias_late_promotion_0/a_6070_7422# V3I000 v3_four_channel_output_load_integration_0/v3_four_channel_shared_support_integration_0/v3_four_channel_bias_reference_distribution_0/v3_four_channel_phase_distribution_0/v3_four_channel_output_collection_0/v3_four_channel_placement_0/v3_channel_selector_late_promotion_3/v3_channel_input_bias_late_promotion_0/a_5824_6978# VGND sky130_fd_pr__nfet_01v8 ad=0.6206 pd=6.02 as=1.9575 ps=15.24 w=0.84 l=0.6
X2298 v3_four_channel_output_load_integration_0/v3_four_channel_shared_support_integration_0/v3_four_channel_bias_reference_distribution_0/v3_four_channel_phase_distribution_0/v3_four_channel_output_collection_0/v3_four_channel_placement_0/v3_channel_selector_late_promotion_3/v3_channel_input_bias_late_promotion_0/a_6070_7422# v3_four_channel_output_load_integration_0/v3_four_channel_shared_support_integration_0/v3_four_channel_bias_reference_distribution_0/v3_four_channel_phase_distribution_0/v3_four_channel_output_collection_0/v3_four_channel_placement_0/v3_channel_selector_late_promotion_3/v3_selector_route_pilot_0/group3_lo_n v3_four_channel_output_load_integration_0/combined_n VGND sky130_fd_pr__nfet_01v8 ad=0 pd=0 as=0 ps=0 w=0.65 l=0.15
X2299 v3_four_channel_output_load_integration_0/v3_four_channel_shared_support_integration_0/v3_vcm_support_block_0/ref V3I000 VGND sky130_fd_pr__res_xhigh_po_0p35 l=17.36
X2300 v3_four_channel_output_load_integration_0/v3_four_channel_shared_support_integration_0/v3_four_channel_bias_reference_distribution_0/v3_four_channel_phase_distribution_0/v3_four_channel_output_collection_0/v3_four_channel_placement_0/v3_channel_selector_late_promotion_3/v3_channel_input_bias_late_promotion_0/a_7462_23422# v3_four_channel_output_load_integration_0/v3_four_channel_shared_support_integration_0/v3_vcm_support_block_0/ref v3_four_channel_output_load_integration_0/v3_four_channel_shared_support_integration_0/v3_four_channel_bias_reference_distribution_0/v3_four_channel_phase_distribution_0/v3_four_channel_output_collection_0/v3_four_channel_placement_0/v3_channel_selector_late_promotion_3/v3_channel_input_bias_late_promotion_0/a_7166_21688# VGND sky130_fd_pr__nfet_01v8 ad=0.6206 pd=6.02 as=1.9575 ps=15.24 w=0.84 l=0.6
X2301 v3_four_channel_output_load_integration_0/v3_four_channel_shared_support_integration_0/v3_four_channel_bias_reference_distribution_0/v3_four_channel_phase_distribution_0/v3_four_channel_output_collection_0/v3_four_channel_placement_0/v3_channel_selector_late_promotion_3/v3_channel_input_bias_late_promotion_0/a_7462_23422# v3_four_channel_output_load_integration_0/v3_four_channel_shared_support_integration_0/v3_four_channel_bias_reference_distribution_0/v3_four_channel_phase_distribution_0/v3_four_channel_output_collection_0/v3_four_channel_placement_0/v3_channel_selector_late_promotion_3/v3_selector_route_pilot_0/group3_lo_p v3_four_channel_output_load_integration_0/combined_n VGND sky130_fd_pr__nfet_01v8 ad=0 pd=0 as=0 ps=0 w=0.65 l=0.15
X2302 VGND v3_four_channel_output_load_integration_0/v3_four_channel_shared_support_integration_0/v3_tail_bias_support_block_0/vbias v3_four_channel_output_load_integration_0/v3_four_channel_shared_support_integration_0/v3_four_channel_bias_reference_distribution_0/v3_four_channel_phase_distribution_0/v3_four_channel_output_collection_0/v3_four_channel_placement_0/v3_channel_selector_late_promotion_3/v3_channel_input_bias_late_promotion_0/a_4382_21688# VGND sky130_fd_pr__nfet_01v8 ad=0 pd=0 as=0 ps=0 w=5.07 l=1
X2303 VGND v3_four_channel_output_load_integration_0/v3_four_channel_shared_support_integration_0/v3_tail_bias_support_block_0/vbias v3_four_channel_output_load_integration_0/v3_four_channel_shared_support_integration_0/v3_four_channel_bias_reference_distribution_0/v3_four_channel_phase_distribution_0/v3_four_channel_output_collection_0/v3_four_channel_placement_0/v3_channel_selector_late_promotion_3/v3_channel_input_bias_late_promotion_0/a_5774_13688# VGND sky130_fd_pr__nfet_01v8 ad=0 pd=0 as=1.9575 ps=15.24 w=5.07 l=1
X2304 VGND v3_four_channel_output_load_integration_0/v3_four_channel_shared_support_integration_0/v3_tail_bias_support_block_0/vbias v3_four_channel_output_load_integration_0/v3_four_channel_shared_support_integration_0/v3_four_channel_bias_reference_distribution_0/v3_four_channel_phase_distribution_0/v3_four_channel_output_collection_0/v3_four_channel_placement_0/v3_channel_selector_late_promotion_3/v3_channel_input_bias_late_promotion_0/a_7166_17688# VGND sky130_fd_pr__nfet_01v8 ad=0 pd=0 as=1.9575 ps=15.24 w=5.07 l=1
X2305 VGND VGND VGND VGND sky130_fd_pr__nfet_01v8 ad=0 pd=0 as=0 ps=0 w=0.65 l=0.15
X2306 v3_four_channel_output_load_integration_0/combined_p v3_four_channel_output_load_integration_0/v3_four_channel_shared_support_integration_0/v3_four_channel_bias_reference_distribution_0/v3_four_channel_phase_distribution_0/v3_four_channel_output_collection_0/v3_four_channel_placement_0/v3_channel_selector_late_promotion_3/v3_selector_route_pilot_0/group3_lo_p v3_four_channel_output_load_integration_0/v3_four_channel_shared_support_integration_0/v3_four_channel_bias_reference_distribution_0/v3_four_channel_phase_distribution_0/v3_four_channel_output_collection_0/v3_four_channel_placement_0/v3_channel_selector_late_promotion_3/v3_channel_input_bias_late_promotion_0/a_5646_18978# VGND sky130_fd_pr__nfet_01v8 ad=0 pd=0 as=0.6206 ps=6.02 w=0.65 l=0.15
X2307 VGND VGND VGND VGND sky130_fd_pr__nfet_01v8 ad=0 pd=0 as=0 ps=0 w=0.65 l=0.15
X2308 v3_four_channel_output_load_integration_0/v3_four_channel_shared_support_integration_0/v3_four_channel_bias_reference_distribution_0/v3_four_channel_phase_distribution_0/v3_four_channel_output_collection_0/v3_four_channel_placement_0/v3_channel_selector_late_promotion_3/v3_channel_input_bias_late_promotion_0/a_6070_19422# v3_four_channel_output_load_integration_0/v3_four_channel_shared_support_integration_0/v3_four_channel_bias_reference_distribution_0/v3_four_channel_phase_distribution_0/v3_four_channel_output_collection_0/v3_four_channel_placement_0/v3_channel_selector_late_promotion_3/v3_selector_route_pilot_0/group3_lo_n v3_four_channel_output_load_integration_0/combined_p VGND sky130_fd_pr__nfet_01v8 ad=0.6206 pd=6.02 as=0 ps=0 w=0.65 l=0.15
X2309 VGND VGND VGND VGND sky130_fd_pr__nfet_01v8 ad=0 pd=0 as=0 ps=0 w=0.65 l=0.15
X2310 v3_four_channel_output_load_integration_0/combined_p v3_four_channel_output_load_integration_0/v3_four_channel_shared_support_integration_0/v3_four_channel_bias_reference_distribution_0/v3_four_channel_phase_distribution_0/v3_four_channel_output_collection_0/v3_four_channel_placement_0/v3_channel_selector_late_promotion_3/v3_selector_route_pilot_0/group2_lo_p v3_four_channel_output_load_integration_0/v3_four_channel_shared_support_integration_0/v3_four_channel_bias_reference_distribution_0/v3_four_channel_phase_distribution_0/v3_four_channel_output_collection_0/v3_four_channel_placement_0/v3_channel_selector_late_promotion_3/v3_channel_input_bias_late_promotion_0/a_4254_18978# VGND sky130_fd_pr__nfet_01v8 ad=0 pd=0 as=0.6206 ps=6.02 w=0.65 l=0.15
X2311 v3_four_channel_output_load_integration_0/v3_four_channel_shared_support_integration_0/v3_four_channel_bias_reference_distribution_0/v3_four_channel_phase_distribution_0/v3_four_channel_output_collection_0/v3_four_channel_placement_0/v3_channel_selector_late_promotion_3/v3_channel_input_bias_late_promotion_0/a_7216_14978# v3_four_channel_output_load_integration_0/v3_four_channel_shared_support_integration_0/v3_tail_bias_support_block_0/vbias VGND VGND sky130_fd_pr__nfet_01v8 ad=1.9575 pd=15.24 as=0 ps=0 w=5.07 l=1
X2312 VGND VGND VGND VGND sky130_fd_pr__nfet_01v8 ad=0 pd=0 as=0 ps=0 w=0.65 l=0.15
X2313 VGND VGND VGND VGND sky130_fd_pr__nfet_01v8 ad=0 pd=0 as=0 ps=0 w=0.65 l=0.15
X2314 v3_four_channel_output_load_integration_0/v3_four_channel_shared_support_integration_0/v3_four_channel_bias_reference_distribution_0/v3_four_channel_phase_distribution_0/v3_four_channel_output_collection_0/v3_four_channel_placement_0/v3_channel_selector_late_promotion_3/v3_channel_input_bias_late_promotion_0/a_4382_17688# V3I000 v3_four_channel_output_load_integration_0/v3_four_channel_shared_support_integration_0/v3_four_channel_bias_reference_distribution_0/v3_four_channel_phase_distribution_0/v3_four_channel_output_collection_0/v3_four_channel_placement_0/v3_channel_selector_late_promotion_3/v3_channel_input_bias_late_promotion_0/a_4254_18978# VGND sky130_fd_pr__nfet_01v8 ad=1.9575 pd=15.24 as=0 ps=0 w=0.84 l=0.6
X2315 v3_four_channel_output_load_integration_0/v3_four_channel_shared_support_integration_0/v3_four_channel_bias_reference_distribution_0/v3_four_channel_phase_distribution_0/v3_four_channel_output_collection_0/v3_four_channel_placement_0/v3_channel_selector_late_promotion_3/v3_channel_input_bias_late_promotion_0/a_4678_19422# v3_four_channel_output_load_integration_0/v3_four_channel_shared_support_integration_0/v3_four_channel_bias_reference_distribution_0/v3_four_channel_phase_distribution_0/v3_four_channel_output_collection_0/v3_four_channel_placement_0/v3_channel_selector_late_promotion_3/v3_selector_route_pilot_0/group2_lo_n v3_four_channel_output_load_integration_0/combined_p VGND sky130_fd_pr__nfet_01v8 ad=0.6206 pd=6.02 as=0 ps=0 w=0.65 l=0.15
X2316 v3_four_channel_output_load_integration_0/combined_p v3_four_channel_output_load_integration_0/v3_four_channel_shared_support_integration_0/v3_four_channel_bias_reference_distribution_0/v3_four_channel_phase_distribution_0/v3_four_channel_output_collection_0/v3_four_channel_placement_0/v3_channel_selector_late_promotion_3/v3_selector_route_pilot_0/group0_lo_p v3_four_channel_output_load_integration_0/v3_four_channel_shared_support_integration_0/v3_four_channel_bias_reference_distribution_0/v3_four_channel_phase_distribution_0/v3_four_channel_output_collection_0/v3_four_channel_placement_0/v3_channel_selector_late_promotion_3/v3_channel_input_bias_late_promotion_0/a_5646_14978# VGND sky130_fd_pr__nfet_01v8 ad=0 pd=0 as=0.6206 ps=6.02 w=0.65 l=0.15
X2317 v3_four_channel_output_load_integration_0/combined_p v3_four_channel_output_load_integration_0/v3_four_channel_shared_support_integration_0/v3_four_channel_bias_reference_distribution_0/v3_four_channel_phase_distribution_0/v3_four_channel_output_collection_0/v3_four_channel_placement_0/v3_channel_selector_late_promotion_3/v3_selector_route_pilot_0/group2_lo_p v3_four_channel_output_load_integration_0/v3_four_channel_shared_support_integration_0/v3_four_channel_bias_reference_distribution_0/v3_four_channel_phase_distribution_0/v3_four_channel_output_collection_0/v3_four_channel_placement_0/v3_channel_selector_late_promotion_3/v3_channel_input_bias_late_promotion_0/a_7038_18978# VGND sky130_fd_pr__nfet_01v8 ad=0 pd=0 as=0.6206 ps=6.02 w=0.65 l=0.15
X2318 VGND VGND VGND VGND sky130_fd_pr__nfet_01v8 ad=0 pd=0 as=0 ps=0 w=5.07 l=1
X2319 v3_four_channel_output_load_integration_0/v3_four_channel_shared_support_integration_0/v3_four_channel_bias_reference_distribution_0/v3_four_channel_phase_distribution_0/v3_four_channel_output_collection_0/v3_four_channel_placement_0/v3_channel_selector_late_promotion_3/v3_channel_input_bias_late_promotion_0/a_6070_15422# v3_four_channel_output_load_integration_0/v3_four_channel_shared_support_integration_0/v3_four_channel_bias_reference_distribution_0/v3_four_channel_phase_distribution_0/v3_four_channel_output_collection_0/v3_four_channel_placement_0/v3_channel_selector_late_promotion_3/v3_selector_route_pilot_0/group0_lo_n v3_four_channel_output_load_integration_0/combined_p VGND sky130_fd_pr__nfet_01v8 ad=0.6206 pd=6.02 as=0 ps=0 w=0.65 l=0.15
X2320 v3_four_channel_output_load_integration_0/v3_four_channel_shared_support_integration_0/v3_four_channel_bias_reference_distribution_0/v3_four_channel_phase_distribution_0/v3_four_channel_output_collection_0/v3_four_channel_placement_0/v3_channel_selector_late_promotion_3/v3_channel_input_bias_late_promotion_0/a_7166_17688# V3I000 v3_four_channel_output_load_integration_0/v3_four_channel_shared_support_integration_0/v3_four_channel_bias_reference_distribution_0/v3_four_channel_phase_distribution_0/v3_four_channel_output_collection_0/v3_four_channel_placement_0/v3_channel_selector_late_promotion_3/v3_channel_input_bias_late_promotion_0/a_7038_18978# VGND sky130_fd_pr__nfet_01v8 ad=0 pd=0 as=0 ps=0 w=0.84 l=0.6
X2321 v3_four_channel_output_load_integration_0/combined_n v3_four_channel_output_load_integration_0/v3_four_channel_shared_support_integration_0/v3_four_channel_bias_reference_distribution_0/v3_four_channel_phase_distribution_0/v3_four_channel_output_collection_0/v3_four_channel_placement_0/v3_channel_selector_late_promotion_3/v3_selector_route_pilot_0/group3_lo_n v3_four_channel_output_load_integration_0/v3_four_channel_shared_support_integration_0/v3_four_channel_bias_reference_distribution_0/v3_four_channel_phase_distribution_0/v3_four_channel_output_collection_0/v3_four_channel_placement_0/v3_channel_selector_late_promotion_3/v3_channel_input_bias_late_promotion_0/a_5646_18978# VGND sky130_fd_pr__nfet_01v8 ad=0 pd=0 as=0 ps=0 w=0.65 l=0.15
X2322 VGND v3_four_channel_output_load_integration_0/v3_four_channel_shared_support_integration_0/v3_tail_bias_support_block_0/vbias v3_four_channel_output_load_integration_0/v3_four_channel_shared_support_integration_0/v3_four_channel_bias_reference_distribution_0/v3_four_channel_phase_distribution_0/v3_four_channel_output_collection_0/v3_four_channel_placement_0/v3_channel_selector_late_promotion_3/v3_channel_input_bias_late_promotion_0/a_5774_21688# VGND sky130_fd_pr__nfet_01v8 ad=0 pd=0 as=0 ps=0 w=5.07 l=1
X2323 v3_four_channel_output_load_integration_0/v3_four_channel_shared_support_integration_0/v3_four_channel_bias_reference_distribution_0/v3_four_channel_phase_distribution_0/v3_four_channel_output_collection_0/v3_four_channel_placement_0/v3_channel_selector_late_promotion_3/v3_channel_input_bias_late_promotion_0/a_6070_19422# v3_four_channel_output_load_integration_0/v3_four_channel_shared_support_integration_0/v3_vcm_support_block_0/ref v3_four_channel_output_load_integration_0/v3_four_channel_shared_support_integration_0/v3_four_channel_bias_reference_distribution_0/v3_four_channel_phase_distribution_0/v3_four_channel_output_collection_0/v3_four_channel_placement_0/v3_channel_selector_late_promotion_3/v3_channel_input_bias_late_promotion_0/a_5774_17688# VGND sky130_fd_pr__nfet_01v8 ad=0 pd=0 as=0 ps=0 w=0.84 l=0.6
X2324 VGND VGND VGND VGND sky130_fd_pr__nfet_01v8 ad=0 pd=0 as=0 ps=0 w=5.07 l=1
X2325 v3_four_channel_output_load_integration_0/combined_p v3_four_channel_output_load_integration_0/v3_four_channel_shared_support_integration_0/v3_four_channel_bias_reference_distribution_0/v3_four_channel_phase_distribution_0/v3_four_channel_output_collection_0/v3_four_channel_placement_0/v3_channel_selector_late_promotion_3/v3_selector_route_pilot_0/group1_lo_p v3_four_channel_output_load_integration_0/v3_four_channel_shared_support_integration_0/v3_four_channel_bias_reference_distribution_0/v3_four_channel_phase_distribution_0/v3_four_channel_output_collection_0/v3_four_channel_placement_0/v3_channel_selector_late_promotion_3/v3_channel_input_bias_late_promotion_0/a_4254_14978# VGND sky130_fd_pr__nfet_01v8 ad=0 pd=0 as=0.6206 ps=6.02 w=0.65 l=0.15
X2326 v3_four_channel_output_load_integration_0/v3_four_channel_shared_support_integration_0/v3_four_channel_bias_reference_distribution_0/v3_four_channel_phase_distribution_0/v3_four_channel_output_collection_0/v3_four_channel_placement_0/v3_channel_selector_late_promotion_3/v3_channel_input_bias_late_promotion_0/a_6070_19422# v3_four_channel_output_load_integration_0/v3_four_channel_shared_support_integration_0/v3_four_channel_bias_reference_distribution_0/v3_four_channel_phase_distribution_0/v3_four_channel_output_collection_0/v3_four_channel_placement_0/v3_channel_selector_late_promotion_3/v3_selector_route_pilot_0/group3_lo_p v3_four_channel_output_load_integration_0/combined_n VGND sky130_fd_pr__nfet_01v8 ad=0 pd=0 as=0 ps=0 w=0.65 l=0.15
X2327 VGND VGND VGND VGND sky130_fd_pr__nfet_01v8 ad=0 pd=0 as=0 ps=0 w=0.65 l=0.15
X2328 v3_four_channel_output_load_integration_0/v3_four_channel_shared_support_integration_0/v3_four_channel_bias_reference_distribution_0/v3_four_channel_phase_distribution_0/v3_four_channel_output_collection_0/v3_four_channel_placement_0/v3_channel_selector_late_promotion_3/v3_channel_input_bias_late_promotion_0/a_5824_10978# v3_four_channel_output_load_integration_0/v3_four_channel_shared_support_integration_0/v3_tail_bias_support_block_0/vbias VGND VGND sky130_fd_pr__nfet_01v8 ad=1.9575 pd=15.24 as=0 ps=0 w=5.07 l=1
X2329 v3_four_channel_output_load_integration_0/v3_four_channel_shared_support_integration_0/v3_four_channel_bias_reference_distribution_0/v3_four_channel_phase_distribution_0/v3_four_channel_output_collection_0/v3_four_channel_placement_0/v3_channel_selector_late_promotion_3/v3_channel_input_bias_late_promotion_0/a_4382_13688# V3I000 v3_four_channel_output_load_integration_0/v3_four_channel_shared_support_integration_0/v3_four_channel_bias_reference_distribution_0/v3_four_channel_phase_distribution_0/v3_four_channel_output_collection_0/v3_four_channel_placement_0/v3_channel_selector_late_promotion_3/v3_channel_input_bias_late_promotion_0/a_4254_14978# VGND sky130_fd_pr__nfet_01v8 ad=1.9575 pd=15.24 as=0 ps=0 w=0.84 l=0.6
X2330 v3_four_channel_output_load_integration_0/v3_four_channel_shared_support_integration_0/v3_four_channel_bias_reference_distribution_0/v3_four_channel_phase_distribution_0/v3_four_channel_output_collection_0/v3_four_channel_placement_0/v3_channel_selector_late_promotion_3/v3_channel_input_bias_late_promotion_0/a_4678_15422# v3_four_channel_output_load_integration_0/v3_four_channel_shared_support_integration_0/v3_four_channel_bias_reference_distribution_0/v3_four_channel_phase_distribution_0/v3_four_channel_output_collection_0/v3_four_channel_placement_0/v3_channel_selector_late_promotion_3/v3_selector_route_pilot_0/group1_lo_n v3_four_channel_output_load_integration_0/combined_p VGND sky130_fd_pr__nfet_01v8 ad=0.6206 pd=6.02 as=0 ps=0 w=0.65 l=0.15
X2331 v3_four_channel_output_load_integration_0/combined_n v3_four_channel_output_load_integration_0/v3_four_channel_shared_support_integration_0/v3_four_channel_bias_reference_distribution_0/v3_four_channel_phase_distribution_0/v3_four_channel_output_collection_0/v3_four_channel_placement_0/v3_channel_selector_late_promotion_3/v3_selector_route_pilot_0/group2_lo_n v3_four_channel_output_load_integration_0/v3_four_channel_shared_support_integration_0/v3_four_channel_bias_reference_distribution_0/v3_four_channel_phase_distribution_0/v3_four_channel_output_collection_0/v3_four_channel_placement_0/v3_channel_selector_late_promotion_3/v3_channel_input_bias_late_promotion_0/a_4254_18978# VGND sky130_fd_pr__nfet_01v8 ad=0 pd=0 as=0 ps=0 w=0.65 l=0.15
X2332 v3_four_channel_output_load_integration_0/combined_p v3_four_channel_output_load_integration_0/v3_four_channel_shared_support_integration_0/v3_four_channel_bias_reference_distribution_0/v3_four_channel_phase_distribution_0/v3_four_channel_output_collection_0/v3_four_channel_placement_0/v3_channel_selector_late_promotion_3/v3_selector_route_pilot_0/group3_lo_n v3_four_channel_output_load_integration_0/v3_four_channel_shared_support_integration_0/v3_four_channel_bias_reference_distribution_0/v3_four_channel_phase_distribution_0/v3_four_channel_output_collection_0/v3_four_channel_placement_0/v3_channel_selector_late_promotion_3/v3_channel_input_bias_late_promotion_0/a_5646_10978# VGND sky130_fd_pr__nfet_01v8 ad=0 pd=0 as=0.6206 ps=6.02 w=0.65 l=0.15
X2333 v3_four_channel_output_load_integration_0/combined_p v3_four_channel_output_load_integration_0/v3_four_channel_shared_support_integration_0/v3_four_channel_bias_reference_distribution_0/v3_four_channel_phase_distribution_0/v3_four_channel_output_collection_0/v3_four_channel_placement_0/v3_channel_selector_late_promotion_3/v3_selector_route_pilot_0/group1_lo_n v3_four_channel_output_load_integration_0/v3_four_channel_shared_support_integration_0/v3_four_channel_bias_reference_distribution_0/v3_four_channel_phase_distribution_0/v3_four_channel_output_collection_0/v3_four_channel_placement_0/v3_channel_selector_late_promotion_3/v3_channel_input_bias_late_promotion_0/a_7038_14978# VGND sky130_fd_pr__nfet_01v8 ad=0 pd=0 as=0.6206 ps=6.02 w=0.65 l=0.15
X2334 v3_four_channel_output_load_integration_0/v3_four_channel_shared_support_integration_0/v3_four_channel_bias_reference_distribution_0/v3_four_channel_phase_distribution_0/v3_four_channel_output_collection_0/v3_four_channel_placement_0/v3_channel_selector_late_promotion_3/v3_channel_input_bias_late_promotion_0/a_7462_19422# v3_four_channel_output_load_integration_0/v3_four_channel_shared_support_integration_0/v3_four_channel_bias_reference_distribution_0/v3_four_channel_phase_distribution_0/v3_four_channel_output_collection_0/v3_four_channel_placement_0/v3_channel_selector_late_promotion_3/v3_selector_route_pilot_0/group2_lo_n v3_four_channel_output_load_integration_0/combined_p VGND sky130_fd_pr__nfet_01v8 ad=0.6206 pd=6.02 as=0 ps=0 w=0.65 l=0.15
X2335 v3_four_channel_output_load_integration_0/v3_four_channel_shared_support_integration_0/v3_four_channel_bias_reference_distribution_0/v3_four_channel_phase_distribution_0/v3_four_channel_output_collection_0/v3_four_channel_placement_0/v3_channel_selector_late_promotion_3/v3_channel_input_bias_late_promotion_0/a_4678_7422# v3_four_channel_output_load_integration_0/v3_four_channel_shared_support_integration_0/v3_four_channel_bias_reference_distribution_0/v3_four_channel_phase_distribution_0/v3_four_channel_output_collection_0/v3_four_channel_placement_0/v3_channel_selector_late_promotion_3/v3_selector_route_pilot_0/group3_lo_p v3_four_channel_output_load_integration_0/combined_p VGND sky130_fd_pr__nfet_01v8 ad=0.6206 pd=6.02 as=0 ps=0 w=0.65 l=0.15
X2336 v3_four_channel_output_load_integration_0/v3_four_channel_shared_support_integration_0/v3_four_channel_bias_reference_distribution_0/v3_four_channel_phase_distribution_0/v3_four_channel_output_collection_0/v3_four_channel_placement_0/v3_channel_selector_late_promotion_3/v3_channel_input_bias_late_promotion_0/a_6070_11422# v3_four_channel_output_load_integration_0/v3_four_channel_shared_support_integration_0/v3_four_channel_bias_reference_distribution_0/v3_four_channel_phase_distribution_0/v3_four_channel_output_collection_0/v3_four_channel_placement_0/v3_channel_selector_late_promotion_3/v3_selector_route_pilot_0/group3_lo_p v3_four_channel_output_load_integration_0/combined_p VGND sky130_fd_pr__nfet_01v8 ad=0.6206 pd=6.02 as=0 ps=0 w=0.65 l=0.15
X2337 v3_four_channel_output_load_integration_0/v3_four_channel_shared_support_integration_0/v3_four_channel_bias_reference_distribution_0/v3_four_channel_phase_distribution_0/v3_four_channel_output_collection_0/v3_four_channel_placement_0/v3_channel_selector_late_promotion_3/v3_channel_input_bias_late_promotion_0/a_7216_10978# v3_four_channel_output_load_integration_0/v3_four_channel_shared_support_integration_0/v3_tail_bias_support_block_0/vbias VGND VGND sky130_fd_pr__nfet_01v8 ad=0 pd=0 as=0 ps=0 w=5.07 l=1
X2338 v3_four_channel_output_load_integration_0/v3_four_channel_shared_support_integration_0/v3_four_channel_bias_reference_distribution_0/v3_four_channel_phase_distribution_0/v3_four_channel_output_collection_0/v3_four_channel_placement_0/v3_channel_selector_late_promotion_3/v3_channel_input_bias_late_promotion_0/a_7216_14978# v3_four_channel_output_load_integration_0/v3_four_channel_shared_support_integration_0/v3_vcm_support_block_0/ref v3_four_channel_output_load_integration_0/v3_four_channel_shared_support_integration_0/v3_four_channel_bias_reference_distribution_0/v3_four_channel_phase_distribution_0/v3_four_channel_output_collection_0/v3_four_channel_placement_0/v3_channel_selector_late_promotion_3/v3_channel_input_bias_late_promotion_0/a_7038_14978# VGND sky130_fd_pr__nfet_01v8 ad=0 pd=0 as=0 ps=0 w=0.84 l=0.6
X2339 v3_four_channel_output_load_integration_0/v3_four_channel_shared_support_integration_0/v3_four_channel_bias_reference_distribution_0/v3_four_channel_phase_distribution_0/v3_four_channel_output_collection_0/v3_four_channel_placement_0/v3_channel_selector_late_promotion_3/v3_channel_input_bias_late_promotion_0/a_4678_19422# v3_four_channel_output_load_integration_0/v3_four_channel_shared_support_integration_0/v3_vcm_support_block_0/ref v3_four_channel_output_load_integration_0/v3_four_channel_shared_support_integration_0/v3_four_channel_bias_reference_distribution_0/v3_four_channel_phase_distribution_0/v3_four_channel_output_collection_0/v3_four_channel_placement_0/v3_channel_selector_late_promotion_3/v3_channel_input_bias_late_promotion_0/a_4382_17688# VGND sky130_fd_pr__nfet_01v8 ad=0 pd=0 as=0 ps=0 w=0.84 l=0.6
X2340 v3_four_channel_output_load_integration_0/v3_four_channel_shared_support_integration_0/v3_four_channel_bias_reference_distribution_0/v3_four_channel_phase_distribution_0/v3_four_channel_output_collection_0/v3_four_channel_placement_0/v3_channel_selector_late_promotion_3/v3_channel_input_bias_late_promotion_0/a_4678_19422# v3_four_channel_output_load_integration_0/v3_four_channel_shared_support_integration_0/v3_four_channel_bias_reference_distribution_0/v3_four_channel_phase_distribution_0/v3_four_channel_output_collection_0/v3_four_channel_placement_0/v3_channel_selector_late_promotion_3/v3_selector_route_pilot_0/group2_lo_p v3_four_channel_output_load_integration_0/combined_n VGND sky130_fd_pr__nfet_01v8 ad=0 pd=0 as=0 ps=0 w=0.65 l=0.15
X2341 v3_four_channel_output_load_integration_0/combined_n v3_four_channel_output_load_integration_0/v3_four_channel_shared_support_integration_0/v3_four_channel_bias_reference_distribution_0/v3_four_channel_phase_distribution_0/v3_four_channel_output_collection_0/v3_four_channel_placement_0/v3_channel_selector_late_promotion_3/v3_selector_route_pilot_0/group0_lo_n v3_four_channel_output_load_integration_0/v3_four_channel_shared_support_integration_0/v3_four_channel_bias_reference_distribution_0/v3_four_channel_phase_distribution_0/v3_four_channel_output_collection_0/v3_four_channel_placement_0/v3_channel_selector_late_promotion_3/v3_channel_input_bias_late_promotion_0/a_5646_14978# VGND sky130_fd_pr__nfet_01v8 ad=0 pd=0 as=0 ps=0 w=0.65 l=0.15
X2342 v3_four_channel_output_load_integration_0/combined_n v3_four_channel_output_load_integration_0/v3_four_channel_shared_support_integration_0/v3_four_channel_bias_reference_distribution_0/v3_four_channel_phase_distribution_0/v3_four_channel_output_collection_0/v3_four_channel_placement_0/v3_channel_selector_late_promotion_3/v3_selector_route_pilot_0/group2_lo_n v3_four_channel_output_load_integration_0/v3_four_channel_shared_support_integration_0/v3_four_channel_bias_reference_distribution_0/v3_four_channel_phase_distribution_0/v3_four_channel_output_collection_0/v3_four_channel_placement_0/v3_channel_selector_late_promotion_3/v3_channel_input_bias_late_promotion_0/a_7038_18978# VGND sky130_fd_pr__nfet_01v8 ad=0 pd=0 as=0 ps=0 w=0.65 l=0.15
X2343 v3_four_channel_output_load_integration_0/v3_four_channel_shared_support_integration_0/v3_four_channel_bias_reference_distribution_0/v3_four_channel_phase_distribution_0/v3_four_channel_output_collection_0/v3_four_channel_placement_0/v3_channel_selector_late_promotion_3/v3_channel_input_bias_late_promotion_0/a_7462_7422# v3_four_channel_output_load_integration_0/v3_four_channel_shared_support_integration_0/v3_four_channel_bias_reference_distribution_0/v3_four_channel_phase_distribution_0/v3_four_channel_output_collection_0/v3_four_channel_placement_0/v3_channel_selector_late_promotion_3/v3_selector_route_pilot_0/group3_lo_p v3_four_channel_output_load_integration_0/combined_p VGND sky130_fd_pr__nfet_01v8 ad=0.6206 pd=6.02 as=0 ps=0 w=0.65 l=0.15
X2344 VGND v3_four_channel_output_load_integration_0/v3_four_channel_shared_support_integration_0/v3_tail_bias_support_block_0/vbias v3_four_channel_output_load_integration_0/v3_four_channel_shared_support_integration_0/v3_four_channel_bias_reference_distribution_0/v3_four_channel_phase_distribution_0/v3_four_channel_output_collection_0/v3_four_channel_placement_0/v3_channel_selector_late_promotion_3/v3_channel_input_bias_late_promotion_0/a_7166_21688# VGND sky130_fd_pr__nfet_01v8 ad=0 pd=0 as=0 ps=0 w=5.07 l=1
X2345 v3_four_channel_output_load_integration_0/v3_four_channel_shared_support_integration_0/v3_four_channel_bias_reference_distribution_0/v3_four_channel_phase_distribution_0/v3_four_channel_output_collection_0/v3_four_channel_placement_0/v3_channel_selector_late_promotion_3/v3_channel_input_bias_late_promotion_0/a_6070_15422# v3_four_channel_output_load_integration_0/v3_four_channel_shared_support_integration_0/v3_vcm_support_block_0/ref v3_four_channel_output_load_integration_0/v3_four_channel_shared_support_integration_0/v3_four_channel_bias_reference_distribution_0/v3_four_channel_phase_distribution_0/v3_four_channel_output_collection_0/v3_four_channel_placement_0/v3_channel_selector_late_promotion_3/v3_channel_input_bias_late_promotion_0/a_5774_13688# VGND sky130_fd_pr__nfet_01v8 ad=0 pd=0 as=0 ps=0 w=0.84 l=0.6
X2346 v3_four_channel_output_load_integration_0/combined_p v3_four_channel_output_load_integration_0/v3_four_channel_shared_support_integration_0/v3_four_channel_bias_reference_distribution_0/v3_four_channel_phase_distribution_0/v3_four_channel_output_collection_0/v3_four_channel_placement_0/v3_channel_selector_late_promotion_3/v3_selector_route_pilot_0/group2_lo_n v3_four_channel_output_load_integration_0/v3_four_channel_shared_support_integration_0/v3_four_channel_bias_reference_distribution_0/v3_four_channel_phase_distribution_0/v3_four_channel_output_collection_0/v3_four_channel_placement_0/v3_channel_selector_late_promotion_3/v3_channel_input_bias_late_promotion_0/a_4254_10978# VGND sky130_fd_pr__nfet_01v8 ad=0 pd=0 as=0.6206 ps=6.02 w=0.65 l=0.15
X2347 v3_four_channel_output_load_integration_0/v3_four_channel_shared_support_integration_0/v3_four_channel_bias_reference_distribution_0/v3_four_channel_phase_distribution_0/v3_four_channel_output_collection_0/v3_four_channel_placement_0/v3_channel_selector_late_promotion_3/v3_channel_input_bias_late_promotion_0/a_6070_15422# v3_four_channel_output_load_integration_0/v3_four_channel_shared_support_integration_0/v3_four_channel_bias_reference_distribution_0/v3_four_channel_phase_distribution_0/v3_four_channel_output_collection_0/v3_four_channel_placement_0/v3_channel_selector_late_promotion_3/v3_selector_route_pilot_0/group0_lo_p v3_four_channel_output_load_integration_0/combined_n VGND sky130_fd_pr__nfet_01v8 ad=0 pd=0 as=0 ps=0 w=0.65 l=0.15
X2348 v3_four_channel_output_load_integration_0/v3_four_channel_shared_support_integration_0/v3_four_channel_bias_reference_distribution_0/v3_four_channel_phase_distribution_0/v3_four_channel_output_collection_0/v3_four_channel_placement_0/v3_channel_selector_late_promotion_3/v3_channel_input_bias_late_promotion_0/a_5824_6978# v3_four_channel_output_load_integration_0/v3_four_channel_shared_support_integration_0/v3_vcm_support_block_0/ref v3_four_channel_output_load_integration_0/v3_four_channel_shared_support_integration_0/v3_four_channel_bias_reference_distribution_0/v3_four_channel_phase_distribution_0/v3_four_channel_output_collection_0/v3_four_channel_placement_0/v3_channel_selector_late_promotion_3/v3_channel_input_bias_late_promotion_0/a_5646_6978# VGND sky130_fd_pr__nfet_01v8 ad=0 pd=0 as=0.6206 ps=6.02 w=0.84 l=0.6
X2349 v3_four_channel_output_load_integration_0/v3_four_channel_shared_support_integration_0/v3_four_channel_bias_reference_distribution_0/v3_four_channel_phase_distribution_0/v3_four_channel_output_collection_0/v3_four_channel_placement_0/v3_channel_selector_late_promotion_3/v3_channel_input_bias_late_promotion_0/a_5774_17688# V3I000 v3_four_channel_output_load_integration_0/v3_four_channel_shared_support_integration_0/v3_four_channel_bias_reference_distribution_0/v3_four_channel_phase_distribution_0/v3_four_channel_output_collection_0/v3_four_channel_placement_0/v3_channel_selector_late_promotion_3/v3_channel_input_bias_late_promotion_0/a_5646_18978# VGND sky130_fd_pr__nfet_01v8 ad=0 pd=0 as=0 ps=0 w=0.84 l=0.6
X2350 v3_four_channel_output_load_integration_0/combined_p v3_four_channel_output_load_integration_0/v3_four_channel_shared_support_integration_0/v3_four_channel_bias_reference_distribution_0/v3_four_channel_phase_distribution_0/v3_four_channel_output_collection_0/v3_four_channel_placement_0/v3_channel_selector_late_promotion_3/v3_selector_route_pilot_0/group3_lo_p v3_four_channel_output_load_integration_0/v3_four_channel_shared_support_integration_0/v3_four_channel_bias_reference_distribution_0/v3_four_channel_phase_distribution_0/v3_four_channel_output_collection_0/v3_four_channel_placement_0/v3_channel_selector_late_promotion_3/v3_channel_input_bias_late_promotion_0/a_5646_22978# VGND sky130_fd_pr__nfet_01v8 ad=0 pd=0 as=0 ps=0 w=0.65 l=0.15
X2351 v3_four_channel_output_load_integration_0/v3_four_channel_shared_support_integration_0/v3_four_channel_bias_reference_distribution_0/v3_four_channel_phase_distribution_0/v3_four_channel_output_collection_0/v3_four_channel_placement_0/v3_channel_selector_late_promotion_3/v3_channel_input_bias_late_promotion_0/a_5824_6978# v3_four_channel_output_load_integration_0/v3_four_channel_shared_support_integration_0/v3_tail_bias_support_block_0/vbias VGND VGND sky130_fd_pr__nfet_01v8 ad=0 pd=0 as=0 ps=0 w=5.07 l=1
X2352 v3_four_channel_output_load_integration_0/v3_four_channel_shared_support_integration_0/v3_four_channel_bias_reference_distribution_0/v3_four_channel_phase_distribution_0/v3_four_channel_output_collection_0/v3_four_channel_placement_0/v3_channel_selector_late_promotion_3/v3_channel_input_bias_late_promotion_0/a_4432_10978# v3_four_channel_output_load_integration_0/v3_four_channel_shared_support_integration_0/v3_vcm_support_block_0/ref v3_four_channel_output_load_integration_0/v3_four_channel_shared_support_integration_0/v3_four_channel_bias_reference_distribution_0/v3_four_channel_phase_distribution_0/v3_four_channel_output_collection_0/v3_four_channel_placement_0/v3_channel_selector_late_promotion_3/v3_channel_input_bias_late_promotion_0/a_4254_10978# VGND sky130_fd_pr__nfet_01v8 ad=1.9575 pd=15.24 as=0 ps=0 w=0.84 l=0.6
X2353 v3_four_channel_output_load_integration_0/v3_four_channel_shared_support_integration_0/v3_four_channel_bias_reference_distribution_0/v3_four_channel_phase_distribution_0/v3_four_channel_output_collection_0/v3_four_channel_placement_0/v3_channel_selector_late_promotion_3/v3_channel_input_bias_late_promotion_0/a_4678_11422# v3_four_channel_output_load_integration_0/v3_four_channel_shared_support_integration_0/v3_four_channel_bias_reference_distribution_0/v3_four_channel_phase_distribution_0/v3_four_channel_output_collection_0/v3_four_channel_placement_0/v3_channel_selector_late_promotion_3/v3_selector_route_pilot_0/group2_lo_p v3_four_channel_output_load_integration_0/combined_p VGND sky130_fd_pr__nfet_01v8 ad=0.6206 pd=6.02 as=0 ps=0 w=0.65 l=0.15
X2354 v3_four_channel_output_load_integration_0/v3_four_channel_shared_support_integration_0/v3_four_channel_bias_reference_distribution_0/v3_four_channel_phase_distribution_0/v3_four_channel_output_collection_0/v3_four_channel_placement_0/v3_channel_selector_late_promotion_3/v3_channel_input_bias_late_promotion_0/a_6070_23422# v3_four_channel_output_load_integration_0/v3_four_channel_shared_support_integration_0/v3_four_channel_bias_reference_distribution_0/v3_four_channel_phase_distribution_0/v3_four_channel_output_collection_0/v3_four_channel_placement_0/v3_channel_selector_late_promotion_3/v3_selector_route_pilot_0/group3_lo_n v3_four_channel_output_load_integration_0/combined_p VGND sky130_fd_pr__nfet_01v8 ad=0.6206 pd=6.02 as=0 ps=0 w=0.65 l=0.15
X2355 v3_four_channel_output_load_integration_0/combined_n v3_four_channel_output_load_integration_0/v3_four_channel_shared_support_integration_0/v3_four_channel_bias_reference_distribution_0/v3_four_channel_phase_distribution_0/v3_four_channel_output_collection_0/v3_four_channel_placement_0/v3_channel_selector_late_promotion_3/v3_selector_route_pilot_0/group1_lo_n v3_four_channel_output_load_integration_0/v3_four_channel_shared_support_integration_0/v3_four_channel_bias_reference_distribution_0/v3_four_channel_phase_distribution_0/v3_four_channel_output_collection_0/v3_four_channel_placement_0/v3_channel_selector_late_promotion_3/v3_channel_input_bias_late_promotion_0/a_4254_14978# VGND sky130_fd_pr__nfet_01v8 ad=0 pd=0 as=0 ps=0 w=0.65 l=0.15
X2356 v3_four_channel_output_load_integration_0/combined_p v3_four_channel_output_load_integration_0/v3_four_channel_shared_support_integration_0/v3_four_channel_bias_reference_distribution_0/v3_four_channel_phase_distribution_0/v3_four_channel_output_collection_0/v3_four_channel_placement_0/v3_channel_selector_late_promotion_3/v3_selector_route_pilot_0/group2_lo_n v3_four_channel_output_load_integration_0/v3_four_channel_shared_support_integration_0/v3_four_channel_bias_reference_distribution_0/v3_four_channel_phase_distribution_0/v3_four_channel_output_collection_0/v3_four_channel_placement_0/v3_channel_selector_late_promotion_3/v3_channel_input_bias_late_promotion_0/a_7038_10978# VGND sky130_fd_pr__nfet_01v8 ad=0 pd=0 as=0.6206 ps=6.02 w=0.65 l=0.15
X2357 v3_four_channel_output_load_integration_0/v3_four_channel_shared_support_integration_0/v3_four_channel_bias_reference_distribution_0/v3_four_channel_phase_distribution_0/v3_four_channel_output_collection_0/v3_four_channel_placement_0/v3_channel_selector_late_promotion_3/v3_channel_input_bias_late_promotion_0/a_7462_15422# v3_four_channel_output_load_integration_0/v3_four_channel_shared_support_integration_0/v3_four_channel_bias_reference_distribution_0/v3_four_channel_phase_distribution_0/v3_four_channel_output_collection_0/v3_four_channel_placement_0/v3_channel_selector_late_promotion_3/v3_selector_route_pilot_0/group1_lo_p v3_four_channel_output_load_integration_0/combined_p VGND sky130_fd_pr__nfet_01v8 ad=0.6206 pd=6.02 as=0 ps=0 w=0.65 l=0.15
X2358 VGND VGND VGND VGND sky130_fd_pr__nfet_01v8 ad=0 pd=0 as=0 ps=0 w=5.07 l=1
X2359 v3_four_channel_output_load_integration_0/v3_four_channel_shared_support_integration_0/v3_four_channel_bias_reference_distribution_0/v3_four_channel_phase_distribution_0/v3_four_channel_output_collection_0/v3_four_channel_placement_0/v3_channel_selector_late_promotion_3/v3_channel_input_bias_late_promotion_0/a_7216_6978# v3_four_channel_output_load_integration_0/v3_four_channel_shared_support_integration_0/v3_tail_bias_support_block_0/vbias VGND VGND sky130_fd_pr__nfet_01v8 ad=1.9575 pd=15.24 as=0 ps=0 w=5.07 l=1
X2360 v3_four_channel_output_load_integration_0/v3_four_channel_shared_support_integration_0/v3_four_channel_bias_reference_distribution_0/v3_four_channel_phase_distribution_0/v3_four_channel_output_collection_0/v3_four_channel_placement_0/v3_channel_selector_late_promotion_3/v3_channel_input_bias_late_promotion_0/a_7216_10978# v3_four_channel_output_load_integration_0/v3_four_channel_shared_support_integration_0/v3_vcm_support_block_0/ref v3_four_channel_output_load_integration_0/v3_four_channel_shared_support_integration_0/v3_four_channel_bias_reference_distribution_0/v3_four_channel_phase_distribution_0/v3_four_channel_output_collection_0/v3_four_channel_placement_0/v3_channel_selector_late_promotion_3/v3_channel_input_bias_late_promotion_0/a_7038_10978# VGND sky130_fd_pr__nfet_01v8 ad=0 pd=0 as=0 ps=0 w=0.84 l=0.6
X2361 v3_four_channel_output_load_integration_0/v3_four_channel_shared_support_integration_0/v3_four_channel_bias_reference_distribution_0/v3_four_channel_phase_distribution_0/v3_four_channel_output_collection_0/v3_four_channel_placement_0/v3_channel_selector_late_promotion_3/v3_channel_input_bias_late_promotion_0/a_4678_15422# v3_four_channel_output_load_integration_0/v3_four_channel_shared_support_integration_0/v3_vcm_support_block_0/ref v3_four_channel_output_load_integration_0/v3_four_channel_shared_support_integration_0/v3_four_channel_bias_reference_distribution_0/v3_four_channel_phase_distribution_0/v3_four_channel_output_collection_0/v3_four_channel_placement_0/v3_channel_selector_late_promotion_3/v3_channel_input_bias_late_promotion_0/a_4382_13688# VGND sky130_fd_pr__nfet_01v8 ad=0 pd=0 as=0 ps=0 w=0.84 l=0.6
X2362 v3_four_channel_output_load_integration_0/v3_four_channel_shared_support_integration_0/v3_four_channel_bias_reference_distribution_0/v3_four_channel_phase_distribution_0/v3_four_channel_output_collection_0/v3_four_channel_placement_0/v3_channel_selector_late_promotion_3/v3_channel_input_bias_late_promotion_0/a_4678_15422# v3_four_channel_output_load_integration_0/v3_four_channel_shared_support_integration_0/v3_four_channel_bias_reference_distribution_0/v3_four_channel_phase_distribution_0/v3_four_channel_output_collection_0/v3_four_channel_placement_0/v3_channel_selector_late_promotion_3/v3_selector_route_pilot_0/group1_lo_p v3_four_channel_output_load_integration_0/combined_n VGND sky130_fd_pr__nfet_01v8 ad=0 pd=0 as=0 ps=0 w=0.65 l=0.15
X2363 v3_four_channel_output_load_integration_0/combined_p v3_four_channel_output_load_integration_0/v3_four_channel_shared_support_integration_0/v3_four_channel_bias_reference_distribution_0/v3_four_channel_phase_distribution_0/v3_four_channel_output_collection_0/v3_four_channel_placement_0/v3_channel_selector_late_promotion_3/v3_selector_route_pilot_0/group3_lo_p v3_four_channel_output_load_integration_0/v3_four_channel_shared_support_integration_0/v3_four_channel_bias_reference_distribution_0/v3_four_channel_phase_distribution_0/v3_four_channel_output_collection_0/v3_four_channel_placement_0/v3_channel_selector_late_promotion_3/v3_channel_input_bias_late_promotion_0/a_4254_22978# VGND sky130_fd_pr__nfet_01v8 ad=0 pd=0 as=0.6206 ps=6.02 w=0.65 l=0.15
X2364 v3_four_channel_output_load_integration_0/v3_four_channel_shared_support_integration_0/v3_four_channel_bias_reference_distribution_0/v3_four_channel_phase_distribution_0/v3_four_channel_output_collection_0/v3_four_channel_placement_0/v3_channel_selector_late_promotion_3/v3_channel_input_bias_late_promotion_0/a_7462_19422# v3_four_channel_output_load_integration_0/v3_four_channel_shared_support_integration_0/v3_vcm_support_block_0/ref v3_four_channel_output_load_integration_0/v3_four_channel_shared_support_integration_0/v3_four_channel_bias_reference_distribution_0/v3_four_channel_phase_distribution_0/v3_four_channel_output_collection_0/v3_four_channel_placement_0/v3_channel_selector_late_promotion_3/v3_channel_input_bias_late_promotion_0/a_7166_17688# VGND sky130_fd_pr__nfet_01v8 ad=0 pd=0 as=0 ps=0 w=0.84 l=0.6
X2365 v3_four_channel_output_load_integration_0/combined_n v3_four_channel_output_load_integration_0/v3_four_channel_shared_support_integration_0/v3_four_channel_bias_reference_distribution_0/v3_four_channel_phase_distribution_0/v3_four_channel_output_collection_0/v3_four_channel_placement_0/v3_channel_selector_late_promotion_3/v3_selector_route_pilot_0/group3_lo_p v3_four_channel_output_load_integration_0/v3_four_channel_shared_support_integration_0/v3_four_channel_bias_reference_distribution_0/v3_four_channel_phase_distribution_0/v3_four_channel_output_collection_0/v3_four_channel_placement_0/v3_channel_selector_late_promotion_3/v3_channel_input_bias_late_promotion_0/a_5646_10978# VGND sky130_fd_pr__nfet_01v8 ad=0 pd=0 as=0 ps=0 w=0.65 l=0.15
X2366 v3_four_channel_output_load_integration_0/combined_n v3_four_channel_output_load_integration_0/v3_four_channel_shared_support_integration_0/v3_four_channel_bias_reference_distribution_0/v3_four_channel_phase_distribution_0/v3_four_channel_output_collection_0/v3_four_channel_placement_0/v3_channel_selector_late_promotion_3/v3_selector_route_pilot_0/group1_lo_p v3_four_channel_output_load_integration_0/v3_four_channel_shared_support_integration_0/v3_four_channel_bias_reference_distribution_0/v3_four_channel_phase_distribution_0/v3_four_channel_output_collection_0/v3_four_channel_placement_0/v3_channel_selector_late_promotion_3/v3_channel_input_bias_late_promotion_0/a_7038_14978# VGND sky130_fd_pr__nfet_01v8 ad=0 pd=0 as=0 ps=0 w=0.65 l=0.15
X2367 v3_four_channel_output_load_integration_0/v3_four_channel_shared_support_integration_0/v3_four_channel_bias_reference_distribution_0/v3_four_channel_phase_distribution_0/v3_four_channel_output_collection_0/v3_four_channel_placement_0/v3_channel_selector_late_promotion_3/v3_channel_input_bias_late_promotion_0/a_7462_19422# v3_four_channel_output_load_integration_0/v3_four_channel_shared_support_integration_0/v3_four_channel_bias_reference_distribution_0/v3_four_channel_phase_distribution_0/v3_four_channel_output_collection_0/v3_four_channel_placement_0/v3_channel_selector_late_promotion_3/v3_selector_route_pilot_0/group2_lo_p v3_four_channel_output_load_integration_0/combined_n VGND sky130_fd_pr__nfet_01v8 ad=0 pd=0 as=0 ps=0 w=0.65 l=0.15
X2368 v3_four_channel_output_load_integration_0/v3_four_channel_shared_support_integration_0/v3_four_channel_bias_reference_distribution_0/v3_four_channel_phase_distribution_0/v3_four_channel_output_collection_0/v3_four_channel_placement_0/v3_channel_selector_late_promotion_3/v3_channel_input_bias_late_promotion_0/a_4678_7422# V3I000 v3_four_channel_output_load_integration_0/v3_four_channel_shared_support_integration_0/v3_four_channel_bias_reference_distribution_0/v3_four_channel_phase_distribution_0/v3_four_channel_output_collection_0/v3_four_channel_placement_0/v3_channel_selector_late_promotion_3/v3_channel_input_bias_late_promotion_0/a_4432_6978# VGND sky130_fd_pr__nfet_01v8 ad=0 pd=0 as=1.9575 ps=15.24 w=0.84 l=0.6
X2369 v3_four_channel_output_load_integration_0/combined_p v3_four_channel_output_load_integration_0/v3_four_channel_shared_support_integration_0/v3_four_channel_bias_reference_distribution_0/v3_four_channel_phase_distribution_0/v3_four_channel_output_collection_0/v3_four_channel_placement_0/v3_channel_selector_late_promotion_3/v3_selector_route_pilot_0/group3_lo_n v3_four_channel_output_load_integration_0/v3_four_channel_shared_support_integration_0/v3_four_channel_bias_reference_distribution_0/v3_four_channel_phase_distribution_0/v3_four_channel_output_collection_0/v3_four_channel_placement_0/v3_channel_selector_late_promotion_3/v3_channel_input_bias_late_promotion_0/a_5646_6978# VGND sky130_fd_pr__nfet_01v8 ad=0 pd=0 as=0 ps=0 w=0.65 l=0.15
X2370 v3_four_channel_output_load_integration_0/v3_four_channel_shared_support_integration_0/v3_four_channel_bias_reference_distribution_0/v3_four_channel_phase_distribution_0/v3_four_channel_output_collection_0/v3_four_channel_placement_0/v3_channel_selector_late_promotion_3/v3_channel_input_bias_late_promotion_0/a_4678_7422# v3_four_channel_output_load_integration_0/v3_four_channel_shared_support_integration_0/v3_four_channel_bias_reference_distribution_0/v3_four_channel_phase_distribution_0/v3_four_channel_output_collection_0/v3_four_channel_placement_0/v3_channel_selector_late_promotion_3/v3_selector_route_pilot_0/group3_lo_n v3_four_channel_output_load_integration_0/combined_n VGND sky130_fd_pr__nfet_01v8 ad=0 pd=0 as=0 ps=0 w=0.65 l=0.15
X2371 v3_four_channel_output_load_integration_0/v3_four_channel_shared_support_integration_0/v3_four_channel_bias_reference_distribution_0/v3_four_channel_phase_distribution_0/v3_four_channel_output_collection_0/v3_four_channel_placement_0/v3_channel_selector_late_promotion_3/v3_channel_input_bias_late_promotion_0/a_6070_11422# V3I000 v3_four_channel_output_load_integration_0/v3_four_channel_shared_support_integration_0/v3_four_channel_bias_reference_distribution_0/v3_four_channel_phase_distribution_0/v3_four_channel_output_collection_0/v3_four_channel_placement_0/v3_channel_selector_late_promotion_3/v3_channel_input_bias_late_promotion_0/a_5824_10978# VGND sky130_fd_pr__nfet_01v8 ad=0 pd=0 as=0 ps=0 w=0.84 l=0.6
X2372 v3_four_channel_output_load_integration_0/v3_four_channel_shared_support_integration_0/v3_four_channel_bias_reference_distribution_0/v3_four_channel_phase_distribution_0/v3_four_channel_output_collection_0/v3_four_channel_placement_0/v3_channel_selector_late_promotion_3/v3_channel_input_bias_late_promotion_0/a_6070_11422# v3_four_channel_output_load_integration_0/v3_four_channel_shared_support_integration_0/v3_four_channel_bias_reference_distribution_0/v3_four_channel_phase_distribution_0/v3_four_channel_output_collection_0/v3_four_channel_placement_0/v3_channel_selector_late_promotion_3/v3_selector_route_pilot_0/group3_lo_n v3_four_channel_output_load_integration_0/combined_n VGND sky130_fd_pr__nfet_01v8 ad=0 pd=0 as=0 ps=0 w=0.65 l=0.15
X2373 v3_four_channel_output_load_integration_0/v3_four_channel_shared_support_integration_0/v3_four_channel_bias_reference_distribution_0/v3_four_channel_phase_distribution_0/v3_four_channel_output_collection_0/v3_four_channel_placement_0/v3_channel_selector_late_promotion_3/v3_channel_input_bias_late_promotion_0/a_4382_21688# V3I000 v3_four_channel_output_load_integration_0/v3_four_channel_shared_support_integration_0/v3_four_channel_bias_reference_distribution_0/v3_four_channel_phase_distribution_0/v3_four_channel_output_collection_0/v3_four_channel_placement_0/v3_channel_selector_late_promotion_3/v3_channel_input_bias_late_promotion_0/a_4254_22978# VGND sky130_fd_pr__nfet_01v8 ad=0 pd=0 as=0 ps=0 w=0.84 l=0.6
X2374 v3_four_channel_output_load_integration_0/v3_four_channel_shared_support_integration_0/v3_four_channel_bias_reference_distribution_0/v3_four_channel_phase_distribution_0/v3_four_channel_output_collection_0/v3_four_channel_placement_0/v3_channel_selector_late_promotion_3/v3_channel_input_bias_late_promotion_0/a_4678_23422# v3_four_channel_output_load_integration_0/v3_four_channel_shared_support_integration_0/v3_four_channel_bias_reference_distribution_0/v3_four_channel_phase_distribution_0/v3_four_channel_output_collection_0/v3_four_channel_placement_0/v3_channel_selector_late_promotion_3/v3_selector_route_pilot_0/group3_lo_n v3_four_channel_output_load_integration_0/combined_p VGND sky130_fd_pr__nfet_01v8 ad=0 pd=0 as=0 ps=0 w=0.65 l=0.15
X2375 v3_four_channel_output_load_integration_0/combined_p v3_four_channel_output_load_integration_0/v3_four_channel_shared_support_integration_0/v3_four_channel_bias_reference_distribution_0/v3_four_channel_phase_distribution_0/v3_four_channel_output_collection_0/v3_four_channel_placement_0/v3_channel_selector_late_promotion_3/v3_selector_route_pilot_0/group3_lo_n v3_four_channel_output_load_integration_0/v3_four_channel_shared_support_integration_0/v3_four_channel_bias_reference_distribution_0/v3_four_channel_phase_distribution_0/v3_four_channel_output_collection_0/v3_four_channel_placement_0/v3_channel_selector_late_promotion_3/v3_channel_input_bias_late_promotion_0/a_4254_6978# VGND sky130_fd_pr__nfet_01v8 ad=0 pd=0 as=0 ps=0 w=0.65 l=0.15
X2376 v3_four_channel_output_load_integration_0/v3_four_channel_shared_support_integration_0/v3_four_channel_bias_reference_distribution_0/v3_four_channel_phase_distribution_0/v3_four_channel_output_collection_0/v3_four_channel_placement_0/v3_channel_selector_late_promotion_3/v3_channel_input_bias_late_promotion_0/a_5774_13688# V3I000 v3_four_channel_output_load_integration_0/v3_four_channel_shared_support_integration_0/v3_four_channel_bias_reference_distribution_0/v3_four_channel_phase_distribution_0/v3_four_channel_output_collection_0/v3_four_channel_placement_0/v3_channel_selector_late_promotion_3/v3_channel_input_bias_late_promotion_0/a_5646_14978# VGND sky130_fd_pr__nfet_01v8 ad=0 pd=0 as=0 ps=0 w=0.84 l=0.6
X2377 v3_four_channel_output_load_integration_0/combined_p v3_four_channel_output_load_integration_0/v3_four_channel_shared_support_integration_0/v3_four_channel_bias_reference_distribution_0/v3_four_channel_phase_distribution_0/v3_four_channel_output_collection_0/v3_four_channel_placement_0/v3_channel_selector_late_promotion_3/v3_selector_route_pilot_0/group3_lo_p v3_four_channel_output_load_integration_0/v3_four_channel_shared_support_integration_0/v3_four_channel_bias_reference_distribution_0/v3_four_channel_phase_distribution_0/v3_four_channel_output_collection_0/v3_four_channel_placement_0/v3_channel_selector_late_promotion_3/v3_channel_input_bias_late_promotion_0/a_7038_22978# VGND sky130_fd_pr__nfet_01v8 ad=0 pd=0 as=0 ps=0 w=0.65 l=0.15
X2378 v3_four_channel_output_load_integration_0/v3_four_channel_shared_support_integration_0/v3_four_channel_bias_reference_distribution_0/v3_four_channel_phase_distribution_0/v3_four_channel_output_collection_0/v3_four_channel_placement_0/v3_channel_selector_late_promotion_3/v3_channel_input_bias_late_promotion_0/a_7462_7422# V3I000 v3_four_channel_output_load_integration_0/v3_four_channel_shared_support_integration_0/v3_four_channel_bias_reference_distribution_0/v3_four_channel_phase_distribution_0/v3_four_channel_output_collection_0/v3_four_channel_placement_0/v3_channel_selector_late_promotion_3/v3_channel_input_bias_late_promotion_0/a_7216_6978# VGND sky130_fd_pr__nfet_01v8 ad=0 pd=0 as=0 ps=0 w=0.84 l=0.6
X2379 v3_four_channel_output_load_integration_0/v3_four_channel_shared_support_integration_0/v3_four_channel_bias_reference_distribution_0/v3_four_channel_phase_distribution_0/v3_four_channel_output_collection_0/v3_four_channel_placement_0/v3_channel_selector_late_promotion_3/v3_channel_input_bias_late_promotion_0/a_4432_10978# v3_four_channel_output_load_integration_0/v3_four_channel_shared_support_integration_0/v3_tail_bias_support_block_0/vbias VGND VGND sky130_fd_pr__nfet_01v8 ad=0 pd=0 as=0 ps=0 w=5.07 l=1
X2380 v3_four_channel_output_load_integration_0/v3_four_channel_shared_support_integration_0/v3_four_channel_bias_reference_distribution_0/v3_four_channel_phase_distribution_0/v3_four_channel_output_collection_0/v3_four_channel_placement_0/v3_channel_selector_late_promotion_3/v3_channel_input_bias_late_promotion_0/a_7462_7422# v3_four_channel_output_load_integration_0/v3_four_channel_shared_support_integration_0/v3_four_channel_bias_reference_distribution_0/v3_four_channel_phase_distribution_0/v3_four_channel_output_collection_0/v3_four_channel_placement_0/v3_channel_selector_late_promotion_3/v3_selector_route_pilot_0/group3_lo_n v3_four_channel_output_load_integration_0/combined_n VGND sky130_fd_pr__nfet_01v8 ad=0 pd=0 as=0 ps=0 w=0.65 l=0.15
X2381 VGND v3_four_channel_output_load_integration_0/v3_four_channel_shared_support_integration_0/v3_tail_bias_support_block_0/vbias v3_four_channel_output_load_integration_0/v3_four_channel_shared_support_integration_0/v3_four_channel_bias_reference_distribution_0/v3_four_channel_phase_distribution_0/v3_four_channel_output_collection_0/v3_four_channel_placement_0/v3_channel_selector_late_promotion_3/v3_channel_input_bias_late_promotion_0/a_4382_17688# VGND sky130_fd_pr__nfet_01v8 ad=0 pd=0 as=0 ps=0 w=5.07 l=1
X2382 v3_four_channel_output_load_integration_0/combined_p v3_four_channel_output_load_integration_0/v3_four_channel_shared_support_integration_0/v3_four_channel_bias_reference_distribution_0/v3_four_channel_phase_distribution_0/v3_four_channel_output_collection_0/v3_four_channel_placement_0/v3_channel_selector_late_promotion_3/v3_selector_route_pilot_0/group3_lo_n v3_four_channel_output_load_integration_0/v3_four_channel_shared_support_integration_0/v3_four_channel_bias_reference_distribution_0/v3_four_channel_phase_distribution_0/v3_four_channel_output_collection_0/v3_four_channel_placement_0/v3_channel_selector_late_promotion_3/v3_channel_input_bias_late_promotion_0/a_7038_6978# VGND sky130_fd_pr__nfet_01v8 ad=0 pd=0 as=0 ps=0 w=0.65 l=0.15
X2383 v3_four_channel_output_load_integration_0/combined_n v3_four_channel_output_load_integration_0/v3_four_channel_shared_support_integration_0/v3_four_channel_bias_reference_distribution_0/v3_four_channel_phase_distribution_0/v3_four_channel_output_collection_0/v3_four_channel_placement_0/v3_channel_selector_late_promotion_3/v3_selector_route_pilot_0/group2_lo_p v3_four_channel_output_load_integration_0/v3_four_channel_shared_support_integration_0/v3_four_channel_bias_reference_distribution_0/v3_four_channel_phase_distribution_0/v3_four_channel_output_collection_0/v3_four_channel_placement_0/v3_channel_selector_late_promotion_3/v3_channel_input_bias_late_promotion_0/a_4254_10978# VGND sky130_fd_pr__nfet_01v8 ad=0 pd=0 as=0 ps=0 w=0.65 l=0.15
X2384 v3_four_channel_output_load_integration_0/v3_four_channel_shared_support_integration_0/v3_four_channel_bias_reference_distribution_0/v3_four_channel_phase_distribution_0/v3_four_channel_output_collection_0/v3_four_channel_placement_0/v3_channel_selector_late_promotion_3/v3_channel_input_bias_late_promotion_0/a_7462_11422# v3_four_channel_output_load_integration_0/v3_four_channel_shared_support_integration_0/v3_four_channel_bias_reference_distribution_0/v3_four_channel_phase_distribution_0/v3_four_channel_output_collection_0/v3_four_channel_placement_0/v3_channel_selector_late_promotion_3/v3_selector_route_pilot_0/group2_lo_p v3_four_channel_output_load_integration_0/combined_p VGND sky130_fd_pr__nfet_01v8 ad=0 pd=0 as=0 ps=0 w=0.65 l=0.15
X2385 v3_four_channel_output_load_integration_0/v3_four_channel_shared_support_integration_0/v3_four_channel_bias_reference_distribution_0/v3_four_channel_phase_distribution_0/v3_four_channel_output_collection_0/v3_four_channel_placement_0/v3_channel_selector_late_promotion_3/v3_channel_input_bias_late_promotion_0/a_7166_21688# V3I000 v3_four_channel_output_load_integration_0/v3_four_channel_shared_support_integration_0/v3_four_channel_bias_reference_distribution_0/v3_four_channel_phase_distribution_0/v3_four_channel_output_collection_0/v3_four_channel_placement_0/v3_channel_selector_late_promotion_3/v3_channel_input_bias_late_promotion_0/a_7038_22978# VGND sky130_fd_pr__nfet_01v8 ad=0 pd=0 as=0 ps=0 w=0.84 l=0.6
X2386 v3_four_channel_output_load_integration_0/combined_n v3_four_channel_output_load_integration_0/v3_four_channel_shared_support_integration_0/v3_four_channel_bias_reference_distribution_0/v3_four_channel_phase_distribution_0/v3_four_channel_output_collection_0/v3_four_channel_placement_0/v3_channel_selector_late_promotion_3/v3_selector_route_pilot_0/group3_lo_n v3_four_channel_output_load_integration_0/v3_four_channel_shared_support_integration_0/v3_four_channel_bias_reference_distribution_0/v3_four_channel_phase_distribution_0/v3_four_channel_output_collection_0/v3_four_channel_placement_0/v3_channel_selector_late_promotion_3/v3_channel_input_bias_late_promotion_0/a_5646_22978# VGND sky130_fd_pr__nfet_01v8 ad=0 pd=0 as=0 ps=0 w=0.65 l=0.15
X2387 v3_four_channel_output_load_integration_0/v3_four_channel_shared_support_integration_0/v3_four_channel_bias_reference_distribution_0/v3_four_channel_phase_distribution_0/v3_four_channel_output_collection_0/v3_four_channel_placement_0/v3_channel_selector_late_promotion_3/v3_channel_input_bias_late_promotion_0/a_4678_11422# V3I000 v3_four_channel_output_load_integration_0/v3_four_channel_shared_support_integration_0/v3_four_channel_bias_reference_distribution_0/v3_four_channel_phase_distribution_0/v3_four_channel_output_collection_0/v3_four_channel_placement_0/v3_channel_selector_late_promotion_3/v3_channel_input_bias_late_promotion_0/a_4432_10978# VGND sky130_fd_pr__nfet_01v8 ad=0 pd=0 as=0 ps=0 w=0.84 l=0.6
X2388 v3_four_channel_output_load_integration_0/v3_four_channel_shared_support_integration_0/v3_four_channel_bias_reference_distribution_0/v3_four_channel_phase_distribution_0/v3_four_channel_output_collection_0/v3_four_channel_placement_0/v3_channel_selector_late_promotion_3/v3_channel_input_bias_late_promotion_0/a_6070_23422# v3_four_channel_output_load_integration_0/v3_four_channel_shared_support_integration_0/v3_vcm_support_block_0/ref v3_four_channel_output_load_integration_0/v3_four_channel_shared_support_integration_0/v3_four_channel_bias_reference_distribution_0/v3_four_channel_phase_distribution_0/v3_four_channel_output_collection_0/v3_four_channel_placement_0/v3_channel_selector_late_promotion_3/v3_channel_input_bias_late_promotion_0/a_5774_21688# VGND sky130_fd_pr__nfet_01v8 ad=0 pd=0 as=0 ps=0 w=0.84 l=0.6
X2389 v3_four_channel_output_load_integration_0/v3_four_channel_shared_support_integration_0/v3_four_channel_bias_reference_distribution_0/v3_four_channel_phase_distribution_0/v3_four_channel_output_collection_0/v3_four_channel_placement_0/v3_channel_selector_late_promotion_3/v3_channel_input_bias_late_promotion_0/a_6070_23422# v3_four_channel_output_load_integration_0/v3_four_channel_shared_support_integration_0/v3_four_channel_bias_reference_distribution_0/v3_four_channel_phase_distribution_0/v3_four_channel_output_collection_0/v3_four_channel_placement_0/v3_channel_selector_late_promotion_3/v3_selector_route_pilot_0/group3_lo_p v3_four_channel_output_load_integration_0/combined_n VGND sky130_fd_pr__nfet_01v8 ad=0 pd=0 as=0 ps=0 w=0.65 l=0.15
X2390 v3_four_channel_output_load_integration_0/v3_four_channel_shared_support_integration_0/v3_four_channel_bias_reference_distribution_0/v3_four_channel_phase_distribution_0/v3_four_channel_output_collection_0/v3_four_channel_placement_0/v3_channel_selector_late_promotion_3/v3_channel_input_bias_late_promotion_0/a_4678_11422# v3_four_channel_output_load_integration_0/v3_four_channel_shared_support_integration_0/v3_four_channel_bias_reference_distribution_0/v3_four_channel_phase_distribution_0/v3_four_channel_output_collection_0/v3_four_channel_placement_0/v3_channel_selector_late_promotion_3/v3_selector_route_pilot_0/group2_lo_n v3_four_channel_output_load_integration_0/combined_n VGND sky130_fd_pr__nfet_01v8 ad=0 pd=0 as=0 ps=0 w=0.65 l=0.15
X2391 v3_four_channel_output_load_integration_0/v3_four_channel_shared_support_integration_0/v3_four_channel_bias_reference_distribution_0/v3_four_channel_phase_distribution_0/v3_four_channel_output_collection_0/v3_four_channel_placement_0/v3_channel_selector_late_promotion_3/v3_channel_input_bias_late_promotion_0/a_7462_15422# V3I000 v3_four_channel_output_load_integration_0/v3_four_channel_shared_support_integration_0/v3_four_channel_bias_reference_distribution_0/v3_four_channel_phase_distribution_0/v3_four_channel_output_collection_0/v3_four_channel_placement_0/v3_channel_selector_late_promotion_3/v3_channel_input_bias_late_promotion_0/a_7216_14978# VGND sky130_fd_pr__nfet_01v8 ad=0 pd=0 as=0 ps=0 w=0.84 l=0.6
X2392 v3_four_channel_output_load_integration_0/v3_four_channel_shared_support_integration_0/v3_four_channel_bias_reference_distribution_0/v3_four_channel_phase_distribution_0/v3_four_channel_output_collection_0/v3_four_channel_placement_0/v3_channel_selector_late_promotion_3/v3_channel_input_bias_late_promotion_0/a_6070_7422# v3_four_channel_output_load_integration_0/v3_four_channel_shared_support_integration_0/v3_four_channel_bias_reference_distribution_0/v3_four_channel_phase_distribution_0/v3_four_channel_output_collection_0/v3_four_channel_placement_0/v3_channel_selector_late_promotion_3/v3_selector_route_pilot_0/group3_lo_p v3_four_channel_output_load_integration_0/combined_p VGND sky130_fd_pr__nfet_01v8 ad=0 pd=0 as=0 ps=0 w=0.65 l=0.15
X2393 v3_four_channel_output_load_integration_0/combined_n v3_four_channel_output_load_integration_0/v3_four_channel_shared_support_integration_0/v3_four_channel_bias_reference_distribution_0/v3_four_channel_phase_distribution_0/v3_four_channel_output_collection_0/v3_four_channel_placement_0/v3_channel_selector_late_promotion_3/v3_selector_route_pilot_0/group2_lo_p v3_four_channel_output_load_integration_0/v3_four_channel_shared_support_integration_0/v3_four_channel_bias_reference_distribution_0/v3_four_channel_phase_distribution_0/v3_four_channel_output_collection_0/v3_four_channel_placement_0/v3_channel_selector_late_promotion_3/v3_channel_input_bias_late_promotion_0/a_7038_10978# VGND sky130_fd_pr__nfet_01v8 ad=0 pd=0 as=0 ps=0 w=0.65 l=0.15
X2394 v3_four_channel_output_load_integration_0/v3_four_channel_shared_support_integration_0/v3_four_channel_bias_reference_distribution_0/v3_four_channel_phase_distribution_0/v3_four_channel_output_collection_0/v3_four_channel_placement_0/v3_channel_selector_late_promotion_3/v3_channel_input_bias_late_promotion_0/a_7462_15422# v3_four_channel_output_load_integration_0/v3_four_channel_shared_support_integration_0/v3_four_channel_bias_reference_distribution_0/v3_four_channel_phase_distribution_0/v3_four_channel_output_collection_0/v3_four_channel_placement_0/v3_channel_selector_late_promotion_3/v3_selector_route_pilot_0/group1_lo_n v3_four_channel_output_load_integration_0/combined_n VGND sky130_fd_pr__nfet_01v8 ad=0 pd=0 as=0 ps=0 w=0.65 l=0.15
X2395 v3_four_channel_output_load_integration_0/v3_four_channel_shared_support_integration_0/v3_four_channel_bias_reference_distribution_0/v3_four_channel_phase_distribution_0/v3_four_channel_output_collection_0/v3_four_channel_placement_0/v3_channel_selector_late_promotion_3/v3_channel_input_bias_late_promotion_0/a_4432_6978# v3_four_channel_output_load_integration_0/v3_four_channel_shared_support_integration_0/v3_vcm_support_block_0/ref v3_four_channel_output_load_integration_0/v3_four_channel_shared_support_integration_0/v3_four_channel_bias_reference_distribution_0/v3_four_channel_phase_distribution_0/v3_four_channel_output_collection_0/v3_four_channel_placement_0/v3_channel_selector_late_promotion_3/v3_channel_input_bias_late_promotion_0/a_4254_6978# VGND sky130_fd_pr__nfet_01v8 ad=0 pd=0 as=0 ps=0 w=0.84 l=0.6
X2396 v3_four_channel_output_load_integration_0/v3_four_channel_shared_support_integration_0/v3_four_channel_bias_reference_distribution_0/v3_four_channel_phase_distribution_0/v3_four_channel_output_collection_0/v3_four_channel_placement_0/v3_channel_selector_late_promotion_3/v3_channel_input_bias_late_promotion_0/a_5824_10978# v3_four_channel_output_load_integration_0/v3_four_channel_shared_support_integration_0/v3_vcm_support_block_0/ref v3_four_channel_output_load_integration_0/v3_four_channel_shared_support_integration_0/v3_four_channel_bias_reference_distribution_0/v3_four_channel_phase_distribution_0/v3_four_channel_output_collection_0/v3_four_channel_placement_0/v3_channel_selector_late_promotion_3/v3_channel_input_bias_late_promotion_0/a_5646_10978# VGND sky130_fd_pr__nfet_01v8 ad=0 pd=0 as=0 ps=0 w=0.84 l=0.6
X2397 v3_four_channel_output_load_integration_0/combined_n v3_four_channel_output_load_integration_0/v3_four_channel_shared_support_integration_0/v3_four_channel_bias_reference_distribution_0/v3_four_channel_phase_distribution_0/v3_four_channel_output_collection_0/v3_four_channel_placement_0/v3_channel_selector_late_promotion_3/v3_selector_route_pilot_0/group3_lo_n v3_four_channel_output_load_integration_0/v3_four_channel_shared_support_integration_0/v3_four_channel_bias_reference_distribution_0/v3_four_channel_phase_distribution_0/v3_four_channel_output_collection_0/v3_four_channel_placement_0/v3_channel_selector_late_promotion_3/v3_channel_input_bias_late_promotion_0/a_4254_22978# VGND sky130_fd_pr__nfet_01v8 ad=0 pd=0 as=0 ps=0 w=0.65 l=0.15
X2398 v3_four_channel_output_load_integration_0/v3_four_channel_shared_support_integration_0/v3_four_channel_bias_reference_distribution_0/v3_four_channel_phase_distribution_0/v3_four_channel_output_collection_0/v3_four_channel_placement_0/v3_channel_selector_late_promotion_3/v3_channel_input_bias_late_promotion_0/a_7462_23422# v3_four_channel_output_load_integration_0/v3_four_channel_shared_support_integration_0/v3_four_channel_bias_reference_distribution_0/v3_four_channel_phase_distribution_0/v3_four_channel_output_collection_0/v3_four_channel_placement_0/v3_channel_selector_late_promotion_3/v3_selector_route_pilot_0/group3_lo_n v3_four_channel_output_load_integration_0/combined_p VGND sky130_fd_pr__nfet_01v8 ad=0 pd=0 as=0 ps=0 w=0.65 l=0.15
X2399 v3_four_channel_output_load_integration_0/v3_four_channel_shared_support_integration_0/v3_four_channel_bias_reference_distribution_0/v3_four_channel_phase_distribution_0/v3_four_channel_output_collection_0/v3_four_channel_placement_0/v3_channel_selector_late_promotion_3/v3_channel_input_bias_late_promotion_0/a_4432_6978# v3_four_channel_output_load_integration_0/v3_four_channel_shared_support_integration_0/v3_tail_bias_support_block_0/vbias VGND VGND sky130_fd_pr__nfet_01v8 ad=0 pd=0 as=0 ps=0 w=5.07 l=1
X2400 v3_four_channel_output_load_integration_0/v3_four_channel_shared_support_integration_0/v3_four_channel_bias_reference_distribution_0/v3_four_channel_phase_distribution_0/v3_four_channel_output_collection_0/v3_four_channel_placement_0/v3_channel_selector_late_promotion_3/v3_channel_input_bias_late_promotion_0/a_7216_6978# v3_four_channel_output_load_integration_0/v3_four_channel_shared_support_integration_0/v3_vcm_support_block_0/ref v3_four_channel_output_load_integration_0/v3_four_channel_shared_support_integration_0/v3_four_channel_bias_reference_distribution_0/v3_four_channel_phase_distribution_0/v3_four_channel_output_collection_0/v3_four_channel_placement_0/v3_channel_selector_late_promotion_3/v3_channel_input_bias_late_promotion_0/a_7038_6978# VGND sky130_fd_pr__nfet_01v8 ad=0 pd=0 as=0 ps=0 w=0.84 l=0.6
X2401 v3_four_channel_output_load_integration_0/combined_n v3_four_channel_output_load_integration_0/v3_four_channel_shared_support_integration_0/v3_four_channel_bias_reference_distribution_0/v3_four_channel_phase_distribution_0/v3_four_channel_output_collection_0/v3_four_channel_placement_0/v3_channel_selector_late_promotion_3/v3_selector_route_pilot_0/group3_lo_p v3_four_channel_output_load_integration_0/v3_four_channel_shared_support_integration_0/v3_four_channel_bias_reference_distribution_0/v3_four_channel_phase_distribution_0/v3_four_channel_output_collection_0/v3_four_channel_placement_0/v3_channel_selector_late_promotion_3/v3_channel_input_bias_late_promotion_0/a_5646_6978# VGND sky130_fd_pr__nfet_01v8 ad=0 pd=0 as=0 ps=0 w=0.65 l=0.15
X2402 VGND v3_four_channel_output_load_integration_0/v3_four_channel_shared_support_integration_0/v3_tail_bias_support_block_0/vbias v3_four_channel_output_load_integration_0/v3_four_channel_shared_support_integration_0/v3_four_channel_bias_reference_distribution_0/v3_four_channel_phase_distribution_0/v3_four_channel_output_collection_0/v3_four_channel_placement_0/v3_channel_selector_late_promotion_3/v3_channel_input_bias_late_promotion_0/a_4382_13688# VGND sky130_fd_pr__nfet_01v8 ad=0 pd=0 as=0 ps=0 w=5.07 l=1
X2403 VDPWR v3_four_channel_output_load_integration_0/v3_four_channel_shared_support_integration_0/v3_four_channel_bias_reference_distribution_0/v3_four_channel_phase_distribution_0/v3_four_channel_output_collection_0/v3_four_channel_placement_0/v3_channel_selector_late_promotion_3/v3_selector_route_pilot_0/G1_MUX_POS/a_505_21# v3_four_channel_output_load_integration_0/v3_four_channel_shared_support_integration_0/v3_four_channel_bias_reference_distribution_0/v3_four_channel_phase_distribution_0/v3_four_channel_output_collection_0/v3_four_channel_placement_0/v3_channel_selector_late_promotion_3/v3_selector_route_pilot_0/G1_MUX_POS/a_535_374# VDPWR sky130_fd_pr__pfet_01v8_hvt ad=0 pd=0 as=0.0882 ps=1.26 w=0.42 l=0.15
X2404 v3_four_channel_output_load_integration_0/v3_four_channel_shared_support_integration_0/v3_four_channel_bias_reference_distribution_0/v3_four_channel_phase_distribution_0/v3_four_channel_output_collection_0/v3_four_channel_placement_0/v3_channel_selector_late_promotion_3/v3_selector_route_pilot_0/G1_MUX_POS/a_505_21# V3R228 VDPWR VDPWR sky130_fd_pr__pfet_01v8_hvt ad=0.1176 pd=1.4 as=0 ps=0 w=0.42 l=0.15
X2405 v3_four_channel_output_load_integration_0/v3_four_channel_shared_support_integration_0/v3_four_channel_bias_reference_distribution_0/v3_four_channel_phase_distribution_0/v3_four_channel_output_collection_0/v3_four_channel_placement_0/v3_channel_selector_late_promotion_3/v3_selector_route_pilot_0/G1_MUX_POS/a_218_374# V3R228 VDPWR VDPWR sky130_fd_pr__pfet_01v8_hvt ad=0.1533 pd=1.57 as=0 ps=0 w=0.42 l=0.15
X2406 VGND v3_four_channel_output_load_integration_0/v3_four_channel_shared_support_integration_0/v3_four_channel_bias_reference_distribution_0/v3_four_channel_phase_distribution_0/v3_four_channel_output_collection_0/v3_four_channel_placement_0/v3_channel_selector_late_promotion_3/v3_selector_route_pilot_0/G1_MUX_POS/a_505_21# v3_four_channel_output_load_integration_0/v3_four_channel_shared_support_integration_0/v3_four_channel_bias_reference_distribution_0/v3_four_channel_phase_distribution_0/v3_four_channel_output_collection_0/v3_four_channel_placement_0/v3_channel_selector_late_promotion_3/v3_selector_route_pilot_0/G1_MUX_POS/a_439_47# VGND sky130_fd_pr__nfet_01v8 ad=0 pd=0 as=0.1386 ps=1.5 w=0.42 l=0.15
X2407 v3_four_channel_output_load_integration_0/v3_four_channel_shared_support_integration_0/v3_four_channel_bias_reference_distribution_0/v3_four_channel_phase_distribution_0/v3_four_channel_output_collection_0/v3_four_channel_placement_0/v3_channel_selector_late_promotion_3/v3_selector_route_pilot_0/G1_MUX_POS/a_76_199# V3R290 v3_four_channel_output_load_integration_0/v3_four_channel_shared_support_integration_0/v3_four_channel_bias_reference_distribution_0/v3_four_channel_phase_distribution_0/v3_four_channel_output_collection_0/v3_four_channel_placement_0/v3_channel_selector_late_promotion_3/v3_selector_route_pilot_0/G1_MUX_POS/a_218_374# VDPWR sky130_fd_pr__pfet_01v8_hvt ad=0.3864 pd=2.68 as=0 ps=0 w=0.42 l=0.15
X2408 v3_four_channel_output_load_integration_0/v3_four_channel_shared_support_integration_0/v3_four_channel_bias_reference_distribution_0/v3_four_channel_phase_distribution_0/v3_four_channel_output_collection_0/v3_four_channel_placement_0/v3_channel_selector_late_promotion_3/v3_selector_route_pilot_0/G1_MUX_POS/a_505_21# V3R228 VGND VGND sky130_fd_pr__nfet_01v8 ad=0.1092 pd=1.36 as=0 ps=0 w=0.42 l=0.15
X2409 v3_four_channel_output_load_integration_0/v3_four_channel_shared_support_integration_0/v3_four_channel_bias_reference_distribution_0/v3_four_channel_phase_distribution_0/v3_four_channel_output_collection_0/v3_four_channel_placement_0/v3_channel_selector_late_promotion_3/v3_selector_route_pilot_0/G1_MUX_POS/a_439_47# V3R290 v3_four_channel_output_load_integration_0/v3_four_channel_shared_support_integration_0/v3_four_channel_bias_reference_distribution_0/v3_four_channel_phase_distribution_0/v3_four_channel_output_collection_0/v3_four_channel_placement_0/v3_channel_selector_late_promotion_3/v3_selector_route_pilot_0/G1_MUX_POS/a_76_199# VGND sky130_fd_pr__nfet_01v8 ad=0 pd=0 as=0.1995 ps=1.79 w=0.42 l=0.15
X2410 v3_four_channel_output_load_integration_0/v3_four_channel_shared_support_integration_0/v3_four_channel_bias_reference_distribution_0/v3_four_channel_phase_distribution_0/v3_four_channel_output_collection_0/v3_four_channel_placement_0/v3_channel_selector_late_promotion_3/v3_selector_route_pilot_0/G1_MUX_POS/a_535_374# V3R291 v3_four_channel_output_load_integration_0/v3_four_channel_shared_support_integration_0/v3_four_channel_bias_reference_distribution_0/v3_four_channel_phase_distribution_0/v3_four_channel_output_collection_0/v3_four_channel_placement_0/v3_channel_selector_late_promotion_3/v3_selector_route_pilot_0/G1_MUX_POS/a_76_199# VDPWR sky130_fd_pr__pfet_01v8_hvt ad=0 pd=0 as=0 ps=0 w=0.42 l=0.15
X2411 v3_four_channel_output_load_integration_0/v3_four_channel_shared_support_integration_0/v3_four_channel_bias_reference_distribution_0/v3_four_channel_phase_distribution_0/v3_four_channel_output_collection_0/v3_four_channel_placement_0/v3_channel_selector_late_promotion_3/v3_selector_route_pilot_0/G1_MUX_POS/a_76_199# V3R291 v3_four_channel_output_load_integration_0/v3_four_channel_shared_support_integration_0/v3_four_channel_bias_reference_distribution_0/v3_four_channel_phase_distribution_0/v3_four_channel_output_collection_0/v3_four_channel_placement_0/v3_channel_selector_late_promotion_3/v3_selector_route_pilot_0/G1_MUX_POS/a_218_47# VGND sky130_fd_pr__nfet_01v8 ad=0 pd=0 as=0.1386 ps=1.5 w=0.42 l=0.15
X2412 v3_four_channel_output_load_integration_0/v3_four_channel_shared_support_integration_0/v3_four_channel_bias_reference_distribution_0/v3_four_channel_phase_distribution_0/v3_four_channel_output_collection_0/v3_four_channel_placement_0/v3_channel_selector_late_promotion_3/v3_selector_route_pilot_0/G1_MUX_POS/a_218_47# V3R228 VGND VGND sky130_fd_pr__nfet_01v8 ad=0 pd=0 as=0 ps=0 w=0.42 l=0.15
X2413 VDPWR v3_four_channel_output_load_integration_0/v3_four_channel_shared_support_integration_0/v3_four_channel_bias_reference_distribution_0/v3_four_channel_phase_distribution_0/v3_four_channel_output_collection_0/v3_four_channel_placement_0/v3_channel_selector_late_promotion_3/v3_selector_route_pilot_0/G1_MUX_POS/a_76_199# v3_four_channel_output_load_integration_0/v3_four_channel_shared_support_integration_0/v3_four_channel_bias_reference_distribution_0/v3_four_channel_phase_distribution_0/v3_four_channel_output_collection_0/v3_four_channel_placement_0/v3_channel_selector_late_promotion_3/v3_selector_route_pilot_0/G1_MUX_POS/X VDPWR sky130_fd_pr__pfet_01v8_hvt ad=0 pd=0 as=0.26 ps=2.52 w=1 l=0.15
X2414 VGND v3_four_channel_output_load_integration_0/v3_four_channel_shared_support_integration_0/v3_four_channel_bias_reference_distribution_0/v3_four_channel_phase_distribution_0/v3_four_channel_output_collection_0/v3_four_channel_placement_0/v3_channel_selector_late_promotion_3/v3_selector_route_pilot_0/G1_MUX_POS/a_76_199# v3_four_channel_output_load_integration_0/v3_four_channel_shared_support_integration_0/v3_four_channel_bias_reference_distribution_0/v3_four_channel_phase_distribution_0/v3_four_channel_output_collection_0/v3_four_channel_placement_0/v3_channel_selector_late_promotion_3/v3_selector_route_pilot_0/G1_MUX_POS/X VGND sky130_fd_pr__nfet_01v8 ad=0 pd=0 as=0.169 ps=1.82 w=0.65 l=0.15
X2415 VDPWR v3_four_channel_output_load_integration_0/v3_four_channel_shared_support_integration_0/v3_four_channel_bias_reference_distribution_0/v3_four_channel_phase_distribution_0/v3_four_channel_output_collection_0/v3_four_channel_placement_0/v3_channel_selector_late_promotion_3/v3_selector_route_pilot_0/G3_MUX_AXIS/a_505_21# v3_four_channel_output_load_integration_0/v3_four_channel_shared_support_integration_0/v3_four_channel_bias_reference_distribution_0/v3_four_channel_phase_distribution_0/v3_four_channel_output_collection_0/v3_four_channel_placement_0/v3_channel_selector_late_promotion_3/v3_selector_route_pilot_0/G3_MUX_AXIS/a_535_374# VDPWR sky130_fd_pr__pfet_01v8_hvt ad=0 pd=0 as=0.0882 ps=1.26 w=0.42 l=0.15
X2416 v3_four_channel_output_load_integration_0/v3_four_channel_shared_support_integration_0/v3_four_channel_bias_reference_distribution_0/v3_four_channel_phase_distribution_0/v3_four_channel_output_collection_0/v3_four_channel_placement_0/v3_channel_selector_late_promotion_3/v3_selector_route_pilot_0/G3_MUX_AXIS/a_505_21# V3R235 VDPWR VDPWR sky130_fd_pr__pfet_01v8_hvt ad=0.1176 pd=1.4 as=0 ps=0 w=0.42 l=0.15
X2417 v3_four_channel_output_load_integration_0/v3_four_channel_shared_support_integration_0/v3_four_channel_bias_reference_distribution_0/v3_four_channel_phase_distribution_0/v3_four_channel_output_collection_0/v3_four_channel_placement_0/v3_channel_selector_late_promotion_3/v3_selector_route_pilot_0/G3_MUX_AXIS/a_218_374# V3R235 VDPWR VDPWR sky130_fd_pr__pfet_01v8_hvt ad=0.1533 pd=1.57 as=0 ps=0 w=0.42 l=0.15
X2418 VGND v3_four_channel_output_load_integration_0/v3_four_channel_shared_support_integration_0/v3_four_channel_bias_reference_distribution_0/v3_four_channel_phase_distribution_0/v3_four_channel_output_collection_0/v3_four_channel_placement_0/v3_channel_selector_late_promotion_3/v3_selector_route_pilot_0/G3_MUX_AXIS/a_505_21# v3_four_channel_output_load_integration_0/v3_four_channel_shared_support_integration_0/v3_four_channel_bias_reference_distribution_0/v3_four_channel_phase_distribution_0/v3_four_channel_output_collection_0/v3_four_channel_placement_0/v3_channel_selector_late_promotion_3/v3_selector_route_pilot_0/G3_MUX_AXIS/a_439_47# VGND sky130_fd_pr__nfet_01v8 ad=0 pd=0 as=0.1386 ps=1.5 w=0.42 l=0.15
X2419 v3_four_channel_output_load_integration_0/v3_four_channel_shared_support_integration_0/v3_four_channel_bias_reference_distribution_0/v3_four_channel_phase_distribution_0/v3_four_channel_output_collection_0/v3_four_channel_placement_0/v3_channel_selector_late_promotion_3/v3_selector_route_pilot_0/G3_MUX_AXIS/a_76_199# v3_four_channel_output_load_integration_0/v3_four_channel_shared_support_integration_0/v3_four_channel_bias_reference_distribution_0/v3_four_channel_phase_distribution_0/v3_four_channel_output_collection_0/v3_four_channel_placement_0/v3_channel_selector_late_promotion_3/v3_selector_route_pilot_0/G3_MUX_POS/X v3_four_channel_output_load_integration_0/v3_four_channel_shared_support_integration_0/v3_four_channel_bias_reference_distribution_0/v3_four_channel_phase_distribution_0/v3_four_channel_output_collection_0/v3_four_channel_placement_0/v3_channel_selector_late_promotion_3/v3_selector_route_pilot_0/G3_MUX_AXIS/a_218_374# VDPWR sky130_fd_pr__pfet_01v8_hvt ad=0.3864 pd=2.68 as=0 ps=0 w=0.42 l=0.15
X2420 v3_four_channel_output_load_integration_0/v3_four_channel_shared_support_integration_0/v3_four_channel_bias_reference_distribution_0/v3_four_channel_phase_distribution_0/v3_four_channel_output_collection_0/v3_four_channel_placement_0/v3_channel_selector_late_promotion_3/v3_selector_route_pilot_0/G3_MUX_AXIS/a_505_21# V3R235 VGND VGND sky130_fd_pr__nfet_01v8 ad=0.1092 pd=1.36 as=0 ps=0 w=0.42 l=0.15
X2421 v3_four_channel_output_load_integration_0/v3_four_channel_shared_support_integration_0/v3_four_channel_bias_reference_distribution_0/v3_four_channel_phase_distribution_0/v3_four_channel_output_collection_0/v3_four_channel_placement_0/v3_channel_selector_late_promotion_3/v3_selector_route_pilot_0/G3_MUX_AXIS/a_439_47# v3_four_channel_output_load_integration_0/v3_four_channel_shared_support_integration_0/v3_four_channel_bias_reference_distribution_0/v3_four_channel_phase_distribution_0/v3_four_channel_output_collection_0/v3_four_channel_placement_0/v3_channel_selector_late_promotion_3/v3_selector_route_pilot_0/G3_MUX_POS/X v3_four_channel_output_load_integration_0/v3_four_channel_shared_support_integration_0/v3_four_channel_bias_reference_distribution_0/v3_four_channel_phase_distribution_0/v3_four_channel_output_collection_0/v3_four_channel_placement_0/v3_channel_selector_late_promotion_3/v3_selector_route_pilot_0/G3_MUX_AXIS/a_76_199# VGND sky130_fd_pr__nfet_01v8 ad=0 pd=0 as=0.1995 ps=1.79 w=0.42 l=0.15
X2422 v3_four_channel_output_load_integration_0/v3_four_channel_shared_support_integration_0/v3_four_channel_bias_reference_distribution_0/v3_four_channel_phase_distribution_0/v3_four_channel_output_collection_0/v3_four_channel_placement_0/v3_channel_selector_late_promotion_3/v3_selector_route_pilot_0/G3_MUX_AXIS/a_535_374# v3_four_channel_output_load_integration_0/v3_four_channel_shared_support_integration_0/v3_four_channel_bias_reference_distribution_0/v3_four_channel_phase_distribution_0/v3_four_channel_output_collection_0/v3_four_channel_placement_0/v3_channel_selector_late_promotion_3/v3_selector_route_pilot_0/G3_MUX_NEG/X v3_four_channel_output_load_integration_0/v3_four_channel_shared_support_integration_0/v3_four_channel_bias_reference_distribution_0/v3_four_channel_phase_distribution_0/v3_four_channel_output_collection_0/v3_four_channel_placement_0/v3_channel_selector_late_promotion_3/v3_selector_route_pilot_0/G3_MUX_AXIS/a_76_199# VDPWR sky130_fd_pr__pfet_01v8_hvt ad=0 pd=0 as=0 ps=0 w=0.42 l=0.15
X2423 v3_four_channel_output_load_integration_0/v3_four_channel_shared_support_integration_0/v3_four_channel_bias_reference_distribution_0/v3_four_channel_phase_distribution_0/v3_four_channel_output_collection_0/v3_four_channel_placement_0/v3_channel_selector_late_promotion_3/v3_selector_route_pilot_0/G3_MUX_AXIS/a_76_199# v3_four_channel_output_load_integration_0/v3_four_channel_shared_support_integration_0/v3_four_channel_bias_reference_distribution_0/v3_four_channel_phase_distribution_0/v3_four_channel_output_collection_0/v3_four_channel_placement_0/v3_channel_selector_late_promotion_3/v3_selector_route_pilot_0/G3_MUX_NEG/X v3_four_channel_output_load_integration_0/v3_four_channel_shared_support_integration_0/v3_four_channel_bias_reference_distribution_0/v3_four_channel_phase_distribution_0/v3_four_channel_output_collection_0/v3_four_channel_placement_0/v3_channel_selector_late_promotion_3/v3_selector_route_pilot_0/G3_MUX_AXIS/a_218_47# VGND sky130_fd_pr__nfet_01v8 ad=0 pd=0 as=0.1386 ps=1.5 w=0.42 l=0.15
X2424 v3_four_channel_output_load_integration_0/v3_four_channel_shared_support_integration_0/v3_four_channel_bias_reference_distribution_0/v3_four_channel_phase_distribution_0/v3_four_channel_output_collection_0/v3_four_channel_placement_0/v3_channel_selector_late_promotion_3/v3_selector_route_pilot_0/G3_MUX_AXIS/a_218_47# V3R235 VGND VGND sky130_fd_pr__nfet_01v8 ad=0 pd=0 as=0 ps=0 w=0.42 l=0.15
X2425 VDPWR v3_four_channel_output_load_integration_0/v3_four_channel_shared_support_integration_0/v3_four_channel_bias_reference_distribution_0/v3_four_channel_phase_distribution_0/v3_four_channel_output_collection_0/v3_four_channel_placement_0/v3_channel_selector_late_promotion_3/v3_selector_route_pilot_0/G3_MUX_AXIS/a_76_199# v3_four_channel_output_load_integration_0/v3_four_channel_shared_support_integration_0/v3_four_channel_bias_reference_distribution_0/v3_four_channel_phase_distribution_0/v3_four_channel_output_collection_0/v3_four_channel_placement_0/v3_channel_selector_late_promotion_3/v3_selector_route_pilot_0/G3_MUX_AXIS/X VDPWR sky130_fd_pr__pfet_01v8_hvt ad=0 pd=0 as=0.26 ps=2.52 w=1 l=0.15
X2426 VGND v3_four_channel_output_load_integration_0/v3_four_channel_shared_support_integration_0/v3_four_channel_bias_reference_distribution_0/v3_four_channel_phase_distribution_0/v3_four_channel_output_collection_0/v3_four_channel_placement_0/v3_channel_selector_late_promotion_3/v3_selector_route_pilot_0/G3_MUX_AXIS/a_76_199# v3_four_channel_output_load_integration_0/v3_four_channel_shared_support_integration_0/v3_four_channel_bias_reference_distribution_0/v3_four_channel_phase_distribution_0/v3_four_channel_output_collection_0/v3_four_channel_placement_0/v3_channel_selector_late_promotion_3/v3_selector_route_pilot_0/G3_MUX_AXIS/X VGND sky130_fd_pr__nfet_01v8 ad=0 pd=0 as=0.169 ps=1.82 w=0.65 l=0.15
X2427 VDPWR V3R068 v3_four_channel_output_load_integration_0/v3_four_channel_shared_support_integration_0/v3_four_channel_bias_reference_distribution_0/v3_four_channel_phase_distribution_0/v3_four_channel_output_collection_0/v3_four_channel_placement_0/v3_channel_selector_late_promotion_3/v3_selector_route_pilot_0/ENABLE_ANDNOT/a_207_413# VDPWR sky130_fd_pr__pfet_01v8_hvt ad=0 pd=0 as=0.1218 ps=1.42 w=0.42 l=0.15
X2428 v3_four_channel_output_load_integration_0/v3_four_channel_shared_support_integration_0/v3_four_channel_bias_reference_distribution_0/v3_four_channel_phase_distribution_0/v3_four_channel_output_collection_0/v3_four_channel_placement_0/v3_channel_selector_late_promotion_3/v3_selector_route_pilot_0/G3_LO_P_AND/B v3_four_channel_output_load_integration_0/v3_four_channel_shared_support_integration_0/v3_four_channel_bias_reference_distribution_0/v3_four_channel_phase_distribution_0/v3_four_channel_output_collection_0/v3_four_channel_placement_0/v3_channel_selector_late_promotion_3/v3_selector_route_pilot_0/ENABLE_ANDNOT/a_207_413# VDPWR VDPWR sky130_fd_pr__pfet_01v8_hvt ad=0.26 pd=2.52 as=0 ps=0 w=1 l=0.15
X2429 v3_four_channel_output_load_integration_0/v3_four_channel_shared_support_integration_0/v3_four_channel_bias_reference_distribution_0/v3_four_channel_phase_distribution_0/v3_four_channel_output_collection_0/v3_four_channel_placement_0/v3_channel_selector_late_promotion_3/v3_selector_route_pilot_0/ENABLE_ANDNOT/a_297_47# v3_four_channel_output_load_integration_0/v3_four_channel_shared_support_integration_0/v3_four_channel_bias_reference_distribution_0/v3_four_channel_phase_distribution_0/v3_four_channel_output_collection_0/v3_four_channel_placement_0/v3_channel_selector_late_promotion_3/v3_selector_route_pilot_0/ENABLE_ANDNOT/a_27_413# v3_four_channel_output_load_integration_0/v3_four_channel_shared_support_integration_0/v3_four_channel_bias_reference_distribution_0/v3_four_channel_phase_distribution_0/v3_four_channel_output_collection_0/v3_four_channel_placement_0/v3_channel_selector_late_promotion_3/v3_selector_route_pilot_0/ENABLE_ANDNOT/a_207_413# VGND sky130_fd_pr__nfet_01v8 ad=0.1008 pd=1.32 as=0.1092 ps=1.36 w=0.42 l=0.15
X2430 v3_four_channel_output_load_integration_0/v3_four_channel_shared_support_integration_0/v3_four_channel_bias_reference_distribution_0/v3_four_channel_phase_distribution_0/v3_four_channel_output_collection_0/v3_four_channel_placement_0/v3_channel_selector_late_promotion_3/v3_selector_route_pilot_0/G3_LO_P_AND/B v3_four_channel_output_load_integration_0/v3_four_channel_shared_support_integration_0/v3_four_channel_bias_reference_distribution_0/v3_four_channel_phase_distribution_0/v3_four_channel_output_collection_0/v3_four_channel_placement_0/v3_channel_selector_late_promotion_3/v3_selector_route_pilot_0/ENABLE_ANDNOT/a_207_413# VGND VGND sky130_fd_pr__nfet_01v8 ad=0.169 pd=1.82 as=0 ps=0 w=0.65 l=0.15
X2431 v3_four_channel_output_load_integration_0/v3_four_channel_shared_support_integration_0/v3_four_channel_bias_reference_distribution_0/v3_four_channel_phase_distribution_0/v3_four_channel_output_collection_0/v3_four_channel_placement_0/v3_channel_selector_late_promotion_3/v3_selector_route_pilot_0/ENABLE_ANDNOT/a_207_413# v3_four_channel_output_load_integration_0/v3_four_channel_shared_support_integration_0/v3_four_channel_bias_reference_distribution_0/v3_four_channel_phase_distribution_0/v3_four_channel_output_collection_0/v3_four_channel_placement_0/v3_channel_selector_late_promotion_3/v3_selector_route_pilot_0/ENABLE_ANDNOT/a_27_413# VDPWR VDPWR sky130_fd_pr__pfet_01v8_hvt ad=0 pd=0 as=0 ps=0 w=0.42 l=0.15
X2432 VDPWR V3R238 v3_four_channel_output_load_integration_0/v3_four_channel_shared_support_integration_0/v3_four_channel_bias_reference_distribution_0/v3_four_channel_phase_distribution_0/v3_four_channel_output_collection_0/v3_four_channel_placement_0/v3_channel_selector_late_promotion_3/v3_selector_route_pilot_0/ENABLE_ANDNOT/a_27_413# VDPWR sky130_fd_pr__pfet_01v8_hvt ad=0 pd=0 as=0.1092 ps=1.36 w=0.42 l=0.15
X2433 VGND V3R068 v3_four_channel_output_load_integration_0/v3_four_channel_shared_support_integration_0/v3_four_channel_bias_reference_distribution_0/v3_four_channel_phase_distribution_0/v3_four_channel_output_collection_0/v3_four_channel_placement_0/v3_channel_selector_late_promotion_3/v3_selector_route_pilot_0/ENABLE_ANDNOT/a_297_47# VGND sky130_fd_pr__nfet_01v8 ad=0 pd=0 as=0 ps=0 w=0.42 l=0.15
X2434 v3_four_channel_output_load_integration_0/v3_four_channel_shared_support_integration_0/v3_four_channel_bias_reference_distribution_0/v3_four_channel_phase_distribution_0/v3_four_channel_output_collection_0/v3_four_channel_placement_0/v3_channel_selector_late_promotion_3/v3_selector_route_pilot_0/ENABLE_ANDNOT/a_27_413# V3R238 VGND VGND sky130_fd_pr__nfet_01v8 ad=0.1092 pd=1.36 as=0 ps=0 w=0.42 l=0.15
X2435 VDPWR v3_four_channel_output_load_integration_0/v3_four_channel_shared_support_integration_0/v3_four_channel_bias_reference_distribution_0/v3_four_channel_phase_distribution_0/v3_four_channel_output_collection_0/v3_four_channel_placement_0/v3_channel_selector_late_promotion_3/v3_selector_route_pilot_0/G1_MUX_NEG/a_505_21# v3_four_channel_output_load_integration_0/v3_four_channel_shared_support_integration_0/v3_four_channel_bias_reference_distribution_0/v3_four_channel_phase_distribution_0/v3_four_channel_output_collection_0/v3_four_channel_placement_0/v3_channel_selector_late_promotion_3/v3_selector_route_pilot_0/G1_MUX_NEG/a_535_374# VDPWR sky130_fd_pr__pfet_01v8_hvt ad=0 pd=0 as=0.0882 ps=1.26 w=0.42 l=0.15
X2436 v3_four_channel_output_load_integration_0/v3_four_channel_shared_support_integration_0/v3_four_channel_bias_reference_distribution_0/v3_four_channel_phase_distribution_0/v3_four_channel_output_collection_0/v3_four_channel_placement_0/v3_channel_selector_late_promotion_3/v3_selector_route_pilot_0/G1_MUX_NEG/a_505_21# V3R228 VDPWR VDPWR sky130_fd_pr__pfet_01v8_hvt ad=0.1176 pd=1.4 as=0 ps=0 w=0.42 l=0.15
X2437 v3_four_channel_output_load_integration_0/v3_four_channel_shared_support_integration_0/v3_four_channel_bias_reference_distribution_0/v3_four_channel_phase_distribution_0/v3_four_channel_output_collection_0/v3_four_channel_placement_0/v3_channel_selector_late_promotion_3/v3_selector_route_pilot_0/G1_MUX_NEG/a_218_374# V3R228 VDPWR VDPWR sky130_fd_pr__pfet_01v8_hvt ad=0.1533 pd=1.57 as=0 ps=0 w=0.42 l=0.15
X2438 VGND v3_four_channel_output_load_integration_0/v3_four_channel_shared_support_integration_0/v3_four_channel_bias_reference_distribution_0/v3_four_channel_phase_distribution_0/v3_four_channel_output_collection_0/v3_four_channel_placement_0/v3_channel_selector_late_promotion_3/v3_selector_route_pilot_0/G1_MUX_NEG/a_505_21# v3_four_channel_output_load_integration_0/v3_four_channel_shared_support_integration_0/v3_four_channel_bias_reference_distribution_0/v3_four_channel_phase_distribution_0/v3_four_channel_output_collection_0/v3_four_channel_placement_0/v3_channel_selector_late_promotion_3/v3_selector_route_pilot_0/G1_MUX_NEG/a_439_47# VGND sky130_fd_pr__nfet_01v8 ad=0 pd=0 as=0.1386 ps=1.5 w=0.42 l=0.15
X2439 v3_four_channel_output_load_integration_0/v3_four_channel_shared_support_integration_0/v3_four_channel_bias_reference_distribution_0/v3_four_channel_phase_distribution_0/v3_four_channel_output_collection_0/v3_four_channel_placement_0/v3_channel_selector_late_promotion_3/v3_selector_route_pilot_0/G1_MUX_NEG/a_76_199# V3R292 v3_four_channel_output_load_integration_0/v3_four_channel_shared_support_integration_0/v3_four_channel_bias_reference_distribution_0/v3_four_channel_phase_distribution_0/v3_four_channel_output_collection_0/v3_four_channel_placement_0/v3_channel_selector_late_promotion_3/v3_selector_route_pilot_0/G1_MUX_NEG/a_218_374# VDPWR sky130_fd_pr__pfet_01v8_hvt ad=0.3864 pd=2.68 as=0 ps=0 w=0.42 l=0.15
X2440 v3_four_channel_output_load_integration_0/v3_four_channel_shared_support_integration_0/v3_four_channel_bias_reference_distribution_0/v3_four_channel_phase_distribution_0/v3_four_channel_output_collection_0/v3_four_channel_placement_0/v3_channel_selector_late_promotion_3/v3_selector_route_pilot_0/G1_MUX_NEG/a_505_21# V3R228 VGND VGND sky130_fd_pr__nfet_01v8 ad=0.1092 pd=1.36 as=0 ps=0 w=0.42 l=0.15
X2441 v3_four_channel_output_load_integration_0/v3_four_channel_shared_support_integration_0/v3_four_channel_bias_reference_distribution_0/v3_four_channel_phase_distribution_0/v3_four_channel_output_collection_0/v3_four_channel_placement_0/v3_channel_selector_late_promotion_3/v3_selector_route_pilot_0/G1_MUX_NEG/a_439_47# V3R292 v3_four_channel_output_load_integration_0/v3_four_channel_shared_support_integration_0/v3_four_channel_bias_reference_distribution_0/v3_four_channel_phase_distribution_0/v3_four_channel_output_collection_0/v3_four_channel_placement_0/v3_channel_selector_late_promotion_3/v3_selector_route_pilot_0/G1_MUX_NEG/a_76_199# VGND sky130_fd_pr__nfet_01v8 ad=0 pd=0 as=0.1995 ps=1.79 w=0.42 l=0.15
X2442 v3_four_channel_output_load_integration_0/v3_four_channel_shared_support_integration_0/v3_four_channel_bias_reference_distribution_0/v3_four_channel_phase_distribution_0/v3_four_channel_output_collection_0/v3_four_channel_placement_0/v3_channel_selector_late_promotion_3/v3_selector_route_pilot_0/G1_MUX_NEG/a_535_374# V3R293 v3_four_channel_output_load_integration_0/v3_four_channel_shared_support_integration_0/v3_four_channel_bias_reference_distribution_0/v3_four_channel_phase_distribution_0/v3_four_channel_output_collection_0/v3_four_channel_placement_0/v3_channel_selector_late_promotion_3/v3_selector_route_pilot_0/G1_MUX_NEG/a_76_199# VDPWR sky130_fd_pr__pfet_01v8_hvt ad=0 pd=0 as=0 ps=0 w=0.42 l=0.15
X2443 v3_four_channel_output_load_integration_0/v3_four_channel_shared_support_integration_0/v3_four_channel_bias_reference_distribution_0/v3_four_channel_phase_distribution_0/v3_four_channel_output_collection_0/v3_four_channel_placement_0/v3_channel_selector_late_promotion_3/v3_selector_route_pilot_0/G1_MUX_NEG/a_76_199# V3R293 v3_four_channel_output_load_integration_0/v3_four_channel_shared_support_integration_0/v3_four_channel_bias_reference_distribution_0/v3_four_channel_phase_distribution_0/v3_four_channel_output_collection_0/v3_four_channel_placement_0/v3_channel_selector_late_promotion_3/v3_selector_route_pilot_0/G1_MUX_NEG/a_218_47# VGND sky130_fd_pr__nfet_01v8 ad=0 pd=0 as=0.1386 ps=1.5 w=0.42 l=0.15
X2444 v3_four_channel_output_load_integration_0/v3_four_channel_shared_support_integration_0/v3_four_channel_bias_reference_distribution_0/v3_four_channel_phase_distribution_0/v3_four_channel_output_collection_0/v3_four_channel_placement_0/v3_channel_selector_late_promotion_3/v3_selector_route_pilot_0/G1_MUX_NEG/a_218_47# V3R228 VGND VGND sky130_fd_pr__nfet_01v8 ad=0 pd=0 as=0 ps=0 w=0.42 l=0.15
X2445 VDPWR v3_four_channel_output_load_integration_0/v3_four_channel_shared_support_integration_0/v3_four_channel_bias_reference_distribution_0/v3_four_channel_phase_distribution_0/v3_four_channel_output_collection_0/v3_four_channel_placement_0/v3_channel_selector_late_promotion_3/v3_selector_route_pilot_0/G1_MUX_NEG/a_76_199# v3_four_channel_output_load_integration_0/v3_four_channel_shared_support_integration_0/v3_four_channel_bias_reference_distribution_0/v3_four_channel_phase_distribution_0/v3_four_channel_output_collection_0/v3_four_channel_placement_0/v3_channel_selector_late_promotion_3/v3_selector_route_pilot_0/G1_MUX_NEG/X VDPWR sky130_fd_pr__pfet_01v8_hvt ad=0 pd=0 as=0.26 ps=2.52 w=1 l=0.15
X2446 VGND v3_four_channel_output_load_integration_0/v3_four_channel_shared_support_integration_0/v3_four_channel_bias_reference_distribution_0/v3_four_channel_phase_distribution_0/v3_four_channel_output_collection_0/v3_four_channel_placement_0/v3_channel_selector_late_promotion_3/v3_selector_route_pilot_0/G1_MUX_NEG/a_76_199# v3_four_channel_output_load_integration_0/v3_four_channel_shared_support_integration_0/v3_four_channel_bias_reference_distribution_0/v3_four_channel_phase_distribution_0/v3_four_channel_output_collection_0/v3_four_channel_placement_0/v3_channel_selector_late_promotion_3/v3_selector_route_pilot_0/G1_MUX_NEG/X VGND sky130_fd_pr__nfet_01v8 ad=0 pd=0 as=0.169 ps=1.82 w=0.65 l=0.15
X2447 VDPWR v3_four_channel_output_load_integration_0/v3_four_channel_shared_support_integration_0/v3_four_channel_bias_reference_distribution_0/v3_four_channel_phase_distribution_0/v3_four_channel_output_collection_0/v3_four_channel_placement_0/v3_channel_selector_late_promotion_3/v3_selector_route_pilot_0/G3_LO_P_AND/B v3_four_channel_output_load_integration_0/v3_four_channel_shared_support_integration_0/v3_four_channel_bias_reference_distribution_0/v3_four_channel_phase_distribution_0/v3_four_channel_output_collection_0/v3_four_channel_placement_0/v3_channel_selector_late_promotion_3/v3_selector_route_pilot_0/G1_LO_P_AND/a_59_75# VDPWR sky130_fd_pr__pfet_01v8_hvt ad=0 pd=0 as=0.1134 ps=1.38 w=0.42 l=0.15
X2448 v3_four_channel_output_load_integration_0/v3_four_channel_shared_support_integration_0/v3_four_channel_bias_reference_distribution_0/v3_four_channel_phase_distribution_0/v3_four_channel_output_collection_0/v3_four_channel_placement_0/v3_channel_selector_late_promotion_3/v3_selector_route_pilot_0/group1_lo_p v3_four_channel_output_load_integration_0/v3_four_channel_shared_support_integration_0/v3_four_channel_bias_reference_distribution_0/v3_four_channel_phase_distribution_0/v3_four_channel_output_collection_0/v3_four_channel_placement_0/v3_channel_selector_late_promotion_3/v3_selector_route_pilot_0/G1_LO_P_AND/a_59_75# VDPWR VDPWR sky130_fd_pr__pfet_01v8_hvt ad=0.475 pd=2.95 as=0 ps=0 w=1 l=0.15
X2449 VGND v3_four_channel_output_load_integration_0/v3_four_channel_shared_support_integration_0/v3_four_channel_bias_reference_distribution_0/v3_four_channel_phase_distribution_0/v3_four_channel_output_collection_0/v3_four_channel_placement_0/v3_channel_selector_late_promotion_3/v3_selector_route_pilot_0/G3_LO_P_AND/B v3_four_channel_output_load_integration_0/v3_four_channel_shared_support_integration_0/v3_four_channel_bias_reference_distribution_0/v3_four_channel_phase_distribution_0/v3_four_channel_output_collection_0/v3_four_channel_placement_0/v3_channel_selector_late_promotion_3/v3_selector_route_pilot_0/G1_LO_P_AND/a_145_75# VGND sky130_fd_pr__nfet_01v8 ad=0 pd=0 as=0.1134 ps=1.38 w=0.42 l=0.15
X2450 v3_four_channel_output_load_integration_0/v3_four_channel_shared_support_integration_0/v3_four_channel_bias_reference_distribution_0/v3_four_channel_phase_distribution_0/v3_four_channel_output_collection_0/v3_four_channel_placement_0/v3_channel_selector_late_promotion_3/v3_selector_route_pilot_0/G1_LO_P_AND/a_59_75# v3_four_channel_output_load_integration_0/v3_four_channel_shared_support_integration_0/v3_four_channel_bias_reference_distribution_0/v3_four_channel_phase_distribution_0/v3_four_channel_output_collection_0/v3_four_channel_placement_0/v3_channel_selector_late_promotion_3/v3_selector_route_pilot_0/G1_MUX_AXIS/X VDPWR VDPWR sky130_fd_pr__pfet_01v8_hvt ad=0 pd=0 as=0 ps=0 w=0.42 l=0.15
X2451 v3_four_channel_output_load_integration_0/v3_four_channel_shared_support_integration_0/v3_four_channel_bias_reference_distribution_0/v3_four_channel_phase_distribution_0/v3_four_channel_output_collection_0/v3_four_channel_placement_0/v3_channel_selector_late_promotion_3/v3_selector_route_pilot_0/group1_lo_p v3_four_channel_output_load_integration_0/v3_four_channel_shared_support_integration_0/v3_four_channel_bias_reference_distribution_0/v3_four_channel_phase_distribution_0/v3_four_channel_output_collection_0/v3_four_channel_placement_0/v3_channel_selector_late_promotion_3/v3_selector_route_pilot_0/G1_LO_P_AND/a_59_75# VGND VGND sky130_fd_pr__nfet_01v8 ad=0.182 pd=1.86 as=0 ps=0 w=0.65 l=0.15
X2452 v3_four_channel_output_load_integration_0/v3_four_channel_shared_support_integration_0/v3_four_channel_bias_reference_distribution_0/v3_four_channel_phase_distribution_0/v3_four_channel_output_collection_0/v3_four_channel_placement_0/v3_channel_selector_late_promotion_3/v3_selector_route_pilot_0/G1_LO_P_AND/a_145_75# v3_four_channel_output_load_integration_0/v3_four_channel_shared_support_integration_0/v3_four_channel_bias_reference_distribution_0/v3_four_channel_phase_distribution_0/v3_four_channel_output_collection_0/v3_four_channel_placement_0/v3_channel_selector_late_promotion_3/v3_selector_route_pilot_0/G1_MUX_AXIS/X v3_four_channel_output_load_integration_0/v3_four_channel_shared_support_integration_0/v3_four_channel_bias_reference_distribution_0/v3_four_channel_phase_distribution_0/v3_four_channel_output_collection_0/v3_four_channel_placement_0/v3_channel_selector_late_promotion_3/v3_selector_route_pilot_0/G1_LO_P_AND/a_59_75# VGND sky130_fd_pr__nfet_01v8 ad=0 pd=0 as=0.1176 ps=1.4 w=0.42 l=0.15
X2453 VDPWR v3_four_channel_output_load_integration_0/v3_four_channel_shared_support_integration_0/v3_four_channel_bias_reference_distribution_0/v3_four_channel_phase_distribution_0/v3_four_channel_output_collection_0/v3_four_channel_placement_0/v3_channel_selector_late_promotion_3/v3_selector_route_pilot_0/G0_MUX_POS/a_505_21# v3_four_channel_output_load_integration_0/v3_four_channel_shared_support_integration_0/v3_four_channel_bias_reference_distribution_0/v3_four_channel_phase_distribution_0/v3_four_channel_output_collection_0/v3_four_channel_placement_0/v3_channel_selector_late_promotion_3/v3_selector_route_pilot_0/G0_MUX_POS/a_535_374# VDPWR sky130_fd_pr__pfet_01v8_hvt ad=0 pd=0 as=0.0882 ps=1.26 w=0.42 l=0.15
X2454 v3_four_channel_output_load_integration_0/v3_four_channel_shared_support_integration_0/v3_four_channel_bias_reference_distribution_0/v3_four_channel_phase_distribution_0/v3_four_channel_output_collection_0/v3_four_channel_placement_0/v3_channel_selector_late_promotion_3/v3_selector_route_pilot_0/G0_MUX_POS/a_505_21# V3R206 VDPWR VDPWR sky130_fd_pr__pfet_01v8_hvt ad=0.1176 pd=1.4 as=0 ps=0 w=0.42 l=0.15
X2455 v3_four_channel_output_load_integration_0/v3_four_channel_shared_support_integration_0/v3_four_channel_bias_reference_distribution_0/v3_four_channel_phase_distribution_0/v3_four_channel_output_collection_0/v3_four_channel_placement_0/v3_channel_selector_late_promotion_3/v3_selector_route_pilot_0/G0_MUX_POS/a_218_374# V3R206 VDPWR VDPWR sky130_fd_pr__pfet_01v8_hvt ad=0.1533 pd=1.57 as=0 ps=0 w=0.42 l=0.15
X2456 VGND v3_four_channel_output_load_integration_0/v3_four_channel_shared_support_integration_0/v3_four_channel_bias_reference_distribution_0/v3_four_channel_phase_distribution_0/v3_four_channel_output_collection_0/v3_four_channel_placement_0/v3_channel_selector_late_promotion_3/v3_selector_route_pilot_0/G0_MUX_POS/a_505_21# v3_four_channel_output_load_integration_0/v3_four_channel_shared_support_integration_0/v3_four_channel_bias_reference_distribution_0/v3_four_channel_phase_distribution_0/v3_four_channel_output_collection_0/v3_four_channel_placement_0/v3_channel_selector_late_promotion_3/v3_selector_route_pilot_0/G0_MUX_POS/a_439_47# VGND sky130_fd_pr__nfet_01v8 ad=0 pd=0 as=0.1386 ps=1.5 w=0.42 l=0.15
X2457 v3_four_channel_output_load_integration_0/v3_four_channel_shared_support_integration_0/v3_four_channel_bias_reference_distribution_0/v3_four_channel_phase_distribution_0/v3_four_channel_output_collection_0/v3_four_channel_placement_0/v3_channel_selector_late_promotion_3/v3_selector_route_pilot_0/G0_MUX_POS/a_76_199# V3R290 v3_four_channel_output_load_integration_0/v3_four_channel_shared_support_integration_0/v3_four_channel_bias_reference_distribution_0/v3_four_channel_phase_distribution_0/v3_four_channel_output_collection_0/v3_four_channel_placement_0/v3_channel_selector_late_promotion_3/v3_selector_route_pilot_0/G0_MUX_POS/a_218_374# VDPWR sky130_fd_pr__pfet_01v8_hvt ad=0.3864 pd=2.68 as=0 ps=0 w=0.42 l=0.15
X2458 v3_four_channel_output_load_integration_0/v3_four_channel_shared_support_integration_0/v3_four_channel_bias_reference_distribution_0/v3_four_channel_phase_distribution_0/v3_four_channel_output_collection_0/v3_four_channel_placement_0/v3_channel_selector_late_promotion_3/v3_selector_route_pilot_0/G0_MUX_POS/a_505_21# V3R206 VGND VGND sky130_fd_pr__nfet_01v8 ad=0.1092 pd=1.36 as=0 ps=0 w=0.42 l=0.15
X2459 v3_four_channel_output_load_integration_0/v3_four_channel_shared_support_integration_0/v3_four_channel_bias_reference_distribution_0/v3_four_channel_phase_distribution_0/v3_four_channel_output_collection_0/v3_four_channel_placement_0/v3_channel_selector_late_promotion_3/v3_selector_route_pilot_0/G0_MUX_POS/a_439_47# V3R290 v3_four_channel_output_load_integration_0/v3_four_channel_shared_support_integration_0/v3_four_channel_bias_reference_distribution_0/v3_four_channel_phase_distribution_0/v3_four_channel_output_collection_0/v3_four_channel_placement_0/v3_channel_selector_late_promotion_3/v3_selector_route_pilot_0/G0_MUX_POS/a_76_199# VGND sky130_fd_pr__nfet_01v8 ad=0 pd=0 as=0.1995 ps=1.79 w=0.42 l=0.15
X2460 v3_four_channel_output_load_integration_0/v3_four_channel_shared_support_integration_0/v3_four_channel_bias_reference_distribution_0/v3_four_channel_phase_distribution_0/v3_four_channel_output_collection_0/v3_four_channel_placement_0/v3_channel_selector_late_promotion_3/v3_selector_route_pilot_0/G0_MUX_POS/a_535_374# V3R291 v3_four_channel_output_load_integration_0/v3_four_channel_shared_support_integration_0/v3_four_channel_bias_reference_distribution_0/v3_four_channel_phase_distribution_0/v3_four_channel_output_collection_0/v3_four_channel_placement_0/v3_channel_selector_late_promotion_3/v3_selector_route_pilot_0/G0_MUX_POS/a_76_199# VDPWR sky130_fd_pr__pfet_01v8_hvt ad=0 pd=0 as=0 ps=0 w=0.42 l=0.15
X2461 v3_four_channel_output_load_integration_0/v3_four_channel_shared_support_integration_0/v3_four_channel_bias_reference_distribution_0/v3_four_channel_phase_distribution_0/v3_four_channel_output_collection_0/v3_four_channel_placement_0/v3_channel_selector_late_promotion_3/v3_selector_route_pilot_0/G0_MUX_POS/a_76_199# V3R291 v3_four_channel_output_load_integration_0/v3_four_channel_shared_support_integration_0/v3_four_channel_bias_reference_distribution_0/v3_four_channel_phase_distribution_0/v3_four_channel_output_collection_0/v3_four_channel_placement_0/v3_channel_selector_late_promotion_3/v3_selector_route_pilot_0/G0_MUX_POS/a_218_47# VGND sky130_fd_pr__nfet_01v8 ad=0 pd=0 as=0.1386 ps=1.5 w=0.42 l=0.15
X2462 v3_four_channel_output_load_integration_0/v3_four_channel_shared_support_integration_0/v3_four_channel_bias_reference_distribution_0/v3_four_channel_phase_distribution_0/v3_four_channel_output_collection_0/v3_four_channel_placement_0/v3_channel_selector_late_promotion_3/v3_selector_route_pilot_0/G0_MUX_POS/a_218_47# V3R206 VGND VGND sky130_fd_pr__nfet_01v8 ad=0 pd=0 as=0 ps=0 w=0.42 l=0.15
X2463 VDPWR v3_four_channel_output_load_integration_0/v3_four_channel_shared_support_integration_0/v3_four_channel_bias_reference_distribution_0/v3_four_channel_phase_distribution_0/v3_four_channel_output_collection_0/v3_four_channel_placement_0/v3_channel_selector_late_promotion_3/v3_selector_route_pilot_0/G0_MUX_POS/a_76_199# v3_four_channel_output_load_integration_0/v3_four_channel_shared_support_integration_0/v3_four_channel_bias_reference_distribution_0/v3_four_channel_phase_distribution_0/v3_four_channel_output_collection_0/v3_four_channel_placement_0/v3_channel_selector_late_promotion_3/v3_selector_route_pilot_0/G0_MUX_POS/X VDPWR sky130_fd_pr__pfet_01v8_hvt ad=0 pd=0 as=0.26 ps=2.52 w=1 l=0.15
X2464 VGND v3_four_channel_output_load_integration_0/v3_four_channel_shared_support_integration_0/v3_four_channel_bias_reference_distribution_0/v3_four_channel_phase_distribution_0/v3_four_channel_output_collection_0/v3_four_channel_placement_0/v3_channel_selector_late_promotion_3/v3_selector_route_pilot_0/G0_MUX_POS/a_76_199# v3_four_channel_output_load_integration_0/v3_four_channel_shared_support_integration_0/v3_four_channel_bias_reference_distribution_0/v3_four_channel_phase_distribution_0/v3_four_channel_output_collection_0/v3_four_channel_placement_0/v3_channel_selector_late_promotion_3/v3_selector_route_pilot_0/G0_MUX_POS/X VGND sky130_fd_pr__nfet_01v8 ad=0 pd=0 as=0.169 ps=1.82 w=0.65 l=0.15
X2465 VDPWR v3_four_channel_output_load_integration_0/v3_four_channel_shared_support_integration_0/v3_four_channel_bias_reference_distribution_0/v3_four_channel_phase_distribution_0/v3_four_channel_output_collection_0/v3_four_channel_placement_0/v3_channel_selector_late_promotion_3/v3_selector_route_pilot_0/G0_MUX_NEG/a_505_21# v3_four_channel_output_load_integration_0/v3_four_channel_shared_support_integration_0/v3_four_channel_bias_reference_distribution_0/v3_four_channel_phase_distribution_0/v3_four_channel_output_collection_0/v3_four_channel_placement_0/v3_channel_selector_late_promotion_3/v3_selector_route_pilot_0/G0_MUX_NEG/a_535_374# VDPWR sky130_fd_pr__pfet_01v8_hvt ad=0 pd=0 as=0.0882 ps=1.26 w=0.42 l=0.15
X2466 v3_four_channel_output_load_integration_0/v3_four_channel_shared_support_integration_0/v3_four_channel_bias_reference_distribution_0/v3_four_channel_phase_distribution_0/v3_four_channel_output_collection_0/v3_four_channel_placement_0/v3_channel_selector_late_promotion_3/v3_selector_route_pilot_0/G0_MUX_NEG/a_505_21# V3R206 VDPWR VDPWR sky130_fd_pr__pfet_01v8_hvt ad=0.1176 pd=1.4 as=0 ps=0 w=0.42 l=0.15
X2467 v3_four_channel_output_load_integration_0/v3_four_channel_shared_support_integration_0/v3_four_channel_bias_reference_distribution_0/v3_four_channel_phase_distribution_0/v3_four_channel_output_collection_0/v3_four_channel_placement_0/v3_channel_selector_late_promotion_3/v3_selector_route_pilot_0/G0_MUX_NEG/a_218_374# V3R206 VDPWR VDPWR sky130_fd_pr__pfet_01v8_hvt ad=0.1533 pd=1.57 as=0 ps=0 w=0.42 l=0.15
X2468 VGND v3_four_channel_output_load_integration_0/v3_four_channel_shared_support_integration_0/v3_four_channel_bias_reference_distribution_0/v3_four_channel_phase_distribution_0/v3_four_channel_output_collection_0/v3_four_channel_placement_0/v3_channel_selector_late_promotion_3/v3_selector_route_pilot_0/G0_MUX_NEG/a_505_21# v3_four_channel_output_load_integration_0/v3_four_channel_shared_support_integration_0/v3_four_channel_bias_reference_distribution_0/v3_four_channel_phase_distribution_0/v3_four_channel_output_collection_0/v3_four_channel_placement_0/v3_channel_selector_late_promotion_3/v3_selector_route_pilot_0/G0_MUX_NEG/a_439_47# VGND sky130_fd_pr__nfet_01v8 ad=0 pd=0 as=0.1386 ps=1.5 w=0.42 l=0.15
X2469 v3_four_channel_output_load_integration_0/v3_four_channel_shared_support_integration_0/v3_four_channel_bias_reference_distribution_0/v3_four_channel_phase_distribution_0/v3_four_channel_output_collection_0/v3_four_channel_placement_0/v3_channel_selector_late_promotion_3/v3_selector_route_pilot_0/G0_MUX_NEG/a_76_199# V3R292 v3_four_channel_output_load_integration_0/v3_four_channel_shared_support_integration_0/v3_four_channel_bias_reference_distribution_0/v3_four_channel_phase_distribution_0/v3_four_channel_output_collection_0/v3_four_channel_placement_0/v3_channel_selector_late_promotion_3/v3_selector_route_pilot_0/G0_MUX_NEG/a_218_374# VDPWR sky130_fd_pr__pfet_01v8_hvt ad=0.3864 pd=2.68 as=0 ps=0 w=0.42 l=0.15
X2470 v3_four_channel_output_load_integration_0/v3_four_channel_shared_support_integration_0/v3_four_channel_bias_reference_distribution_0/v3_four_channel_phase_distribution_0/v3_four_channel_output_collection_0/v3_four_channel_placement_0/v3_channel_selector_late_promotion_3/v3_selector_route_pilot_0/G0_MUX_NEG/a_505_21# V3R206 VGND VGND sky130_fd_pr__nfet_01v8 ad=0.1092 pd=1.36 as=0 ps=0 w=0.42 l=0.15
X2471 v3_four_channel_output_load_integration_0/v3_four_channel_shared_support_integration_0/v3_four_channel_bias_reference_distribution_0/v3_four_channel_phase_distribution_0/v3_four_channel_output_collection_0/v3_four_channel_placement_0/v3_channel_selector_late_promotion_3/v3_selector_route_pilot_0/G0_MUX_NEG/a_439_47# V3R292 v3_four_channel_output_load_integration_0/v3_four_channel_shared_support_integration_0/v3_four_channel_bias_reference_distribution_0/v3_four_channel_phase_distribution_0/v3_four_channel_output_collection_0/v3_four_channel_placement_0/v3_channel_selector_late_promotion_3/v3_selector_route_pilot_0/G0_MUX_NEG/a_76_199# VGND sky130_fd_pr__nfet_01v8 ad=0 pd=0 as=0.1995 ps=1.79 w=0.42 l=0.15
X2472 v3_four_channel_output_load_integration_0/v3_four_channel_shared_support_integration_0/v3_four_channel_bias_reference_distribution_0/v3_four_channel_phase_distribution_0/v3_four_channel_output_collection_0/v3_four_channel_placement_0/v3_channel_selector_late_promotion_3/v3_selector_route_pilot_0/G0_MUX_NEG/a_535_374# V3R293 v3_four_channel_output_load_integration_0/v3_four_channel_shared_support_integration_0/v3_four_channel_bias_reference_distribution_0/v3_four_channel_phase_distribution_0/v3_four_channel_output_collection_0/v3_four_channel_placement_0/v3_channel_selector_late_promotion_3/v3_selector_route_pilot_0/G0_MUX_NEG/a_76_199# VDPWR sky130_fd_pr__pfet_01v8_hvt ad=0 pd=0 as=0 ps=0 w=0.42 l=0.15
X2473 v3_four_channel_output_load_integration_0/v3_four_channel_shared_support_integration_0/v3_four_channel_bias_reference_distribution_0/v3_four_channel_phase_distribution_0/v3_four_channel_output_collection_0/v3_four_channel_placement_0/v3_channel_selector_late_promotion_3/v3_selector_route_pilot_0/G0_MUX_NEG/a_76_199# V3R293 v3_four_channel_output_load_integration_0/v3_four_channel_shared_support_integration_0/v3_four_channel_bias_reference_distribution_0/v3_four_channel_phase_distribution_0/v3_four_channel_output_collection_0/v3_four_channel_placement_0/v3_channel_selector_late_promotion_3/v3_selector_route_pilot_0/G0_MUX_NEG/a_218_47# VGND sky130_fd_pr__nfet_01v8 ad=0 pd=0 as=0.1386 ps=1.5 w=0.42 l=0.15
X2474 v3_four_channel_output_load_integration_0/v3_four_channel_shared_support_integration_0/v3_four_channel_bias_reference_distribution_0/v3_four_channel_phase_distribution_0/v3_four_channel_output_collection_0/v3_four_channel_placement_0/v3_channel_selector_late_promotion_3/v3_selector_route_pilot_0/G0_MUX_NEG/a_218_47# V3R206 VGND VGND sky130_fd_pr__nfet_01v8 ad=0 pd=0 as=0 ps=0 w=0.42 l=0.15
X2475 VDPWR v3_four_channel_output_load_integration_0/v3_four_channel_shared_support_integration_0/v3_four_channel_bias_reference_distribution_0/v3_four_channel_phase_distribution_0/v3_four_channel_output_collection_0/v3_four_channel_placement_0/v3_channel_selector_late_promotion_3/v3_selector_route_pilot_0/G0_MUX_NEG/a_76_199# v3_four_channel_output_load_integration_0/v3_four_channel_shared_support_integration_0/v3_four_channel_bias_reference_distribution_0/v3_four_channel_phase_distribution_0/v3_four_channel_output_collection_0/v3_four_channel_placement_0/v3_channel_selector_late_promotion_3/v3_selector_route_pilot_0/G0_MUX_NEG/X VDPWR sky130_fd_pr__pfet_01v8_hvt ad=0 pd=0 as=0.26 ps=2.52 w=1 l=0.15
X2476 VGND v3_four_channel_output_load_integration_0/v3_four_channel_shared_support_integration_0/v3_four_channel_bias_reference_distribution_0/v3_four_channel_phase_distribution_0/v3_four_channel_output_collection_0/v3_four_channel_placement_0/v3_channel_selector_late_promotion_3/v3_selector_route_pilot_0/G0_MUX_NEG/a_76_199# v3_four_channel_output_load_integration_0/v3_four_channel_shared_support_integration_0/v3_four_channel_bias_reference_distribution_0/v3_four_channel_phase_distribution_0/v3_four_channel_output_collection_0/v3_four_channel_placement_0/v3_channel_selector_late_promotion_3/v3_selector_route_pilot_0/G0_MUX_NEG/X VGND sky130_fd_pr__nfet_01v8 ad=0 pd=0 as=0.169 ps=1.82 w=0.65 l=0.15
X2477 VDPWR v3_four_channel_output_load_integration_0/v3_four_channel_shared_support_integration_0/v3_four_channel_bias_reference_distribution_0/v3_four_channel_phase_distribution_0/v3_four_channel_output_collection_0/v3_four_channel_placement_0/v3_channel_selector_late_promotion_3/v3_selector_route_pilot_0/G2_MUX_AXIS/a_505_21# v3_four_channel_output_load_integration_0/v3_four_channel_shared_support_integration_0/v3_four_channel_bias_reference_distribution_0/v3_four_channel_phase_distribution_0/v3_four_channel_output_collection_0/v3_four_channel_placement_0/v3_channel_selector_late_promotion_3/v3_selector_route_pilot_0/G2_MUX_AXIS/a_535_374# VDPWR sky130_fd_pr__pfet_01v8_hvt ad=0 pd=0 as=0.0882 ps=1.26 w=0.42 l=0.15
X2478 v3_four_channel_output_load_integration_0/v3_four_channel_shared_support_integration_0/v3_four_channel_bias_reference_distribution_0/v3_four_channel_phase_distribution_0/v3_four_channel_output_collection_0/v3_four_channel_placement_0/v3_channel_selector_late_promotion_3/v3_selector_route_pilot_0/G2_MUX_AXIS/a_505_21# V3R233 VDPWR VDPWR sky130_fd_pr__pfet_01v8_hvt ad=0.1176 pd=1.4 as=0 ps=0 w=0.42 l=0.15
X2479 v3_four_channel_output_load_integration_0/v3_four_channel_shared_support_integration_0/v3_four_channel_bias_reference_distribution_0/v3_four_channel_phase_distribution_0/v3_four_channel_output_collection_0/v3_four_channel_placement_0/v3_channel_selector_late_promotion_3/v3_selector_route_pilot_0/G2_MUX_AXIS/a_218_374# V3R233 VDPWR VDPWR sky130_fd_pr__pfet_01v8_hvt ad=0.1533 pd=1.57 as=0 ps=0 w=0.42 l=0.15
X2480 VGND v3_four_channel_output_load_integration_0/v3_four_channel_shared_support_integration_0/v3_four_channel_bias_reference_distribution_0/v3_four_channel_phase_distribution_0/v3_four_channel_output_collection_0/v3_four_channel_placement_0/v3_channel_selector_late_promotion_3/v3_selector_route_pilot_0/G2_MUX_AXIS/a_505_21# v3_four_channel_output_load_integration_0/v3_four_channel_shared_support_integration_0/v3_four_channel_bias_reference_distribution_0/v3_four_channel_phase_distribution_0/v3_four_channel_output_collection_0/v3_four_channel_placement_0/v3_channel_selector_late_promotion_3/v3_selector_route_pilot_0/G2_MUX_AXIS/a_439_47# VGND sky130_fd_pr__nfet_01v8 ad=0 pd=0 as=0.1386 ps=1.5 w=0.42 l=0.15
X2481 v3_four_channel_output_load_integration_0/v3_four_channel_shared_support_integration_0/v3_four_channel_bias_reference_distribution_0/v3_four_channel_phase_distribution_0/v3_four_channel_output_collection_0/v3_four_channel_placement_0/v3_channel_selector_late_promotion_3/v3_selector_route_pilot_0/G2_MUX_AXIS/a_76_199# v3_four_channel_output_load_integration_0/v3_four_channel_shared_support_integration_0/v3_four_channel_bias_reference_distribution_0/v3_four_channel_phase_distribution_0/v3_four_channel_output_collection_0/v3_four_channel_placement_0/v3_channel_selector_late_promotion_3/v3_selector_route_pilot_0/G2_MUX_POS/X v3_four_channel_output_load_integration_0/v3_four_channel_shared_support_integration_0/v3_four_channel_bias_reference_distribution_0/v3_four_channel_phase_distribution_0/v3_four_channel_output_collection_0/v3_four_channel_placement_0/v3_channel_selector_late_promotion_3/v3_selector_route_pilot_0/G2_MUX_AXIS/a_218_374# VDPWR sky130_fd_pr__pfet_01v8_hvt ad=0.3864 pd=2.68 as=0 ps=0 w=0.42 l=0.15
X2482 v3_four_channel_output_load_integration_0/v3_four_channel_shared_support_integration_0/v3_four_channel_bias_reference_distribution_0/v3_four_channel_phase_distribution_0/v3_four_channel_output_collection_0/v3_four_channel_placement_0/v3_channel_selector_late_promotion_3/v3_selector_route_pilot_0/G2_MUX_AXIS/a_505_21# V3R233 VGND VGND sky130_fd_pr__nfet_01v8 ad=0.1092 pd=1.36 as=0 ps=0 w=0.42 l=0.15
X2483 v3_four_channel_output_load_integration_0/v3_four_channel_shared_support_integration_0/v3_four_channel_bias_reference_distribution_0/v3_four_channel_phase_distribution_0/v3_four_channel_output_collection_0/v3_four_channel_placement_0/v3_channel_selector_late_promotion_3/v3_selector_route_pilot_0/G2_MUX_AXIS/a_439_47# v3_four_channel_output_load_integration_0/v3_four_channel_shared_support_integration_0/v3_four_channel_bias_reference_distribution_0/v3_four_channel_phase_distribution_0/v3_four_channel_output_collection_0/v3_four_channel_placement_0/v3_channel_selector_late_promotion_3/v3_selector_route_pilot_0/G2_MUX_POS/X v3_four_channel_output_load_integration_0/v3_four_channel_shared_support_integration_0/v3_four_channel_bias_reference_distribution_0/v3_four_channel_phase_distribution_0/v3_four_channel_output_collection_0/v3_four_channel_placement_0/v3_channel_selector_late_promotion_3/v3_selector_route_pilot_0/G2_MUX_AXIS/a_76_199# VGND sky130_fd_pr__nfet_01v8 ad=0 pd=0 as=0.1995 ps=1.79 w=0.42 l=0.15
X2484 v3_four_channel_output_load_integration_0/v3_four_channel_shared_support_integration_0/v3_four_channel_bias_reference_distribution_0/v3_four_channel_phase_distribution_0/v3_four_channel_output_collection_0/v3_four_channel_placement_0/v3_channel_selector_late_promotion_3/v3_selector_route_pilot_0/G2_MUX_AXIS/a_535_374# v3_four_channel_output_load_integration_0/v3_four_channel_shared_support_integration_0/v3_four_channel_bias_reference_distribution_0/v3_four_channel_phase_distribution_0/v3_four_channel_output_collection_0/v3_four_channel_placement_0/v3_channel_selector_late_promotion_3/v3_selector_route_pilot_0/G2_MUX_NEG/X v3_four_channel_output_load_integration_0/v3_four_channel_shared_support_integration_0/v3_four_channel_bias_reference_distribution_0/v3_four_channel_phase_distribution_0/v3_four_channel_output_collection_0/v3_four_channel_placement_0/v3_channel_selector_late_promotion_3/v3_selector_route_pilot_0/G2_MUX_AXIS/a_76_199# VDPWR sky130_fd_pr__pfet_01v8_hvt ad=0 pd=0 as=0 ps=0 w=0.42 l=0.15
X2485 v3_four_channel_output_load_integration_0/v3_four_channel_shared_support_integration_0/v3_four_channel_bias_reference_distribution_0/v3_four_channel_phase_distribution_0/v3_four_channel_output_collection_0/v3_four_channel_placement_0/v3_channel_selector_late_promotion_3/v3_selector_route_pilot_0/G2_MUX_AXIS/a_76_199# v3_four_channel_output_load_integration_0/v3_four_channel_shared_support_integration_0/v3_four_channel_bias_reference_distribution_0/v3_four_channel_phase_distribution_0/v3_four_channel_output_collection_0/v3_four_channel_placement_0/v3_channel_selector_late_promotion_3/v3_selector_route_pilot_0/G2_MUX_NEG/X v3_four_channel_output_load_integration_0/v3_four_channel_shared_support_integration_0/v3_four_channel_bias_reference_distribution_0/v3_four_channel_phase_distribution_0/v3_four_channel_output_collection_0/v3_four_channel_placement_0/v3_channel_selector_late_promotion_3/v3_selector_route_pilot_0/G2_MUX_AXIS/a_218_47# VGND sky130_fd_pr__nfet_01v8 ad=0 pd=0 as=0.1386 ps=1.5 w=0.42 l=0.15
X2486 v3_four_channel_output_load_integration_0/v3_four_channel_shared_support_integration_0/v3_four_channel_bias_reference_distribution_0/v3_four_channel_phase_distribution_0/v3_four_channel_output_collection_0/v3_four_channel_placement_0/v3_channel_selector_late_promotion_3/v3_selector_route_pilot_0/G2_MUX_AXIS/a_218_47# V3R233 VGND VGND sky130_fd_pr__nfet_01v8 ad=0 pd=0 as=0 ps=0 w=0.42 l=0.15
X2487 VDPWR v3_four_channel_output_load_integration_0/v3_four_channel_shared_support_integration_0/v3_four_channel_bias_reference_distribution_0/v3_four_channel_phase_distribution_0/v3_four_channel_output_collection_0/v3_four_channel_placement_0/v3_channel_selector_late_promotion_3/v3_selector_route_pilot_0/G2_MUX_AXIS/a_76_199# v3_four_channel_output_load_integration_0/v3_four_channel_shared_support_integration_0/v3_four_channel_bias_reference_distribution_0/v3_four_channel_phase_distribution_0/v3_four_channel_output_collection_0/v3_four_channel_placement_0/v3_channel_selector_late_promotion_3/v3_selector_route_pilot_0/G2_MUX_AXIS/X VDPWR sky130_fd_pr__pfet_01v8_hvt ad=0 pd=0 as=0.26 ps=2.52 w=1 l=0.15
X2488 VGND v3_four_channel_output_load_integration_0/v3_four_channel_shared_support_integration_0/v3_four_channel_bias_reference_distribution_0/v3_four_channel_phase_distribution_0/v3_four_channel_output_collection_0/v3_four_channel_placement_0/v3_channel_selector_late_promotion_3/v3_selector_route_pilot_0/G2_MUX_AXIS/a_76_199# v3_four_channel_output_load_integration_0/v3_four_channel_shared_support_integration_0/v3_four_channel_bias_reference_distribution_0/v3_four_channel_phase_distribution_0/v3_four_channel_output_collection_0/v3_four_channel_placement_0/v3_channel_selector_late_promotion_3/v3_selector_route_pilot_0/G2_MUX_AXIS/X VGND sky130_fd_pr__nfet_01v8 ad=0 pd=0 as=0.169 ps=1.82 w=0.65 l=0.15
X2489 VDPWR v3_four_channel_output_load_integration_0/v3_four_channel_shared_support_integration_0/v3_four_channel_bias_reference_distribution_0/v3_four_channel_phase_distribution_0/v3_four_channel_output_collection_0/v3_four_channel_placement_0/v3_channel_selector_late_promotion_3/v3_selector_route_pilot_0/G3_MUX_POS/a_505_21# v3_four_channel_output_load_integration_0/v3_four_channel_shared_support_integration_0/v3_four_channel_bias_reference_distribution_0/v3_four_channel_phase_distribution_0/v3_four_channel_output_collection_0/v3_four_channel_placement_0/v3_channel_selector_late_promotion_3/v3_selector_route_pilot_0/G3_MUX_POS/a_535_374# VDPWR sky130_fd_pr__pfet_01v8_hvt ad=0 pd=0 as=0.0882 ps=1.26 w=0.42 l=0.15
X2490 v3_four_channel_output_load_integration_0/v3_four_channel_shared_support_integration_0/v3_four_channel_bias_reference_distribution_0/v3_four_channel_phase_distribution_0/v3_four_channel_output_collection_0/v3_four_channel_placement_0/v3_channel_selector_late_promotion_3/v3_selector_route_pilot_0/G3_MUX_POS/a_505_21# V3R234 VDPWR VDPWR sky130_fd_pr__pfet_01v8_hvt ad=0.1176 pd=1.4 as=0 ps=0 w=0.42 l=0.15
X2491 v3_four_channel_output_load_integration_0/v3_four_channel_shared_support_integration_0/v3_four_channel_bias_reference_distribution_0/v3_four_channel_phase_distribution_0/v3_four_channel_output_collection_0/v3_four_channel_placement_0/v3_channel_selector_late_promotion_3/v3_selector_route_pilot_0/G3_MUX_POS/a_218_374# V3R234 VDPWR VDPWR sky130_fd_pr__pfet_01v8_hvt ad=0.1533 pd=1.57 as=0 ps=0 w=0.42 l=0.15
X2492 VGND v3_four_channel_output_load_integration_0/v3_four_channel_shared_support_integration_0/v3_four_channel_bias_reference_distribution_0/v3_four_channel_phase_distribution_0/v3_four_channel_output_collection_0/v3_four_channel_placement_0/v3_channel_selector_late_promotion_3/v3_selector_route_pilot_0/G3_MUX_POS/a_505_21# v3_four_channel_output_load_integration_0/v3_four_channel_shared_support_integration_0/v3_four_channel_bias_reference_distribution_0/v3_four_channel_phase_distribution_0/v3_four_channel_output_collection_0/v3_four_channel_placement_0/v3_channel_selector_late_promotion_3/v3_selector_route_pilot_0/G3_MUX_POS/a_439_47# VGND sky130_fd_pr__nfet_01v8 ad=0 pd=0 as=0.1386 ps=1.5 w=0.42 l=0.15
X2493 v3_four_channel_output_load_integration_0/v3_four_channel_shared_support_integration_0/v3_four_channel_bias_reference_distribution_0/v3_four_channel_phase_distribution_0/v3_four_channel_output_collection_0/v3_four_channel_placement_0/v3_channel_selector_late_promotion_3/v3_selector_route_pilot_0/G3_MUX_POS/a_76_199# V3R290 v3_four_channel_output_load_integration_0/v3_four_channel_shared_support_integration_0/v3_four_channel_bias_reference_distribution_0/v3_four_channel_phase_distribution_0/v3_four_channel_output_collection_0/v3_four_channel_placement_0/v3_channel_selector_late_promotion_3/v3_selector_route_pilot_0/G3_MUX_POS/a_218_374# VDPWR sky130_fd_pr__pfet_01v8_hvt ad=0.3864 pd=2.68 as=0 ps=0 w=0.42 l=0.15
X2494 v3_four_channel_output_load_integration_0/v3_four_channel_shared_support_integration_0/v3_four_channel_bias_reference_distribution_0/v3_four_channel_phase_distribution_0/v3_four_channel_output_collection_0/v3_four_channel_placement_0/v3_channel_selector_late_promotion_3/v3_selector_route_pilot_0/G3_MUX_POS/a_505_21# V3R234 VGND VGND sky130_fd_pr__nfet_01v8 ad=0.1092 pd=1.36 as=0 ps=0 w=0.42 l=0.15
X2495 v3_four_channel_output_load_integration_0/v3_four_channel_shared_support_integration_0/v3_four_channel_bias_reference_distribution_0/v3_four_channel_phase_distribution_0/v3_four_channel_output_collection_0/v3_four_channel_placement_0/v3_channel_selector_late_promotion_3/v3_selector_route_pilot_0/G3_MUX_POS/a_439_47# V3R290 v3_four_channel_output_load_integration_0/v3_four_channel_shared_support_integration_0/v3_four_channel_bias_reference_distribution_0/v3_four_channel_phase_distribution_0/v3_four_channel_output_collection_0/v3_four_channel_placement_0/v3_channel_selector_late_promotion_3/v3_selector_route_pilot_0/G3_MUX_POS/a_76_199# VGND sky130_fd_pr__nfet_01v8 ad=0 pd=0 as=0.1995 ps=1.79 w=0.42 l=0.15
X2496 v3_four_channel_output_load_integration_0/v3_four_channel_shared_support_integration_0/v3_four_channel_bias_reference_distribution_0/v3_four_channel_phase_distribution_0/v3_four_channel_output_collection_0/v3_four_channel_placement_0/v3_channel_selector_late_promotion_3/v3_selector_route_pilot_0/G3_MUX_POS/a_535_374# V3R291 v3_four_channel_output_load_integration_0/v3_four_channel_shared_support_integration_0/v3_four_channel_bias_reference_distribution_0/v3_four_channel_phase_distribution_0/v3_four_channel_output_collection_0/v3_four_channel_placement_0/v3_channel_selector_late_promotion_3/v3_selector_route_pilot_0/G3_MUX_POS/a_76_199# VDPWR sky130_fd_pr__pfet_01v8_hvt ad=0 pd=0 as=0 ps=0 w=0.42 l=0.15
X2497 v3_four_channel_output_load_integration_0/v3_four_channel_shared_support_integration_0/v3_four_channel_bias_reference_distribution_0/v3_four_channel_phase_distribution_0/v3_four_channel_output_collection_0/v3_four_channel_placement_0/v3_channel_selector_late_promotion_3/v3_selector_route_pilot_0/G3_MUX_POS/a_76_199# V3R291 v3_four_channel_output_load_integration_0/v3_four_channel_shared_support_integration_0/v3_four_channel_bias_reference_distribution_0/v3_four_channel_phase_distribution_0/v3_four_channel_output_collection_0/v3_four_channel_placement_0/v3_channel_selector_late_promotion_3/v3_selector_route_pilot_0/G3_MUX_POS/a_218_47# VGND sky130_fd_pr__nfet_01v8 ad=0 pd=0 as=0.1386 ps=1.5 w=0.42 l=0.15
X2498 v3_four_channel_output_load_integration_0/v3_four_channel_shared_support_integration_0/v3_four_channel_bias_reference_distribution_0/v3_four_channel_phase_distribution_0/v3_four_channel_output_collection_0/v3_four_channel_placement_0/v3_channel_selector_late_promotion_3/v3_selector_route_pilot_0/G3_MUX_POS/a_218_47# V3R234 VGND VGND sky130_fd_pr__nfet_01v8 ad=0 pd=0 as=0 ps=0 w=0.42 l=0.15
X2499 VDPWR v3_four_channel_output_load_integration_0/v3_four_channel_shared_support_integration_0/v3_four_channel_bias_reference_distribution_0/v3_four_channel_phase_distribution_0/v3_four_channel_output_collection_0/v3_four_channel_placement_0/v3_channel_selector_late_promotion_3/v3_selector_route_pilot_0/G3_MUX_POS/a_76_199# v3_four_channel_output_load_integration_0/v3_four_channel_shared_support_integration_0/v3_four_channel_bias_reference_distribution_0/v3_four_channel_phase_distribution_0/v3_four_channel_output_collection_0/v3_four_channel_placement_0/v3_channel_selector_late_promotion_3/v3_selector_route_pilot_0/G3_MUX_POS/X VDPWR sky130_fd_pr__pfet_01v8_hvt ad=0 pd=0 as=0.26 ps=2.52 w=1 l=0.15
X2500 VGND v3_four_channel_output_load_integration_0/v3_four_channel_shared_support_integration_0/v3_four_channel_bias_reference_distribution_0/v3_four_channel_phase_distribution_0/v3_four_channel_output_collection_0/v3_four_channel_placement_0/v3_channel_selector_late_promotion_3/v3_selector_route_pilot_0/G3_MUX_POS/a_76_199# v3_four_channel_output_load_integration_0/v3_four_channel_shared_support_integration_0/v3_four_channel_bias_reference_distribution_0/v3_four_channel_phase_distribution_0/v3_four_channel_output_collection_0/v3_four_channel_placement_0/v3_channel_selector_late_promotion_3/v3_selector_route_pilot_0/G3_MUX_POS/X VGND sky130_fd_pr__nfet_01v8 ad=0 pd=0 as=0.169 ps=1.82 w=0.65 l=0.15
X2501 VDPWR v3_four_channel_output_load_integration_0/v3_four_channel_shared_support_integration_0/v3_four_channel_bias_reference_distribution_0/v3_four_channel_phase_distribution_0/v3_four_channel_output_collection_0/v3_four_channel_placement_0/v3_channel_selector_late_promotion_3/v3_selector_route_pilot_0/G3_MUX_NEG/a_505_21# v3_four_channel_output_load_integration_0/v3_four_channel_shared_support_integration_0/v3_four_channel_bias_reference_distribution_0/v3_four_channel_phase_distribution_0/v3_four_channel_output_collection_0/v3_four_channel_placement_0/v3_channel_selector_late_promotion_3/v3_selector_route_pilot_0/G3_MUX_NEG/a_535_374# VDPWR sky130_fd_pr__pfet_01v8_hvt ad=0 pd=0 as=0.0882 ps=1.26 w=0.42 l=0.15
X2502 v3_four_channel_output_load_integration_0/v3_four_channel_shared_support_integration_0/v3_four_channel_bias_reference_distribution_0/v3_four_channel_phase_distribution_0/v3_four_channel_output_collection_0/v3_four_channel_placement_0/v3_channel_selector_late_promotion_3/v3_selector_route_pilot_0/G3_MUX_NEG/a_505_21# V3R234 VDPWR VDPWR sky130_fd_pr__pfet_01v8_hvt ad=0.1176 pd=1.4 as=0 ps=0 w=0.42 l=0.15
X2503 v3_four_channel_output_load_integration_0/v3_four_channel_shared_support_integration_0/v3_four_channel_bias_reference_distribution_0/v3_four_channel_phase_distribution_0/v3_four_channel_output_collection_0/v3_four_channel_placement_0/v3_channel_selector_late_promotion_3/v3_selector_route_pilot_0/G3_MUX_NEG/a_218_374# V3R234 VDPWR VDPWR sky130_fd_pr__pfet_01v8_hvt ad=0.1533 pd=1.57 as=0 ps=0 w=0.42 l=0.15
X2504 VGND v3_four_channel_output_load_integration_0/v3_four_channel_shared_support_integration_0/v3_four_channel_bias_reference_distribution_0/v3_four_channel_phase_distribution_0/v3_four_channel_output_collection_0/v3_four_channel_placement_0/v3_channel_selector_late_promotion_3/v3_selector_route_pilot_0/G3_MUX_NEG/a_505_21# v3_four_channel_output_load_integration_0/v3_four_channel_shared_support_integration_0/v3_four_channel_bias_reference_distribution_0/v3_four_channel_phase_distribution_0/v3_four_channel_output_collection_0/v3_four_channel_placement_0/v3_channel_selector_late_promotion_3/v3_selector_route_pilot_0/G3_MUX_NEG/a_439_47# VGND sky130_fd_pr__nfet_01v8 ad=0 pd=0 as=0.1386 ps=1.5 w=0.42 l=0.15
X2505 v3_four_channel_output_load_integration_0/v3_four_channel_shared_support_integration_0/v3_four_channel_bias_reference_distribution_0/v3_four_channel_phase_distribution_0/v3_four_channel_output_collection_0/v3_four_channel_placement_0/v3_channel_selector_late_promotion_3/v3_selector_route_pilot_0/G3_MUX_NEG/a_76_199# V3R292 v3_four_channel_output_load_integration_0/v3_four_channel_shared_support_integration_0/v3_four_channel_bias_reference_distribution_0/v3_four_channel_phase_distribution_0/v3_four_channel_output_collection_0/v3_four_channel_placement_0/v3_channel_selector_late_promotion_3/v3_selector_route_pilot_0/G3_MUX_NEG/a_218_374# VDPWR sky130_fd_pr__pfet_01v8_hvt ad=0.3864 pd=2.68 as=0 ps=0 w=0.42 l=0.15
X2506 v3_four_channel_output_load_integration_0/v3_four_channel_shared_support_integration_0/v3_four_channel_bias_reference_distribution_0/v3_four_channel_phase_distribution_0/v3_four_channel_output_collection_0/v3_four_channel_placement_0/v3_channel_selector_late_promotion_3/v3_selector_route_pilot_0/G3_MUX_NEG/a_505_21# V3R234 VGND VGND sky130_fd_pr__nfet_01v8 ad=0.1092 pd=1.36 as=0 ps=0 w=0.42 l=0.15
X2507 v3_four_channel_output_load_integration_0/v3_four_channel_shared_support_integration_0/v3_four_channel_bias_reference_distribution_0/v3_four_channel_phase_distribution_0/v3_four_channel_output_collection_0/v3_four_channel_placement_0/v3_channel_selector_late_promotion_3/v3_selector_route_pilot_0/G3_MUX_NEG/a_439_47# V3R292 v3_four_channel_output_load_integration_0/v3_four_channel_shared_support_integration_0/v3_four_channel_bias_reference_distribution_0/v3_four_channel_phase_distribution_0/v3_four_channel_output_collection_0/v3_four_channel_placement_0/v3_channel_selector_late_promotion_3/v3_selector_route_pilot_0/G3_MUX_NEG/a_76_199# VGND sky130_fd_pr__nfet_01v8 ad=0 pd=0 as=0.1995 ps=1.79 w=0.42 l=0.15
X2508 v3_four_channel_output_load_integration_0/v3_four_channel_shared_support_integration_0/v3_four_channel_bias_reference_distribution_0/v3_four_channel_phase_distribution_0/v3_four_channel_output_collection_0/v3_four_channel_placement_0/v3_channel_selector_late_promotion_3/v3_selector_route_pilot_0/G3_MUX_NEG/a_535_374# V3R293 v3_four_channel_output_load_integration_0/v3_four_channel_shared_support_integration_0/v3_four_channel_bias_reference_distribution_0/v3_four_channel_phase_distribution_0/v3_four_channel_output_collection_0/v3_four_channel_placement_0/v3_channel_selector_late_promotion_3/v3_selector_route_pilot_0/G3_MUX_NEG/a_76_199# VDPWR sky130_fd_pr__pfet_01v8_hvt ad=0 pd=0 as=0 ps=0 w=0.42 l=0.15
X2509 v3_four_channel_output_load_integration_0/v3_four_channel_shared_support_integration_0/v3_four_channel_bias_reference_distribution_0/v3_four_channel_phase_distribution_0/v3_four_channel_output_collection_0/v3_four_channel_placement_0/v3_channel_selector_late_promotion_3/v3_selector_route_pilot_0/G3_MUX_NEG/a_76_199# V3R293 v3_four_channel_output_load_integration_0/v3_four_channel_shared_support_integration_0/v3_four_channel_bias_reference_distribution_0/v3_four_channel_phase_distribution_0/v3_four_channel_output_collection_0/v3_four_channel_placement_0/v3_channel_selector_late_promotion_3/v3_selector_route_pilot_0/G3_MUX_NEG/a_218_47# VGND sky130_fd_pr__nfet_01v8 ad=0 pd=0 as=0.1386 ps=1.5 w=0.42 l=0.15
X2510 v3_four_channel_output_load_integration_0/v3_four_channel_shared_support_integration_0/v3_four_channel_bias_reference_distribution_0/v3_four_channel_phase_distribution_0/v3_four_channel_output_collection_0/v3_four_channel_placement_0/v3_channel_selector_late_promotion_3/v3_selector_route_pilot_0/G3_MUX_NEG/a_218_47# V3R234 VGND VGND sky130_fd_pr__nfet_01v8 ad=0 pd=0 as=0 ps=0 w=0.42 l=0.15
X2511 VDPWR v3_four_channel_output_load_integration_0/v3_four_channel_shared_support_integration_0/v3_four_channel_bias_reference_distribution_0/v3_four_channel_phase_distribution_0/v3_four_channel_output_collection_0/v3_four_channel_placement_0/v3_channel_selector_late_promotion_3/v3_selector_route_pilot_0/G3_MUX_NEG/a_76_199# v3_four_channel_output_load_integration_0/v3_four_channel_shared_support_integration_0/v3_four_channel_bias_reference_distribution_0/v3_four_channel_phase_distribution_0/v3_four_channel_output_collection_0/v3_four_channel_placement_0/v3_channel_selector_late_promotion_3/v3_selector_route_pilot_0/G3_MUX_NEG/X VDPWR sky130_fd_pr__pfet_01v8_hvt ad=0 pd=0 as=0.26 ps=2.52 w=1 l=0.15
X2512 VGND v3_four_channel_output_load_integration_0/v3_four_channel_shared_support_integration_0/v3_four_channel_bias_reference_distribution_0/v3_four_channel_phase_distribution_0/v3_four_channel_output_collection_0/v3_four_channel_placement_0/v3_channel_selector_late_promotion_3/v3_selector_route_pilot_0/G3_MUX_NEG/a_76_199# v3_four_channel_output_load_integration_0/v3_four_channel_shared_support_integration_0/v3_four_channel_bias_reference_distribution_0/v3_four_channel_phase_distribution_0/v3_four_channel_output_collection_0/v3_four_channel_placement_0/v3_channel_selector_late_promotion_3/v3_selector_route_pilot_0/G3_MUX_NEG/X VGND sky130_fd_pr__nfet_01v8 ad=0 pd=0 as=0.169 ps=1.82 w=0.65 l=0.15
X2513 VDPWR v3_four_channel_output_load_integration_0/v3_four_channel_shared_support_integration_0/v3_four_channel_bias_reference_distribution_0/v3_four_channel_phase_distribution_0/v3_four_channel_output_collection_0/v3_four_channel_placement_0/v3_channel_selector_late_promotion_3/v3_selector_route_pilot_0/G3_LO_P_AND/B v3_four_channel_output_load_integration_0/v3_four_channel_shared_support_integration_0/v3_four_channel_bias_reference_distribution_0/v3_four_channel_phase_distribution_0/v3_four_channel_output_collection_0/v3_four_channel_placement_0/v3_channel_selector_late_promotion_3/v3_selector_route_pilot_0/G0_LO_P_AND/a_59_75# VDPWR sky130_fd_pr__pfet_01v8_hvt ad=0 pd=0 as=0.1134 ps=1.38 w=0.42 l=0.15
X2514 v3_four_channel_output_load_integration_0/v3_four_channel_shared_support_integration_0/v3_four_channel_bias_reference_distribution_0/v3_four_channel_phase_distribution_0/v3_four_channel_output_collection_0/v3_four_channel_placement_0/v3_channel_selector_late_promotion_3/v3_selector_route_pilot_0/group0_lo_p v3_four_channel_output_load_integration_0/v3_four_channel_shared_support_integration_0/v3_four_channel_bias_reference_distribution_0/v3_four_channel_phase_distribution_0/v3_four_channel_output_collection_0/v3_four_channel_placement_0/v3_channel_selector_late_promotion_3/v3_selector_route_pilot_0/G0_LO_P_AND/a_59_75# VDPWR VDPWR sky130_fd_pr__pfet_01v8_hvt ad=0.475 pd=2.95 as=0 ps=0 w=1 l=0.15
X2515 VGND v3_four_channel_output_load_integration_0/v3_four_channel_shared_support_integration_0/v3_four_channel_bias_reference_distribution_0/v3_four_channel_phase_distribution_0/v3_four_channel_output_collection_0/v3_four_channel_placement_0/v3_channel_selector_late_promotion_3/v3_selector_route_pilot_0/G3_LO_P_AND/B v3_four_channel_output_load_integration_0/v3_four_channel_shared_support_integration_0/v3_four_channel_bias_reference_distribution_0/v3_four_channel_phase_distribution_0/v3_four_channel_output_collection_0/v3_four_channel_placement_0/v3_channel_selector_late_promotion_3/v3_selector_route_pilot_0/G0_LO_P_AND/a_145_75# VGND sky130_fd_pr__nfet_01v8 ad=0 pd=0 as=0.1134 ps=1.38 w=0.42 l=0.15
X2516 v3_four_channel_output_load_integration_0/v3_four_channel_shared_support_integration_0/v3_four_channel_bias_reference_distribution_0/v3_four_channel_phase_distribution_0/v3_four_channel_output_collection_0/v3_four_channel_placement_0/v3_channel_selector_late_promotion_3/v3_selector_route_pilot_0/G0_LO_P_AND/a_59_75# v3_four_channel_output_load_integration_0/v3_four_channel_shared_support_integration_0/v3_four_channel_bias_reference_distribution_0/v3_four_channel_phase_distribution_0/v3_four_channel_output_collection_0/v3_four_channel_placement_0/v3_channel_selector_late_promotion_3/v3_selector_route_pilot_0/G0_MUX_AXIS/X VDPWR VDPWR sky130_fd_pr__pfet_01v8_hvt ad=0 pd=0 as=0 ps=0 w=0.42 l=0.15
X2517 v3_four_channel_output_load_integration_0/v3_four_channel_shared_support_integration_0/v3_four_channel_bias_reference_distribution_0/v3_four_channel_phase_distribution_0/v3_four_channel_output_collection_0/v3_four_channel_placement_0/v3_channel_selector_late_promotion_3/v3_selector_route_pilot_0/group0_lo_p v3_four_channel_output_load_integration_0/v3_four_channel_shared_support_integration_0/v3_four_channel_bias_reference_distribution_0/v3_four_channel_phase_distribution_0/v3_four_channel_output_collection_0/v3_four_channel_placement_0/v3_channel_selector_late_promotion_3/v3_selector_route_pilot_0/G0_LO_P_AND/a_59_75# VGND VGND sky130_fd_pr__nfet_01v8 ad=0.182 pd=1.86 as=0 ps=0 w=0.65 l=0.15
X2518 v3_four_channel_output_load_integration_0/v3_four_channel_shared_support_integration_0/v3_four_channel_bias_reference_distribution_0/v3_four_channel_phase_distribution_0/v3_four_channel_output_collection_0/v3_four_channel_placement_0/v3_channel_selector_late_promotion_3/v3_selector_route_pilot_0/G0_LO_P_AND/a_145_75# v3_four_channel_output_load_integration_0/v3_four_channel_shared_support_integration_0/v3_four_channel_bias_reference_distribution_0/v3_four_channel_phase_distribution_0/v3_four_channel_output_collection_0/v3_four_channel_placement_0/v3_channel_selector_late_promotion_3/v3_selector_route_pilot_0/G0_MUX_AXIS/X v3_four_channel_output_load_integration_0/v3_four_channel_shared_support_integration_0/v3_four_channel_bias_reference_distribution_0/v3_four_channel_phase_distribution_0/v3_four_channel_output_collection_0/v3_four_channel_placement_0/v3_channel_selector_late_promotion_3/v3_selector_route_pilot_0/G0_LO_P_AND/a_59_75# VGND sky130_fd_pr__nfet_01v8 ad=0 pd=0 as=0.1176 ps=1.4 w=0.42 l=0.15
X2519 VDPWR v3_four_channel_output_load_integration_0/v3_four_channel_shared_support_integration_0/v3_four_channel_bias_reference_distribution_0/v3_four_channel_phase_distribution_0/v3_four_channel_output_collection_0/v3_four_channel_placement_0/v3_channel_selector_late_promotion_3/v3_selector_route_pilot_0/G3_LO_P_AND/B v3_four_channel_output_load_integration_0/v3_four_channel_shared_support_integration_0/v3_four_channel_bias_reference_distribution_0/v3_four_channel_phase_distribution_0/v3_four_channel_output_collection_0/v3_four_channel_placement_0/v3_channel_selector_late_promotion_3/v3_selector_route_pilot_0/G3_LO_N_ANDNOT/a_207_413# VDPWR sky130_fd_pr__pfet_01v8_hvt ad=0 pd=0 as=0.1218 ps=1.42 w=0.42 l=0.15
X2520 v3_four_channel_output_load_integration_0/v3_four_channel_shared_support_integration_0/v3_four_channel_bias_reference_distribution_0/v3_four_channel_phase_distribution_0/v3_four_channel_output_collection_0/v3_four_channel_placement_0/v3_channel_selector_late_promotion_3/v3_selector_route_pilot_0/group3_lo_n v3_four_channel_output_load_integration_0/v3_four_channel_shared_support_integration_0/v3_four_channel_bias_reference_distribution_0/v3_four_channel_phase_distribution_0/v3_four_channel_output_collection_0/v3_four_channel_placement_0/v3_channel_selector_late_promotion_3/v3_selector_route_pilot_0/G3_LO_N_ANDNOT/a_207_413# VDPWR VDPWR sky130_fd_pr__pfet_01v8_hvt ad=0.26 pd=2.52 as=0 ps=0 w=1 l=0.15
X2521 v3_four_channel_output_load_integration_0/v3_four_channel_shared_support_integration_0/v3_four_channel_bias_reference_distribution_0/v3_four_channel_phase_distribution_0/v3_four_channel_output_collection_0/v3_four_channel_placement_0/v3_channel_selector_late_promotion_3/v3_selector_route_pilot_0/G3_LO_N_ANDNOT/a_297_47# v3_four_channel_output_load_integration_0/v3_four_channel_shared_support_integration_0/v3_four_channel_bias_reference_distribution_0/v3_four_channel_phase_distribution_0/v3_four_channel_output_collection_0/v3_four_channel_placement_0/v3_channel_selector_late_promotion_3/v3_selector_route_pilot_0/G3_LO_N_ANDNOT/a_27_413# v3_four_channel_output_load_integration_0/v3_four_channel_shared_support_integration_0/v3_four_channel_bias_reference_distribution_0/v3_four_channel_phase_distribution_0/v3_four_channel_output_collection_0/v3_four_channel_placement_0/v3_channel_selector_late_promotion_3/v3_selector_route_pilot_0/G3_LO_N_ANDNOT/a_207_413# VGND sky130_fd_pr__nfet_01v8 ad=0.1008 pd=1.32 as=0.1092 ps=1.36 w=0.42 l=0.15
X2522 v3_four_channel_output_load_integration_0/v3_four_channel_shared_support_integration_0/v3_four_channel_bias_reference_distribution_0/v3_four_channel_phase_distribution_0/v3_four_channel_output_collection_0/v3_four_channel_placement_0/v3_channel_selector_late_promotion_3/v3_selector_route_pilot_0/group3_lo_n v3_four_channel_output_load_integration_0/v3_four_channel_shared_support_integration_0/v3_four_channel_bias_reference_distribution_0/v3_four_channel_phase_distribution_0/v3_four_channel_output_collection_0/v3_four_channel_placement_0/v3_channel_selector_late_promotion_3/v3_selector_route_pilot_0/G3_LO_N_ANDNOT/a_207_413# VGND VGND sky130_fd_pr__nfet_01v8 ad=0.169 pd=1.82 as=0 ps=0 w=0.65 l=0.15
X2523 v3_four_channel_output_load_integration_0/v3_four_channel_shared_support_integration_0/v3_four_channel_bias_reference_distribution_0/v3_four_channel_phase_distribution_0/v3_four_channel_output_collection_0/v3_four_channel_placement_0/v3_channel_selector_late_promotion_3/v3_selector_route_pilot_0/G3_LO_N_ANDNOT/a_207_413# v3_four_channel_output_load_integration_0/v3_four_channel_shared_support_integration_0/v3_four_channel_bias_reference_distribution_0/v3_four_channel_phase_distribution_0/v3_four_channel_output_collection_0/v3_four_channel_placement_0/v3_channel_selector_late_promotion_3/v3_selector_route_pilot_0/G3_LO_N_ANDNOT/a_27_413# VDPWR VDPWR sky130_fd_pr__pfet_01v8_hvt ad=0 pd=0 as=0 ps=0 w=0.42 l=0.15
X2524 VDPWR v3_four_channel_output_load_integration_0/v3_four_channel_shared_support_integration_0/v3_four_channel_bias_reference_distribution_0/v3_four_channel_phase_distribution_0/v3_four_channel_output_collection_0/v3_four_channel_placement_0/v3_channel_selector_late_promotion_3/v3_selector_route_pilot_0/G3_MUX_AXIS/X v3_four_channel_output_load_integration_0/v3_four_channel_shared_support_integration_0/v3_four_channel_bias_reference_distribution_0/v3_four_channel_phase_distribution_0/v3_four_channel_output_collection_0/v3_four_channel_placement_0/v3_channel_selector_late_promotion_3/v3_selector_route_pilot_0/G3_LO_N_ANDNOT/a_27_413# VDPWR sky130_fd_pr__pfet_01v8_hvt ad=0 pd=0 as=0.1092 ps=1.36 w=0.42 l=0.15
X2525 VGND v3_four_channel_output_load_integration_0/v3_four_channel_shared_support_integration_0/v3_four_channel_bias_reference_distribution_0/v3_four_channel_phase_distribution_0/v3_four_channel_output_collection_0/v3_four_channel_placement_0/v3_channel_selector_late_promotion_3/v3_selector_route_pilot_0/G3_LO_P_AND/B v3_four_channel_output_load_integration_0/v3_four_channel_shared_support_integration_0/v3_four_channel_bias_reference_distribution_0/v3_four_channel_phase_distribution_0/v3_four_channel_output_collection_0/v3_four_channel_placement_0/v3_channel_selector_late_promotion_3/v3_selector_route_pilot_0/G3_LO_N_ANDNOT/a_297_47# VGND sky130_fd_pr__nfet_01v8 ad=0 pd=0 as=0 ps=0 w=0.42 l=0.15
X2526 v3_four_channel_output_load_integration_0/v3_four_channel_shared_support_integration_0/v3_four_channel_bias_reference_distribution_0/v3_four_channel_phase_distribution_0/v3_four_channel_output_collection_0/v3_four_channel_placement_0/v3_channel_selector_late_promotion_3/v3_selector_route_pilot_0/G3_LO_N_ANDNOT/a_27_413# v3_four_channel_output_load_integration_0/v3_four_channel_shared_support_integration_0/v3_four_channel_bias_reference_distribution_0/v3_four_channel_phase_distribution_0/v3_four_channel_output_collection_0/v3_four_channel_placement_0/v3_channel_selector_late_promotion_3/v3_selector_route_pilot_0/G3_MUX_AXIS/X VGND VGND sky130_fd_pr__nfet_01v8 ad=0.1092 pd=1.36 as=0 ps=0 w=0.42 l=0.15
X2527 VDPWR v3_four_channel_output_load_integration_0/v3_four_channel_shared_support_integration_0/v3_four_channel_bias_reference_distribution_0/v3_four_channel_phase_distribution_0/v3_four_channel_output_collection_0/v3_four_channel_placement_0/v3_channel_selector_late_promotion_3/v3_selector_route_pilot_0/G3_LO_P_AND/B v3_four_channel_output_load_integration_0/v3_four_channel_shared_support_integration_0/v3_four_channel_bias_reference_distribution_0/v3_four_channel_phase_distribution_0/v3_four_channel_output_collection_0/v3_four_channel_placement_0/v3_channel_selector_late_promotion_3/v3_selector_route_pilot_0/G2_LO_N_ANDNOT/a_207_413# VDPWR sky130_fd_pr__pfet_01v8_hvt ad=0 pd=0 as=0.1218 ps=1.42 w=0.42 l=0.15
X2528 v3_four_channel_output_load_integration_0/v3_four_channel_shared_support_integration_0/v3_four_channel_bias_reference_distribution_0/v3_four_channel_phase_distribution_0/v3_four_channel_output_collection_0/v3_four_channel_placement_0/v3_channel_selector_late_promotion_3/v3_selector_route_pilot_0/group2_lo_n v3_four_channel_output_load_integration_0/v3_four_channel_shared_support_integration_0/v3_four_channel_bias_reference_distribution_0/v3_four_channel_phase_distribution_0/v3_four_channel_output_collection_0/v3_four_channel_placement_0/v3_channel_selector_late_promotion_3/v3_selector_route_pilot_0/G2_LO_N_ANDNOT/a_207_413# VDPWR VDPWR sky130_fd_pr__pfet_01v8_hvt ad=0.26 pd=2.52 as=0 ps=0 w=1 l=0.15
X2529 v3_four_channel_output_load_integration_0/v3_four_channel_shared_support_integration_0/v3_four_channel_bias_reference_distribution_0/v3_four_channel_phase_distribution_0/v3_four_channel_output_collection_0/v3_four_channel_placement_0/v3_channel_selector_late_promotion_3/v3_selector_route_pilot_0/G2_LO_N_ANDNOT/a_297_47# v3_four_channel_output_load_integration_0/v3_four_channel_shared_support_integration_0/v3_four_channel_bias_reference_distribution_0/v3_four_channel_phase_distribution_0/v3_four_channel_output_collection_0/v3_four_channel_placement_0/v3_channel_selector_late_promotion_3/v3_selector_route_pilot_0/G2_LO_N_ANDNOT/a_27_413# v3_four_channel_output_load_integration_0/v3_four_channel_shared_support_integration_0/v3_four_channel_bias_reference_distribution_0/v3_four_channel_phase_distribution_0/v3_four_channel_output_collection_0/v3_four_channel_placement_0/v3_channel_selector_late_promotion_3/v3_selector_route_pilot_0/G2_LO_N_ANDNOT/a_207_413# VGND sky130_fd_pr__nfet_01v8 ad=0.1008 pd=1.32 as=0.1092 ps=1.36 w=0.42 l=0.15
X2530 v3_four_channel_output_load_integration_0/v3_four_channel_shared_support_integration_0/v3_four_channel_bias_reference_distribution_0/v3_four_channel_phase_distribution_0/v3_four_channel_output_collection_0/v3_four_channel_placement_0/v3_channel_selector_late_promotion_3/v3_selector_route_pilot_0/group2_lo_n v3_four_channel_output_load_integration_0/v3_four_channel_shared_support_integration_0/v3_four_channel_bias_reference_distribution_0/v3_four_channel_phase_distribution_0/v3_four_channel_output_collection_0/v3_four_channel_placement_0/v3_channel_selector_late_promotion_3/v3_selector_route_pilot_0/G2_LO_N_ANDNOT/a_207_413# VGND VGND sky130_fd_pr__nfet_01v8 ad=0.169 pd=1.82 as=0 ps=0 w=0.65 l=0.15
X2531 v3_four_channel_output_load_integration_0/v3_four_channel_shared_support_integration_0/v3_four_channel_bias_reference_distribution_0/v3_four_channel_phase_distribution_0/v3_four_channel_output_collection_0/v3_four_channel_placement_0/v3_channel_selector_late_promotion_3/v3_selector_route_pilot_0/G2_LO_N_ANDNOT/a_207_413# v3_four_channel_output_load_integration_0/v3_four_channel_shared_support_integration_0/v3_four_channel_bias_reference_distribution_0/v3_four_channel_phase_distribution_0/v3_four_channel_output_collection_0/v3_four_channel_placement_0/v3_channel_selector_late_promotion_3/v3_selector_route_pilot_0/G2_LO_N_ANDNOT/a_27_413# VDPWR VDPWR sky130_fd_pr__pfet_01v8_hvt ad=0 pd=0 as=0 ps=0 w=0.42 l=0.15
X2532 VDPWR v3_four_channel_output_load_integration_0/v3_four_channel_shared_support_integration_0/v3_four_channel_bias_reference_distribution_0/v3_four_channel_phase_distribution_0/v3_four_channel_output_collection_0/v3_four_channel_placement_0/v3_channel_selector_late_promotion_3/v3_selector_route_pilot_0/G2_MUX_AXIS/X v3_four_channel_output_load_integration_0/v3_four_channel_shared_support_integration_0/v3_four_channel_bias_reference_distribution_0/v3_four_channel_phase_distribution_0/v3_four_channel_output_collection_0/v3_four_channel_placement_0/v3_channel_selector_late_promotion_3/v3_selector_route_pilot_0/G2_LO_N_ANDNOT/a_27_413# VDPWR sky130_fd_pr__pfet_01v8_hvt ad=0 pd=0 as=0.1092 ps=1.36 w=0.42 l=0.15
X2533 VGND v3_four_channel_output_load_integration_0/v3_four_channel_shared_support_integration_0/v3_four_channel_bias_reference_distribution_0/v3_four_channel_phase_distribution_0/v3_four_channel_output_collection_0/v3_four_channel_placement_0/v3_channel_selector_late_promotion_3/v3_selector_route_pilot_0/G3_LO_P_AND/B v3_four_channel_output_load_integration_0/v3_four_channel_shared_support_integration_0/v3_four_channel_bias_reference_distribution_0/v3_four_channel_phase_distribution_0/v3_four_channel_output_collection_0/v3_four_channel_placement_0/v3_channel_selector_late_promotion_3/v3_selector_route_pilot_0/G2_LO_N_ANDNOT/a_297_47# VGND sky130_fd_pr__nfet_01v8 ad=0 pd=0 as=0 ps=0 w=0.42 l=0.15
X2534 v3_four_channel_output_load_integration_0/v3_four_channel_shared_support_integration_0/v3_four_channel_bias_reference_distribution_0/v3_four_channel_phase_distribution_0/v3_four_channel_output_collection_0/v3_four_channel_placement_0/v3_channel_selector_late_promotion_3/v3_selector_route_pilot_0/G2_LO_N_ANDNOT/a_27_413# v3_four_channel_output_load_integration_0/v3_four_channel_shared_support_integration_0/v3_four_channel_bias_reference_distribution_0/v3_four_channel_phase_distribution_0/v3_four_channel_output_collection_0/v3_four_channel_placement_0/v3_channel_selector_late_promotion_3/v3_selector_route_pilot_0/G2_MUX_AXIS/X VGND VGND sky130_fd_pr__nfet_01v8 ad=0.1092 pd=1.36 as=0 ps=0 w=0.42 l=0.15
X2535 VDPWR v3_four_channel_output_load_integration_0/v3_four_channel_shared_support_integration_0/v3_four_channel_bias_reference_distribution_0/v3_four_channel_phase_distribution_0/v3_four_channel_output_collection_0/v3_four_channel_placement_0/v3_channel_selector_late_promotion_3/v3_selector_route_pilot_0/G3_LO_P_AND/B v3_four_channel_output_load_integration_0/v3_four_channel_shared_support_integration_0/v3_four_channel_bias_reference_distribution_0/v3_four_channel_phase_distribution_0/v3_four_channel_output_collection_0/v3_four_channel_placement_0/v3_channel_selector_late_promotion_3/v3_selector_route_pilot_0/G0_LO_N_ANDNOT/a_207_413# VDPWR sky130_fd_pr__pfet_01v8_hvt ad=0 pd=0 as=0.1218 ps=1.42 w=0.42 l=0.15
X2536 v3_four_channel_output_load_integration_0/v3_four_channel_shared_support_integration_0/v3_four_channel_bias_reference_distribution_0/v3_four_channel_phase_distribution_0/v3_four_channel_output_collection_0/v3_four_channel_placement_0/v3_channel_selector_late_promotion_3/v3_selector_route_pilot_0/group0_lo_n v3_four_channel_output_load_integration_0/v3_four_channel_shared_support_integration_0/v3_four_channel_bias_reference_distribution_0/v3_four_channel_phase_distribution_0/v3_four_channel_output_collection_0/v3_four_channel_placement_0/v3_channel_selector_late_promotion_3/v3_selector_route_pilot_0/G0_LO_N_ANDNOT/a_207_413# VDPWR VDPWR sky130_fd_pr__pfet_01v8_hvt ad=0.26 pd=2.52 as=0 ps=0 w=1 l=0.15
X2537 v3_four_channel_output_load_integration_0/v3_four_channel_shared_support_integration_0/v3_four_channel_bias_reference_distribution_0/v3_four_channel_phase_distribution_0/v3_four_channel_output_collection_0/v3_four_channel_placement_0/v3_channel_selector_late_promotion_3/v3_selector_route_pilot_0/G0_LO_N_ANDNOT/a_297_47# v3_four_channel_output_load_integration_0/v3_four_channel_shared_support_integration_0/v3_four_channel_bias_reference_distribution_0/v3_four_channel_phase_distribution_0/v3_four_channel_output_collection_0/v3_four_channel_placement_0/v3_channel_selector_late_promotion_3/v3_selector_route_pilot_0/G0_LO_N_ANDNOT/a_27_413# v3_four_channel_output_load_integration_0/v3_four_channel_shared_support_integration_0/v3_four_channel_bias_reference_distribution_0/v3_four_channel_phase_distribution_0/v3_four_channel_output_collection_0/v3_four_channel_placement_0/v3_channel_selector_late_promotion_3/v3_selector_route_pilot_0/G0_LO_N_ANDNOT/a_207_413# VGND sky130_fd_pr__nfet_01v8 ad=0.1008 pd=1.32 as=0.1092 ps=1.36 w=0.42 l=0.15
X2538 v3_four_channel_output_load_integration_0/v3_four_channel_shared_support_integration_0/v3_four_channel_bias_reference_distribution_0/v3_four_channel_phase_distribution_0/v3_four_channel_output_collection_0/v3_four_channel_placement_0/v3_channel_selector_late_promotion_3/v3_selector_route_pilot_0/group0_lo_n v3_four_channel_output_load_integration_0/v3_four_channel_shared_support_integration_0/v3_four_channel_bias_reference_distribution_0/v3_four_channel_phase_distribution_0/v3_four_channel_output_collection_0/v3_four_channel_placement_0/v3_channel_selector_late_promotion_3/v3_selector_route_pilot_0/G0_LO_N_ANDNOT/a_207_413# VGND VGND sky130_fd_pr__nfet_01v8 ad=0.169 pd=1.82 as=0 ps=0 w=0.65 l=0.15
X2539 v3_four_channel_output_load_integration_0/v3_four_channel_shared_support_integration_0/v3_four_channel_bias_reference_distribution_0/v3_four_channel_phase_distribution_0/v3_four_channel_output_collection_0/v3_four_channel_placement_0/v3_channel_selector_late_promotion_3/v3_selector_route_pilot_0/G0_LO_N_ANDNOT/a_207_413# v3_four_channel_output_load_integration_0/v3_four_channel_shared_support_integration_0/v3_four_channel_bias_reference_distribution_0/v3_four_channel_phase_distribution_0/v3_four_channel_output_collection_0/v3_four_channel_placement_0/v3_channel_selector_late_promotion_3/v3_selector_route_pilot_0/G0_LO_N_ANDNOT/a_27_413# VDPWR VDPWR sky130_fd_pr__pfet_01v8_hvt ad=0 pd=0 as=0 ps=0 w=0.42 l=0.15
X2540 VDPWR v3_four_channel_output_load_integration_0/v3_four_channel_shared_support_integration_0/v3_four_channel_bias_reference_distribution_0/v3_four_channel_phase_distribution_0/v3_four_channel_output_collection_0/v3_four_channel_placement_0/v3_channel_selector_late_promotion_3/v3_selector_route_pilot_0/G0_MUX_AXIS/X v3_four_channel_output_load_integration_0/v3_four_channel_shared_support_integration_0/v3_four_channel_bias_reference_distribution_0/v3_four_channel_phase_distribution_0/v3_four_channel_output_collection_0/v3_four_channel_placement_0/v3_channel_selector_late_promotion_3/v3_selector_route_pilot_0/G0_LO_N_ANDNOT/a_27_413# VDPWR sky130_fd_pr__pfet_01v8_hvt ad=0 pd=0 as=0.1092 ps=1.36 w=0.42 l=0.15
X2541 VGND v3_four_channel_output_load_integration_0/v3_four_channel_shared_support_integration_0/v3_four_channel_bias_reference_distribution_0/v3_four_channel_phase_distribution_0/v3_four_channel_output_collection_0/v3_four_channel_placement_0/v3_channel_selector_late_promotion_3/v3_selector_route_pilot_0/G3_LO_P_AND/B v3_four_channel_output_load_integration_0/v3_four_channel_shared_support_integration_0/v3_four_channel_bias_reference_distribution_0/v3_four_channel_phase_distribution_0/v3_four_channel_output_collection_0/v3_four_channel_placement_0/v3_channel_selector_late_promotion_3/v3_selector_route_pilot_0/G0_LO_N_ANDNOT/a_297_47# VGND sky130_fd_pr__nfet_01v8 ad=0 pd=0 as=0 ps=0 w=0.42 l=0.15
X2542 v3_four_channel_output_load_integration_0/v3_four_channel_shared_support_integration_0/v3_four_channel_bias_reference_distribution_0/v3_four_channel_phase_distribution_0/v3_four_channel_output_collection_0/v3_four_channel_placement_0/v3_channel_selector_late_promotion_3/v3_selector_route_pilot_0/G0_LO_N_ANDNOT/a_27_413# v3_four_channel_output_load_integration_0/v3_four_channel_shared_support_integration_0/v3_four_channel_bias_reference_distribution_0/v3_four_channel_phase_distribution_0/v3_four_channel_output_collection_0/v3_four_channel_placement_0/v3_channel_selector_late_promotion_3/v3_selector_route_pilot_0/G0_MUX_AXIS/X VGND VGND sky130_fd_pr__nfet_01v8 ad=0.1092 pd=1.36 as=0 ps=0 w=0.42 l=0.15
X2543 VDPWR v3_four_channel_output_load_integration_0/v3_four_channel_shared_support_integration_0/v3_four_channel_bias_reference_distribution_0/v3_four_channel_phase_distribution_0/v3_four_channel_output_collection_0/v3_four_channel_placement_0/v3_channel_selector_late_promotion_3/v3_selector_route_pilot_0/G1_MUX_AXIS/a_505_21# v3_four_channel_output_load_integration_0/v3_four_channel_shared_support_integration_0/v3_four_channel_bias_reference_distribution_0/v3_four_channel_phase_distribution_0/v3_four_channel_output_collection_0/v3_four_channel_placement_0/v3_channel_selector_late_promotion_3/v3_selector_route_pilot_0/G1_MUX_AXIS/a_535_374# VDPWR sky130_fd_pr__pfet_01v8_hvt ad=0 pd=0 as=0.0882 ps=1.26 w=0.42 l=0.15
X2544 v3_four_channel_output_load_integration_0/v3_four_channel_shared_support_integration_0/v3_four_channel_bias_reference_distribution_0/v3_four_channel_phase_distribution_0/v3_four_channel_output_collection_0/v3_four_channel_placement_0/v3_channel_selector_late_promotion_3/v3_selector_route_pilot_0/G1_MUX_AXIS/a_505_21# V3R231 VDPWR VDPWR sky130_fd_pr__pfet_01v8_hvt ad=0.1176 pd=1.4 as=0 ps=0 w=0.42 l=0.15
X2545 v3_four_channel_output_load_integration_0/v3_four_channel_shared_support_integration_0/v3_four_channel_bias_reference_distribution_0/v3_four_channel_phase_distribution_0/v3_four_channel_output_collection_0/v3_four_channel_placement_0/v3_channel_selector_late_promotion_3/v3_selector_route_pilot_0/G1_MUX_AXIS/a_218_374# V3R231 VDPWR VDPWR sky130_fd_pr__pfet_01v8_hvt ad=0.1533 pd=1.57 as=0 ps=0 w=0.42 l=0.15
X2546 VGND v3_four_channel_output_load_integration_0/v3_four_channel_shared_support_integration_0/v3_four_channel_bias_reference_distribution_0/v3_four_channel_phase_distribution_0/v3_four_channel_output_collection_0/v3_four_channel_placement_0/v3_channel_selector_late_promotion_3/v3_selector_route_pilot_0/G1_MUX_AXIS/a_505_21# v3_four_channel_output_load_integration_0/v3_four_channel_shared_support_integration_0/v3_four_channel_bias_reference_distribution_0/v3_four_channel_phase_distribution_0/v3_four_channel_output_collection_0/v3_four_channel_placement_0/v3_channel_selector_late_promotion_3/v3_selector_route_pilot_0/G1_MUX_AXIS/a_439_47# VGND sky130_fd_pr__nfet_01v8 ad=0 pd=0 as=0.1386 ps=1.5 w=0.42 l=0.15
X2547 v3_four_channel_output_load_integration_0/v3_four_channel_shared_support_integration_0/v3_four_channel_bias_reference_distribution_0/v3_four_channel_phase_distribution_0/v3_four_channel_output_collection_0/v3_four_channel_placement_0/v3_channel_selector_late_promotion_3/v3_selector_route_pilot_0/G1_MUX_AXIS/a_76_199# v3_four_channel_output_load_integration_0/v3_four_channel_shared_support_integration_0/v3_four_channel_bias_reference_distribution_0/v3_four_channel_phase_distribution_0/v3_four_channel_output_collection_0/v3_four_channel_placement_0/v3_channel_selector_late_promotion_3/v3_selector_route_pilot_0/G1_MUX_POS/X v3_four_channel_output_load_integration_0/v3_four_channel_shared_support_integration_0/v3_four_channel_bias_reference_distribution_0/v3_four_channel_phase_distribution_0/v3_four_channel_output_collection_0/v3_four_channel_placement_0/v3_channel_selector_late_promotion_3/v3_selector_route_pilot_0/G1_MUX_AXIS/a_218_374# VDPWR sky130_fd_pr__pfet_01v8_hvt ad=0.3864 pd=2.68 as=0 ps=0 w=0.42 l=0.15
X2548 v3_four_channel_output_load_integration_0/v3_four_channel_shared_support_integration_0/v3_four_channel_bias_reference_distribution_0/v3_four_channel_phase_distribution_0/v3_four_channel_output_collection_0/v3_four_channel_placement_0/v3_channel_selector_late_promotion_3/v3_selector_route_pilot_0/G1_MUX_AXIS/a_505_21# V3R231 VGND VGND sky130_fd_pr__nfet_01v8 ad=0.1092 pd=1.36 as=0 ps=0 w=0.42 l=0.15
X2549 v3_four_channel_output_load_integration_0/v3_four_channel_shared_support_integration_0/v3_four_channel_bias_reference_distribution_0/v3_four_channel_phase_distribution_0/v3_four_channel_output_collection_0/v3_four_channel_placement_0/v3_channel_selector_late_promotion_3/v3_selector_route_pilot_0/G1_MUX_AXIS/a_439_47# v3_four_channel_output_load_integration_0/v3_four_channel_shared_support_integration_0/v3_four_channel_bias_reference_distribution_0/v3_four_channel_phase_distribution_0/v3_four_channel_output_collection_0/v3_four_channel_placement_0/v3_channel_selector_late_promotion_3/v3_selector_route_pilot_0/G1_MUX_POS/X v3_four_channel_output_load_integration_0/v3_four_channel_shared_support_integration_0/v3_four_channel_bias_reference_distribution_0/v3_four_channel_phase_distribution_0/v3_four_channel_output_collection_0/v3_four_channel_placement_0/v3_channel_selector_late_promotion_3/v3_selector_route_pilot_0/G1_MUX_AXIS/a_76_199# VGND sky130_fd_pr__nfet_01v8 ad=0 pd=0 as=0.1995 ps=1.79 w=0.42 l=0.15
X2550 v3_four_channel_output_load_integration_0/v3_four_channel_shared_support_integration_0/v3_four_channel_bias_reference_distribution_0/v3_four_channel_phase_distribution_0/v3_four_channel_output_collection_0/v3_four_channel_placement_0/v3_channel_selector_late_promotion_3/v3_selector_route_pilot_0/G1_MUX_AXIS/a_535_374# v3_four_channel_output_load_integration_0/v3_four_channel_shared_support_integration_0/v3_four_channel_bias_reference_distribution_0/v3_four_channel_phase_distribution_0/v3_four_channel_output_collection_0/v3_four_channel_placement_0/v3_channel_selector_late_promotion_3/v3_selector_route_pilot_0/G1_MUX_NEG/X v3_four_channel_output_load_integration_0/v3_four_channel_shared_support_integration_0/v3_four_channel_bias_reference_distribution_0/v3_four_channel_phase_distribution_0/v3_four_channel_output_collection_0/v3_four_channel_placement_0/v3_channel_selector_late_promotion_3/v3_selector_route_pilot_0/G1_MUX_AXIS/a_76_199# VDPWR sky130_fd_pr__pfet_01v8_hvt ad=0 pd=0 as=0 ps=0 w=0.42 l=0.15
X2551 v3_four_channel_output_load_integration_0/v3_four_channel_shared_support_integration_0/v3_four_channel_bias_reference_distribution_0/v3_four_channel_phase_distribution_0/v3_four_channel_output_collection_0/v3_four_channel_placement_0/v3_channel_selector_late_promotion_3/v3_selector_route_pilot_0/G1_MUX_AXIS/a_76_199# v3_four_channel_output_load_integration_0/v3_four_channel_shared_support_integration_0/v3_four_channel_bias_reference_distribution_0/v3_four_channel_phase_distribution_0/v3_four_channel_output_collection_0/v3_four_channel_placement_0/v3_channel_selector_late_promotion_3/v3_selector_route_pilot_0/G1_MUX_NEG/X v3_four_channel_output_load_integration_0/v3_four_channel_shared_support_integration_0/v3_four_channel_bias_reference_distribution_0/v3_four_channel_phase_distribution_0/v3_four_channel_output_collection_0/v3_four_channel_placement_0/v3_channel_selector_late_promotion_3/v3_selector_route_pilot_0/G1_MUX_AXIS/a_218_47# VGND sky130_fd_pr__nfet_01v8 ad=0 pd=0 as=0.1386 ps=1.5 w=0.42 l=0.15
X2552 v3_four_channel_output_load_integration_0/v3_four_channel_shared_support_integration_0/v3_four_channel_bias_reference_distribution_0/v3_four_channel_phase_distribution_0/v3_four_channel_output_collection_0/v3_four_channel_placement_0/v3_channel_selector_late_promotion_3/v3_selector_route_pilot_0/G1_MUX_AXIS/a_218_47# V3R231 VGND VGND sky130_fd_pr__nfet_01v8 ad=0 pd=0 as=0 ps=0 w=0.42 l=0.15
X2553 VDPWR v3_four_channel_output_load_integration_0/v3_four_channel_shared_support_integration_0/v3_four_channel_bias_reference_distribution_0/v3_four_channel_phase_distribution_0/v3_four_channel_output_collection_0/v3_four_channel_placement_0/v3_channel_selector_late_promotion_3/v3_selector_route_pilot_0/G1_MUX_AXIS/a_76_199# v3_four_channel_output_load_integration_0/v3_four_channel_shared_support_integration_0/v3_four_channel_bias_reference_distribution_0/v3_four_channel_phase_distribution_0/v3_four_channel_output_collection_0/v3_four_channel_placement_0/v3_channel_selector_late_promotion_3/v3_selector_route_pilot_0/G1_MUX_AXIS/X VDPWR sky130_fd_pr__pfet_01v8_hvt ad=0 pd=0 as=0.26 ps=2.52 w=1 l=0.15
X2554 VGND v3_four_channel_output_load_integration_0/v3_four_channel_shared_support_integration_0/v3_four_channel_bias_reference_distribution_0/v3_four_channel_phase_distribution_0/v3_four_channel_output_collection_0/v3_four_channel_placement_0/v3_channel_selector_late_promotion_3/v3_selector_route_pilot_0/G1_MUX_AXIS/a_76_199# v3_four_channel_output_load_integration_0/v3_four_channel_shared_support_integration_0/v3_four_channel_bias_reference_distribution_0/v3_four_channel_phase_distribution_0/v3_four_channel_output_collection_0/v3_four_channel_placement_0/v3_channel_selector_late_promotion_3/v3_selector_route_pilot_0/G1_MUX_AXIS/X VGND sky130_fd_pr__nfet_01v8 ad=0 pd=0 as=0.169 ps=1.82 w=0.65 l=0.15
X2555 VDPWR v3_four_channel_output_load_integration_0/v3_four_channel_shared_support_integration_0/v3_four_channel_bias_reference_distribution_0/v3_four_channel_phase_distribution_0/v3_four_channel_output_collection_0/v3_four_channel_placement_0/v3_channel_selector_late_promotion_3/v3_selector_route_pilot_0/G3_LO_P_AND/B v3_four_channel_output_load_integration_0/v3_four_channel_shared_support_integration_0/v3_four_channel_bias_reference_distribution_0/v3_four_channel_phase_distribution_0/v3_four_channel_output_collection_0/v3_four_channel_placement_0/v3_channel_selector_late_promotion_3/v3_selector_route_pilot_0/G1_LO_N_ANDNOT/a_207_413# VDPWR sky130_fd_pr__pfet_01v8_hvt ad=0 pd=0 as=0.1218 ps=1.42 w=0.42 l=0.15
X2556 v3_four_channel_output_load_integration_0/v3_four_channel_shared_support_integration_0/v3_four_channel_bias_reference_distribution_0/v3_four_channel_phase_distribution_0/v3_four_channel_output_collection_0/v3_four_channel_placement_0/v3_channel_selector_late_promotion_3/v3_selector_route_pilot_0/group1_lo_n v3_four_channel_output_load_integration_0/v3_four_channel_shared_support_integration_0/v3_four_channel_bias_reference_distribution_0/v3_four_channel_phase_distribution_0/v3_four_channel_output_collection_0/v3_four_channel_placement_0/v3_channel_selector_late_promotion_3/v3_selector_route_pilot_0/G1_LO_N_ANDNOT/a_207_413# VDPWR VDPWR sky130_fd_pr__pfet_01v8_hvt ad=0.26 pd=2.52 as=0 ps=0 w=1 l=0.15
X2557 v3_four_channel_output_load_integration_0/v3_four_channel_shared_support_integration_0/v3_four_channel_bias_reference_distribution_0/v3_four_channel_phase_distribution_0/v3_four_channel_output_collection_0/v3_four_channel_placement_0/v3_channel_selector_late_promotion_3/v3_selector_route_pilot_0/G1_LO_N_ANDNOT/a_297_47# v3_four_channel_output_load_integration_0/v3_four_channel_shared_support_integration_0/v3_four_channel_bias_reference_distribution_0/v3_four_channel_phase_distribution_0/v3_four_channel_output_collection_0/v3_four_channel_placement_0/v3_channel_selector_late_promotion_3/v3_selector_route_pilot_0/G1_LO_N_ANDNOT/a_27_413# v3_four_channel_output_load_integration_0/v3_four_channel_shared_support_integration_0/v3_four_channel_bias_reference_distribution_0/v3_four_channel_phase_distribution_0/v3_four_channel_output_collection_0/v3_four_channel_placement_0/v3_channel_selector_late_promotion_3/v3_selector_route_pilot_0/G1_LO_N_ANDNOT/a_207_413# VGND sky130_fd_pr__nfet_01v8 ad=0.1008 pd=1.32 as=0.1092 ps=1.36 w=0.42 l=0.15
X2558 v3_four_channel_output_load_integration_0/v3_four_channel_shared_support_integration_0/v3_four_channel_bias_reference_distribution_0/v3_four_channel_phase_distribution_0/v3_four_channel_output_collection_0/v3_four_channel_placement_0/v3_channel_selector_late_promotion_3/v3_selector_route_pilot_0/group1_lo_n v3_four_channel_output_load_integration_0/v3_four_channel_shared_support_integration_0/v3_four_channel_bias_reference_distribution_0/v3_four_channel_phase_distribution_0/v3_four_channel_output_collection_0/v3_four_channel_placement_0/v3_channel_selector_late_promotion_3/v3_selector_route_pilot_0/G1_LO_N_ANDNOT/a_207_413# VGND VGND sky130_fd_pr__nfet_01v8 ad=0.169 pd=1.82 as=0 ps=0 w=0.65 l=0.15
X2559 v3_four_channel_output_load_integration_0/v3_four_channel_shared_support_integration_0/v3_four_channel_bias_reference_distribution_0/v3_four_channel_phase_distribution_0/v3_four_channel_output_collection_0/v3_four_channel_placement_0/v3_channel_selector_late_promotion_3/v3_selector_route_pilot_0/G1_LO_N_ANDNOT/a_207_413# v3_four_channel_output_load_integration_0/v3_four_channel_shared_support_integration_0/v3_four_channel_bias_reference_distribution_0/v3_four_channel_phase_distribution_0/v3_four_channel_output_collection_0/v3_four_channel_placement_0/v3_channel_selector_late_promotion_3/v3_selector_route_pilot_0/G1_LO_N_ANDNOT/a_27_413# VDPWR VDPWR sky130_fd_pr__pfet_01v8_hvt ad=0 pd=0 as=0 ps=0 w=0.42 l=0.15
X2560 VDPWR v3_four_channel_output_load_integration_0/v3_four_channel_shared_support_integration_0/v3_four_channel_bias_reference_distribution_0/v3_four_channel_phase_distribution_0/v3_four_channel_output_collection_0/v3_four_channel_placement_0/v3_channel_selector_late_promotion_3/v3_selector_route_pilot_0/G1_MUX_AXIS/X v3_four_channel_output_load_integration_0/v3_four_channel_shared_support_integration_0/v3_four_channel_bias_reference_distribution_0/v3_four_channel_phase_distribution_0/v3_four_channel_output_collection_0/v3_four_channel_placement_0/v3_channel_selector_late_promotion_3/v3_selector_route_pilot_0/G1_LO_N_ANDNOT/a_27_413# VDPWR sky130_fd_pr__pfet_01v8_hvt ad=0 pd=0 as=0.1092 ps=1.36 w=0.42 l=0.15
X2561 VGND v3_four_channel_output_load_integration_0/v3_four_channel_shared_support_integration_0/v3_four_channel_bias_reference_distribution_0/v3_four_channel_phase_distribution_0/v3_four_channel_output_collection_0/v3_four_channel_placement_0/v3_channel_selector_late_promotion_3/v3_selector_route_pilot_0/G3_LO_P_AND/B v3_four_channel_output_load_integration_0/v3_four_channel_shared_support_integration_0/v3_four_channel_bias_reference_distribution_0/v3_four_channel_phase_distribution_0/v3_four_channel_output_collection_0/v3_four_channel_placement_0/v3_channel_selector_late_promotion_3/v3_selector_route_pilot_0/G1_LO_N_ANDNOT/a_297_47# VGND sky130_fd_pr__nfet_01v8 ad=0 pd=0 as=0 ps=0 w=0.42 l=0.15
X2562 v3_four_channel_output_load_integration_0/v3_four_channel_shared_support_integration_0/v3_four_channel_bias_reference_distribution_0/v3_four_channel_phase_distribution_0/v3_four_channel_output_collection_0/v3_four_channel_placement_0/v3_channel_selector_late_promotion_3/v3_selector_route_pilot_0/G1_LO_N_ANDNOT/a_27_413# v3_four_channel_output_load_integration_0/v3_four_channel_shared_support_integration_0/v3_four_channel_bias_reference_distribution_0/v3_four_channel_phase_distribution_0/v3_four_channel_output_collection_0/v3_four_channel_placement_0/v3_channel_selector_late_promotion_3/v3_selector_route_pilot_0/G1_MUX_AXIS/X VGND VGND sky130_fd_pr__nfet_01v8 ad=0.1092 pd=1.36 as=0 ps=0 w=0.42 l=0.15
X2563 VDPWR v3_four_channel_output_load_integration_0/v3_four_channel_shared_support_integration_0/v3_four_channel_bias_reference_distribution_0/v3_four_channel_phase_distribution_0/v3_four_channel_output_collection_0/v3_four_channel_placement_0/v3_channel_selector_late_promotion_3/v3_selector_route_pilot_0/G3_LO_P_AND/B v3_four_channel_output_load_integration_0/v3_four_channel_shared_support_integration_0/v3_four_channel_bias_reference_distribution_0/v3_four_channel_phase_distribution_0/v3_four_channel_output_collection_0/v3_four_channel_placement_0/v3_channel_selector_late_promotion_3/v3_selector_route_pilot_0/G3_LO_P_AND/a_59_75# VDPWR sky130_fd_pr__pfet_01v8_hvt ad=0 pd=0 as=0.1134 ps=1.38 w=0.42 l=0.15
X2564 v3_four_channel_output_load_integration_0/v3_four_channel_shared_support_integration_0/v3_four_channel_bias_reference_distribution_0/v3_four_channel_phase_distribution_0/v3_four_channel_output_collection_0/v3_four_channel_placement_0/v3_channel_selector_late_promotion_3/v3_selector_route_pilot_0/group3_lo_p v3_four_channel_output_load_integration_0/v3_four_channel_shared_support_integration_0/v3_four_channel_bias_reference_distribution_0/v3_four_channel_phase_distribution_0/v3_four_channel_output_collection_0/v3_four_channel_placement_0/v3_channel_selector_late_promotion_3/v3_selector_route_pilot_0/G3_LO_P_AND/a_59_75# VDPWR VDPWR sky130_fd_pr__pfet_01v8_hvt ad=0.475 pd=2.95 as=0 ps=0 w=1 l=0.15
X2565 VGND v3_four_channel_output_load_integration_0/v3_four_channel_shared_support_integration_0/v3_four_channel_bias_reference_distribution_0/v3_four_channel_phase_distribution_0/v3_four_channel_output_collection_0/v3_four_channel_placement_0/v3_channel_selector_late_promotion_3/v3_selector_route_pilot_0/G3_LO_P_AND/B v3_four_channel_output_load_integration_0/v3_four_channel_shared_support_integration_0/v3_four_channel_bias_reference_distribution_0/v3_four_channel_phase_distribution_0/v3_four_channel_output_collection_0/v3_four_channel_placement_0/v3_channel_selector_late_promotion_3/v3_selector_route_pilot_0/G3_LO_P_AND/a_145_75# VGND sky130_fd_pr__nfet_01v8 ad=0 pd=0 as=0.1134 ps=1.38 w=0.42 l=0.15
X2566 v3_four_channel_output_load_integration_0/v3_four_channel_shared_support_integration_0/v3_four_channel_bias_reference_distribution_0/v3_four_channel_phase_distribution_0/v3_four_channel_output_collection_0/v3_four_channel_placement_0/v3_channel_selector_late_promotion_3/v3_selector_route_pilot_0/G3_LO_P_AND/a_59_75# v3_four_channel_output_load_integration_0/v3_four_channel_shared_support_integration_0/v3_four_channel_bias_reference_distribution_0/v3_four_channel_phase_distribution_0/v3_four_channel_output_collection_0/v3_four_channel_placement_0/v3_channel_selector_late_promotion_3/v3_selector_route_pilot_0/G3_MUX_AXIS/X VDPWR VDPWR sky130_fd_pr__pfet_01v8_hvt ad=0 pd=0 as=0 ps=0 w=0.42 l=0.15
X2567 v3_four_channel_output_load_integration_0/v3_four_channel_shared_support_integration_0/v3_four_channel_bias_reference_distribution_0/v3_four_channel_phase_distribution_0/v3_four_channel_output_collection_0/v3_four_channel_placement_0/v3_channel_selector_late_promotion_3/v3_selector_route_pilot_0/group3_lo_p v3_four_channel_output_load_integration_0/v3_four_channel_shared_support_integration_0/v3_four_channel_bias_reference_distribution_0/v3_four_channel_phase_distribution_0/v3_four_channel_output_collection_0/v3_four_channel_placement_0/v3_channel_selector_late_promotion_3/v3_selector_route_pilot_0/G3_LO_P_AND/a_59_75# VGND VGND sky130_fd_pr__nfet_01v8 ad=0.182 pd=1.86 as=0 ps=0 w=0.65 l=0.15
X2568 v3_four_channel_output_load_integration_0/v3_four_channel_shared_support_integration_0/v3_four_channel_bias_reference_distribution_0/v3_four_channel_phase_distribution_0/v3_four_channel_output_collection_0/v3_four_channel_placement_0/v3_channel_selector_late_promotion_3/v3_selector_route_pilot_0/G3_LO_P_AND/a_145_75# v3_four_channel_output_load_integration_0/v3_four_channel_shared_support_integration_0/v3_four_channel_bias_reference_distribution_0/v3_four_channel_phase_distribution_0/v3_four_channel_output_collection_0/v3_four_channel_placement_0/v3_channel_selector_late_promotion_3/v3_selector_route_pilot_0/G3_MUX_AXIS/X v3_four_channel_output_load_integration_0/v3_four_channel_shared_support_integration_0/v3_four_channel_bias_reference_distribution_0/v3_four_channel_phase_distribution_0/v3_four_channel_output_collection_0/v3_four_channel_placement_0/v3_channel_selector_late_promotion_3/v3_selector_route_pilot_0/G3_LO_P_AND/a_59_75# VGND sky130_fd_pr__nfet_01v8 ad=0 pd=0 as=0.1176 ps=1.4 w=0.42 l=0.15
X2569 VDPWR v3_four_channel_output_load_integration_0/v3_four_channel_shared_support_integration_0/v3_four_channel_bias_reference_distribution_0/v3_four_channel_phase_distribution_0/v3_four_channel_output_collection_0/v3_four_channel_placement_0/v3_channel_selector_late_promotion_3/v3_selector_route_pilot_0/G2_MUX_POS/a_505_21# v3_four_channel_output_load_integration_0/v3_four_channel_shared_support_integration_0/v3_four_channel_bias_reference_distribution_0/v3_four_channel_phase_distribution_0/v3_four_channel_output_collection_0/v3_four_channel_placement_0/v3_channel_selector_late_promotion_3/v3_selector_route_pilot_0/G2_MUX_POS/a_535_374# VDPWR sky130_fd_pr__pfet_01v8_hvt ad=0 pd=0 as=0.0882 ps=1.26 w=0.42 l=0.15
X2570 v3_four_channel_output_load_integration_0/v3_four_channel_shared_support_integration_0/v3_four_channel_bias_reference_distribution_0/v3_four_channel_phase_distribution_0/v3_four_channel_output_collection_0/v3_four_channel_placement_0/v3_channel_selector_late_promotion_3/v3_selector_route_pilot_0/G2_MUX_POS/a_505_21# V3R232 VDPWR VDPWR sky130_fd_pr__pfet_01v8_hvt ad=0.1176 pd=1.4 as=0 ps=0 w=0.42 l=0.15
X2571 v3_four_channel_output_load_integration_0/v3_four_channel_shared_support_integration_0/v3_four_channel_bias_reference_distribution_0/v3_four_channel_phase_distribution_0/v3_four_channel_output_collection_0/v3_four_channel_placement_0/v3_channel_selector_late_promotion_3/v3_selector_route_pilot_0/G2_MUX_POS/a_218_374# V3R232 VDPWR VDPWR sky130_fd_pr__pfet_01v8_hvt ad=0.1533 pd=1.57 as=0 ps=0 w=0.42 l=0.15
X2572 VGND v3_four_channel_output_load_integration_0/v3_four_channel_shared_support_integration_0/v3_four_channel_bias_reference_distribution_0/v3_four_channel_phase_distribution_0/v3_four_channel_output_collection_0/v3_four_channel_placement_0/v3_channel_selector_late_promotion_3/v3_selector_route_pilot_0/G2_MUX_POS/a_505_21# v3_four_channel_output_load_integration_0/v3_four_channel_shared_support_integration_0/v3_four_channel_bias_reference_distribution_0/v3_four_channel_phase_distribution_0/v3_four_channel_output_collection_0/v3_four_channel_placement_0/v3_channel_selector_late_promotion_3/v3_selector_route_pilot_0/G2_MUX_POS/a_439_47# VGND sky130_fd_pr__nfet_01v8 ad=0 pd=0 as=0.1386 ps=1.5 w=0.42 l=0.15
X2573 v3_four_channel_output_load_integration_0/v3_four_channel_shared_support_integration_0/v3_four_channel_bias_reference_distribution_0/v3_four_channel_phase_distribution_0/v3_four_channel_output_collection_0/v3_four_channel_placement_0/v3_channel_selector_late_promotion_3/v3_selector_route_pilot_0/G2_MUX_POS/a_76_199# V3R290 v3_four_channel_output_load_integration_0/v3_four_channel_shared_support_integration_0/v3_four_channel_bias_reference_distribution_0/v3_four_channel_phase_distribution_0/v3_four_channel_output_collection_0/v3_four_channel_placement_0/v3_channel_selector_late_promotion_3/v3_selector_route_pilot_0/G2_MUX_POS/a_218_374# VDPWR sky130_fd_pr__pfet_01v8_hvt ad=0.3864 pd=2.68 as=0 ps=0 w=0.42 l=0.15
X2574 v3_four_channel_output_load_integration_0/v3_four_channel_shared_support_integration_0/v3_four_channel_bias_reference_distribution_0/v3_four_channel_phase_distribution_0/v3_four_channel_output_collection_0/v3_four_channel_placement_0/v3_channel_selector_late_promotion_3/v3_selector_route_pilot_0/G2_MUX_POS/a_505_21# V3R232 VGND VGND sky130_fd_pr__nfet_01v8 ad=0.1092 pd=1.36 as=0 ps=0 w=0.42 l=0.15
X2575 v3_four_channel_output_load_integration_0/v3_four_channel_shared_support_integration_0/v3_four_channel_bias_reference_distribution_0/v3_four_channel_phase_distribution_0/v3_four_channel_output_collection_0/v3_four_channel_placement_0/v3_channel_selector_late_promotion_3/v3_selector_route_pilot_0/G2_MUX_POS/a_439_47# V3R290 v3_four_channel_output_load_integration_0/v3_four_channel_shared_support_integration_0/v3_four_channel_bias_reference_distribution_0/v3_four_channel_phase_distribution_0/v3_four_channel_output_collection_0/v3_four_channel_placement_0/v3_channel_selector_late_promotion_3/v3_selector_route_pilot_0/G2_MUX_POS/a_76_199# VGND sky130_fd_pr__nfet_01v8 ad=0 pd=0 as=0.1995 ps=1.79 w=0.42 l=0.15
X2576 v3_four_channel_output_load_integration_0/v3_four_channel_shared_support_integration_0/v3_four_channel_bias_reference_distribution_0/v3_four_channel_phase_distribution_0/v3_four_channel_output_collection_0/v3_four_channel_placement_0/v3_channel_selector_late_promotion_3/v3_selector_route_pilot_0/G2_MUX_POS/a_535_374# V3R291 v3_four_channel_output_load_integration_0/v3_four_channel_shared_support_integration_0/v3_four_channel_bias_reference_distribution_0/v3_four_channel_phase_distribution_0/v3_four_channel_output_collection_0/v3_four_channel_placement_0/v3_channel_selector_late_promotion_3/v3_selector_route_pilot_0/G2_MUX_POS/a_76_199# VDPWR sky130_fd_pr__pfet_01v8_hvt ad=0 pd=0 as=0 ps=0 w=0.42 l=0.15
X2577 v3_four_channel_output_load_integration_0/v3_four_channel_shared_support_integration_0/v3_four_channel_bias_reference_distribution_0/v3_four_channel_phase_distribution_0/v3_four_channel_output_collection_0/v3_four_channel_placement_0/v3_channel_selector_late_promotion_3/v3_selector_route_pilot_0/G2_MUX_POS/a_76_199# V3R291 v3_four_channel_output_load_integration_0/v3_four_channel_shared_support_integration_0/v3_four_channel_bias_reference_distribution_0/v3_four_channel_phase_distribution_0/v3_four_channel_output_collection_0/v3_four_channel_placement_0/v3_channel_selector_late_promotion_3/v3_selector_route_pilot_0/G2_MUX_POS/a_218_47# VGND sky130_fd_pr__nfet_01v8 ad=0 pd=0 as=0.1386 ps=1.5 w=0.42 l=0.15
X2578 v3_four_channel_output_load_integration_0/v3_four_channel_shared_support_integration_0/v3_four_channel_bias_reference_distribution_0/v3_four_channel_phase_distribution_0/v3_four_channel_output_collection_0/v3_four_channel_placement_0/v3_channel_selector_late_promotion_3/v3_selector_route_pilot_0/G2_MUX_POS/a_218_47# V3R232 VGND VGND sky130_fd_pr__nfet_01v8 ad=0 pd=0 as=0 ps=0 w=0.42 l=0.15
X2579 VDPWR v3_four_channel_output_load_integration_0/v3_four_channel_shared_support_integration_0/v3_four_channel_bias_reference_distribution_0/v3_four_channel_phase_distribution_0/v3_four_channel_output_collection_0/v3_four_channel_placement_0/v3_channel_selector_late_promotion_3/v3_selector_route_pilot_0/G2_MUX_POS/a_76_199# v3_four_channel_output_load_integration_0/v3_four_channel_shared_support_integration_0/v3_four_channel_bias_reference_distribution_0/v3_four_channel_phase_distribution_0/v3_four_channel_output_collection_0/v3_four_channel_placement_0/v3_channel_selector_late_promotion_3/v3_selector_route_pilot_0/G2_MUX_POS/X VDPWR sky130_fd_pr__pfet_01v8_hvt ad=0 pd=0 as=0.26 ps=2.52 w=1 l=0.15
X2580 VGND v3_four_channel_output_load_integration_0/v3_four_channel_shared_support_integration_0/v3_four_channel_bias_reference_distribution_0/v3_four_channel_phase_distribution_0/v3_four_channel_output_collection_0/v3_four_channel_placement_0/v3_channel_selector_late_promotion_3/v3_selector_route_pilot_0/G2_MUX_POS/a_76_199# v3_four_channel_output_load_integration_0/v3_four_channel_shared_support_integration_0/v3_four_channel_bias_reference_distribution_0/v3_four_channel_phase_distribution_0/v3_four_channel_output_collection_0/v3_four_channel_placement_0/v3_channel_selector_late_promotion_3/v3_selector_route_pilot_0/G2_MUX_POS/X VGND sky130_fd_pr__nfet_01v8 ad=0 pd=0 as=0.169 ps=1.82 w=0.65 l=0.15
X2581 VDPWR v3_four_channel_output_load_integration_0/v3_four_channel_shared_support_integration_0/v3_four_channel_bias_reference_distribution_0/v3_four_channel_phase_distribution_0/v3_four_channel_output_collection_0/v3_four_channel_placement_0/v3_channel_selector_late_promotion_3/v3_selector_route_pilot_0/G2_MUX_NEG/a_505_21# v3_four_channel_output_load_integration_0/v3_four_channel_shared_support_integration_0/v3_four_channel_bias_reference_distribution_0/v3_four_channel_phase_distribution_0/v3_four_channel_output_collection_0/v3_four_channel_placement_0/v3_channel_selector_late_promotion_3/v3_selector_route_pilot_0/G2_MUX_NEG/a_535_374# VDPWR sky130_fd_pr__pfet_01v8_hvt ad=0 pd=0 as=0.0882 ps=1.26 w=0.42 l=0.15
X2582 v3_four_channel_output_load_integration_0/v3_four_channel_shared_support_integration_0/v3_four_channel_bias_reference_distribution_0/v3_four_channel_phase_distribution_0/v3_four_channel_output_collection_0/v3_four_channel_placement_0/v3_channel_selector_late_promotion_3/v3_selector_route_pilot_0/G2_MUX_NEG/a_505_21# V3R232 VDPWR VDPWR sky130_fd_pr__pfet_01v8_hvt ad=0.1176 pd=1.4 as=0 ps=0 w=0.42 l=0.15
X2583 v3_four_channel_output_load_integration_0/v3_four_channel_shared_support_integration_0/v3_four_channel_bias_reference_distribution_0/v3_four_channel_phase_distribution_0/v3_four_channel_output_collection_0/v3_four_channel_placement_0/v3_channel_selector_late_promotion_3/v3_selector_route_pilot_0/G2_MUX_NEG/a_218_374# V3R232 VDPWR VDPWR sky130_fd_pr__pfet_01v8_hvt ad=0.1533 pd=1.57 as=0 ps=0 w=0.42 l=0.15
X2584 VGND v3_four_channel_output_load_integration_0/v3_four_channel_shared_support_integration_0/v3_four_channel_bias_reference_distribution_0/v3_four_channel_phase_distribution_0/v3_four_channel_output_collection_0/v3_four_channel_placement_0/v3_channel_selector_late_promotion_3/v3_selector_route_pilot_0/G2_MUX_NEG/a_505_21# v3_four_channel_output_load_integration_0/v3_four_channel_shared_support_integration_0/v3_four_channel_bias_reference_distribution_0/v3_four_channel_phase_distribution_0/v3_four_channel_output_collection_0/v3_four_channel_placement_0/v3_channel_selector_late_promotion_3/v3_selector_route_pilot_0/G2_MUX_NEG/a_439_47# VGND sky130_fd_pr__nfet_01v8 ad=0 pd=0 as=0.1386 ps=1.5 w=0.42 l=0.15
X2585 v3_four_channel_output_load_integration_0/v3_four_channel_shared_support_integration_0/v3_four_channel_bias_reference_distribution_0/v3_four_channel_phase_distribution_0/v3_four_channel_output_collection_0/v3_four_channel_placement_0/v3_channel_selector_late_promotion_3/v3_selector_route_pilot_0/G2_MUX_NEG/a_76_199# V3R292 v3_four_channel_output_load_integration_0/v3_four_channel_shared_support_integration_0/v3_four_channel_bias_reference_distribution_0/v3_four_channel_phase_distribution_0/v3_four_channel_output_collection_0/v3_four_channel_placement_0/v3_channel_selector_late_promotion_3/v3_selector_route_pilot_0/G2_MUX_NEG/a_218_374# VDPWR sky130_fd_pr__pfet_01v8_hvt ad=0.3864 pd=2.68 as=0 ps=0 w=0.42 l=0.15
X2586 v3_four_channel_output_load_integration_0/v3_four_channel_shared_support_integration_0/v3_four_channel_bias_reference_distribution_0/v3_four_channel_phase_distribution_0/v3_four_channel_output_collection_0/v3_four_channel_placement_0/v3_channel_selector_late_promotion_3/v3_selector_route_pilot_0/G2_MUX_NEG/a_505_21# V3R232 VGND VGND sky130_fd_pr__nfet_01v8 ad=0.1092 pd=1.36 as=0 ps=0 w=0.42 l=0.15
X2587 v3_four_channel_output_load_integration_0/v3_four_channel_shared_support_integration_0/v3_four_channel_bias_reference_distribution_0/v3_four_channel_phase_distribution_0/v3_four_channel_output_collection_0/v3_four_channel_placement_0/v3_channel_selector_late_promotion_3/v3_selector_route_pilot_0/G2_MUX_NEG/a_439_47# V3R292 v3_four_channel_output_load_integration_0/v3_four_channel_shared_support_integration_0/v3_four_channel_bias_reference_distribution_0/v3_four_channel_phase_distribution_0/v3_four_channel_output_collection_0/v3_four_channel_placement_0/v3_channel_selector_late_promotion_3/v3_selector_route_pilot_0/G2_MUX_NEG/a_76_199# VGND sky130_fd_pr__nfet_01v8 ad=0 pd=0 as=0.1995 ps=1.79 w=0.42 l=0.15
X2588 v3_four_channel_output_load_integration_0/v3_four_channel_shared_support_integration_0/v3_four_channel_bias_reference_distribution_0/v3_four_channel_phase_distribution_0/v3_four_channel_output_collection_0/v3_four_channel_placement_0/v3_channel_selector_late_promotion_3/v3_selector_route_pilot_0/G2_MUX_NEG/a_535_374# V3R293 v3_four_channel_output_load_integration_0/v3_four_channel_shared_support_integration_0/v3_four_channel_bias_reference_distribution_0/v3_four_channel_phase_distribution_0/v3_four_channel_output_collection_0/v3_four_channel_placement_0/v3_channel_selector_late_promotion_3/v3_selector_route_pilot_0/G2_MUX_NEG/a_76_199# VDPWR sky130_fd_pr__pfet_01v8_hvt ad=0 pd=0 as=0 ps=0 w=0.42 l=0.15
X2589 v3_four_channel_output_load_integration_0/v3_four_channel_shared_support_integration_0/v3_four_channel_bias_reference_distribution_0/v3_four_channel_phase_distribution_0/v3_four_channel_output_collection_0/v3_four_channel_placement_0/v3_channel_selector_late_promotion_3/v3_selector_route_pilot_0/G2_MUX_NEG/a_76_199# V3R293 v3_four_channel_output_load_integration_0/v3_four_channel_shared_support_integration_0/v3_four_channel_bias_reference_distribution_0/v3_four_channel_phase_distribution_0/v3_four_channel_output_collection_0/v3_four_channel_placement_0/v3_channel_selector_late_promotion_3/v3_selector_route_pilot_0/G2_MUX_NEG/a_218_47# VGND sky130_fd_pr__nfet_01v8 ad=0 pd=0 as=0.1386 ps=1.5 w=0.42 l=0.15
X2590 v3_four_channel_output_load_integration_0/v3_four_channel_shared_support_integration_0/v3_four_channel_bias_reference_distribution_0/v3_four_channel_phase_distribution_0/v3_four_channel_output_collection_0/v3_four_channel_placement_0/v3_channel_selector_late_promotion_3/v3_selector_route_pilot_0/G2_MUX_NEG/a_218_47# V3R232 VGND VGND sky130_fd_pr__nfet_01v8 ad=0 pd=0 as=0 ps=0 w=0.42 l=0.15
X2591 VDPWR v3_four_channel_output_load_integration_0/v3_four_channel_shared_support_integration_0/v3_four_channel_bias_reference_distribution_0/v3_four_channel_phase_distribution_0/v3_four_channel_output_collection_0/v3_four_channel_placement_0/v3_channel_selector_late_promotion_3/v3_selector_route_pilot_0/G2_MUX_NEG/a_76_199# v3_four_channel_output_load_integration_0/v3_four_channel_shared_support_integration_0/v3_four_channel_bias_reference_distribution_0/v3_four_channel_phase_distribution_0/v3_four_channel_output_collection_0/v3_four_channel_placement_0/v3_channel_selector_late_promotion_3/v3_selector_route_pilot_0/G2_MUX_NEG/X VDPWR sky130_fd_pr__pfet_01v8_hvt ad=0 pd=0 as=0.26 ps=2.52 w=1 l=0.15
X2592 VGND v3_four_channel_output_load_integration_0/v3_four_channel_shared_support_integration_0/v3_four_channel_bias_reference_distribution_0/v3_four_channel_phase_distribution_0/v3_four_channel_output_collection_0/v3_four_channel_placement_0/v3_channel_selector_late_promotion_3/v3_selector_route_pilot_0/G2_MUX_NEG/a_76_199# v3_four_channel_output_load_integration_0/v3_four_channel_shared_support_integration_0/v3_four_channel_bias_reference_distribution_0/v3_four_channel_phase_distribution_0/v3_four_channel_output_collection_0/v3_four_channel_placement_0/v3_channel_selector_late_promotion_3/v3_selector_route_pilot_0/G2_MUX_NEG/X VGND sky130_fd_pr__nfet_01v8 ad=0 pd=0 as=0.169 ps=1.82 w=0.65 l=0.15
X2593 VDPWR v3_four_channel_output_load_integration_0/v3_four_channel_shared_support_integration_0/v3_four_channel_bias_reference_distribution_0/v3_four_channel_phase_distribution_0/v3_four_channel_output_collection_0/v3_four_channel_placement_0/v3_channel_selector_late_promotion_3/v3_selector_route_pilot_0/G0_MUX_AXIS/a_505_21# v3_four_channel_output_load_integration_0/v3_four_channel_shared_support_integration_0/v3_four_channel_bias_reference_distribution_0/v3_four_channel_phase_distribution_0/v3_four_channel_output_collection_0/v3_four_channel_placement_0/v3_channel_selector_late_promotion_3/v3_selector_route_pilot_0/G0_MUX_AXIS/a_535_374# VDPWR sky130_fd_pr__pfet_01v8_hvt ad=0 pd=0 as=0.0882 ps=1.26 w=0.42 l=0.15
X2594 v3_four_channel_output_load_integration_0/v3_four_channel_shared_support_integration_0/v3_four_channel_bias_reference_distribution_0/v3_four_channel_phase_distribution_0/v3_four_channel_output_collection_0/v3_four_channel_placement_0/v3_channel_selector_late_promotion_3/v3_selector_route_pilot_0/G0_MUX_AXIS/a_505_21# V3R217 VDPWR VDPWR sky130_fd_pr__pfet_01v8_hvt ad=0.1176 pd=1.4 as=0 ps=0 w=0.42 l=0.15
X2595 v3_four_channel_output_load_integration_0/v3_four_channel_shared_support_integration_0/v3_four_channel_bias_reference_distribution_0/v3_four_channel_phase_distribution_0/v3_four_channel_output_collection_0/v3_four_channel_placement_0/v3_channel_selector_late_promotion_3/v3_selector_route_pilot_0/G0_MUX_AXIS/a_218_374# V3R217 VDPWR VDPWR sky130_fd_pr__pfet_01v8_hvt ad=0.1533 pd=1.57 as=0 ps=0 w=0.42 l=0.15
X2596 VGND v3_four_channel_output_load_integration_0/v3_four_channel_shared_support_integration_0/v3_four_channel_bias_reference_distribution_0/v3_four_channel_phase_distribution_0/v3_four_channel_output_collection_0/v3_four_channel_placement_0/v3_channel_selector_late_promotion_3/v3_selector_route_pilot_0/G0_MUX_AXIS/a_505_21# v3_four_channel_output_load_integration_0/v3_four_channel_shared_support_integration_0/v3_four_channel_bias_reference_distribution_0/v3_four_channel_phase_distribution_0/v3_four_channel_output_collection_0/v3_four_channel_placement_0/v3_channel_selector_late_promotion_3/v3_selector_route_pilot_0/G0_MUX_AXIS/a_439_47# VGND sky130_fd_pr__nfet_01v8 ad=0 pd=0 as=0.1386 ps=1.5 w=0.42 l=0.15
X2597 v3_four_channel_output_load_integration_0/v3_four_channel_shared_support_integration_0/v3_four_channel_bias_reference_distribution_0/v3_four_channel_phase_distribution_0/v3_four_channel_output_collection_0/v3_four_channel_placement_0/v3_channel_selector_late_promotion_3/v3_selector_route_pilot_0/G0_MUX_AXIS/a_76_199# v3_four_channel_output_load_integration_0/v3_four_channel_shared_support_integration_0/v3_four_channel_bias_reference_distribution_0/v3_four_channel_phase_distribution_0/v3_four_channel_output_collection_0/v3_four_channel_placement_0/v3_channel_selector_late_promotion_3/v3_selector_route_pilot_0/G0_MUX_POS/X v3_four_channel_output_load_integration_0/v3_four_channel_shared_support_integration_0/v3_four_channel_bias_reference_distribution_0/v3_four_channel_phase_distribution_0/v3_four_channel_output_collection_0/v3_four_channel_placement_0/v3_channel_selector_late_promotion_3/v3_selector_route_pilot_0/G0_MUX_AXIS/a_218_374# VDPWR sky130_fd_pr__pfet_01v8_hvt ad=0.3864 pd=2.68 as=0 ps=0 w=0.42 l=0.15
X2598 v3_four_channel_output_load_integration_0/v3_four_channel_shared_support_integration_0/v3_four_channel_bias_reference_distribution_0/v3_four_channel_phase_distribution_0/v3_four_channel_output_collection_0/v3_four_channel_placement_0/v3_channel_selector_late_promotion_3/v3_selector_route_pilot_0/G0_MUX_AXIS/a_505_21# V3R217 VGND VGND sky130_fd_pr__nfet_01v8 ad=0.1092 pd=1.36 as=0 ps=0 w=0.42 l=0.15
X2599 v3_four_channel_output_load_integration_0/v3_four_channel_shared_support_integration_0/v3_four_channel_bias_reference_distribution_0/v3_four_channel_phase_distribution_0/v3_four_channel_output_collection_0/v3_four_channel_placement_0/v3_channel_selector_late_promotion_3/v3_selector_route_pilot_0/G0_MUX_AXIS/a_439_47# v3_four_channel_output_load_integration_0/v3_four_channel_shared_support_integration_0/v3_four_channel_bias_reference_distribution_0/v3_four_channel_phase_distribution_0/v3_four_channel_output_collection_0/v3_four_channel_placement_0/v3_channel_selector_late_promotion_3/v3_selector_route_pilot_0/G0_MUX_POS/X v3_four_channel_output_load_integration_0/v3_four_channel_shared_support_integration_0/v3_four_channel_bias_reference_distribution_0/v3_four_channel_phase_distribution_0/v3_four_channel_output_collection_0/v3_four_channel_placement_0/v3_channel_selector_late_promotion_3/v3_selector_route_pilot_0/G0_MUX_AXIS/a_76_199# VGND sky130_fd_pr__nfet_01v8 ad=0 pd=0 as=0.1995 ps=1.79 w=0.42 l=0.15
X2600 v3_four_channel_output_load_integration_0/v3_four_channel_shared_support_integration_0/v3_four_channel_bias_reference_distribution_0/v3_four_channel_phase_distribution_0/v3_four_channel_output_collection_0/v3_four_channel_placement_0/v3_channel_selector_late_promotion_3/v3_selector_route_pilot_0/G0_MUX_AXIS/a_535_374# v3_four_channel_output_load_integration_0/v3_four_channel_shared_support_integration_0/v3_four_channel_bias_reference_distribution_0/v3_four_channel_phase_distribution_0/v3_four_channel_output_collection_0/v3_four_channel_placement_0/v3_channel_selector_late_promotion_3/v3_selector_route_pilot_0/G0_MUX_NEG/X v3_four_channel_output_load_integration_0/v3_four_channel_shared_support_integration_0/v3_four_channel_bias_reference_distribution_0/v3_four_channel_phase_distribution_0/v3_four_channel_output_collection_0/v3_four_channel_placement_0/v3_channel_selector_late_promotion_3/v3_selector_route_pilot_0/G0_MUX_AXIS/a_76_199# VDPWR sky130_fd_pr__pfet_01v8_hvt ad=0 pd=0 as=0 ps=0 w=0.42 l=0.15
X2601 v3_four_channel_output_load_integration_0/v3_four_channel_shared_support_integration_0/v3_four_channel_bias_reference_distribution_0/v3_four_channel_phase_distribution_0/v3_four_channel_output_collection_0/v3_four_channel_placement_0/v3_channel_selector_late_promotion_3/v3_selector_route_pilot_0/G0_MUX_AXIS/a_76_199# v3_four_channel_output_load_integration_0/v3_four_channel_shared_support_integration_0/v3_four_channel_bias_reference_distribution_0/v3_four_channel_phase_distribution_0/v3_four_channel_output_collection_0/v3_four_channel_placement_0/v3_channel_selector_late_promotion_3/v3_selector_route_pilot_0/G0_MUX_NEG/X v3_four_channel_output_load_integration_0/v3_four_channel_shared_support_integration_0/v3_four_channel_bias_reference_distribution_0/v3_four_channel_phase_distribution_0/v3_four_channel_output_collection_0/v3_four_channel_placement_0/v3_channel_selector_late_promotion_3/v3_selector_route_pilot_0/G0_MUX_AXIS/a_218_47# VGND sky130_fd_pr__nfet_01v8 ad=0 pd=0 as=0.1386 ps=1.5 w=0.42 l=0.15
X2602 v3_four_channel_output_load_integration_0/v3_four_channel_shared_support_integration_0/v3_four_channel_bias_reference_distribution_0/v3_four_channel_phase_distribution_0/v3_four_channel_output_collection_0/v3_four_channel_placement_0/v3_channel_selector_late_promotion_3/v3_selector_route_pilot_0/G0_MUX_AXIS/a_218_47# V3R217 VGND VGND sky130_fd_pr__nfet_01v8 ad=0 pd=0 as=0 ps=0 w=0.42 l=0.15
X2603 VDPWR v3_four_channel_output_load_integration_0/v3_four_channel_shared_support_integration_0/v3_four_channel_bias_reference_distribution_0/v3_four_channel_phase_distribution_0/v3_four_channel_output_collection_0/v3_four_channel_placement_0/v3_channel_selector_late_promotion_3/v3_selector_route_pilot_0/G0_MUX_AXIS/a_76_199# v3_four_channel_output_load_integration_0/v3_four_channel_shared_support_integration_0/v3_four_channel_bias_reference_distribution_0/v3_four_channel_phase_distribution_0/v3_four_channel_output_collection_0/v3_four_channel_placement_0/v3_channel_selector_late_promotion_3/v3_selector_route_pilot_0/G0_MUX_AXIS/X VDPWR sky130_fd_pr__pfet_01v8_hvt ad=0 pd=0 as=0.26 ps=2.52 w=1 l=0.15
X2604 VGND v3_four_channel_output_load_integration_0/v3_four_channel_shared_support_integration_0/v3_four_channel_bias_reference_distribution_0/v3_four_channel_phase_distribution_0/v3_four_channel_output_collection_0/v3_four_channel_placement_0/v3_channel_selector_late_promotion_3/v3_selector_route_pilot_0/G0_MUX_AXIS/a_76_199# v3_four_channel_output_load_integration_0/v3_four_channel_shared_support_integration_0/v3_four_channel_bias_reference_distribution_0/v3_four_channel_phase_distribution_0/v3_four_channel_output_collection_0/v3_four_channel_placement_0/v3_channel_selector_late_promotion_3/v3_selector_route_pilot_0/G0_MUX_AXIS/X VGND sky130_fd_pr__nfet_01v8 ad=0 pd=0 as=0.169 ps=1.82 w=0.65 l=0.15
X2605 VDPWR v3_four_channel_output_load_integration_0/v3_four_channel_shared_support_integration_0/v3_four_channel_bias_reference_distribution_0/v3_four_channel_phase_distribution_0/v3_four_channel_output_collection_0/v3_four_channel_placement_0/v3_channel_selector_late_promotion_3/v3_selector_route_pilot_0/G3_LO_P_AND/B v3_four_channel_output_load_integration_0/v3_four_channel_shared_support_integration_0/v3_four_channel_bias_reference_distribution_0/v3_four_channel_phase_distribution_0/v3_four_channel_output_collection_0/v3_four_channel_placement_0/v3_channel_selector_late_promotion_3/v3_selector_route_pilot_0/G2_LO_P_AND/a_59_75# VDPWR sky130_fd_pr__pfet_01v8_hvt ad=0 pd=0 as=0.1134 ps=1.38 w=0.42 l=0.15
X2606 v3_four_channel_output_load_integration_0/v3_four_channel_shared_support_integration_0/v3_four_channel_bias_reference_distribution_0/v3_four_channel_phase_distribution_0/v3_four_channel_output_collection_0/v3_four_channel_placement_0/v3_channel_selector_late_promotion_3/v3_selector_route_pilot_0/group2_lo_p v3_four_channel_output_load_integration_0/v3_four_channel_shared_support_integration_0/v3_four_channel_bias_reference_distribution_0/v3_four_channel_phase_distribution_0/v3_four_channel_output_collection_0/v3_four_channel_placement_0/v3_channel_selector_late_promotion_3/v3_selector_route_pilot_0/G2_LO_P_AND/a_59_75# VDPWR VDPWR sky130_fd_pr__pfet_01v8_hvt ad=0.475 pd=2.95 as=0 ps=0 w=1 l=0.15
X2607 VGND v3_four_channel_output_load_integration_0/v3_four_channel_shared_support_integration_0/v3_four_channel_bias_reference_distribution_0/v3_four_channel_phase_distribution_0/v3_four_channel_output_collection_0/v3_four_channel_placement_0/v3_channel_selector_late_promotion_3/v3_selector_route_pilot_0/G3_LO_P_AND/B v3_four_channel_output_load_integration_0/v3_four_channel_shared_support_integration_0/v3_four_channel_bias_reference_distribution_0/v3_four_channel_phase_distribution_0/v3_four_channel_output_collection_0/v3_four_channel_placement_0/v3_channel_selector_late_promotion_3/v3_selector_route_pilot_0/G2_LO_P_AND/a_145_75# VGND sky130_fd_pr__nfet_01v8 ad=0 pd=0 as=0.1134 ps=1.38 w=0.42 l=0.15
X2608 v3_four_channel_output_load_integration_0/v3_four_channel_shared_support_integration_0/v3_four_channel_bias_reference_distribution_0/v3_four_channel_phase_distribution_0/v3_four_channel_output_collection_0/v3_four_channel_placement_0/v3_channel_selector_late_promotion_3/v3_selector_route_pilot_0/G2_LO_P_AND/a_59_75# v3_four_channel_output_load_integration_0/v3_four_channel_shared_support_integration_0/v3_four_channel_bias_reference_distribution_0/v3_four_channel_phase_distribution_0/v3_four_channel_output_collection_0/v3_four_channel_placement_0/v3_channel_selector_late_promotion_3/v3_selector_route_pilot_0/G2_MUX_AXIS/X VDPWR VDPWR sky130_fd_pr__pfet_01v8_hvt ad=0 pd=0 as=0 ps=0 w=0.42 l=0.15
X2609 v3_four_channel_output_load_integration_0/v3_four_channel_shared_support_integration_0/v3_four_channel_bias_reference_distribution_0/v3_four_channel_phase_distribution_0/v3_four_channel_output_collection_0/v3_four_channel_placement_0/v3_channel_selector_late_promotion_3/v3_selector_route_pilot_0/group2_lo_p v3_four_channel_output_load_integration_0/v3_four_channel_shared_support_integration_0/v3_four_channel_bias_reference_distribution_0/v3_four_channel_phase_distribution_0/v3_four_channel_output_collection_0/v3_four_channel_placement_0/v3_channel_selector_late_promotion_3/v3_selector_route_pilot_0/G2_LO_P_AND/a_59_75# VGND VGND sky130_fd_pr__nfet_01v8 ad=0.182 pd=1.86 as=0 ps=0 w=0.65 l=0.15
X2610 v3_four_channel_output_load_integration_0/v3_four_channel_shared_support_integration_0/v3_four_channel_bias_reference_distribution_0/v3_four_channel_phase_distribution_0/v3_four_channel_output_collection_0/v3_four_channel_placement_0/v3_channel_selector_late_promotion_3/v3_selector_route_pilot_0/G2_LO_P_AND/a_145_75# v3_four_channel_output_load_integration_0/v3_four_channel_shared_support_integration_0/v3_four_channel_bias_reference_distribution_0/v3_four_channel_phase_distribution_0/v3_four_channel_output_collection_0/v3_four_channel_placement_0/v3_channel_selector_late_promotion_3/v3_selector_route_pilot_0/G2_MUX_AXIS/X v3_four_channel_output_load_integration_0/v3_four_channel_shared_support_integration_0/v3_four_channel_bias_reference_distribution_0/v3_four_channel_phase_distribution_0/v3_four_channel_output_collection_0/v3_four_channel_placement_0/v3_channel_selector_late_promotion_3/v3_selector_route_pilot_0/G2_LO_P_AND/a_59_75# VGND sky130_fd_pr__nfet_01v8 ad=0 pd=0 as=0.1176 ps=1.4 w=0.42 l=0.15
X2611 VDPWR v3_four_channel_output_load_integration_0/combined_p VGND sky130_fd_pr__res_high_po_1p41 l=11.61
X2612 VDPWR v3_four_channel_output_load_integration_0/combined_n VGND sky130_fd_pr__res_high_po_1p41 l=11.61
X2613 sky130_fd_sc_hd__dfrtp_1_29/a_805_47# sky130_fd_sc_hd__dfrtp_1_29/a_761_289# sky130_fd_sc_hd__dfrtp_1_29/a_639_47# VGND sky130_fd_pr__nfet_01v8 ad=0.0882 pd=1.26 as=0.2802 ps=2.2 w=0.42 l=0.15
X2614 sky130_fd_sc_hd__dfrtp_1_29/a_1217_47# sky130_fd_sc_hd__dfrtp_1_29/a_27_47# sky130_fd_sc_hd__dfrtp_1_29/a_1108_47# VGND sky130_fd_pr__special_nfet_01v8 ad=0.1338 pd=1.5 as=0.1422 ps=1.51 w=0.36 l=0.15
X2615 sky130_fd_sc_hd__dfrtp_1_29/a_1283_21# sky130_fd_sc_hd__dfrtp_1_29/a_1108_47# sky130_fd_sc_hd__dfrtp_1_29/a_1462_47# VGND sky130_fd_pr__nfet_01v8 ad=0.1092 pd=1.36 as=0.1281 ps=1.45 w=0.42 l=0.15
X2616 sky130_fd_sc_hd__dfrtp_1_29/a_651_413# sky130_fd_sc_hd__dfrtp_1_29/a_27_47# sky130_fd_sc_hd__dfrtp_1_29/a_543_47# VDPWR sky130_fd_pr__pfet_01v8_hvt ad=0.3402 pd=3.3 as=0.1449 ps=1.53 w=0.42 l=0.15
X2617 sky130_fd_sc_hd__dfrtp_1_29/a_1108_47# sky130_fd_sc_hd__dfrtp_1_29/a_193_47# sky130_fd_sc_hd__dfrtp_1_29/a_761_289# VGND sky130_fd_pr__special_nfet_01v8 ad=0 pd=0 as=0.1998 ps=1.97 w=0.36 l=0.15
X2618 VGND V3R303 sky130_fd_sc_hd__dfrtp_1_29/a_805_47# VGND sky130_fd_pr__nfet_01v8 ad=0 pd=0 as=0 ps=0 w=0.42 l=0.15
X2619 V3R200 sky130_fd_sc_hd__dfrtp_1_29/a_1283_21# VDPWR VDPWR sky130_fd_pr__pfet_01v8_hvt ad=0.26 pd=2.52 as=0 ps=0 w=1 l=0.15
X2620 VDPWR V3R084 sky130_fd_sc_hd__dfrtp_1_29/a_27_47# VDPWR sky130_fd_pr__pfet_01v8_hvt ad=0 pd=0 as=0.1664 ps=1.8 w=0.64 l=0.15
X2621 sky130_fd_sc_hd__dfrtp_1_29/a_448_47# V3R073 VDPWR VDPWR sky130_fd_pr__pfet_01v8_hvt ad=0.1302 pd=1.46 as=0 ps=0 w=0.42 l=0.15
X2622 sky130_fd_sc_hd__dfrtp_1_29/a_761_289# sky130_fd_sc_hd__dfrtp_1_29/a_543_47# VGND VGND sky130_fd_pr__nfet_01v8 ad=0 pd=0 as=0 ps=0 w=0.64 l=0.15
X2623 sky130_fd_sc_hd__dfrtp_1_29/a_193_47# sky130_fd_sc_hd__dfrtp_1_29/a_27_47# VGND VGND sky130_fd_pr__nfet_01v8 ad=0.1092 pd=1.36 as=0 ps=0 w=0.42 l=0.15
X2624 sky130_fd_sc_hd__dfrtp_1_29/a_1108_47# sky130_fd_sc_hd__dfrtp_1_29/a_27_47# sky130_fd_sc_hd__dfrtp_1_29/a_761_289# VDPWR sky130_fd_pr__pfet_01v8_hvt ad=0.1176 pd=1.4 as=0.2583 ps=2.37 w=0.42 l=0.15
X2625 sky130_fd_sc_hd__dfrtp_1_29/a_1462_47# V3R303 VGND VGND sky130_fd_pr__nfet_01v8 ad=0 pd=0 as=0 ps=0 w=0.42 l=0.15
X2626 sky130_fd_sc_hd__dfrtp_1_29/a_543_47# sky130_fd_sc_hd__dfrtp_1_29/a_27_47# sky130_fd_sc_hd__dfrtp_1_29/a_448_47# VGND sky130_fd_pr__special_nfet_01v8 ad=0.1188 pd=1.38 as=0.132 ps=1.49 w=0.36 l=0.15
X2627 sky130_fd_sc_hd__dfrtp_1_29/a_543_47# sky130_fd_sc_hd__dfrtp_1_29/a_193_47# sky130_fd_sc_hd__dfrtp_1_29/a_448_47# VDPWR sky130_fd_pr__pfet_01v8_hvt ad=0 pd=0 as=0 ps=0 w=0.42 l=0.15
X2628 sky130_fd_sc_hd__dfrtp_1_29/a_448_47# V3R073 VGND VGND sky130_fd_pr__nfet_01v8 ad=0 pd=0 as=0 ps=0 w=0.42 l=0.15
X2629 VDPWR sky130_fd_sc_hd__dfrtp_1_29/a_1283_21# sky130_fd_sc_hd__dfrtp_1_29/a_1270_413# VDPWR sky130_fd_pr__pfet_01v8_hvt ad=0 pd=0 as=0.1134 ps=1.38 w=0.42 l=0.15
X2630 VDPWR sky130_fd_sc_hd__dfrtp_1_29/a_1108_47# sky130_fd_sc_hd__dfrtp_1_29/a_1283_21# VDPWR sky130_fd_pr__pfet_01v8_hvt ad=0 pd=0 as=0.1134 ps=1.38 w=0.42 l=0.15
X2631 sky130_fd_sc_hd__dfrtp_1_29/a_1270_413# sky130_fd_sc_hd__dfrtp_1_29/a_193_47# sky130_fd_sc_hd__dfrtp_1_29/a_1108_47# VDPWR sky130_fd_pr__pfet_01v8_hvt ad=0 pd=0 as=0 ps=0 w=0.42 l=0.15
X2632 sky130_fd_sc_hd__dfrtp_1_29/a_193_47# sky130_fd_sc_hd__dfrtp_1_29/a_27_47# VDPWR VDPWR sky130_fd_pr__pfet_01v8_hvt ad=0.1664 pd=1.8 as=0 ps=0 w=0.64 l=0.15
X2633 sky130_fd_sc_hd__dfrtp_1_29/a_1283_21# V3R303 VDPWR VDPWR sky130_fd_pr__pfet_01v8_hvt ad=0 pd=0 as=0 ps=0 w=0.42 l=0.15
X2634 VDPWR sky130_fd_sc_hd__dfrtp_1_29/a_761_289# sky130_fd_sc_hd__dfrtp_1_29/a_651_413# VDPWR sky130_fd_pr__pfet_01v8_hvt ad=0 pd=0 as=0 ps=0 w=0.42 l=0.15
X2635 V3R200 sky130_fd_sc_hd__dfrtp_1_29/a_1283_21# VGND VGND sky130_fd_pr__nfet_01v8 ad=0.169 pd=1.82 as=0 ps=0 w=0.65 l=0.15
X2636 sky130_fd_sc_hd__dfrtp_1_29/a_639_47# sky130_fd_sc_hd__dfrtp_1_29/a_193_47# sky130_fd_sc_hd__dfrtp_1_29/a_543_47# VGND sky130_fd_pr__special_nfet_01v8 ad=0 pd=0 as=0 ps=0 w=0.36 l=0.15
X2637 VGND sky130_fd_sc_hd__dfrtp_1_29/a_1283_21# sky130_fd_sc_hd__dfrtp_1_29/a_1217_47# VGND sky130_fd_pr__nfet_01v8 ad=0 pd=0 as=0 ps=0 w=0.42 l=0.15
X2638 sky130_fd_sc_hd__dfrtp_1_29/a_651_413# V3R303 VDPWR VDPWR sky130_fd_pr__pfet_01v8_hvt ad=0 pd=0 as=0 ps=0 w=0.42 l=0.15
X2639 VGND V3R084 sky130_fd_sc_hd__dfrtp_1_29/a_27_47# VGND sky130_fd_pr__nfet_01v8 ad=0 pd=0 as=0.1092 ps=1.36 w=0.42 l=0.15
X2640 sky130_fd_sc_hd__dfrtp_1_29/a_761_289# sky130_fd_sc_hd__dfrtp_1_29/a_543_47# VDPWR VDPWR sky130_fd_pr__pfet_01v8_hvt ad=0 pd=0 as=0 ps=0 w=0.84 l=0.15
X2641 sky130_fd_sc_hd__dfrtp_1_18/a_805_47# sky130_fd_sc_hd__dfrtp_1_18/a_761_289# sky130_fd_sc_hd__dfrtp_1_18/a_639_47# VGND sky130_fd_pr__nfet_01v8 ad=0.0882 pd=1.26 as=0.2802 ps=2.2 w=0.42 l=0.15
X2642 sky130_fd_sc_hd__dfrtp_1_18/a_1217_47# sky130_fd_sc_hd__dfrtp_1_18/a_27_47# sky130_fd_sc_hd__dfrtp_1_18/a_1108_47# VGND sky130_fd_pr__special_nfet_01v8 ad=0.1338 pd=1.5 as=0.1422 ps=1.51 w=0.36 l=0.15
X2643 sky130_fd_sc_hd__dfrtp_1_18/a_1283_21# sky130_fd_sc_hd__dfrtp_1_18/a_1108_47# sky130_fd_sc_hd__dfrtp_1_18/a_1462_47# VGND sky130_fd_pr__nfet_01v8 ad=0.1092 pd=1.36 as=0.1281 ps=1.45 w=0.42 l=0.15
X2644 sky130_fd_sc_hd__dfrtp_1_18/a_651_413# sky130_fd_sc_hd__dfrtp_1_18/a_27_47# sky130_fd_sc_hd__dfrtp_1_18/a_543_47# VDPWR sky130_fd_pr__pfet_01v8_hvt ad=0.3402 pd=3.3 as=0.1449 ps=1.53 w=0.42 l=0.15
X2645 sky130_fd_sc_hd__dfrtp_1_18/a_1108_47# sky130_fd_sc_hd__dfrtp_1_18/a_193_47# sky130_fd_sc_hd__dfrtp_1_18/a_761_289# VGND sky130_fd_pr__special_nfet_01v8 ad=0 pd=0 as=0.1998 ps=1.97 w=0.36 l=0.15
X2646 VGND V3R299 sky130_fd_sc_hd__dfrtp_1_18/a_805_47# VGND sky130_fd_pr__nfet_01v8 ad=0 pd=0 as=0 ps=0 w=0.42 l=0.15
X2647 V3R168 sky130_fd_sc_hd__dfrtp_1_18/a_1283_21# VDPWR VDPWR sky130_fd_pr__pfet_01v8_hvt ad=0.26 pd=2.52 as=0 ps=0 w=1 l=0.15
X2648 VDPWR V3R056 sky130_fd_sc_hd__dfrtp_1_18/a_27_47# VDPWR sky130_fd_pr__pfet_01v8_hvt ad=0 pd=0 as=0.1664 ps=1.8 w=0.64 l=0.15
X2649 sky130_fd_sc_hd__dfrtp_1_18/a_448_47# V3R112 VDPWR VDPWR sky130_fd_pr__pfet_01v8_hvt ad=0.1302 pd=1.46 as=0 ps=0 w=0.42 l=0.15
X2650 sky130_fd_sc_hd__dfrtp_1_18/a_761_289# sky130_fd_sc_hd__dfrtp_1_18/a_543_47# VGND VGND sky130_fd_pr__nfet_01v8 ad=0 pd=0 as=0 ps=0 w=0.64 l=0.15
X2651 sky130_fd_sc_hd__dfrtp_1_18/a_193_47# sky130_fd_sc_hd__dfrtp_1_18/a_27_47# VGND VGND sky130_fd_pr__nfet_01v8 ad=0.1092 pd=1.36 as=0 ps=0 w=0.42 l=0.15
X2652 sky130_fd_sc_hd__dfrtp_1_18/a_1108_47# sky130_fd_sc_hd__dfrtp_1_18/a_27_47# sky130_fd_sc_hd__dfrtp_1_18/a_761_289# VDPWR sky130_fd_pr__pfet_01v8_hvt ad=0.1176 pd=1.4 as=0.2583 ps=2.37 w=0.42 l=0.15
X2653 sky130_fd_sc_hd__dfrtp_1_18/a_1462_47# V3R299 VGND VGND sky130_fd_pr__nfet_01v8 ad=0 pd=0 as=0 ps=0 w=0.42 l=0.15
X2654 sky130_fd_sc_hd__dfrtp_1_18/a_543_47# sky130_fd_sc_hd__dfrtp_1_18/a_27_47# sky130_fd_sc_hd__dfrtp_1_18/a_448_47# VGND sky130_fd_pr__special_nfet_01v8 ad=0.1188 pd=1.38 as=0.132 ps=1.49 w=0.36 l=0.15
X2655 sky130_fd_sc_hd__dfrtp_1_18/a_543_47# sky130_fd_sc_hd__dfrtp_1_18/a_193_47# sky130_fd_sc_hd__dfrtp_1_18/a_448_47# VDPWR sky130_fd_pr__pfet_01v8_hvt ad=0 pd=0 as=0 ps=0 w=0.42 l=0.15
X2656 sky130_fd_sc_hd__dfrtp_1_18/a_448_47# V3R112 VGND VGND sky130_fd_pr__nfet_01v8 ad=0 pd=0 as=0 ps=0 w=0.42 l=0.15
X2657 VDPWR sky130_fd_sc_hd__dfrtp_1_18/a_1283_21# sky130_fd_sc_hd__dfrtp_1_18/a_1270_413# VDPWR sky130_fd_pr__pfet_01v8_hvt ad=0 pd=0 as=0.1134 ps=1.38 w=0.42 l=0.15
X2658 VDPWR sky130_fd_sc_hd__dfrtp_1_18/a_1108_47# sky130_fd_sc_hd__dfrtp_1_18/a_1283_21# VDPWR sky130_fd_pr__pfet_01v8_hvt ad=0 pd=0 as=0.1134 ps=1.38 w=0.42 l=0.15
X2659 sky130_fd_sc_hd__dfrtp_1_18/a_1270_413# sky130_fd_sc_hd__dfrtp_1_18/a_193_47# sky130_fd_sc_hd__dfrtp_1_18/a_1108_47# VDPWR sky130_fd_pr__pfet_01v8_hvt ad=0 pd=0 as=0 ps=0 w=0.42 l=0.15
X2660 sky130_fd_sc_hd__dfrtp_1_18/a_193_47# sky130_fd_sc_hd__dfrtp_1_18/a_27_47# VDPWR VDPWR sky130_fd_pr__pfet_01v8_hvt ad=0.1664 pd=1.8 as=0 ps=0 w=0.64 l=0.15
X2661 sky130_fd_sc_hd__dfrtp_1_18/a_1283_21# V3R299 VDPWR VDPWR sky130_fd_pr__pfet_01v8_hvt ad=0 pd=0 as=0 ps=0 w=0.42 l=0.15
X2662 VDPWR sky130_fd_sc_hd__dfrtp_1_18/a_761_289# sky130_fd_sc_hd__dfrtp_1_18/a_651_413# VDPWR sky130_fd_pr__pfet_01v8_hvt ad=0 pd=0 as=0 ps=0 w=0.42 l=0.15
X2663 V3R168 sky130_fd_sc_hd__dfrtp_1_18/a_1283_21# VGND VGND sky130_fd_pr__nfet_01v8 ad=0.169 pd=1.82 as=0 ps=0 w=0.65 l=0.15
X2664 sky130_fd_sc_hd__dfrtp_1_18/a_639_47# sky130_fd_sc_hd__dfrtp_1_18/a_193_47# sky130_fd_sc_hd__dfrtp_1_18/a_543_47# VGND sky130_fd_pr__special_nfet_01v8 ad=0 pd=0 as=0 ps=0 w=0.36 l=0.15
X2665 VGND sky130_fd_sc_hd__dfrtp_1_18/a_1283_21# sky130_fd_sc_hd__dfrtp_1_18/a_1217_47# VGND sky130_fd_pr__nfet_01v8 ad=0 pd=0 as=0 ps=0 w=0.42 l=0.15
X2666 sky130_fd_sc_hd__dfrtp_1_18/a_651_413# V3R299 VDPWR VDPWR sky130_fd_pr__pfet_01v8_hvt ad=0 pd=0 as=0 ps=0 w=0.42 l=0.15
X2667 VGND V3R056 sky130_fd_sc_hd__dfrtp_1_18/a_27_47# VGND sky130_fd_pr__nfet_01v8 ad=0 pd=0 as=0.1092 ps=1.36 w=0.42 l=0.15
X2668 sky130_fd_sc_hd__dfrtp_1_18/a_761_289# sky130_fd_sc_hd__dfrtp_1_18/a_543_47# VDPWR VDPWR sky130_fd_pr__pfet_01v8_hvt ad=0 pd=0 as=0 ps=0 w=0.84 l=0.15
X2669 VDPWR V3R001 sky130_fd_sc_hd__nor2_1_1/a_109_297# VDPWR sky130_fd_pr__pfet_01v8_hvt ad=0 pd=0 as=0.21 ps=2.42 w=1 l=0.15
X2670 VGND V3R001 V3R244 VGND sky130_fd_pr__nfet_01v8 ad=0 pd=0 as=0.1755 ps=1.84 w=0.65 l=0.15
X2671 sky130_fd_sc_hd__nor2_1_1/a_109_297# V3R000 V3R244 VDPWR sky130_fd_pr__pfet_01v8_hvt ad=0 pd=0 as=0.26 ps=2.52 w=1 l=0.15
X2672 V3R244 V3R000 VGND VGND sky130_fd_pr__nfet_01v8 ad=0 pd=0 as=0 ps=0 w=0.65 l=0.15
X2673 VGND sky130_fd_sc_hd__dfstp_1_4/a_652_21# sky130_fd_sc_hd__dfstp_1_4/a_586_47# VGND sky130_fd_pr__nfet_01v8 ad=0 pd=0 as=0.1341 ps=1.5 w=0.42 l=0.15
X2674 sky130_fd_sc_hd__dfstp_1_4/a_956_413# sky130_fd_sc_hd__dfstp_1_4/a_476_47# VDPWR VDPWR sky130_fd_pr__pfet_01v8_hvt ad=0.0966 pd=1.3 as=0 ps=0 w=0.42 l=0.15
X2675 VDPWR sky130_fd_sc_hd__dfstp_1_4/a_476_47# sky130_fd_sc_hd__dfstp_1_4/a_652_21# VDPWR sky130_fd_pr__pfet_01v8_hvt ad=0 pd=0 as=0.1134 ps=1.38 w=0.42 l=0.15
X2676 VDPWR V3R083 sky130_fd_sc_hd__dfstp_1_4/a_27_47# VDPWR sky130_fd_pr__pfet_01v8_hvt ad=0 pd=0 as=0.1664 ps=1.8 w=0.64 l=0.15
X2677 sky130_fd_sc_hd__dfstp_1_4/a_586_47# sky130_fd_sc_hd__dfstp_1_4/a_193_47# sky130_fd_sc_hd__dfstp_1_4/a_476_47# VGND sky130_fd_pr__special_nfet_01v8 ad=0 pd=0 as=0.144 ps=1.52 w=0.36 l=0.15
X2678 sky130_fd_sc_hd__dfstp_1_4/a_1056_47# sky130_fd_sc_hd__dfstp_1_4/a_476_47# VGND VGND sky130_fd_pr__nfet_01v8 ad=0.0882 pd=1.26 as=0 ps=0 w=0.42 l=0.15
X2679 sky130_fd_sc_hd__dfstp_1_4/a_476_47# sky130_fd_sc_hd__dfstp_1_4/a_27_47# sky130_fd_sc_hd__dfstp_1_4/a_381_47# VGND sky130_fd_pr__special_nfet_01v8 ad=0 pd=0 as=0.187 ps=1.93 w=0.36 l=0.15
X2680 sky130_fd_sc_hd__dfstp_1_4/a_381_47# V3R262 VDPWR VDPWR sky130_fd_pr__pfet_01v8_hvt ad=0.2499 pd=2.35 as=0 ps=0 w=0.84 l=0.15
X2681 sky130_fd_sc_hd__dfstp_1_4/a_652_21# V3R302 VDPWR VDPWR sky130_fd_pr__pfet_01v8_hvt ad=0 pd=0 as=0 ps=0 w=0.42 l=0.15
X2682 sky130_fd_sc_hd__dfstp_1_4/a_1224_47# sky130_fd_sc_hd__dfstp_1_4/a_27_47# sky130_fd_sc_hd__dfstp_1_4/a_1032_413# VGND sky130_fd_pr__nfet_01v8 ad=0.0882 pd=1.26 as=0.1386 ps=1.5 w=0.42 l=0.15
X2683 sky130_fd_sc_hd__dfstp_1_4/a_562_413# sky130_fd_sc_hd__dfstp_1_4/a_27_47# sky130_fd_sc_hd__dfstp_1_4/a_476_47# VDPWR sky130_fd_pr__pfet_01v8_hvt ad=0.189 pd=1.74 as=0.1134 ps=1.38 w=0.42 l=0.15
X2684 VGND sky130_fd_sc_hd__dfstp_1_4/a_1032_413# sky130_fd_sc_hd__dfstp_1_4/a_1602_47# VGND sky130_fd_pr__nfet_01v8 ad=0 pd=0 as=0.1092 ps=1.36 w=0.42 l=0.15
X2685 VDPWR sky130_fd_sc_hd__dfstp_1_4/a_1182_261# sky130_fd_sc_hd__dfstp_1_4/a_1140_413# VDPWR sky130_fd_pr__pfet_01v8_hvt ad=0 pd=0 as=0.0882 ps=1.26 w=0.42 l=0.15
X2686 V3R053 sky130_fd_sc_hd__dfstp_1_4/a_1602_47# VDPWR VDPWR sky130_fd_pr__pfet_01v8_hvt ad=0.26 pd=2.52 as=0 ps=0 w=1 l=0.15
X2687 sky130_fd_sc_hd__dfstp_1_4/a_1032_413# sky130_fd_sc_hd__dfstp_1_4/a_193_47# sky130_fd_sc_hd__dfstp_1_4/a_1056_47# VGND sky130_fd_pr__nfet_01v8 ad=0 pd=0 as=0 ps=0 w=0.42 l=0.15
X2688 sky130_fd_sc_hd__dfstp_1_4/a_476_47# sky130_fd_sc_hd__dfstp_1_4/a_193_47# sky130_fd_sc_hd__dfstp_1_4/a_381_47# VDPWR sky130_fd_pr__pfet_01v8_hvt ad=0 pd=0 as=0 ps=0 w=0.42 l=0.15
X2689 sky130_fd_sc_hd__dfstp_1_4/a_1296_47# sky130_fd_sc_hd__dfstp_1_4/a_1182_261# sky130_fd_sc_hd__dfstp_1_4/a_1224_47# VGND sky130_fd_pr__nfet_01v8 ad=0.0966 pd=1.3 as=0 ps=0 w=0.42 l=0.15
X2690 sky130_fd_sc_hd__dfstp_1_4/a_193_47# sky130_fd_sc_hd__dfstp_1_4/a_27_47# VGND VGND sky130_fd_pr__nfet_01v8 ad=0.1092 pd=1.36 as=0 ps=0 w=0.42 l=0.15
X2691 VDPWR sky130_fd_sc_hd__dfstp_1_4/a_652_21# sky130_fd_sc_hd__dfstp_1_4/a_562_413# VDPWR sky130_fd_pr__pfet_01v8_hvt ad=0 pd=0 as=0 ps=0 w=0.42 l=0.15
X2692 VDPWR V3R302 sky130_fd_sc_hd__dfstp_1_4/a_1032_413# VDPWR sky130_fd_pr__pfet_01v8_hvt ad=0 pd=0 as=0.273 ps=2.98 w=0.42 l=0.15
X2693 sky130_fd_sc_hd__dfstp_1_4/a_1032_413# sky130_fd_sc_hd__dfstp_1_4/a_27_47# sky130_fd_sc_hd__dfstp_1_4/a_956_413# VDPWR sky130_fd_pr__pfet_01v8_hvt ad=0 pd=0 as=0 ps=0 w=0.42 l=0.15
X2694 sky130_fd_sc_hd__dfstp_1_4/a_1182_261# sky130_fd_sc_hd__dfstp_1_4/a_1032_413# VDPWR VDPWR sky130_fd_pr__pfet_01v8_hvt ad=0.2184 pd=2.2 as=0 ps=0 w=0.84 l=0.15
X2695 V3R053 sky130_fd_sc_hd__dfstp_1_4/a_1602_47# VGND VGND sky130_fd_pr__nfet_01v8 ad=0.169 pd=1.82 as=0 ps=0 w=0.65 l=0.15
X2696 sky130_fd_sc_hd__dfstp_1_4/a_193_47# sky130_fd_sc_hd__dfstp_1_4/a_27_47# VDPWR VDPWR sky130_fd_pr__pfet_01v8_hvt ad=0.1664 pd=1.8 as=0 ps=0 w=0.64 l=0.15
X2697 sky130_fd_sc_hd__dfstp_1_4/a_1140_413# sky130_fd_sc_hd__dfstp_1_4/a_193_47# sky130_fd_sc_hd__dfstp_1_4/a_1032_413# VDPWR sky130_fd_pr__pfet_01v8_hvt ad=0 pd=0 as=0 ps=0 w=0.42 l=0.15
X2698 VDPWR sky130_fd_sc_hd__dfstp_1_4/a_1032_413# sky130_fd_sc_hd__dfstp_1_4/a_1602_47# VDPWR sky130_fd_pr__pfet_01v8_hvt ad=0 pd=0 as=0.1664 ps=1.8 w=0.64 l=0.15
X2699 sky130_fd_sc_hd__dfstp_1_4/a_796_47# V3R302 VGND VGND sky130_fd_pr__nfet_01v8 ad=0.0882 pd=1.26 as=0 ps=0 w=0.42 l=0.15
X2700 sky130_fd_sc_hd__dfstp_1_4/a_381_47# V3R262 VGND VGND sky130_fd_pr__nfet_01v8 ad=0 pd=0 as=0 ps=0 w=0.64 l=0.15
X2701 sky130_fd_sc_hd__dfstp_1_4/a_1182_261# sky130_fd_sc_hd__dfstp_1_4/a_1032_413# VGND VGND sky130_fd_pr__nfet_01v8 ad=0.1404 pd=1.6 as=0 ps=0 w=0.54 l=0.15
X2702 sky130_fd_sc_hd__dfstp_1_4/a_652_21# sky130_fd_sc_hd__dfstp_1_4/a_476_47# sky130_fd_sc_hd__dfstp_1_4/a_796_47# VGND sky130_fd_pr__nfet_01v8 ad=0.1092 pd=1.36 as=0 ps=0 w=0.42 l=0.15
X2703 VGND V3R083 sky130_fd_sc_hd__dfstp_1_4/a_27_47# VGND sky130_fd_pr__nfet_01v8 ad=0 pd=0 as=0.1092 ps=1.36 w=0.42 l=0.15
X2704 VGND V3R302 sky130_fd_sc_hd__dfstp_1_4/a_1296_47# VGND sky130_fd_pr__nfet_01v8 ad=0 pd=0 as=0 ps=0 w=0.42 l=0.15
X2705 V3R275 sky130_fd_sc_hd__xor2_1_9/a_35_297# sky130_fd_sc_hd__xor2_1_9/a_285_297# VDPWR sky130_fd_pr__pfet_01v8_hvt ad=0.3 pd=2.6 as=0.53 ps=5.06 w=1 l=0.15
X2706 V3R275 V3R008 sky130_fd_sc_hd__xor2_1_9/a_285_47# VGND sky130_fd_pr__nfet_01v8 ad=0.5005 pd=2.84 as=0.1755 ps=1.84 w=0.65 l=0.15
X2707 sky130_fd_sc_hd__xor2_1_9/a_35_297# V3R008 VGND VGND sky130_fd_pr__nfet_01v8 ad=0.1755 pd=1.84 as=0 ps=0 w=0.65 l=0.15
X2708 sky130_fd_sc_hd__xor2_1_9/a_117_297# V3R008 sky130_fd_sc_hd__xor2_1_9/a_35_297# VDPWR sky130_fd_pr__pfet_01v8_hvt ad=0.27 pd=2.54 as=0.26 ps=2.52 w=1 l=0.15
X2709 VDPWR V3R008 sky130_fd_sc_hd__xor2_1_9/a_285_297# VDPWR sky130_fd_pr__pfet_01v8_hvt ad=0 pd=0 as=0 ps=0 w=1 l=0.15
X2710 VGND V3R204 sky130_fd_sc_hd__xor2_1_9/a_35_297# VGND sky130_fd_pr__nfet_01v8 ad=0 pd=0 as=0 ps=0 w=0.65 l=0.15
X2711 VGND sky130_fd_sc_hd__xor2_1_9/a_35_297# V3R275 VGND sky130_fd_pr__nfet_01v8 ad=0 pd=0 as=0 ps=0 w=0.65 l=0.15
X2712 sky130_fd_sc_hd__xor2_1_9/a_285_297# V3R204 VDPWR VDPWR sky130_fd_pr__pfet_01v8_hvt ad=0 pd=0 as=0 ps=0 w=1 l=0.15
X2713 VDPWR V3R204 sky130_fd_sc_hd__xor2_1_9/a_117_297# VDPWR sky130_fd_pr__pfet_01v8_hvt ad=0 pd=0 as=0 ps=0 w=1 l=0.15
X2714 sky130_fd_sc_hd__xor2_1_9/a_285_47# V3R204 VGND VGND sky130_fd_pr__nfet_01v8 ad=0 pd=0 as=0 ps=0 w=0.65 l=0.15
X2715 VDPWR V3R203 sky130_fd_sc_hd__and2_1_0/a_59_75# VDPWR sky130_fd_pr__pfet_01v8_hvt ad=0 pd=0 as=0.1134 ps=1.38 w=0.42 l=0.15
X2716 V3R294 sky130_fd_sc_hd__and2_1_0/a_59_75# VDPWR VDPWR sky130_fd_pr__pfet_01v8_hvt ad=0.475 pd=2.95 as=0 ps=0 w=1 l=0.15
X2717 VGND V3R203 sky130_fd_sc_hd__and2_1_0/a_145_75# VGND sky130_fd_pr__nfet_01v8 ad=0 pd=0 as=0.1134 ps=1.38 w=0.42 l=0.15
X2718 sky130_fd_sc_hd__and2_1_0/a_59_75# V3R291 VDPWR VDPWR sky130_fd_pr__pfet_01v8_hvt ad=0 pd=0 as=0 ps=0 w=0.42 l=0.15
X2719 V3R294 sky130_fd_sc_hd__and2_1_0/a_59_75# VGND VGND sky130_fd_pr__nfet_01v8 ad=0.182 pd=1.86 as=0 ps=0 w=0.65 l=0.15
X2720 sky130_fd_sc_hd__and2_1_0/a_145_75# V3R291 sky130_fd_sc_hd__and2_1_0/a_59_75# VGND sky130_fd_pr__nfet_01v8 ad=0 pd=0 as=0.1176 ps=1.4 w=0.42 l=0.15
X2721 sky130_fd_sc_hd__dfrtp_1_3/a_805_47# sky130_fd_sc_hd__dfrtp_1_3/a_761_289# sky130_fd_sc_hd__dfrtp_1_3/a_639_47# VGND sky130_fd_pr__nfet_01v8 ad=0.0882 pd=1.26 as=0.2802 ps=2.2 w=0.42 l=0.15
X2722 sky130_fd_sc_hd__dfrtp_1_3/a_1217_47# sky130_fd_sc_hd__dfrtp_1_3/a_27_47# sky130_fd_sc_hd__dfrtp_1_3/a_1108_47# VGND sky130_fd_pr__special_nfet_01v8 ad=0.1338 pd=1.5 as=0.1422 ps=1.51 w=0.36 l=0.15
X2723 sky130_fd_sc_hd__dfrtp_1_3/a_1283_21# sky130_fd_sc_hd__dfrtp_1_3/a_1108_47# sky130_fd_sc_hd__dfrtp_1_3/a_1462_47# VGND sky130_fd_pr__nfet_01v8 ad=0.1092 pd=1.36 as=0.1281 ps=1.45 w=0.42 l=0.15
X2724 sky130_fd_sc_hd__dfrtp_1_3/a_651_413# sky130_fd_sc_hd__dfrtp_1_3/a_27_47# sky130_fd_sc_hd__dfrtp_1_3/a_543_47# VDPWR sky130_fd_pr__pfet_01v8_hvt ad=0.3402 pd=3.3 as=0.1449 ps=1.53 w=0.42 l=0.15
X2725 sky130_fd_sc_hd__dfrtp_1_3/a_1108_47# sky130_fd_sc_hd__dfrtp_1_3/a_193_47# sky130_fd_sc_hd__dfrtp_1_3/a_761_289# VGND sky130_fd_pr__special_nfet_01v8 ad=0 pd=0 as=0.1998 ps=1.97 w=0.36 l=0.15
X2726 VGND V3R303 sky130_fd_sc_hd__dfrtp_1_3/a_805_47# VGND sky130_fd_pr__nfet_01v8 ad=0 pd=0 as=0 ps=0 w=0.42 l=0.15
X2727 V3R058 sky130_fd_sc_hd__dfrtp_1_3/a_1283_21# VDPWR VDPWR sky130_fd_pr__pfet_01v8_hvt ad=0.26 pd=2.52 as=0 ps=0 w=1 l=0.15
X2728 VDPWR V3R057 sky130_fd_sc_hd__dfrtp_1_3/a_27_47# VDPWR sky130_fd_pr__pfet_01v8_hvt ad=0 pd=0 as=0.1664 ps=1.8 w=0.64 l=0.15
X2729 sky130_fd_sc_hd__dfrtp_1_3/a_448_47# V3R193 VDPWR VDPWR sky130_fd_pr__pfet_01v8_hvt ad=0.1302 pd=1.46 as=0 ps=0 w=0.42 l=0.15
X2730 sky130_fd_sc_hd__dfrtp_1_3/a_761_289# sky130_fd_sc_hd__dfrtp_1_3/a_543_47# VGND VGND sky130_fd_pr__nfet_01v8 ad=0 pd=0 as=0 ps=0 w=0.64 l=0.15
X2731 sky130_fd_sc_hd__dfrtp_1_3/a_193_47# sky130_fd_sc_hd__dfrtp_1_3/a_27_47# VGND VGND sky130_fd_pr__nfet_01v8 ad=0.1092 pd=1.36 as=0 ps=0 w=0.42 l=0.15
X2732 sky130_fd_sc_hd__dfrtp_1_3/a_1108_47# sky130_fd_sc_hd__dfrtp_1_3/a_27_47# sky130_fd_sc_hd__dfrtp_1_3/a_761_289# VDPWR sky130_fd_pr__pfet_01v8_hvt ad=0.1176 pd=1.4 as=0.2583 ps=2.37 w=0.42 l=0.15
X2733 sky130_fd_sc_hd__dfrtp_1_3/a_1462_47# V3R303 VGND VGND sky130_fd_pr__nfet_01v8 ad=0 pd=0 as=0 ps=0 w=0.42 l=0.15
X2734 sky130_fd_sc_hd__dfrtp_1_3/a_543_47# sky130_fd_sc_hd__dfrtp_1_3/a_27_47# sky130_fd_sc_hd__dfrtp_1_3/a_448_47# VGND sky130_fd_pr__special_nfet_01v8 ad=0.1188 pd=1.38 as=0.132 ps=1.49 w=0.36 l=0.15
X2735 sky130_fd_sc_hd__dfrtp_1_3/a_543_47# sky130_fd_sc_hd__dfrtp_1_3/a_193_47# sky130_fd_sc_hd__dfrtp_1_3/a_448_47# VDPWR sky130_fd_pr__pfet_01v8_hvt ad=0 pd=0 as=0 ps=0 w=0.42 l=0.15
X2736 sky130_fd_sc_hd__dfrtp_1_3/a_448_47# V3R193 VGND VGND sky130_fd_pr__nfet_01v8 ad=0 pd=0 as=0 ps=0 w=0.42 l=0.15
X2737 VDPWR sky130_fd_sc_hd__dfrtp_1_3/a_1283_21# sky130_fd_sc_hd__dfrtp_1_3/a_1270_413# VDPWR sky130_fd_pr__pfet_01v8_hvt ad=0 pd=0 as=0.1134 ps=1.38 w=0.42 l=0.15
X2738 VDPWR sky130_fd_sc_hd__dfrtp_1_3/a_1108_47# sky130_fd_sc_hd__dfrtp_1_3/a_1283_21# VDPWR sky130_fd_pr__pfet_01v8_hvt ad=0 pd=0 as=0.1134 ps=1.38 w=0.42 l=0.15
X2739 sky130_fd_sc_hd__dfrtp_1_3/a_1270_413# sky130_fd_sc_hd__dfrtp_1_3/a_193_47# sky130_fd_sc_hd__dfrtp_1_3/a_1108_47# VDPWR sky130_fd_pr__pfet_01v8_hvt ad=0 pd=0 as=0 ps=0 w=0.42 l=0.15
X2740 sky130_fd_sc_hd__dfrtp_1_3/a_193_47# sky130_fd_sc_hd__dfrtp_1_3/a_27_47# VDPWR VDPWR sky130_fd_pr__pfet_01v8_hvt ad=0.1664 pd=1.8 as=0 ps=0 w=0.64 l=0.15
X2741 sky130_fd_sc_hd__dfrtp_1_3/a_1283_21# V3R303 VDPWR VDPWR sky130_fd_pr__pfet_01v8_hvt ad=0 pd=0 as=0 ps=0 w=0.42 l=0.15
X2742 VDPWR sky130_fd_sc_hd__dfrtp_1_3/a_761_289# sky130_fd_sc_hd__dfrtp_1_3/a_651_413# VDPWR sky130_fd_pr__pfet_01v8_hvt ad=0 pd=0 as=0 ps=0 w=0.42 l=0.15
X2743 V3R058 sky130_fd_sc_hd__dfrtp_1_3/a_1283_21# VGND VGND sky130_fd_pr__nfet_01v8 ad=0.169 pd=1.82 as=0 ps=0 w=0.65 l=0.15
X2744 sky130_fd_sc_hd__dfrtp_1_3/a_639_47# sky130_fd_sc_hd__dfrtp_1_3/a_193_47# sky130_fd_sc_hd__dfrtp_1_3/a_543_47# VGND sky130_fd_pr__special_nfet_01v8 ad=0 pd=0 as=0 ps=0 w=0.36 l=0.15
X2745 VGND sky130_fd_sc_hd__dfrtp_1_3/a_1283_21# sky130_fd_sc_hd__dfrtp_1_3/a_1217_47# VGND sky130_fd_pr__nfet_01v8 ad=0 pd=0 as=0 ps=0 w=0.42 l=0.15
X2746 sky130_fd_sc_hd__dfrtp_1_3/a_651_413# V3R303 VDPWR VDPWR sky130_fd_pr__pfet_01v8_hvt ad=0 pd=0 as=0 ps=0 w=0.42 l=0.15
X2747 VGND V3R057 sky130_fd_sc_hd__dfrtp_1_3/a_27_47# VGND sky130_fd_pr__nfet_01v8 ad=0 pd=0 as=0.1092 ps=1.36 w=0.42 l=0.15
X2748 sky130_fd_sc_hd__dfrtp_1_3/a_761_289# sky130_fd_sc_hd__dfrtp_1_3/a_543_47# VDPWR VDPWR sky130_fd_pr__pfet_01v8_hvt ad=0 pd=0 as=0 ps=0 w=0.84 l=0.15
X2749 sky130_fd_sc_hd__dfrtp_1_19/a_805_47# sky130_fd_sc_hd__dfrtp_1_19/a_761_289# sky130_fd_sc_hd__dfrtp_1_19/a_639_47# VGND sky130_fd_pr__nfet_01v8 ad=0.0882 pd=1.26 as=0.2802 ps=2.2 w=0.42 l=0.15
X2750 sky130_fd_sc_hd__dfrtp_1_19/a_1217_47# sky130_fd_sc_hd__dfrtp_1_19/a_27_47# sky130_fd_sc_hd__dfrtp_1_19/a_1108_47# VGND sky130_fd_pr__special_nfet_01v8 ad=0.1338 pd=1.5 as=0.1422 ps=1.51 w=0.36 l=0.15
X2751 sky130_fd_sc_hd__dfrtp_1_19/a_1283_21# sky130_fd_sc_hd__dfrtp_1_19/a_1108_47# sky130_fd_sc_hd__dfrtp_1_19/a_1462_47# VGND sky130_fd_pr__nfet_01v8 ad=0.1092 pd=1.36 as=0.1281 ps=1.45 w=0.42 l=0.15
X2752 sky130_fd_sc_hd__dfrtp_1_19/a_651_413# sky130_fd_sc_hd__dfrtp_1_19/a_27_47# sky130_fd_sc_hd__dfrtp_1_19/a_543_47# VDPWR sky130_fd_pr__pfet_01v8_hvt ad=0.3402 pd=3.3 as=0.1449 ps=1.53 w=0.42 l=0.15
X2753 sky130_fd_sc_hd__dfrtp_1_19/a_1108_47# sky130_fd_sc_hd__dfrtp_1_19/a_193_47# sky130_fd_sc_hd__dfrtp_1_19/a_761_289# VGND sky130_fd_pr__special_nfet_01v8 ad=0 pd=0 as=0.1998 ps=1.97 w=0.36 l=0.15
X2754 VGND V3R301 sky130_fd_sc_hd__dfrtp_1_19/a_805_47# VGND sky130_fd_pr__nfet_01v8 ad=0 pd=0 as=0 ps=0 w=0.42 l=0.15
X2755 V3R029 sky130_fd_sc_hd__dfrtp_1_19/a_1283_21# VDPWR VDPWR sky130_fd_pr__pfet_01v8_hvt ad=0.26 pd=2.52 as=0 ps=0 w=1 l=0.15
X2756 VDPWR V3R082 sky130_fd_sc_hd__dfrtp_1_19/a_27_47# VDPWR sky130_fd_pr__pfet_01v8_hvt ad=0 pd=0 as=0.1664 ps=1.8 w=0.64 l=0.15
X2757 sky130_fd_sc_hd__dfrtp_1_19/a_448_47# V3R144 VDPWR VDPWR sky130_fd_pr__pfet_01v8_hvt ad=0.1302 pd=1.46 as=0 ps=0 w=0.42 l=0.15
X2758 sky130_fd_sc_hd__dfrtp_1_19/a_761_289# sky130_fd_sc_hd__dfrtp_1_19/a_543_47# VGND VGND sky130_fd_pr__nfet_01v8 ad=0 pd=0 as=0 ps=0 w=0.64 l=0.15
X2759 sky130_fd_sc_hd__dfrtp_1_19/a_193_47# sky130_fd_sc_hd__dfrtp_1_19/a_27_47# VGND VGND sky130_fd_pr__nfet_01v8 ad=0.1092 pd=1.36 as=0 ps=0 w=0.42 l=0.15
X2760 sky130_fd_sc_hd__dfrtp_1_19/a_1108_47# sky130_fd_sc_hd__dfrtp_1_19/a_27_47# sky130_fd_sc_hd__dfrtp_1_19/a_761_289# VDPWR sky130_fd_pr__pfet_01v8_hvt ad=0.1176 pd=1.4 as=0.2583 ps=2.37 w=0.42 l=0.15
X2761 sky130_fd_sc_hd__dfrtp_1_19/a_1462_47# V3R301 VGND VGND sky130_fd_pr__nfet_01v8 ad=0 pd=0 as=0 ps=0 w=0.42 l=0.15
X2762 sky130_fd_sc_hd__dfrtp_1_19/a_543_47# sky130_fd_sc_hd__dfrtp_1_19/a_27_47# sky130_fd_sc_hd__dfrtp_1_19/a_448_47# VGND sky130_fd_pr__special_nfet_01v8 ad=0.1188 pd=1.38 as=0.132 ps=1.49 w=0.36 l=0.15
X2763 sky130_fd_sc_hd__dfrtp_1_19/a_543_47# sky130_fd_sc_hd__dfrtp_1_19/a_193_47# sky130_fd_sc_hd__dfrtp_1_19/a_448_47# VDPWR sky130_fd_pr__pfet_01v8_hvt ad=0 pd=0 as=0 ps=0 w=0.42 l=0.15
X2764 sky130_fd_sc_hd__dfrtp_1_19/a_448_47# V3R144 VGND VGND sky130_fd_pr__nfet_01v8 ad=0 pd=0 as=0 ps=0 w=0.42 l=0.15
X2765 VDPWR sky130_fd_sc_hd__dfrtp_1_19/a_1283_21# sky130_fd_sc_hd__dfrtp_1_19/a_1270_413# VDPWR sky130_fd_pr__pfet_01v8_hvt ad=0 pd=0 as=0.1134 ps=1.38 w=0.42 l=0.15
X2766 VDPWR sky130_fd_sc_hd__dfrtp_1_19/a_1108_47# sky130_fd_sc_hd__dfrtp_1_19/a_1283_21# VDPWR sky130_fd_pr__pfet_01v8_hvt ad=0 pd=0 as=0.1134 ps=1.38 w=0.42 l=0.15
X2767 sky130_fd_sc_hd__dfrtp_1_19/a_1270_413# sky130_fd_sc_hd__dfrtp_1_19/a_193_47# sky130_fd_sc_hd__dfrtp_1_19/a_1108_47# VDPWR sky130_fd_pr__pfet_01v8_hvt ad=0 pd=0 as=0 ps=0 w=0.42 l=0.15
X2768 sky130_fd_sc_hd__dfrtp_1_19/a_193_47# sky130_fd_sc_hd__dfrtp_1_19/a_27_47# VDPWR VDPWR sky130_fd_pr__pfet_01v8_hvt ad=0.1664 pd=1.8 as=0 ps=0 w=0.64 l=0.15
X2769 sky130_fd_sc_hd__dfrtp_1_19/a_1283_21# V3R301 VDPWR VDPWR sky130_fd_pr__pfet_01v8_hvt ad=0 pd=0 as=0 ps=0 w=0.42 l=0.15
X2770 VDPWR sky130_fd_sc_hd__dfrtp_1_19/a_761_289# sky130_fd_sc_hd__dfrtp_1_19/a_651_413# VDPWR sky130_fd_pr__pfet_01v8_hvt ad=0 pd=0 as=0 ps=0 w=0.42 l=0.15
X2771 V3R029 sky130_fd_sc_hd__dfrtp_1_19/a_1283_21# VGND VGND sky130_fd_pr__nfet_01v8 ad=0.169 pd=1.82 as=0 ps=0 w=0.65 l=0.15
X2772 sky130_fd_sc_hd__dfrtp_1_19/a_639_47# sky130_fd_sc_hd__dfrtp_1_19/a_193_47# sky130_fd_sc_hd__dfrtp_1_19/a_543_47# VGND sky130_fd_pr__special_nfet_01v8 ad=0 pd=0 as=0 ps=0 w=0.36 l=0.15
X2773 VGND sky130_fd_sc_hd__dfrtp_1_19/a_1283_21# sky130_fd_sc_hd__dfrtp_1_19/a_1217_47# VGND sky130_fd_pr__nfet_01v8 ad=0 pd=0 as=0 ps=0 w=0.42 l=0.15
X2774 sky130_fd_sc_hd__dfrtp_1_19/a_651_413# V3R301 VDPWR VDPWR sky130_fd_pr__pfet_01v8_hvt ad=0 pd=0 as=0 ps=0 w=0.42 l=0.15
X2775 VGND V3R082 sky130_fd_sc_hd__dfrtp_1_19/a_27_47# VGND sky130_fd_pr__nfet_01v8 ad=0 pd=0 as=0.1092 ps=1.36 w=0.42 l=0.15
X2776 sky130_fd_sc_hd__dfrtp_1_19/a_761_289# sky130_fd_sc_hd__dfrtp_1_19/a_543_47# VDPWR VDPWR sky130_fd_pr__pfet_01v8_hvt ad=0 pd=0 as=0 ps=0 w=0.84 l=0.15
X2777 VGND sky130_fd_sc_hd__dfstp_1_5/a_652_21# sky130_fd_sc_hd__dfstp_1_5/a_586_47# VGND sky130_fd_pr__nfet_01v8 ad=0 pd=0 as=0.1341 ps=1.5 w=0.42 l=0.15
X2778 sky130_fd_sc_hd__dfstp_1_5/a_956_413# sky130_fd_sc_hd__dfstp_1_5/a_476_47# VDPWR VDPWR sky130_fd_pr__pfet_01v8_hvt ad=0.0966 pd=1.3 as=0 ps=0 w=0.42 l=0.15
X2779 VDPWR sky130_fd_sc_hd__dfstp_1_5/a_476_47# sky130_fd_sc_hd__dfstp_1_5/a_652_21# VDPWR sky130_fd_pr__pfet_01v8_hvt ad=0 pd=0 as=0.1134 ps=1.38 w=0.42 l=0.15
X2780 VDPWR V3R055 sky130_fd_sc_hd__dfstp_1_5/a_27_47# VDPWR sky130_fd_pr__pfet_01v8_hvt ad=0 pd=0 as=0.1664 ps=1.8 w=0.64 l=0.15
X2781 sky130_fd_sc_hd__dfstp_1_5/a_586_47# sky130_fd_sc_hd__dfstp_1_5/a_193_47# sky130_fd_sc_hd__dfstp_1_5/a_476_47# VGND sky130_fd_pr__special_nfet_01v8 ad=0 pd=0 as=0.144 ps=1.52 w=0.36 l=0.15
X2782 sky130_fd_sc_hd__dfstp_1_5/a_1056_47# sky130_fd_sc_hd__dfstp_1_5/a_476_47# VGND VGND sky130_fd_pr__nfet_01v8 ad=0.0882 pd=1.26 as=0 ps=0 w=0.42 l=0.15
X2783 sky130_fd_sc_hd__dfstp_1_5/a_476_47# sky130_fd_sc_hd__dfstp_1_5/a_27_47# sky130_fd_sc_hd__dfstp_1_5/a_381_47# VGND sky130_fd_pr__special_nfet_01v8 ad=0 pd=0 as=0.187 ps=1.93 w=0.36 l=0.15
X2784 sky130_fd_sc_hd__dfstp_1_5/a_381_47# V3R097 VDPWR VDPWR sky130_fd_pr__pfet_01v8_hvt ad=0.2499 pd=2.35 as=0 ps=0 w=0.84 l=0.15
X2785 sky130_fd_sc_hd__dfstp_1_5/a_652_21# V3R298 VDPWR VDPWR sky130_fd_pr__pfet_01v8_hvt ad=0 pd=0 as=0 ps=0 w=0.42 l=0.15
X2786 sky130_fd_sc_hd__dfstp_1_5/a_1224_47# sky130_fd_sc_hd__dfstp_1_5/a_27_47# sky130_fd_sc_hd__dfstp_1_5/a_1032_413# VGND sky130_fd_pr__nfet_01v8 ad=0.0882 pd=1.26 as=0.1386 ps=1.5 w=0.42 l=0.15
X2787 sky130_fd_sc_hd__dfstp_1_5/a_562_413# sky130_fd_sc_hd__dfstp_1_5/a_27_47# sky130_fd_sc_hd__dfstp_1_5/a_476_47# VDPWR sky130_fd_pr__pfet_01v8_hvt ad=0.189 pd=1.74 as=0.1134 ps=1.38 w=0.42 l=0.15
X2788 VGND sky130_fd_sc_hd__dfstp_1_5/a_1032_413# sky130_fd_sc_hd__dfstp_1_5/a_1602_47# VGND sky130_fd_pr__nfet_01v8 ad=0 pd=0 as=0.1092 ps=1.36 w=0.42 l=0.15
X2789 VDPWR sky130_fd_sc_hd__dfstp_1_5/a_1182_261# sky130_fd_sc_hd__dfstp_1_5/a_1140_413# VDPWR sky130_fd_pr__pfet_01v8_hvt ad=0 pd=0 as=0.0882 ps=1.26 w=0.42 l=0.15
X2790 V3R152 sky130_fd_sc_hd__dfstp_1_5/a_1602_47# VDPWR VDPWR sky130_fd_pr__pfet_01v8_hvt ad=0.26 pd=2.52 as=0 ps=0 w=1 l=0.15
X2791 sky130_fd_sc_hd__dfstp_1_5/a_1032_413# sky130_fd_sc_hd__dfstp_1_5/a_193_47# sky130_fd_sc_hd__dfstp_1_5/a_1056_47# VGND sky130_fd_pr__nfet_01v8 ad=0 pd=0 as=0 ps=0 w=0.42 l=0.15
X2792 sky130_fd_sc_hd__dfstp_1_5/a_476_47# sky130_fd_sc_hd__dfstp_1_5/a_193_47# sky130_fd_sc_hd__dfstp_1_5/a_381_47# VDPWR sky130_fd_pr__pfet_01v8_hvt ad=0 pd=0 as=0 ps=0 w=0.42 l=0.15
X2793 sky130_fd_sc_hd__dfstp_1_5/a_1296_47# sky130_fd_sc_hd__dfstp_1_5/a_1182_261# sky130_fd_sc_hd__dfstp_1_5/a_1224_47# VGND sky130_fd_pr__nfet_01v8 ad=0.0966 pd=1.3 as=0 ps=0 w=0.42 l=0.15
X2794 sky130_fd_sc_hd__dfstp_1_5/a_193_47# sky130_fd_sc_hd__dfstp_1_5/a_27_47# VGND VGND sky130_fd_pr__nfet_01v8 ad=0.1092 pd=1.36 as=0 ps=0 w=0.42 l=0.15
X2795 VDPWR sky130_fd_sc_hd__dfstp_1_5/a_652_21# sky130_fd_sc_hd__dfstp_1_5/a_562_413# VDPWR sky130_fd_pr__pfet_01v8_hvt ad=0 pd=0 as=0 ps=0 w=0.42 l=0.15
X2796 VDPWR V3R298 sky130_fd_sc_hd__dfstp_1_5/a_1032_413# VDPWR sky130_fd_pr__pfet_01v8_hvt ad=0 pd=0 as=0.273 ps=2.98 w=0.42 l=0.15
X2797 sky130_fd_sc_hd__dfstp_1_5/a_1032_413# sky130_fd_sc_hd__dfstp_1_5/a_27_47# sky130_fd_sc_hd__dfstp_1_5/a_956_413# VDPWR sky130_fd_pr__pfet_01v8_hvt ad=0 pd=0 as=0 ps=0 w=0.42 l=0.15
X2798 sky130_fd_sc_hd__dfstp_1_5/a_1182_261# sky130_fd_sc_hd__dfstp_1_5/a_1032_413# VDPWR VDPWR sky130_fd_pr__pfet_01v8_hvt ad=0.2184 pd=2.2 as=0 ps=0 w=0.84 l=0.15
X2799 V3R152 sky130_fd_sc_hd__dfstp_1_5/a_1602_47# VGND VGND sky130_fd_pr__nfet_01v8 ad=0.169 pd=1.82 as=0 ps=0 w=0.65 l=0.15
X2800 sky130_fd_sc_hd__dfstp_1_5/a_193_47# sky130_fd_sc_hd__dfstp_1_5/a_27_47# VDPWR VDPWR sky130_fd_pr__pfet_01v8_hvt ad=0.1664 pd=1.8 as=0 ps=0 w=0.64 l=0.15
X2801 sky130_fd_sc_hd__dfstp_1_5/a_1140_413# sky130_fd_sc_hd__dfstp_1_5/a_193_47# sky130_fd_sc_hd__dfstp_1_5/a_1032_413# VDPWR sky130_fd_pr__pfet_01v8_hvt ad=0 pd=0 as=0 ps=0 w=0.42 l=0.15
X2802 VDPWR sky130_fd_sc_hd__dfstp_1_5/a_1032_413# sky130_fd_sc_hd__dfstp_1_5/a_1602_47# VDPWR sky130_fd_pr__pfet_01v8_hvt ad=0 pd=0 as=0.1664 ps=1.8 w=0.64 l=0.15
X2803 sky130_fd_sc_hd__dfstp_1_5/a_796_47# V3R298 VGND VGND sky130_fd_pr__nfet_01v8 ad=0.0882 pd=1.26 as=0 ps=0 w=0.42 l=0.15
X2804 sky130_fd_sc_hd__dfstp_1_5/a_381_47# V3R097 VGND VGND sky130_fd_pr__nfet_01v8 ad=0 pd=0 as=0 ps=0 w=0.64 l=0.15
X2805 sky130_fd_sc_hd__dfstp_1_5/a_1182_261# sky130_fd_sc_hd__dfstp_1_5/a_1032_413# VGND VGND sky130_fd_pr__nfet_01v8 ad=0.1404 pd=1.6 as=0 ps=0 w=0.54 l=0.15
X2806 sky130_fd_sc_hd__dfstp_1_5/a_652_21# sky130_fd_sc_hd__dfstp_1_5/a_476_47# sky130_fd_sc_hd__dfstp_1_5/a_796_47# VGND sky130_fd_pr__nfet_01v8 ad=0.1092 pd=1.36 as=0 ps=0 w=0.42 l=0.15
X2807 VGND V3R055 sky130_fd_sc_hd__dfstp_1_5/a_27_47# VGND sky130_fd_pr__nfet_01v8 ad=0 pd=0 as=0.1092 ps=1.36 w=0.42 l=0.15
X2808 VGND V3R298 sky130_fd_sc_hd__dfstp_1_5/a_1296_47# VGND sky130_fd_pr__nfet_01v8 ad=0 pd=0 as=0 ps=0 w=0.42 l=0.15
X2809 VDPWR V3R203 sky130_fd_sc_hd__and2_1_1/a_59_75# VDPWR sky130_fd_pr__pfet_01v8_hvt ad=0 pd=0 as=0.1134 ps=1.38 w=0.42 l=0.15
X2810 V3R266 sky130_fd_sc_hd__and2_1_1/a_59_75# VDPWR VDPWR sky130_fd_pr__pfet_01v8_hvt ad=0.475 pd=2.95 as=0 ps=0 w=1 l=0.15
X2811 VGND V3R203 sky130_fd_sc_hd__and2_1_1/a_145_75# VGND sky130_fd_pr__nfet_01v8 ad=0 pd=0 as=0.1134 ps=1.38 w=0.42 l=0.15
X2812 sky130_fd_sc_hd__and2_1_1/a_59_75# V3R079 VDPWR VDPWR sky130_fd_pr__pfet_01v8_hvt ad=0 pd=0 as=0 ps=0 w=0.42 l=0.15
X2813 V3R266 sky130_fd_sc_hd__and2_1_1/a_59_75# VGND VGND sky130_fd_pr__nfet_01v8 ad=0.182 pd=1.86 as=0 ps=0 w=0.65 l=0.15
X2814 sky130_fd_sc_hd__and2_1_1/a_145_75# V3R079 sky130_fd_sc_hd__and2_1_1/a_59_75# VGND sky130_fd_pr__nfet_01v8 ad=0 pd=0 as=0.1176 ps=1.4 w=0.42 l=0.15
X2815 sky130_fd_sc_hd__dfrtp_1_4/a_805_47# sky130_fd_sc_hd__dfrtp_1_4/a_761_289# sky130_fd_sc_hd__dfrtp_1_4/a_639_47# VGND sky130_fd_pr__nfet_01v8 ad=0.0882 pd=1.26 as=0.2802 ps=2.2 w=0.42 l=0.15
X2816 sky130_fd_sc_hd__dfrtp_1_4/a_1217_47# sky130_fd_sc_hd__dfrtp_1_4/a_27_47# sky130_fd_sc_hd__dfrtp_1_4/a_1108_47# VGND sky130_fd_pr__special_nfet_01v8 ad=0.1338 pd=1.5 as=0.1422 ps=1.51 w=0.36 l=0.15
X2817 sky130_fd_sc_hd__dfrtp_1_4/a_1283_21# sky130_fd_sc_hd__dfrtp_1_4/a_1108_47# sky130_fd_sc_hd__dfrtp_1_4/a_1462_47# VGND sky130_fd_pr__nfet_01v8 ad=0.1092 pd=1.36 as=0.1281 ps=1.45 w=0.42 l=0.15
X2818 sky130_fd_sc_hd__dfrtp_1_4/a_651_413# sky130_fd_sc_hd__dfrtp_1_4/a_27_47# sky130_fd_sc_hd__dfrtp_1_4/a_543_47# VDPWR sky130_fd_pr__pfet_01v8_hvt ad=0.3402 pd=3.3 as=0.1449 ps=1.53 w=0.42 l=0.15
X2819 sky130_fd_sc_hd__dfrtp_1_4/a_1108_47# sky130_fd_sc_hd__dfrtp_1_4/a_193_47# sky130_fd_sc_hd__dfrtp_1_4/a_761_289# VGND sky130_fd_pr__special_nfet_01v8 ad=0 pd=0 as=0.1998 ps=1.97 w=0.36 l=0.15
X2820 VGND V3R299 sky130_fd_sc_hd__dfrtp_1_4/a_805_47# VGND sky130_fd_pr__nfet_01v8 ad=0 pd=0 as=0 ps=0 w=0.42 l=0.15
X2821 V3R174 sky130_fd_sc_hd__dfrtp_1_4/a_1283_21# VDPWR VDPWR sky130_fd_pr__pfet_01v8_hvt ad=0.26 pd=2.52 as=0 ps=0 w=1 l=0.15
X2822 VDPWR V3R056 sky130_fd_sc_hd__dfrtp_1_4/a_27_47# VDPWR sky130_fd_pr__pfet_01v8_hvt ad=0 pd=0 as=0.1664 ps=1.8 w=0.64 l=0.15
X2823 sky130_fd_sc_hd__dfrtp_1_4/a_448_47# V3R117 VDPWR VDPWR sky130_fd_pr__pfet_01v8_hvt ad=0.1302 pd=1.46 as=0 ps=0 w=0.42 l=0.15
X2824 sky130_fd_sc_hd__dfrtp_1_4/a_761_289# sky130_fd_sc_hd__dfrtp_1_4/a_543_47# VGND VGND sky130_fd_pr__nfet_01v8 ad=0 pd=0 as=0 ps=0 w=0.64 l=0.15
X2825 sky130_fd_sc_hd__dfrtp_1_4/a_193_47# sky130_fd_sc_hd__dfrtp_1_4/a_27_47# VGND VGND sky130_fd_pr__nfet_01v8 ad=0.1092 pd=1.36 as=0 ps=0 w=0.42 l=0.15
X2826 sky130_fd_sc_hd__dfrtp_1_4/a_1108_47# sky130_fd_sc_hd__dfrtp_1_4/a_27_47# sky130_fd_sc_hd__dfrtp_1_4/a_761_289# VDPWR sky130_fd_pr__pfet_01v8_hvt ad=0.1176 pd=1.4 as=0.2583 ps=2.37 w=0.42 l=0.15
X2827 sky130_fd_sc_hd__dfrtp_1_4/a_1462_47# V3R299 VGND VGND sky130_fd_pr__nfet_01v8 ad=0 pd=0 as=0 ps=0 w=0.42 l=0.15
X2828 sky130_fd_sc_hd__dfrtp_1_4/a_543_47# sky130_fd_sc_hd__dfrtp_1_4/a_27_47# sky130_fd_sc_hd__dfrtp_1_4/a_448_47# VGND sky130_fd_pr__special_nfet_01v8 ad=0.1188 pd=1.38 as=0.132 ps=1.49 w=0.36 l=0.15
X2829 sky130_fd_sc_hd__dfrtp_1_4/a_543_47# sky130_fd_sc_hd__dfrtp_1_4/a_193_47# sky130_fd_sc_hd__dfrtp_1_4/a_448_47# VDPWR sky130_fd_pr__pfet_01v8_hvt ad=0 pd=0 as=0 ps=0 w=0.42 l=0.15
X2830 sky130_fd_sc_hd__dfrtp_1_4/a_448_47# V3R117 VGND VGND sky130_fd_pr__nfet_01v8 ad=0 pd=0 as=0 ps=0 w=0.42 l=0.15
X2831 VDPWR sky130_fd_sc_hd__dfrtp_1_4/a_1283_21# sky130_fd_sc_hd__dfrtp_1_4/a_1270_413# VDPWR sky130_fd_pr__pfet_01v8_hvt ad=0 pd=0 as=0.1134 ps=1.38 w=0.42 l=0.15
X2832 VDPWR sky130_fd_sc_hd__dfrtp_1_4/a_1108_47# sky130_fd_sc_hd__dfrtp_1_4/a_1283_21# VDPWR sky130_fd_pr__pfet_01v8_hvt ad=0 pd=0 as=0.1134 ps=1.38 w=0.42 l=0.15
X2833 sky130_fd_sc_hd__dfrtp_1_4/a_1270_413# sky130_fd_sc_hd__dfrtp_1_4/a_193_47# sky130_fd_sc_hd__dfrtp_1_4/a_1108_47# VDPWR sky130_fd_pr__pfet_01v8_hvt ad=0 pd=0 as=0 ps=0 w=0.42 l=0.15
X2834 sky130_fd_sc_hd__dfrtp_1_4/a_193_47# sky130_fd_sc_hd__dfrtp_1_4/a_27_47# VDPWR VDPWR sky130_fd_pr__pfet_01v8_hvt ad=0.1664 pd=1.8 as=0 ps=0 w=0.64 l=0.15
X2835 sky130_fd_sc_hd__dfrtp_1_4/a_1283_21# V3R299 VDPWR VDPWR sky130_fd_pr__pfet_01v8_hvt ad=0 pd=0 as=0 ps=0 w=0.42 l=0.15
X2836 VDPWR sky130_fd_sc_hd__dfrtp_1_4/a_761_289# sky130_fd_sc_hd__dfrtp_1_4/a_651_413# VDPWR sky130_fd_pr__pfet_01v8_hvt ad=0 pd=0 as=0 ps=0 w=0.42 l=0.15
X2837 V3R174 sky130_fd_sc_hd__dfrtp_1_4/a_1283_21# VGND VGND sky130_fd_pr__nfet_01v8 ad=0.169 pd=1.82 as=0 ps=0 w=0.65 l=0.15
X2838 sky130_fd_sc_hd__dfrtp_1_4/a_639_47# sky130_fd_sc_hd__dfrtp_1_4/a_193_47# sky130_fd_sc_hd__dfrtp_1_4/a_543_47# VGND sky130_fd_pr__special_nfet_01v8 ad=0 pd=0 as=0 ps=0 w=0.36 l=0.15
X2839 VGND sky130_fd_sc_hd__dfrtp_1_4/a_1283_21# sky130_fd_sc_hd__dfrtp_1_4/a_1217_47# VGND sky130_fd_pr__nfet_01v8 ad=0 pd=0 as=0 ps=0 w=0.42 l=0.15
X2840 sky130_fd_sc_hd__dfrtp_1_4/a_651_413# V3R299 VDPWR VDPWR sky130_fd_pr__pfet_01v8_hvt ad=0 pd=0 as=0 ps=0 w=0.42 l=0.15
X2841 VGND V3R056 sky130_fd_sc_hd__dfrtp_1_4/a_27_47# VGND sky130_fd_pr__nfet_01v8 ad=0 pd=0 as=0.1092 ps=1.36 w=0.42 l=0.15
X2842 sky130_fd_sc_hd__dfrtp_1_4/a_761_289# sky130_fd_sc_hd__dfrtp_1_4/a_543_47# VDPWR VDPWR sky130_fd_pr__pfet_01v8_hvt ad=0 pd=0 as=0 ps=0 w=0.84 l=0.15
X2843 VGND sky130_fd_sc_hd__dfstp_1_6/a_652_21# sky130_fd_sc_hd__dfstp_1_6/a_586_47# VGND sky130_fd_pr__nfet_01v8 ad=0 pd=0 as=0.1341 ps=1.5 w=0.42 l=0.15
X2844 sky130_fd_sc_hd__dfstp_1_6/a_956_413# sky130_fd_sc_hd__dfstp_1_6/a_476_47# VDPWR VDPWR sky130_fd_pr__pfet_01v8_hvt ad=0.0966 pd=1.3 as=0 ps=0 w=0.42 l=0.15
X2845 VDPWR sky130_fd_sc_hd__dfstp_1_6/a_476_47# sky130_fd_sc_hd__dfstp_1_6/a_652_21# VDPWR sky130_fd_pr__pfet_01v8_hvt ad=0 pd=0 as=0.1134 ps=1.38 w=0.42 l=0.15
X2846 VDPWR V3R081 sky130_fd_sc_hd__dfstp_1_6/a_27_47# VDPWR sky130_fd_pr__pfet_01v8_hvt ad=0 pd=0 as=0.1664 ps=1.8 w=0.64 l=0.15
X2847 sky130_fd_sc_hd__dfstp_1_6/a_586_47# sky130_fd_sc_hd__dfstp_1_6/a_193_47# sky130_fd_sc_hd__dfstp_1_6/a_476_47# VGND sky130_fd_pr__special_nfet_01v8 ad=0 pd=0 as=0.144 ps=1.52 w=0.36 l=0.15
X2848 sky130_fd_sc_hd__dfstp_1_6/a_1056_47# sky130_fd_sc_hd__dfstp_1_6/a_476_47# VGND VGND sky130_fd_pr__nfet_01v8 ad=0.0882 pd=1.26 as=0 ps=0 w=0.42 l=0.15
X2849 sky130_fd_sc_hd__dfstp_1_6/a_476_47# sky130_fd_sc_hd__dfstp_1_6/a_27_47# sky130_fd_sc_hd__dfstp_1_6/a_381_47# VGND sky130_fd_pr__special_nfet_01v8 ad=0 pd=0 as=0.187 ps=1.93 w=0.36 l=0.15
X2850 sky130_fd_sc_hd__dfstp_1_6/a_381_47# V3R129 VDPWR VDPWR sky130_fd_pr__pfet_01v8_hvt ad=0.2499 pd=2.35 as=0 ps=0 w=0.84 l=0.15
X2851 sky130_fd_sc_hd__dfstp_1_6/a_652_21# V3R300 VDPWR VDPWR sky130_fd_pr__pfet_01v8_hvt ad=0 pd=0 as=0 ps=0 w=0.42 l=0.15
X2852 sky130_fd_sc_hd__dfstp_1_6/a_1224_47# sky130_fd_sc_hd__dfstp_1_6/a_27_47# sky130_fd_sc_hd__dfstp_1_6/a_1032_413# VGND sky130_fd_pr__nfet_01v8 ad=0.0882 pd=1.26 as=0.1386 ps=1.5 w=0.42 l=0.15
X2853 sky130_fd_sc_hd__dfstp_1_6/a_562_413# sky130_fd_sc_hd__dfstp_1_6/a_27_47# sky130_fd_sc_hd__dfstp_1_6/a_476_47# VDPWR sky130_fd_pr__pfet_01v8_hvt ad=0.189 pd=1.74 as=0.1134 ps=1.38 w=0.42 l=0.15
X2854 VGND sky130_fd_sc_hd__dfstp_1_6/a_1032_413# sky130_fd_sc_hd__dfstp_1_6/a_1602_47# VGND sky130_fd_pr__nfet_01v8 ad=0 pd=0 as=0.1092 ps=1.36 w=0.42 l=0.15
X2855 VDPWR sky130_fd_sc_hd__dfstp_1_6/a_1182_261# sky130_fd_sc_hd__dfstp_1_6/a_1140_413# VDPWR sky130_fd_pr__pfet_01v8_hvt ad=0 pd=0 as=0.0882 ps=1.26 w=0.42 l=0.15
X2856 V3R013 sky130_fd_sc_hd__dfstp_1_6/a_1602_47# VDPWR VDPWR sky130_fd_pr__pfet_01v8_hvt ad=0.26 pd=2.52 as=0 ps=0 w=1 l=0.15
X2857 sky130_fd_sc_hd__dfstp_1_6/a_1032_413# sky130_fd_sc_hd__dfstp_1_6/a_193_47# sky130_fd_sc_hd__dfstp_1_6/a_1056_47# VGND sky130_fd_pr__nfet_01v8 ad=0 pd=0 as=0 ps=0 w=0.42 l=0.15
X2858 sky130_fd_sc_hd__dfstp_1_6/a_476_47# sky130_fd_sc_hd__dfstp_1_6/a_193_47# sky130_fd_sc_hd__dfstp_1_6/a_381_47# VDPWR sky130_fd_pr__pfet_01v8_hvt ad=0 pd=0 as=0 ps=0 w=0.42 l=0.15
X2859 sky130_fd_sc_hd__dfstp_1_6/a_1296_47# sky130_fd_sc_hd__dfstp_1_6/a_1182_261# sky130_fd_sc_hd__dfstp_1_6/a_1224_47# VGND sky130_fd_pr__nfet_01v8 ad=0.0966 pd=1.3 as=0 ps=0 w=0.42 l=0.15
X2860 sky130_fd_sc_hd__dfstp_1_6/a_193_47# sky130_fd_sc_hd__dfstp_1_6/a_27_47# VGND VGND sky130_fd_pr__nfet_01v8 ad=0.1092 pd=1.36 as=0 ps=0 w=0.42 l=0.15
X2861 VDPWR sky130_fd_sc_hd__dfstp_1_6/a_652_21# sky130_fd_sc_hd__dfstp_1_6/a_562_413# VDPWR sky130_fd_pr__pfet_01v8_hvt ad=0 pd=0 as=0 ps=0 w=0.42 l=0.15
X2862 VDPWR V3R300 sky130_fd_sc_hd__dfstp_1_6/a_1032_413# VDPWR sky130_fd_pr__pfet_01v8_hvt ad=0 pd=0 as=0.273 ps=2.98 w=0.42 l=0.15
X2863 sky130_fd_sc_hd__dfstp_1_6/a_1032_413# sky130_fd_sc_hd__dfstp_1_6/a_27_47# sky130_fd_sc_hd__dfstp_1_6/a_956_413# VDPWR sky130_fd_pr__pfet_01v8_hvt ad=0 pd=0 as=0 ps=0 w=0.42 l=0.15
X2864 sky130_fd_sc_hd__dfstp_1_6/a_1182_261# sky130_fd_sc_hd__dfstp_1_6/a_1032_413# VDPWR VDPWR sky130_fd_pr__pfet_01v8_hvt ad=0.2184 pd=2.2 as=0 ps=0 w=0.84 l=0.15
X2865 V3R013 sky130_fd_sc_hd__dfstp_1_6/a_1602_47# VGND VGND sky130_fd_pr__nfet_01v8 ad=0.169 pd=1.82 as=0 ps=0 w=0.65 l=0.15
X2866 sky130_fd_sc_hd__dfstp_1_6/a_193_47# sky130_fd_sc_hd__dfstp_1_6/a_27_47# VDPWR VDPWR sky130_fd_pr__pfet_01v8_hvt ad=0.1664 pd=1.8 as=0 ps=0 w=0.64 l=0.15
X2867 sky130_fd_sc_hd__dfstp_1_6/a_1140_413# sky130_fd_sc_hd__dfstp_1_6/a_193_47# sky130_fd_sc_hd__dfstp_1_6/a_1032_413# VDPWR sky130_fd_pr__pfet_01v8_hvt ad=0 pd=0 as=0 ps=0 w=0.42 l=0.15
X2868 VDPWR sky130_fd_sc_hd__dfstp_1_6/a_1032_413# sky130_fd_sc_hd__dfstp_1_6/a_1602_47# VDPWR sky130_fd_pr__pfet_01v8_hvt ad=0 pd=0 as=0.1664 ps=1.8 w=0.64 l=0.15
X2869 sky130_fd_sc_hd__dfstp_1_6/a_796_47# V3R300 VGND VGND sky130_fd_pr__nfet_01v8 ad=0.0882 pd=1.26 as=0 ps=0 w=0.42 l=0.15
X2870 sky130_fd_sc_hd__dfstp_1_6/a_381_47# V3R129 VGND VGND sky130_fd_pr__nfet_01v8 ad=0 pd=0 as=0 ps=0 w=0.64 l=0.15
X2871 sky130_fd_sc_hd__dfstp_1_6/a_1182_261# sky130_fd_sc_hd__dfstp_1_6/a_1032_413# VGND VGND sky130_fd_pr__nfet_01v8 ad=0.1404 pd=1.6 as=0 ps=0 w=0.54 l=0.15
X2872 sky130_fd_sc_hd__dfstp_1_6/a_652_21# sky130_fd_sc_hd__dfstp_1_6/a_476_47# sky130_fd_sc_hd__dfstp_1_6/a_796_47# VGND sky130_fd_pr__nfet_01v8 ad=0.1092 pd=1.36 as=0 ps=0 w=0.42 l=0.15
X2873 VGND V3R081 sky130_fd_sc_hd__dfstp_1_6/a_27_47# VGND sky130_fd_pr__nfet_01v8 ad=0 pd=0 as=0.1092 ps=1.36 w=0.42 l=0.15
X2874 VGND V3R300 sky130_fd_sc_hd__dfstp_1_6/a_1296_47# VGND sky130_fd_pr__nfet_01v8 ad=0 pd=0 as=0 ps=0 w=0.42 l=0.15
X2875 sky130_fd_sc_hd__or2b_1_0/a_219_297# sky130_fd_sc_hd__or2b_1_0/a_27_53# VGND VGND sky130_fd_pr__nfet_01v8 ad=0.0567 pd=0.69 as=0.1575 ps=1.17 w=0.42 l=0.15
X2876 VGND V3R000 sky130_fd_sc_hd__or2b_1_0/a_27_53# VGND sky130_fd_pr__nfet_01v8 ad=0.1575 pd=1.17 as=0.1092 ps=1.36 w=0.42 l=0.15
X2877 VDPWR V3R001 sky130_fd_sc_hd__or2b_1_0/a_301_297# VDPWR sky130_fd_pr__pfet_01v8_hvt ad=0.14825 pd=1.34 as=0.0441 ps=0.63 w=0.42 l=0.15
X2878 V3R255 sky130_fd_sc_hd__or2b_1_0/a_219_297# VGND VGND sky130_fd_pr__nfet_01v8 ad=0.1755 pd=1.84 as=0.10187 ps=0.99 w=0.65 l=0.15
X2879 sky130_fd_sc_hd__or2b_1_0/a_301_297# sky130_fd_sc_hd__or2b_1_0/a_27_53# sky130_fd_sc_hd__or2b_1_0/a_219_297# VDPWR sky130_fd_pr__pfet_01v8_hvt ad=0.0441 pd=0.63 as=0.1092 ps=1.36 w=0.42 l=0.15
X2880 V3R255 sky130_fd_sc_hd__or2b_1_0/a_219_297# VDPWR VDPWR sky130_fd_pr__pfet_01v8_hvt ad=0.27 pd=2.54 as=0.14825 ps=1.34 w=1 l=0.15
X2881 sky130_fd_sc_hd__or2b_1_0/a_27_53# V3R000 VDPWR VDPWR sky130_fd_pr__pfet_01v8_hvt ad=0.1176 pd=1.4 as=0.1092 ps=1.36 w=0.42 l=0.15
X2882 VGND V3R001 sky130_fd_sc_hd__or2b_1_0/a_219_297# VGND sky130_fd_pr__nfet_01v8 ad=0.10187 pd=0.99 as=0.0567 ps=0.69 w=0.42 l=0.15
X2883 VDPWR V3R203 sky130_fd_sc_hd__and2_1_2/a_59_75# VDPWR sky130_fd_pr__pfet_01v8_hvt ad=0 pd=0 as=0.1134 ps=1.38 w=0.42 l=0.15
X2884 V3R264 sky130_fd_sc_hd__and2_1_2/a_59_75# VDPWR VDPWR sky130_fd_pr__pfet_01v8_hvt ad=0.475 pd=2.95 as=0 ps=0 w=1 l=0.15
X2885 VGND V3R203 sky130_fd_sc_hd__and2_1_2/a_145_75# VGND sky130_fd_pr__nfet_01v8 ad=0 pd=0 as=0.1134 ps=1.38 w=0.42 l=0.15
X2886 sky130_fd_sc_hd__and2_1_2/a_59_75# V3R077 VDPWR VDPWR sky130_fd_pr__pfet_01v8_hvt ad=0 pd=0 as=0 ps=0 w=0.42 l=0.15
X2887 V3R264 sky130_fd_sc_hd__and2_1_2/a_59_75# VGND VGND sky130_fd_pr__nfet_01v8 ad=0.182 pd=1.86 as=0 ps=0 w=0.65 l=0.15
X2888 sky130_fd_sc_hd__and2_1_2/a_145_75# V3R077 sky130_fd_sc_hd__and2_1_2/a_59_75# VGND sky130_fd_pr__nfet_01v8 ad=0 pd=0 as=0.1176 ps=1.4 w=0.42 l=0.15
X2889 sky130_fd_sc_hd__dfrtp_1_5/a_805_47# sky130_fd_sc_hd__dfrtp_1_5/a_761_289# sky130_fd_sc_hd__dfrtp_1_5/a_639_47# VGND sky130_fd_pr__nfet_01v8 ad=0.0882 pd=1.26 as=0.2802 ps=2.2 w=0.42 l=0.15
X2890 sky130_fd_sc_hd__dfrtp_1_5/a_1217_47# sky130_fd_sc_hd__dfrtp_1_5/a_27_47# sky130_fd_sc_hd__dfrtp_1_5/a_1108_47# VGND sky130_fd_pr__special_nfet_01v8 ad=0.1338 pd=1.5 as=0.1422 ps=1.51 w=0.36 l=0.15
X2891 sky130_fd_sc_hd__dfrtp_1_5/a_1283_21# sky130_fd_sc_hd__dfrtp_1_5/a_1108_47# sky130_fd_sc_hd__dfrtp_1_5/a_1462_47# VGND sky130_fd_pr__nfet_01v8 ad=0.1092 pd=1.36 as=0.1281 ps=1.45 w=0.42 l=0.15
X2892 sky130_fd_sc_hd__dfrtp_1_5/a_651_413# sky130_fd_sc_hd__dfrtp_1_5/a_27_47# sky130_fd_sc_hd__dfrtp_1_5/a_543_47# VDPWR sky130_fd_pr__pfet_01v8_hvt ad=0.3402 pd=3.3 as=0.1449 ps=1.53 w=0.42 l=0.15
X2893 sky130_fd_sc_hd__dfrtp_1_5/a_1108_47# sky130_fd_sc_hd__dfrtp_1_5/a_193_47# sky130_fd_sc_hd__dfrtp_1_5/a_761_289# VGND sky130_fd_pr__special_nfet_01v8 ad=0 pd=0 as=0.1998 ps=1.97 w=0.36 l=0.15
X2894 VGND V3R301 sky130_fd_sc_hd__dfrtp_1_5/a_805_47# VGND sky130_fd_pr__nfet_01v8 ad=0 pd=0 as=0 ps=0 w=0.42 l=0.15
X2895 V3R035 sky130_fd_sc_hd__dfrtp_1_5/a_1283_21# VDPWR VDPWR sky130_fd_pr__pfet_01v8_hvt ad=0.26 pd=2.52 as=0 ps=0 w=1 l=0.15
X2896 VDPWR V3R082 sky130_fd_sc_hd__dfrtp_1_5/a_27_47# VDPWR sky130_fd_pr__pfet_01v8_hvt ad=0 pd=0 as=0.1664 ps=1.8 w=0.64 l=0.15
X2897 sky130_fd_sc_hd__dfrtp_1_5/a_448_47# V3R149 VDPWR VDPWR sky130_fd_pr__pfet_01v8_hvt ad=0.1302 pd=1.46 as=0 ps=0 w=0.42 l=0.15
X2898 sky130_fd_sc_hd__dfrtp_1_5/a_761_289# sky130_fd_sc_hd__dfrtp_1_5/a_543_47# VGND VGND sky130_fd_pr__nfet_01v8 ad=0 pd=0 as=0 ps=0 w=0.64 l=0.15
X2899 sky130_fd_sc_hd__dfrtp_1_5/a_193_47# sky130_fd_sc_hd__dfrtp_1_5/a_27_47# VGND VGND sky130_fd_pr__nfet_01v8 ad=0.1092 pd=1.36 as=0 ps=0 w=0.42 l=0.15
X2900 sky130_fd_sc_hd__dfrtp_1_5/a_1108_47# sky130_fd_sc_hd__dfrtp_1_5/a_27_47# sky130_fd_sc_hd__dfrtp_1_5/a_761_289# VDPWR sky130_fd_pr__pfet_01v8_hvt ad=0.1176 pd=1.4 as=0.2583 ps=2.37 w=0.42 l=0.15
X2901 sky130_fd_sc_hd__dfrtp_1_5/a_1462_47# V3R301 VGND VGND sky130_fd_pr__nfet_01v8 ad=0 pd=0 as=0 ps=0 w=0.42 l=0.15
X2902 sky130_fd_sc_hd__dfrtp_1_5/a_543_47# sky130_fd_sc_hd__dfrtp_1_5/a_27_47# sky130_fd_sc_hd__dfrtp_1_5/a_448_47# VGND sky130_fd_pr__special_nfet_01v8 ad=0.1188 pd=1.38 as=0.132 ps=1.49 w=0.36 l=0.15
X2903 sky130_fd_sc_hd__dfrtp_1_5/a_543_47# sky130_fd_sc_hd__dfrtp_1_5/a_193_47# sky130_fd_sc_hd__dfrtp_1_5/a_448_47# VDPWR sky130_fd_pr__pfet_01v8_hvt ad=0 pd=0 as=0 ps=0 w=0.42 l=0.15
X2904 sky130_fd_sc_hd__dfrtp_1_5/a_448_47# V3R149 VGND VGND sky130_fd_pr__nfet_01v8 ad=0 pd=0 as=0 ps=0 w=0.42 l=0.15
X2905 VDPWR sky130_fd_sc_hd__dfrtp_1_5/a_1283_21# sky130_fd_sc_hd__dfrtp_1_5/a_1270_413# VDPWR sky130_fd_pr__pfet_01v8_hvt ad=0 pd=0 as=0.1134 ps=1.38 w=0.42 l=0.15
X2906 VDPWR sky130_fd_sc_hd__dfrtp_1_5/a_1108_47# sky130_fd_sc_hd__dfrtp_1_5/a_1283_21# VDPWR sky130_fd_pr__pfet_01v8_hvt ad=0 pd=0 as=0.1134 ps=1.38 w=0.42 l=0.15
X2907 sky130_fd_sc_hd__dfrtp_1_5/a_1270_413# sky130_fd_sc_hd__dfrtp_1_5/a_193_47# sky130_fd_sc_hd__dfrtp_1_5/a_1108_47# VDPWR sky130_fd_pr__pfet_01v8_hvt ad=0 pd=0 as=0 ps=0 w=0.42 l=0.15
X2908 sky130_fd_sc_hd__dfrtp_1_5/a_193_47# sky130_fd_sc_hd__dfrtp_1_5/a_27_47# VDPWR VDPWR sky130_fd_pr__pfet_01v8_hvt ad=0.1664 pd=1.8 as=0 ps=0 w=0.64 l=0.15
X2909 sky130_fd_sc_hd__dfrtp_1_5/a_1283_21# V3R301 VDPWR VDPWR sky130_fd_pr__pfet_01v8_hvt ad=0 pd=0 as=0 ps=0 w=0.42 l=0.15
X2910 VDPWR sky130_fd_sc_hd__dfrtp_1_5/a_761_289# sky130_fd_sc_hd__dfrtp_1_5/a_651_413# VDPWR sky130_fd_pr__pfet_01v8_hvt ad=0 pd=0 as=0 ps=0 w=0.42 l=0.15
X2911 V3R035 sky130_fd_sc_hd__dfrtp_1_5/a_1283_21# VGND VGND sky130_fd_pr__nfet_01v8 ad=0.169 pd=1.82 as=0 ps=0 w=0.65 l=0.15
X2912 sky130_fd_sc_hd__dfrtp_1_5/a_639_47# sky130_fd_sc_hd__dfrtp_1_5/a_193_47# sky130_fd_sc_hd__dfrtp_1_5/a_543_47# VGND sky130_fd_pr__special_nfet_01v8 ad=0 pd=0 as=0 ps=0 w=0.36 l=0.15
X2913 VGND sky130_fd_sc_hd__dfrtp_1_5/a_1283_21# sky130_fd_sc_hd__dfrtp_1_5/a_1217_47# VGND sky130_fd_pr__nfet_01v8 ad=0 pd=0 as=0 ps=0 w=0.42 l=0.15
X2914 sky130_fd_sc_hd__dfrtp_1_5/a_651_413# V3R301 VDPWR VDPWR sky130_fd_pr__pfet_01v8_hvt ad=0 pd=0 as=0 ps=0 w=0.42 l=0.15
X2915 VGND V3R082 sky130_fd_sc_hd__dfrtp_1_5/a_27_47# VGND sky130_fd_pr__nfet_01v8 ad=0 pd=0 as=0.1092 ps=1.36 w=0.42 l=0.15
X2916 sky130_fd_sc_hd__dfrtp_1_5/a_761_289# sky130_fd_sc_hd__dfrtp_1_5/a_543_47# VDPWR VDPWR sky130_fd_pr__pfet_01v8_hvt ad=0 pd=0 as=0 ps=0 w=0.84 l=0.15
X2917 VDPWR sky130_fd_sc_hd__mux2_1_90/a_505_21# sky130_fd_sc_hd__mux2_1_90/a_535_374# VDPWR sky130_fd_pr__pfet_01v8_hvt ad=0 pd=0 as=0.0882 ps=1.26 w=0.42 l=0.15
X2918 sky130_fd_sc_hd__mux2_1_90/a_505_21# V3R061 VDPWR VDPWR sky130_fd_pr__pfet_01v8_hvt ad=0.1176 pd=1.4 as=0 ps=0 w=0.42 l=0.15
X2919 sky130_fd_sc_hd__mux2_1_90/a_218_374# V3R061 VDPWR VDPWR sky130_fd_pr__pfet_01v8_hvt ad=0.1533 pd=1.57 as=0 ps=0 w=0.42 l=0.15
X2920 VGND sky130_fd_sc_hd__mux2_1_90/a_505_21# sky130_fd_sc_hd__mux2_1_90/a_439_47# VGND sky130_fd_pr__nfet_01v8 ad=0 pd=0 as=0.1386 ps=1.5 w=0.42 l=0.15
X2921 sky130_fd_sc_hd__mux2_1_90/a_76_199# V3R177 sky130_fd_sc_hd__mux2_1_90/a_218_374# VDPWR sky130_fd_pr__pfet_01v8_hvt ad=0.3864 pd=2.68 as=0 ps=0 w=0.42 l=0.15
X2922 sky130_fd_sc_hd__mux2_1_90/a_505_21# V3R061 VGND VGND sky130_fd_pr__nfet_01v8 ad=0.1092 pd=1.36 as=0 ps=0 w=0.42 l=0.15
X2923 sky130_fd_sc_hd__mux2_1_90/a_439_47# V3R177 sky130_fd_sc_hd__mux2_1_90/a_76_199# VGND sky130_fd_pr__nfet_01v8 ad=0 pd=0 as=0.1995 ps=1.79 w=0.42 l=0.15
X2924 sky130_fd_sc_hd__mux2_1_90/a_535_374# V3R176 sky130_fd_sc_hd__mux2_1_90/a_76_199# VDPWR sky130_fd_pr__pfet_01v8_hvt ad=0 pd=0 as=0 ps=0 w=0.42 l=0.15
X2925 sky130_fd_sc_hd__mux2_1_90/a_76_199# V3R176 sky130_fd_sc_hd__mux2_1_90/a_218_47# VGND sky130_fd_pr__nfet_01v8 ad=0 pd=0 as=0.1386 ps=1.5 w=0.42 l=0.15
X2926 sky130_fd_sc_hd__mux2_1_90/a_218_47# V3R061 VGND VGND sky130_fd_pr__nfet_01v8 ad=0 pd=0 as=0 ps=0 w=0.42 l=0.15
X2927 VDPWR sky130_fd_sc_hd__mux2_1_90/a_76_199# V3R090 VDPWR sky130_fd_pr__pfet_01v8_hvt ad=0 pd=0 as=0.26 ps=2.52 w=1 l=0.15
X2928 VGND sky130_fd_sc_hd__mux2_1_90/a_76_199# V3R090 VGND sky130_fd_pr__nfet_01v8 ad=0 pd=0 as=0.169 ps=1.82 w=0.65 l=0.15
X2929 VGND sky130_fd_sc_hd__dfstp_1_7/a_652_21# sky130_fd_sc_hd__dfstp_1_7/a_586_47# VGND sky130_fd_pr__nfet_01v8 ad=0 pd=0 as=0.1341 ps=1.5 w=0.42 l=0.15
X2930 sky130_fd_sc_hd__dfstp_1_7/a_956_413# sky130_fd_sc_hd__dfstp_1_7/a_476_47# VDPWR VDPWR sky130_fd_pr__pfet_01v8_hvt ad=0.0966 pd=1.3 as=0 ps=0 w=0.42 l=0.15
X2931 VDPWR sky130_fd_sc_hd__dfstp_1_7/a_476_47# sky130_fd_sc_hd__dfstp_1_7/a_652_21# VDPWR sky130_fd_pr__pfet_01v8_hvt ad=0 pd=0 as=0.1134 ps=1.38 w=0.42 l=0.15
X2932 VDPWR V3R055 sky130_fd_sc_hd__dfstp_1_7/a_27_47# VDPWR sky130_fd_pr__pfet_01v8_hvt ad=0 pd=0 as=0.1664 ps=1.8 w=0.64 l=0.15
X2933 sky130_fd_sc_hd__dfstp_1_7/a_586_47# sky130_fd_sc_hd__dfstp_1_7/a_193_47# sky130_fd_sc_hd__dfstp_1_7/a_476_47# VGND sky130_fd_pr__special_nfet_01v8 ad=0 pd=0 as=0.144 ps=1.52 w=0.36 l=0.15
X2934 sky130_fd_sc_hd__dfstp_1_7/a_1056_47# sky130_fd_sc_hd__dfstp_1_7/a_476_47# VGND VGND sky130_fd_pr__nfet_01v8 ad=0.0882 pd=1.26 as=0 ps=0 w=0.42 l=0.15
X2935 sky130_fd_sc_hd__dfstp_1_7/a_476_47# sky130_fd_sc_hd__dfstp_1_7/a_27_47# sky130_fd_sc_hd__dfstp_1_7/a_381_47# VGND sky130_fd_pr__special_nfet_01v8 ad=0 pd=0 as=0.187 ps=1.93 w=0.36 l=0.15
X2936 sky130_fd_sc_hd__dfstp_1_7/a_381_47# V3R089 VDPWR VDPWR sky130_fd_pr__pfet_01v8_hvt ad=0.2499 pd=2.35 as=0 ps=0 w=0.84 l=0.15
X2937 sky130_fd_sc_hd__dfstp_1_7/a_652_21# V3R298 VDPWR VDPWR sky130_fd_pr__pfet_01v8_hvt ad=0 pd=0 as=0 ps=0 w=0.42 l=0.15
X2938 sky130_fd_sc_hd__dfstp_1_7/a_1224_47# sky130_fd_sc_hd__dfstp_1_7/a_27_47# sky130_fd_sc_hd__dfstp_1_7/a_1032_413# VGND sky130_fd_pr__nfet_01v8 ad=0.0882 pd=1.26 as=0.1386 ps=1.5 w=0.42 l=0.15
X2939 sky130_fd_sc_hd__dfstp_1_7/a_562_413# sky130_fd_sc_hd__dfstp_1_7/a_27_47# sky130_fd_sc_hd__dfstp_1_7/a_476_47# VDPWR sky130_fd_pr__pfet_01v8_hvt ad=0.189 pd=1.74 as=0.1134 ps=1.38 w=0.42 l=0.15
X2940 VGND sky130_fd_sc_hd__dfstp_1_7/a_1032_413# sky130_fd_sc_hd__dfstp_1_7/a_1602_47# VGND sky130_fd_pr__nfet_01v8 ad=0 pd=0 as=0.1092 ps=1.36 w=0.42 l=0.15
X2941 VDPWR sky130_fd_sc_hd__dfstp_1_7/a_1182_261# sky130_fd_sc_hd__dfstp_1_7/a_1140_413# VDPWR sky130_fd_pr__pfet_01v8_hvt ad=0 pd=0 as=0.0882 ps=1.26 w=0.42 l=0.15
X2942 V3R175 sky130_fd_sc_hd__dfstp_1_7/a_1602_47# VDPWR VDPWR sky130_fd_pr__pfet_01v8_hvt ad=0.26 pd=2.52 as=0 ps=0 w=1 l=0.15
X2943 sky130_fd_sc_hd__dfstp_1_7/a_1032_413# sky130_fd_sc_hd__dfstp_1_7/a_193_47# sky130_fd_sc_hd__dfstp_1_7/a_1056_47# VGND sky130_fd_pr__nfet_01v8 ad=0 pd=0 as=0 ps=0 w=0.42 l=0.15
X2944 sky130_fd_sc_hd__dfstp_1_7/a_476_47# sky130_fd_sc_hd__dfstp_1_7/a_193_47# sky130_fd_sc_hd__dfstp_1_7/a_381_47# VDPWR sky130_fd_pr__pfet_01v8_hvt ad=0 pd=0 as=0 ps=0 w=0.42 l=0.15
X2945 sky130_fd_sc_hd__dfstp_1_7/a_1296_47# sky130_fd_sc_hd__dfstp_1_7/a_1182_261# sky130_fd_sc_hd__dfstp_1_7/a_1224_47# VGND sky130_fd_pr__nfet_01v8 ad=0.0966 pd=1.3 as=0 ps=0 w=0.42 l=0.15
X2946 sky130_fd_sc_hd__dfstp_1_7/a_193_47# sky130_fd_sc_hd__dfstp_1_7/a_27_47# VGND VGND sky130_fd_pr__nfet_01v8 ad=0.1092 pd=1.36 as=0 ps=0 w=0.42 l=0.15
X2947 VDPWR sky130_fd_sc_hd__dfstp_1_7/a_652_21# sky130_fd_sc_hd__dfstp_1_7/a_562_413# VDPWR sky130_fd_pr__pfet_01v8_hvt ad=0 pd=0 as=0 ps=0 w=0.42 l=0.15
X2948 VDPWR V3R298 sky130_fd_sc_hd__dfstp_1_7/a_1032_413# VDPWR sky130_fd_pr__pfet_01v8_hvt ad=0 pd=0 as=0.273 ps=2.98 w=0.42 l=0.15
X2949 sky130_fd_sc_hd__dfstp_1_7/a_1032_413# sky130_fd_sc_hd__dfstp_1_7/a_27_47# sky130_fd_sc_hd__dfstp_1_7/a_956_413# VDPWR sky130_fd_pr__pfet_01v8_hvt ad=0 pd=0 as=0 ps=0 w=0.42 l=0.15
X2950 sky130_fd_sc_hd__dfstp_1_7/a_1182_261# sky130_fd_sc_hd__dfstp_1_7/a_1032_413# VDPWR VDPWR sky130_fd_pr__pfet_01v8_hvt ad=0.2184 pd=2.2 as=0 ps=0 w=0.84 l=0.15
X2951 V3R175 sky130_fd_sc_hd__dfstp_1_7/a_1602_47# VGND VGND sky130_fd_pr__nfet_01v8 ad=0.169 pd=1.82 as=0 ps=0 w=0.65 l=0.15
X2952 sky130_fd_sc_hd__dfstp_1_7/a_193_47# sky130_fd_sc_hd__dfstp_1_7/a_27_47# VDPWR VDPWR sky130_fd_pr__pfet_01v8_hvt ad=0.1664 pd=1.8 as=0 ps=0 w=0.64 l=0.15
X2953 sky130_fd_sc_hd__dfstp_1_7/a_1140_413# sky130_fd_sc_hd__dfstp_1_7/a_193_47# sky130_fd_sc_hd__dfstp_1_7/a_1032_413# VDPWR sky130_fd_pr__pfet_01v8_hvt ad=0 pd=0 as=0 ps=0 w=0.42 l=0.15
X2954 VDPWR sky130_fd_sc_hd__dfstp_1_7/a_1032_413# sky130_fd_sc_hd__dfstp_1_7/a_1602_47# VDPWR sky130_fd_pr__pfet_01v8_hvt ad=0 pd=0 as=0.1664 ps=1.8 w=0.64 l=0.15
X2955 sky130_fd_sc_hd__dfstp_1_7/a_796_47# V3R298 VGND VGND sky130_fd_pr__nfet_01v8 ad=0.0882 pd=1.26 as=0 ps=0 w=0.42 l=0.15
X2956 sky130_fd_sc_hd__dfstp_1_7/a_381_47# V3R089 VGND VGND sky130_fd_pr__nfet_01v8 ad=0 pd=0 as=0 ps=0 w=0.64 l=0.15
X2957 sky130_fd_sc_hd__dfstp_1_7/a_1182_261# sky130_fd_sc_hd__dfstp_1_7/a_1032_413# VGND VGND sky130_fd_pr__nfet_01v8 ad=0.1404 pd=1.6 as=0 ps=0 w=0.54 l=0.15
X2958 sky130_fd_sc_hd__dfstp_1_7/a_652_21# sky130_fd_sc_hd__dfstp_1_7/a_476_47# sky130_fd_sc_hd__dfstp_1_7/a_796_47# VGND sky130_fd_pr__nfet_01v8 ad=0.1092 pd=1.36 as=0 ps=0 w=0.42 l=0.15
X2959 VGND V3R055 sky130_fd_sc_hd__dfstp_1_7/a_27_47# VGND sky130_fd_pr__nfet_01v8 ad=0 pd=0 as=0.1092 ps=1.36 w=0.42 l=0.15
X2960 VGND V3R298 sky130_fd_sc_hd__dfstp_1_7/a_1296_47# VGND sky130_fd_pr__nfet_01v8 ad=0 pd=0 as=0 ps=0 w=0.42 l=0.15
X2961 VDPWR sky130_fd_sc_hd__buf_4_0/a_27_47# V3R301 VDPWR sky130_fd_pr__pfet_01v8_hvt ad=0.26 pd=2.52 as=0.135 ps=1.27 w=1 l=0.15
X2962 V3R301 sky130_fd_sc_hd__buf_4_0/a_27_47# VDPWR VDPWR sky130_fd_pr__pfet_01v8_hvt ad=0.135 pd=1.27 as=0.135 ps=1.27 w=1 l=0.15
X2963 VDPWR sky130_fd_sc_hd__buf_4_0/a_27_47# V3R301 VDPWR sky130_fd_pr__pfet_01v8_hvt ad=0.135 pd=1.27 as=0.135 ps=1.27 w=1 l=0.15
X2964 V3R301 sky130_fd_sc_hd__buf_4_0/a_27_47# VDPWR VDPWR sky130_fd_pr__pfet_01v8_hvt ad=0.135 pd=1.27 as=0.135 ps=1.27 w=1 l=0.15
X2965 V3R301 sky130_fd_sc_hd__buf_4_0/a_27_47# VGND VGND sky130_fd_pr__nfet_01v8 ad=0.08775 pd=0.92 as=0.08775 ps=0.92 w=0.65 l=0.15
X2966 V3R301 sky130_fd_sc_hd__buf_4_0/a_27_47# VGND VGND sky130_fd_pr__nfet_01v8 ad=0.08775 pd=0.92 as=0.08775 ps=0.92 w=0.65 l=0.15
X2967 VGND sky130_fd_sc_hd__buf_4_0/a_27_47# V3R301 VGND sky130_fd_pr__nfet_01v8 ad=0.08775 pd=0.92 as=0.08775 ps=0.92 w=0.65 l=0.15
X2968 VGND sky130_fd_sc_hd__buf_4_0/a_27_47# V3R301 VGND sky130_fd_pr__nfet_01v8 ad=0.169 pd=1.82 as=0.08775 ps=0.92 w=0.65 l=0.15
X2969 VDPWR V3R297 sky130_fd_sc_hd__buf_4_0/a_27_47# VDPWR sky130_fd_pr__pfet_01v8_hvt ad=0.135 pd=1.27 as=0.26 ps=2.52 w=1 l=0.15
X2970 VGND V3R297 sky130_fd_sc_hd__buf_4_0/a_27_47# VGND sky130_fd_pr__nfet_01v8 ad=0.08775 pd=0.92 as=0.169 ps=1.82 w=0.65 l=0.15
X2971 sky130_fd_sc_hd__or2b_1_1/a_219_297# sky130_fd_sc_hd__or2b_1_1/a_27_53# VGND VGND sky130_fd_pr__nfet_01v8 ad=0.1134 pd=1.38 as=0 ps=0 w=0.42 l=0.15
X2972 VGND V3R268 sky130_fd_sc_hd__or2b_1_1/a_27_53# VGND sky130_fd_pr__nfet_01v8 ad=0 pd=0 as=0.1092 ps=1.36 w=0.42 l=0.15
X2973 VDPWR V3R053 sky130_fd_sc_hd__or2b_1_1/a_301_297# VDPWR sky130_fd_pr__pfet_01v8_hvt ad=0 pd=0 as=0.0882 ps=1.26 w=0.42 l=0.15
X2974 V3R269 sky130_fd_sc_hd__or2b_1_1/a_219_297# VGND VGND sky130_fd_pr__nfet_01v8 ad=0.1755 pd=1.84 as=0 ps=0 w=0.65 l=0.15
X2975 sky130_fd_sc_hd__or2b_1_1/a_301_297# sky130_fd_sc_hd__or2b_1_1/a_27_53# sky130_fd_sc_hd__or2b_1_1/a_219_297# VDPWR sky130_fd_pr__pfet_01v8_hvt ad=0 pd=0 as=0.1092 ps=1.36 w=0.42 l=0.15
X2976 V3R269 sky130_fd_sc_hd__or2b_1_1/a_219_297# VDPWR VDPWR sky130_fd_pr__pfet_01v8_hvt ad=0.27 pd=2.54 as=0 ps=0 w=1 l=0.15
X2977 sky130_fd_sc_hd__or2b_1_1/a_27_53# V3R268 VDPWR VDPWR sky130_fd_pr__pfet_01v8_hvt ad=0.1176 pd=1.4 as=0 ps=0 w=0.42 l=0.15
X2978 VGND V3R053 sky130_fd_sc_hd__or2b_1_1/a_219_297# VGND sky130_fd_pr__nfet_01v8 ad=0 pd=0 as=0 ps=0 w=0.42 l=0.15
X2979 VDPWR V3R203 sky130_fd_sc_hd__and2_1_3/a_59_75# VDPWR sky130_fd_pr__pfet_01v8_hvt ad=0 pd=0 as=0.1134 ps=1.38 w=0.42 l=0.15
X2980 V3R265 sky130_fd_sc_hd__and2_1_3/a_59_75# VDPWR VDPWR sky130_fd_pr__pfet_01v8_hvt ad=0.475 pd=2.95 as=0 ps=0 w=1 l=0.15
X2981 VGND V3R203 sky130_fd_sc_hd__and2_1_3/a_145_75# VGND sky130_fd_pr__nfet_01v8 ad=0 pd=0 as=0.1134 ps=1.38 w=0.42 l=0.15
X2982 sky130_fd_sc_hd__and2_1_3/a_59_75# V3R078 VDPWR VDPWR sky130_fd_pr__pfet_01v8_hvt ad=0 pd=0 as=0 ps=0 w=0.42 l=0.15
X2983 V3R265 sky130_fd_sc_hd__and2_1_3/a_59_75# VGND VGND sky130_fd_pr__nfet_01v8 ad=0.182 pd=1.86 as=0 ps=0 w=0.65 l=0.15
X2984 sky130_fd_sc_hd__and2_1_3/a_145_75# V3R078 sky130_fd_sc_hd__and2_1_3/a_59_75# VGND sky130_fd_pr__nfet_01v8 ad=0 pd=0 as=0.1176 ps=1.4 w=0.42 l=0.15
X2985 sky130_fd_sc_hd__dfrtp_1_6/a_805_47# sky130_fd_sc_hd__dfrtp_1_6/a_761_289# sky130_fd_sc_hd__dfrtp_1_6/a_639_47# VGND sky130_fd_pr__nfet_01v8 ad=0.0882 pd=1.26 as=0.2802 ps=2.2 w=0.42 l=0.15
X2986 sky130_fd_sc_hd__dfrtp_1_6/a_1217_47# sky130_fd_sc_hd__dfrtp_1_6/a_27_47# sky130_fd_sc_hd__dfrtp_1_6/a_1108_47# VGND sky130_fd_pr__special_nfet_01v8 ad=0.1338 pd=1.5 as=0.1422 ps=1.51 w=0.36 l=0.15
X2987 sky130_fd_sc_hd__dfrtp_1_6/a_1283_21# sky130_fd_sc_hd__dfrtp_1_6/a_1108_47# sky130_fd_sc_hd__dfrtp_1_6/a_1462_47# VGND sky130_fd_pr__nfet_01v8 ad=0.1092 pd=1.36 as=0.1281 ps=1.45 w=0.42 l=0.15
X2988 sky130_fd_sc_hd__dfrtp_1_6/a_651_413# sky130_fd_sc_hd__dfrtp_1_6/a_27_47# sky130_fd_sc_hd__dfrtp_1_6/a_543_47# VDPWR sky130_fd_pr__pfet_01v8_hvt ad=0.3402 pd=3.3 as=0.1449 ps=1.53 w=0.42 l=0.15
X2989 sky130_fd_sc_hd__dfrtp_1_6/a_1108_47# sky130_fd_sc_hd__dfrtp_1_6/a_193_47# sky130_fd_sc_hd__dfrtp_1_6/a_761_289# VGND sky130_fd_pr__special_nfet_01v8 ad=0 pd=0 as=0.1998 ps=1.97 w=0.36 l=0.15
X2990 VGND V3R299 sky130_fd_sc_hd__dfrtp_1_6/a_805_47# VGND sky130_fd_pr__nfet_01v8 ad=0 pd=0 as=0 ps=0 w=0.42 l=0.15
X2991 V3R173 sky130_fd_sc_hd__dfrtp_1_6/a_1283_21# VDPWR VDPWR sky130_fd_pr__pfet_01v8_hvt ad=0.26 pd=2.52 as=0 ps=0 w=1 l=0.15
X2992 VDPWR V3R056 sky130_fd_sc_hd__dfrtp_1_6/a_27_47# VDPWR sky130_fd_pr__pfet_01v8_hvt ad=0 pd=0 as=0.1664 ps=1.8 w=0.64 l=0.15
X2993 sky130_fd_sc_hd__dfrtp_1_6/a_448_47# V3R116 VDPWR VDPWR sky130_fd_pr__pfet_01v8_hvt ad=0.1302 pd=1.46 as=0 ps=0 w=0.42 l=0.15
X2994 sky130_fd_sc_hd__dfrtp_1_6/a_761_289# sky130_fd_sc_hd__dfrtp_1_6/a_543_47# VGND VGND sky130_fd_pr__nfet_01v8 ad=0 pd=0 as=0 ps=0 w=0.64 l=0.15
X2995 sky130_fd_sc_hd__dfrtp_1_6/a_193_47# sky130_fd_sc_hd__dfrtp_1_6/a_27_47# VGND VGND sky130_fd_pr__nfet_01v8 ad=0.1092 pd=1.36 as=0 ps=0 w=0.42 l=0.15
X2996 sky130_fd_sc_hd__dfrtp_1_6/a_1108_47# sky130_fd_sc_hd__dfrtp_1_6/a_27_47# sky130_fd_sc_hd__dfrtp_1_6/a_761_289# VDPWR sky130_fd_pr__pfet_01v8_hvt ad=0.1176 pd=1.4 as=0.2583 ps=2.37 w=0.42 l=0.15
X2997 sky130_fd_sc_hd__dfrtp_1_6/a_1462_47# V3R299 VGND VGND sky130_fd_pr__nfet_01v8 ad=0 pd=0 as=0 ps=0 w=0.42 l=0.15
X2998 sky130_fd_sc_hd__dfrtp_1_6/a_543_47# sky130_fd_sc_hd__dfrtp_1_6/a_27_47# sky130_fd_sc_hd__dfrtp_1_6/a_448_47# VGND sky130_fd_pr__special_nfet_01v8 ad=0.1188 pd=1.38 as=0.132 ps=1.49 w=0.36 l=0.15
X2999 sky130_fd_sc_hd__dfrtp_1_6/a_543_47# sky130_fd_sc_hd__dfrtp_1_6/a_193_47# sky130_fd_sc_hd__dfrtp_1_6/a_448_47# VDPWR sky130_fd_pr__pfet_01v8_hvt ad=0 pd=0 as=0 ps=0 w=0.42 l=0.15
X3000 sky130_fd_sc_hd__dfrtp_1_6/a_448_47# V3R116 VGND VGND sky130_fd_pr__nfet_01v8 ad=0 pd=0 as=0 ps=0 w=0.42 l=0.15
X3001 VDPWR sky130_fd_sc_hd__dfrtp_1_6/a_1283_21# sky130_fd_sc_hd__dfrtp_1_6/a_1270_413# VDPWR sky130_fd_pr__pfet_01v8_hvt ad=0 pd=0 as=0.1134 ps=1.38 w=0.42 l=0.15
X3002 VDPWR sky130_fd_sc_hd__dfrtp_1_6/a_1108_47# sky130_fd_sc_hd__dfrtp_1_6/a_1283_21# VDPWR sky130_fd_pr__pfet_01v8_hvt ad=0 pd=0 as=0.1134 ps=1.38 w=0.42 l=0.15
X3003 sky130_fd_sc_hd__dfrtp_1_6/a_1270_413# sky130_fd_sc_hd__dfrtp_1_6/a_193_47# sky130_fd_sc_hd__dfrtp_1_6/a_1108_47# VDPWR sky130_fd_pr__pfet_01v8_hvt ad=0 pd=0 as=0 ps=0 w=0.42 l=0.15
X3004 sky130_fd_sc_hd__dfrtp_1_6/a_193_47# sky130_fd_sc_hd__dfrtp_1_6/a_27_47# VDPWR VDPWR sky130_fd_pr__pfet_01v8_hvt ad=0.1664 pd=1.8 as=0 ps=0 w=0.64 l=0.15
X3005 sky130_fd_sc_hd__dfrtp_1_6/a_1283_21# V3R299 VDPWR VDPWR sky130_fd_pr__pfet_01v8_hvt ad=0 pd=0 as=0 ps=0 w=0.42 l=0.15
X3006 VDPWR sky130_fd_sc_hd__dfrtp_1_6/a_761_289# sky130_fd_sc_hd__dfrtp_1_6/a_651_413# VDPWR sky130_fd_pr__pfet_01v8_hvt ad=0 pd=0 as=0 ps=0 w=0.42 l=0.15
X3007 V3R173 sky130_fd_sc_hd__dfrtp_1_6/a_1283_21# VGND VGND sky130_fd_pr__nfet_01v8 ad=0.169 pd=1.82 as=0 ps=0 w=0.65 l=0.15
X3008 sky130_fd_sc_hd__dfrtp_1_6/a_639_47# sky130_fd_sc_hd__dfrtp_1_6/a_193_47# sky130_fd_sc_hd__dfrtp_1_6/a_543_47# VGND sky130_fd_pr__special_nfet_01v8 ad=0 pd=0 as=0 ps=0 w=0.36 l=0.15
X3009 VGND sky130_fd_sc_hd__dfrtp_1_6/a_1283_21# sky130_fd_sc_hd__dfrtp_1_6/a_1217_47# VGND sky130_fd_pr__nfet_01v8 ad=0 pd=0 as=0 ps=0 w=0.42 l=0.15
X3010 sky130_fd_sc_hd__dfrtp_1_6/a_651_413# V3R299 VDPWR VDPWR sky130_fd_pr__pfet_01v8_hvt ad=0 pd=0 as=0 ps=0 w=0.42 l=0.15
X3011 VGND V3R056 sky130_fd_sc_hd__dfrtp_1_6/a_27_47# VGND sky130_fd_pr__nfet_01v8 ad=0 pd=0 as=0.1092 ps=1.36 w=0.42 l=0.15
X3012 sky130_fd_sc_hd__dfrtp_1_6/a_761_289# sky130_fd_sc_hd__dfrtp_1_6/a_543_47# VDPWR VDPWR sky130_fd_pr__pfet_01v8_hvt ad=0 pd=0 as=0 ps=0 w=0.84 l=0.15
X3013 VDPWR sky130_fd_sc_hd__mux2_1_80/a_505_21# sky130_fd_sc_hd__mux2_1_80/a_535_374# VDPWR sky130_fd_pr__pfet_01v8_hvt ad=0 pd=0 as=0.0882 ps=1.26 w=0.42 l=0.15
X3014 sky130_fd_sc_hd__mux2_1_80/a_505_21# V3R061 VDPWR VDPWR sky130_fd_pr__pfet_01v8_hvt ad=0.1176 pd=1.4 as=0 ps=0 w=0.42 l=0.15
X3015 sky130_fd_sc_hd__mux2_1_80/a_218_374# V3R061 VDPWR VDPWR sky130_fd_pr__pfet_01v8_hvt ad=0.1533 pd=1.57 as=0 ps=0 w=0.42 l=0.15
X3016 VGND sky130_fd_sc_hd__mux2_1_80/a_505_21# sky130_fd_sc_hd__mux2_1_80/a_439_47# VGND sky130_fd_pr__nfet_01v8 ad=0 pd=0 as=0.1386 ps=1.5 w=0.42 l=0.15
X3017 sky130_fd_sc_hd__mux2_1_80/a_76_199# V3R151 sky130_fd_sc_hd__mux2_1_80/a_218_374# VDPWR sky130_fd_pr__pfet_01v8_hvt ad=0.3864 pd=2.68 as=0 ps=0 w=0.42 l=0.15
X3018 sky130_fd_sc_hd__mux2_1_80/a_505_21# V3R061 VGND VGND sky130_fd_pr__nfet_01v8 ad=0.1092 pd=1.36 as=0 ps=0 w=0.42 l=0.15
X3019 sky130_fd_sc_hd__mux2_1_80/a_439_47# V3R151 sky130_fd_sc_hd__mux2_1_80/a_76_199# VGND sky130_fd_pr__nfet_01v8 ad=0 pd=0 as=0.1995 ps=1.79 w=0.42 l=0.15
X3020 sky130_fd_sc_hd__mux2_1_80/a_535_374# V3R181 sky130_fd_sc_hd__mux2_1_80/a_76_199# VDPWR sky130_fd_pr__pfet_01v8_hvt ad=0 pd=0 as=0 ps=0 w=0.42 l=0.15
X3021 sky130_fd_sc_hd__mux2_1_80/a_76_199# V3R181 sky130_fd_sc_hd__mux2_1_80/a_218_47# VGND sky130_fd_pr__nfet_01v8 ad=0 pd=0 as=0.1386 ps=1.5 w=0.42 l=0.15
X3022 sky130_fd_sc_hd__mux2_1_80/a_218_47# V3R061 VGND VGND sky130_fd_pr__nfet_01v8 ad=0 pd=0 as=0 ps=0 w=0.42 l=0.15
X3023 VDPWR sky130_fd_sc_hd__mux2_1_80/a_76_199# V3R095 VDPWR sky130_fd_pr__pfet_01v8_hvt ad=0 pd=0 as=0.26 ps=2.52 w=1 l=0.15
X3024 VGND sky130_fd_sc_hd__mux2_1_80/a_76_199# V3R095 VGND sky130_fd_pr__nfet_01v8 ad=0 pd=0 as=0.169 ps=1.82 w=0.65 l=0.15
X3025 VDPWR sky130_fd_sc_hd__mux2_1_91/a_505_21# sky130_fd_sc_hd__mux2_1_91/a_535_374# VDPWR sky130_fd_pr__pfet_01v8_hvt ad=0 pd=0 as=0.0882 ps=1.26 w=0.42 l=0.15
X3026 sky130_fd_sc_hd__mux2_1_91/a_505_21# V3R044 VDPWR VDPWR sky130_fd_pr__pfet_01v8_hvt ad=0.1176 pd=1.4 as=0 ps=0 w=0.42 l=0.15
X3027 sky130_fd_sc_hd__mux2_1_91/a_218_374# V3R044 VDPWR VDPWR sky130_fd_pr__pfet_01v8_hvt ad=0.1533 pd=1.57 as=0 ps=0 w=0.42 l=0.15
X3028 VGND sky130_fd_sc_hd__mux2_1_91/a_505_21# sky130_fd_sc_hd__mux2_1_91/a_439_47# VGND sky130_fd_pr__nfet_01v8 ad=0 pd=0 as=0.1386 ps=1.5 w=0.42 l=0.15
X3029 sky130_fd_sc_hd__mux2_1_91/a_76_199# V3R037 sky130_fd_sc_hd__mux2_1_91/a_218_374# VDPWR sky130_fd_pr__pfet_01v8_hvt ad=0.3864 pd=2.68 as=0 ps=0 w=0.42 l=0.15
X3030 sky130_fd_sc_hd__mux2_1_91/a_505_21# V3R044 VGND VGND sky130_fd_pr__nfet_01v8 ad=0.1092 pd=1.36 as=0 ps=0 w=0.42 l=0.15
X3031 sky130_fd_sc_hd__mux2_1_91/a_439_47# V3R037 sky130_fd_sc_hd__mux2_1_91/a_76_199# VGND sky130_fd_pr__nfet_01v8 ad=0 pd=0 as=0.1995 ps=1.79 w=0.42 l=0.15
X3032 sky130_fd_sc_hd__mux2_1_91/a_535_374# V3R176 sky130_fd_sc_hd__mux2_1_91/a_76_199# VDPWR sky130_fd_pr__pfet_01v8_hvt ad=0 pd=0 as=0 ps=0 w=0.42 l=0.15
X3033 sky130_fd_sc_hd__mux2_1_91/a_76_199# V3R176 sky130_fd_sc_hd__mux2_1_91/a_218_47# VGND sky130_fd_pr__nfet_01v8 ad=0 pd=0 as=0.1386 ps=1.5 w=0.42 l=0.15
X3034 sky130_fd_sc_hd__mux2_1_91/a_218_47# V3R044 VGND VGND sky130_fd_pr__nfet_01v8 ad=0 pd=0 as=0 ps=0 w=0.42 l=0.15
X3035 VDPWR sky130_fd_sc_hd__mux2_1_91/a_76_199# V3R122 VDPWR sky130_fd_pr__pfet_01v8_hvt ad=0 pd=0 as=0.26 ps=2.52 w=1 l=0.15
X3036 VGND sky130_fd_sc_hd__mux2_1_91/a_76_199# V3R122 VGND sky130_fd_pr__nfet_01v8 ad=0 pd=0 as=0.169 ps=1.82 w=0.65 l=0.15
X3037 VGND sky130_fd_sc_hd__dfstp_1_8/a_652_21# sky130_fd_sc_hd__dfstp_1_8/a_586_47# VGND sky130_fd_pr__nfet_01v8 ad=0 pd=0 as=0.1341 ps=1.5 w=0.42 l=0.15
X3038 sky130_fd_sc_hd__dfstp_1_8/a_956_413# sky130_fd_sc_hd__dfstp_1_8/a_476_47# VDPWR VDPWR sky130_fd_pr__pfet_01v8_hvt ad=0.0966 pd=1.3 as=0 ps=0 w=0.42 l=0.15
X3039 VDPWR sky130_fd_sc_hd__dfstp_1_8/a_476_47# sky130_fd_sc_hd__dfstp_1_8/a_652_21# VDPWR sky130_fd_pr__pfet_01v8_hvt ad=0 pd=0 as=0.1134 ps=1.38 w=0.42 l=0.15
X3040 VDPWR V3R081 sky130_fd_sc_hd__dfstp_1_8/a_27_47# VDPWR sky130_fd_pr__pfet_01v8_hvt ad=0 pd=0 as=0.1664 ps=1.8 w=0.64 l=0.15
X3041 sky130_fd_sc_hd__dfstp_1_8/a_586_47# sky130_fd_sc_hd__dfstp_1_8/a_193_47# sky130_fd_sc_hd__dfstp_1_8/a_476_47# VGND sky130_fd_pr__special_nfet_01v8 ad=0 pd=0 as=0.144 ps=1.52 w=0.36 l=0.15
X3042 sky130_fd_sc_hd__dfstp_1_8/a_1056_47# sky130_fd_sc_hd__dfstp_1_8/a_476_47# VGND VGND sky130_fd_pr__nfet_01v8 ad=0.0882 pd=1.26 as=0 ps=0 w=0.42 l=0.15
X3043 sky130_fd_sc_hd__dfstp_1_8/a_476_47# sky130_fd_sc_hd__dfstp_1_8/a_27_47# sky130_fd_sc_hd__dfstp_1_8/a_381_47# VGND sky130_fd_pr__special_nfet_01v8 ad=0 pd=0 as=0.187 ps=1.93 w=0.36 l=0.15
X3044 sky130_fd_sc_hd__dfstp_1_8/a_381_47# V3R121 VDPWR VDPWR sky130_fd_pr__pfet_01v8_hvt ad=0.2499 pd=2.35 as=0 ps=0 w=0.84 l=0.15
X3045 sky130_fd_sc_hd__dfstp_1_8/a_652_21# V3R300 VDPWR VDPWR sky130_fd_pr__pfet_01v8_hvt ad=0 pd=0 as=0 ps=0 w=0.42 l=0.15
X3046 sky130_fd_sc_hd__dfstp_1_8/a_1224_47# sky130_fd_sc_hd__dfstp_1_8/a_27_47# sky130_fd_sc_hd__dfstp_1_8/a_1032_413# VGND sky130_fd_pr__nfet_01v8 ad=0.0882 pd=1.26 as=0.1386 ps=1.5 w=0.42 l=0.15
X3047 sky130_fd_sc_hd__dfstp_1_8/a_562_413# sky130_fd_sc_hd__dfstp_1_8/a_27_47# sky130_fd_sc_hd__dfstp_1_8/a_476_47# VDPWR sky130_fd_pr__pfet_01v8_hvt ad=0.189 pd=1.74 as=0.1134 ps=1.38 w=0.42 l=0.15
X3048 VGND sky130_fd_sc_hd__dfstp_1_8/a_1032_413# sky130_fd_sc_hd__dfstp_1_8/a_1602_47# VGND sky130_fd_pr__nfet_01v8 ad=0 pd=0 as=0.1092 ps=1.36 w=0.42 l=0.15
X3049 VDPWR sky130_fd_sc_hd__dfstp_1_8/a_1182_261# sky130_fd_sc_hd__dfstp_1_8/a_1140_413# VDPWR sky130_fd_pr__pfet_01v8_hvt ad=0 pd=0 as=0.0882 ps=1.26 w=0.42 l=0.15
X3050 V3R036 sky130_fd_sc_hd__dfstp_1_8/a_1602_47# VDPWR VDPWR sky130_fd_pr__pfet_01v8_hvt ad=0.26 pd=2.52 as=0 ps=0 w=1 l=0.15
X3051 sky130_fd_sc_hd__dfstp_1_8/a_1032_413# sky130_fd_sc_hd__dfstp_1_8/a_193_47# sky130_fd_sc_hd__dfstp_1_8/a_1056_47# VGND sky130_fd_pr__nfet_01v8 ad=0 pd=0 as=0 ps=0 w=0.42 l=0.15
X3052 sky130_fd_sc_hd__dfstp_1_8/a_476_47# sky130_fd_sc_hd__dfstp_1_8/a_193_47# sky130_fd_sc_hd__dfstp_1_8/a_381_47# VDPWR sky130_fd_pr__pfet_01v8_hvt ad=0 pd=0 as=0 ps=0 w=0.42 l=0.15
X3053 sky130_fd_sc_hd__dfstp_1_8/a_1296_47# sky130_fd_sc_hd__dfstp_1_8/a_1182_261# sky130_fd_sc_hd__dfstp_1_8/a_1224_47# VGND sky130_fd_pr__nfet_01v8 ad=0.0966 pd=1.3 as=0 ps=0 w=0.42 l=0.15
X3054 sky130_fd_sc_hd__dfstp_1_8/a_193_47# sky130_fd_sc_hd__dfstp_1_8/a_27_47# VGND VGND sky130_fd_pr__nfet_01v8 ad=0.1092 pd=1.36 as=0 ps=0 w=0.42 l=0.15
X3055 VDPWR sky130_fd_sc_hd__dfstp_1_8/a_652_21# sky130_fd_sc_hd__dfstp_1_8/a_562_413# VDPWR sky130_fd_pr__pfet_01v8_hvt ad=0 pd=0 as=0 ps=0 w=0.42 l=0.15
X3056 VDPWR V3R300 sky130_fd_sc_hd__dfstp_1_8/a_1032_413# VDPWR sky130_fd_pr__pfet_01v8_hvt ad=0 pd=0 as=0.273 ps=2.98 w=0.42 l=0.15
X3057 sky130_fd_sc_hd__dfstp_1_8/a_1032_413# sky130_fd_sc_hd__dfstp_1_8/a_27_47# sky130_fd_sc_hd__dfstp_1_8/a_956_413# VDPWR sky130_fd_pr__pfet_01v8_hvt ad=0 pd=0 as=0 ps=0 w=0.42 l=0.15
X3058 sky130_fd_sc_hd__dfstp_1_8/a_1182_261# sky130_fd_sc_hd__dfstp_1_8/a_1032_413# VDPWR VDPWR sky130_fd_pr__pfet_01v8_hvt ad=0.2184 pd=2.2 as=0 ps=0 w=0.84 l=0.15
X3059 V3R036 sky130_fd_sc_hd__dfstp_1_8/a_1602_47# VGND VGND sky130_fd_pr__nfet_01v8 ad=0.169 pd=1.82 as=0 ps=0 w=0.65 l=0.15
X3060 sky130_fd_sc_hd__dfstp_1_8/a_193_47# sky130_fd_sc_hd__dfstp_1_8/a_27_47# VDPWR VDPWR sky130_fd_pr__pfet_01v8_hvt ad=0.1664 pd=1.8 as=0 ps=0 w=0.64 l=0.15
X3061 sky130_fd_sc_hd__dfstp_1_8/a_1140_413# sky130_fd_sc_hd__dfstp_1_8/a_193_47# sky130_fd_sc_hd__dfstp_1_8/a_1032_413# VDPWR sky130_fd_pr__pfet_01v8_hvt ad=0 pd=0 as=0 ps=0 w=0.42 l=0.15
X3062 VDPWR sky130_fd_sc_hd__dfstp_1_8/a_1032_413# sky130_fd_sc_hd__dfstp_1_8/a_1602_47# VDPWR sky130_fd_pr__pfet_01v8_hvt ad=0 pd=0 as=0.1664 ps=1.8 w=0.64 l=0.15
X3063 sky130_fd_sc_hd__dfstp_1_8/a_796_47# V3R300 VGND VGND sky130_fd_pr__nfet_01v8 ad=0.0882 pd=1.26 as=0 ps=0 w=0.42 l=0.15
X3064 sky130_fd_sc_hd__dfstp_1_8/a_381_47# V3R121 VGND VGND sky130_fd_pr__nfet_01v8 ad=0 pd=0 as=0 ps=0 w=0.64 l=0.15
X3065 sky130_fd_sc_hd__dfstp_1_8/a_1182_261# sky130_fd_sc_hd__dfstp_1_8/a_1032_413# VGND VGND sky130_fd_pr__nfet_01v8 ad=0.1404 pd=1.6 as=0 ps=0 w=0.54 l=0.15
X3066 sky130_fd_sc_hd__dfstp_1_8/a_652_21# sky130_fd_sc_hd__dfstp_1_8/a_476_47# sky130_fd_sc_hd__dfstp_1_8/a_796_47# VGND sky130_fd_pr__nfet_01v8 ad=0.1092 pd=1.36 as=0 ps=0 w=0.42 l=0.15
X3067 VGND V3R081 sky130_fd_sc_hd__dfstp_1_8/a_27_47# VGND sky130_fd_pr__nfet_01v8 ad=0 pd=0 as=0.1092 ps=1.36 w=0.42 l=0.15
X3068 VGND V3R300 sky130_fd_sc_hd__dfstp_1_8/a_1296_47# VGND sky130_fd_pr__nfet_01v8 ad=0 pd=0 as=0 ps=0 w=0.42 l=0.15
X3069 VDPWR sky130_fd_sc_hd__buf_4_1/a_27_47# V3R303 VDPWR sky130_fd_pr__pfet_01v8_hvt ad=0 pd=0 as=0.54 ps=5.08 w=1 l=0.15
X3070 V3R303 sky130_fd_sc_hd__buf_4_1/a_27_47# VDPWR VDPWR sky130_fd_pr__pfet_01v8_hvt ad=0 pd=0 as=0 ps=0 w=1 l=0.15
X3071 VDPWR sky130_fd_sc_hd__buf_4_1/a_27_47# V3R303 VDPWR sky130_fd_pr__pfet_01v8_hvt ad=0 pd=0 as=0 ps=0 w=1 l=0.15
X3072 V3R303 sky130_fd_sc_hd__buf_4_1/a_27_47# VDPWR VDPWR sky130_fd_pr__pfet_01v8_hvt ad=0 pd=0 as=0 ps=0 w=1 l=0.15
X3073 V3R303 sky130_fd_sc_hd__buf_4_1/a_27_47# VGND VGND sky130_fd_pr__nfet_01v8 ad=0.351 pd=3.68 as=0 ps=0 w=0.65 l=0.15
X3074 V3R303 sky130_fd_sc_hd__buf_4_1/a_27_47# VGND VGND sky130_fd_pr__nfet_01v8 ad=0 pd=0 as=0 ps=0 w=0.65 l=0.15
X3075 VGND sky130_fd_sc_hd__buf_4_1/a_27_47# V3R303 VGND sky130_fd_pr__nfet_01v8 ad=0 pd=0 as=0 ps=0 w=0.65 l=0.15
X3076 VGND sky130_fd_sc_hd__buf_4_1/a_27_47# V3R303 VGND sky130_fd_pr__nfet_01v8 ad=0 pd=0 as=0 ps=0 w=0.65 l=0.15
X3077 VDPWR V3R297 sky130_fd_sc_hd__buf_4_1/a_27_47# VDPWR sky130_fd_pr__pfet_01v8_hvt ad=0 pd=0 as=0.26 ps=2.52 w=1 l=0.15
X3078 VGND V3R297 sky130_fd_sc_hd__buf_4_1/a_27_47# VGND sky130_fd_pr__nfet_01v8 ad=0 pd=0 as=0.169 ps=1.82 w=0.65 l=0.15
X3079 sky130_fd_sc_hd__or2b_1_2/a_219_297# sky130_fd_sc_hd__or2b_1_2/a_27_53# VGND VGND sky130_fd_pr__nfet_01v8 ad=0.1134 pd=1.38 as=0 ps=0 w=0.42 l=0.15
X3080 VGND V3R203 sky130_fd_sc_hd__or2b_1_2/a_27_53# VGND sky130_fd_pr__nfet_01v8 ad=0 pd=0 as=0.1092 ps=1.36 w=0.42 l=0.15
X3081 VDPWR V3R053 sky130_fd_sc_hd__or2b_1_2/a_301_297# VDPWR sky130_fd_pr__pfet_01v8_hvt ad=0 pd=0 as=0.0882 ps=1.26 w=0.42 l=0.15
X3082 V3R238 sky130_fd_sc_hd__or2b_1_2/a_219_297# VGND VGND sky130_fd_pr__nfet_01v8 ad=0.1755 pd=1.84 as=0 ps=0 w=0.65 l=0.15
X3083 sky130_fd_sc_hd__or2b_1_2/a_301_297# sky130_fd_sc_hd__or2b_1_2/a_27_53# sky130_fd_sc_hd__or2b_1_2/a_219_297# VDPWR sky130_fd_pr__pfet_01v8_hvt ad=0 pd=0 as=0.1092 ps=1.36 w=0.42 l=0.15
X3084 V3R238 sky130_fd_sc_hd__or2b_1_2/a_219_297# VDPWR VDPWR sky130_fd_pr__pfet_01v8_hvt ad=0.27 pd=2.54 as=0 ps=0 w=1 l=0.15
X3085 sky130_fd_sc_hd__or2b_1_2/a_27_53# V3R203 VDPWR VDPWR sky130_fd_pr__pfet_01v8_hvt ad=0.1176 pd=1.4 as=0 ps=0 w=0.42 l=0.15
X3086 VGND V3R053 sky130_fd_sc_hd__or2b_1_2/a_219_297# VGND sky130_fd_pr__nfet_01v8 ad=0 pd=0 as=0 ps=0 w=0.42 l=0.15
X3087 VDPWR V3R000 sky130_fd_sc_hd__and2_1_4/a_59_75# VDPWR sky130_fd_pr__pfet_01v8_hvt ad=0 pd=0 as=0.1134 ps=1.38 w=0.42 l=0.15
X3088 V3R245 sky130_fd_sc_hd__and2_1_4/a_59_75# VDPWR VDPWR sky130_fd_pr__pfet_01v8_hvt ad=0.475 pd=2.95 as=0 ps=0 w=1 l=0.15
X3089 VGND V3R000 sky130_fd_sc_hd__and2_1_4/a_145_75# VGND sky130_fd_pr__nfet_01v8 ad=0 pd=0 as=0.1134 ps=1.38 w=0.42 l=0.15
X3090 sky130_fd_sc_hd__and2_1_4/a_59_75# V3R001 VDPWR VDPWR sky130_fd_pr__pfet_01v8_hvt ad=0 pd=0 as=0 ps=0 w=0.42 l=0.15
X3091 V3R245 sky130_fd_sc_hd__and2_1_4/a_59_75# VGND VGND sky130_fd_pr__nfet_01v8 ad=0.182 pd=1.86 as=0 ps=0 w=0.65 l=0.15
X3092 sky130_fd_sc_hd__and2_1_4/a_145_75# V3R001 sky130_fd_sc_hd__and2_1_4/a_59_75# VGND sky130_fd_pr__nfet_01v8 ad=0 pd=0 as=0.1176 ps=1.4 w=0.42 l=0.15
X3093 sky130_fd_sc_hd__dfrtp_1_7/a_805_47# sky130_fd_sc_hd__dfrtp_1_7/a_761_289# sky130_fd_sc_hd__dfrtp_1_7/a_639_47# VGND sky130_fd_pr__nfet_01v8 ad=0.0882 pd=1.26 as=0.2802 ps=2.2 w=0.42 l=0.15
X3094 sky130_fd_sc_hd__dfrtp_1_7/a_1217_47# sky130_fd_sc_hd__dfrtp_1_7/a_27_47# sky130_fd_sc_hd__dfrtp_1_7/a_1108_47# VGND sky130_fd_pr__special_nfet_01v8 ad=0.1338 pd=1.5 as=0.1422 ps=1.51 w=0.36 l=0.15
X3095 sky130_fd_sc_hd__dfrtp_1_7/a_1283_21# sky130_fd_sc_hd__dfrtp_1_7/a_1108_47# sky130_fd_sc_hd__dfrtp_1_7/a_1462_47# VGND sky130_fd_pr__nfet_01v8 ad=0.1092 pd=1.36 as=0.1281 ps=1.45 w=0.42 l=0.15
X3096 sky130_fd_sc_hd__dfrtp_1_7/a_651_413# sky130_fd_sc_hd__dfrtp_1_7/a_27_47# sky130_fd_sc_hd__dfrtp_1_7/a_543_47# VDPWR sky130_fd_pr__pfet_01v8_hvt ad=0.3402 pd=3.3 as=0.1449 ps=1.53 w=0.42 l=0.15
X3097 sky130_fd_sc_hd__dfrtp_1_7/a_1108_47# sky130_fd_sc_hd__dfrtp_1_7/a_193_47# sky130_fd_sc_hd__dfrtp_1_7/a_761_289# VGND sky130_fd_pr__special_nfet_01v8 ad=0 pd=0 as=0.1998 ps=1.97 w=0.36 l=0.15
X3098 VGND V3R301 sky130_fd_sc_hd__dfrtp_1_7/a_805_47# VGND sky130_fd_pr__nfet_01v8 ad=0 pd=0 as=0 ps=0 w=0.42 l=0.15
X3099 V3R034 sky130_fd_sc_hd__dfrtp_1_7/a_1283_21# VDPWR VDPWR sky130_fd_pr__pfet_01v8_hvt ad=0.26 pd=2.52 as=0 ps=0 w=1 l=0.15
X3100 VDPWR V3R082 sky130_fd_sc_hd__dfrtp_1_7/a_27_47# VDPWR sky130_fd_pr__pfet_01v8_hvt ad=0 pd=0 as=0.1664 ps=1.8 w=0.64 l=0.15
X3101 sky130_fd_sc_hd__dfrtp_1_7/a_448_47# V3R148 VDPWR VDPWR sky130_fd_pr__pfet_01v8_hvt ad=0.1302 pd=1.46 as=0 ps=0 w=0.42 l=0.15
X3102 sky130_fd_sc_hd__dfrtp_1_7/a_761_289# sky130_fd_sc_hd__dfrtp_1_7/a_543_47# VGND VGND sky130_fd_pr__nfet_01v8 ad=0 pd=0 as=0 ps=0 w=0.64 l=0.15
X3103 sky130_fd_sc_hd__dfrtp_1_7/a_193_47# sky130_fd_sc_hd__dfrtp_1_7/a_27_47# VGND VGND sky130_fd_pr__nfet_01v8 ad=0.1092 pd=1.36 as=0 ps=0 w=0.42 l=0.15
X3104 sky130_fd_sc_hd__dfrtp_1_7/a_1108_47# sky130_fd_sc_hd__dfrtp_1_7/a_27_47# sky130_fd_sc_hd__dfrtp_1_7/a_761_289# VDPWR sky130_fd_pr__pfet_01v8_hvt ad=0.1176 pd=1.4 as=0.2583 ps=2.37 w=0.42 l=0.15
X3105 sky130_fd_sc_hd__dfrtp_1_7/a_1462_47# V3R301 VGND VGND sky130_fd_pr__nfet_01v8 ad=0 pd=0 as=0 ps=0 w=0.42 l=0.15
X3106 sky130_fd_sc_hd__dfrtp_1_7/a_543_47# sky130_fd_sc_hd__dfrtp_1_7/a_27_47# sky130_fd_sc_hd__dfrtp_1_7/a_448_47# VGND sky130_fd_pr__special_nfet_01v8 ad=0.1188 pd=1.38 as=0.132 ps=1.49 w=0.36 l=0.15
X3107 sky130_fd_sc_hd__dfrtp_1_7/a_543_47# sky130_fd_sc_hd__dfrtp_1_7/a_193_47# sky130_fd_sc_hd__dfrtp_1_7/a_448_47# VDPWR sky130_fd_pr__pfet_01v8_hvt ad=0 pd=0 as=0 ps=0 w=0.42 l=0.15
X3108 sky130_fd_sc_hd__dfrtp_1_7/a_448_47# V3R148 VGND VGND sky130_fd_pr__nfet_01v8 ad=0 pd=0 as=0 ps=0 w=0.42 l=0.15
X3109 VDPWR sky130_fd_sc_hd__dfrtp_1_7/a_1283_21# sky130_fd_sc_hd__dfrtp_1_7/a_1270_413# VDPWR sky130_fd_pr__pfet_01v8_hvt ad=0 pd=0 as=0.1134 ps=1.38 w=0.42 l=0.15
X3110 VDPWR sky130_fd_sc_hd__dfrtp_1_7/a_1108_47# sky130_fd_sc_hd__dfrtp_1_7/a_1283_21# VDPWR sky130_fd_pr__pfet_01v8_hvt ad=0 pd=0 as=0.1134 ps=1.38 w=0.42 l=0.15
X3111 sky130_fd_sc_hd__dfrtp_1_7/a_1270_413# sky130_fd_sc_hd__dfrtp_1_7/a_193_47# sky130_fd_sc_hd__dfrtp_1_7/a_1108_47# VDPWR sky130_fd_pr__pfet_01v8_hvt ad=0 pd=0 as=0 ps=0 w=0.42 l=0.15
X3112 sky130_fd_sc_hd__dfrtp_1_7/a_193_47# sky130_fd_sc_hd__dfrtp_1_7/a_27_47# VDPWR VDPWR sky130_fd_pr__pfet_01v8_hvt ad=0.1664 pd=1.8 as=0 ps=0 w=0.64 l=0.15
X3113 sky130_fd_sc_hd__dfrtp_1_7/a_1283_21# V3R301 VDPWR VDPWR sky130_fd_pr__pfet_01v8_hvt ad=0 pd=0 as=0 ps=0 w=0.42 l=0.15
X3114 VDPWR sky130_fd_sc_hd__dfrtp_1_7/a_761_289# sky130_fd_sc_hd__dfrtp_1_7/a_651_413# VDPWR sky130_fd_pr__pfet_01v8_hvt ad=0 pd=0 as=0 ps=0 w=0.42 l=0.15
X3115 V3R034 sky130_fd_sc_hd__dfrtp_1_7/a_1283_21# VGND VGND sky130_fd_pr__nfet_01v8 ad=0.169 pd=1.82 as=0 ps=0 w=0.65 l=0.15
X3116 sky130_fd_sc_hd__dfrtp_1_7/a_639_47# sky130_fd_sc_hd__dfrtp_1_7/a_193_47# sky130_fd_sc_hd__dfrtp_1_7/a_543_47# VGND sky130_fd_pr__special_nfet_01v8 ad=0 pd=0 as=0 ps=0 w=0.36 l=0.15
X3117 VGND sky130_fd_sc_hd__dfrtp_1_7/a_1283_21# sky130_fd_sc_hd__dfrtp_1_7/a_1217_47# VGND sky130_fd_pr__nfet_01v8 ad=0 pd=0 as=0 ps=0 w=0.42 l=0.15
X3118 sky130_fd_sc_hd__dfrtp_1_7/a_651_413# V3R301 VDPWR VDPWR sky130_fd_pr__pfet_01v8_hvt ad=0 pd=0 as=0 ps=0 w=0.42 l=0.15
X3119 VGND V3R082 sky130_fd_sc_hd__dfrtp_1_7/a_27_47# VGND sky130_fd_pr__nfet_01v8 ad=0 pd=0 as=0.1092 ps=1.36 w=0.42 l=0.15
X3120 sky130_fd_sc_hd__dfrtp_1_7/a_761_289# sky130_fd_sc_hd__dfrtp_1_7/a_543_47# VDPWR VDPWR sky130_fd_pr__pfet_01v8_hvt ad=0 pd=0 as=0 ps=0 w=0.84 l=0.15
X3121 VDPWR sky130_fd_sc_hd__mux2_1_92/a_505_21# sky130_fd_sc_hd__mux2_1_92/a_535_374# VDPWR sky130_fd_pr__pfet_01v8_hvt ad=0 pd=0 as=0.0882 ps=1.26 w=0.42 l=0.15
X3122 sky130_fd_sc_hd__mux2_1_92/a_505_21# V3R061 VDPWR VDPWR sky130_fd_pr__pfet_01v8_hvt ad=0.1176 pd=1.4 as=0 ps=0 w=0.42 l=0.15
X3123 sky130_fd_sc_hd__mux2_1_92/a_218_374# V3R061 VDPWR VDPWR sky130_fd_pr__pfet_01v8_hvt ad=0.1533 pd=1.57 as=0 ps=0 w=0.42 l=0.15
X3124 VGND sky130_fd_sc_hd__mux2_1_92/a_505_21# sky130_fd_sc_hd__mux2_1_92/a_439_47# VGND sky130_fd_pr__nfet_01v8 ad=0 pd=0 as=0.1386 ps=1.5 w=0.42 l=0.15
X3125 sky130_fd_sc_hd__mux2_1_92/a_76_199# V3R178 sky130_fd_sc_hd__mux2_1_92/a_218_374# VDPWR sky130_fd_pr__pfet_01v8_hvt ad=0.3864 pd=2.68 as=0 ps=0 w=0.42 l=0.15
X3126 sky130_fd_sc_hd__mux2_1_92/a_505_21# V3R061 VGND VGND sky130_fd_pr__nfet_01v8 ad=0.1092 pd=1.36 as=0 ps=0 w=0.42 l=0.15
X3127 sky130_fd_sc_hd__mux2_1_92/a_439_47# V3R178 sky130_fd_sc_hd__mux2_1_92/a_76_199# VGND sky130_fd_pr__nfet_01v8 ad=0 pd=0 as=0.1995 ps=1.79 w=0.42 l=0.15
X3128 sky130_fd_sc_hd__mux2_1_92/a_535_374# V3R177 sky130_fd_sc_hd__mux2_1_92/a_76_199# VDPWR sky130_fd_pr__pfet_01v8_hvt ad=0 pd=0 as=0 ps=0 w=0.42 l=0.15
X3129 sky130_fd_sc_hd__mux2_1_92/a_76_199# V3R177 sky130_fd_sc_hd__mux2_1_92/a_218_47# VGND sky130_fd_pr__nfet_01v8 ad=0 pd=0 as=0.1386 ps=1.5 w=0.42 l=0.15
X3130 sky130_fd_sc_hd__mux2_1_92/a_218_47# V3R061 VGND VGND sky130_fd_pr__nfet_01v8 ad=0 pd=0 as=0 ps=0 w=0.42 l=0.15
X3131 VDPWR sky130_fd_sc_hd__mux2_1_92/a_76_199# V3R091 VDPWR sky130_fd_pr__pfet_01v8_hvt ad=0 pd=0 as=0.26 ps=2.52 w=1 l=0.15
X3132 VGND sky130_fd_sc_hd__mux2_1_92/a_76_199# V3R091 VGND sky130_fd_pr__nfet_01v8 ad=0 pd=0 as=0.169 ps=1.82 w=0.65 l=0.15
X3133 VDPWR sky130_fd_sc_hd__mux2_1_81/a_505_21# sky130_fd_sc_hd__mux2_1_81/a_535_374# VDPWR sky130_fd_pr__pfet_01v8_hvt ad=0 pd=0 as=0.0882 ps=1.26 w=0.42 l=0.15
X3134 sky130_fd_sc_hd__mux2_1_81/a_505_21# V3R044 VDPWR VDPWR sky130_fd_pr__pfet_01v8_hvt ad=0.1176 pd=1.4 as=0 ps=0 w=0.42 l=0.15
X3135 sky130_fd_sc_hd__mux2_1_81/a_218_374# V3R044 VDPWR VDPWR sky130_fd_pr__pfet_01v8_hvt ad=0.1533 pd=1.57 as=0 ps=0 w=0.42 l=0.15
X3136 VGND sky130_fd_sc_hd__mux2_1_81/a_505_21# sky130_fd_sc_hd__mux2_1_81/a_439_47# VGND sky130_fd_pr__nfet_01v8 ad=0 pd=0 as=0.1386 ps=1.5 w=0.42 l=0.15
X3137 sky130_fd_sc_hd__mux2_1_81/a_76_199# V3R042 sky130_fd_sc_hd__mux2_1_81/a_218_374# VDPWR sky130_fd_pr__pfet_01v8_hvt ad=0.3864 pd=2.68 as=0 ps=0 w=0.42 l=0.15
X3138 sky130_fd_sc_hd__mux2_1_81/a_505_21# V3R044 VGND VGND sky130_fd_pr__nfet_01v8 ad=0.1092 pd=1.36 as=0 ps=0 w=0.42 l=0.15
X3139 sky130_fd_sc_hd__mux2_1_81/a_439_47# V3R042 sky130_fd_sc_hd__mux2_1_81/a_76_199# VGND sky130_fd_pr__nfet_01v8 ad=0 pd=0 as=0.1995 ps=1.79 w=0.42 l=0.15
X3140 sky130_fd_sc_hd__mux2_1_81/a_535_374# V3R181 sky130_fd_sc_hd__mux2_1_81/a_76_199# VDPWR sky130_fd_pr__pfet_01v8_hvt ad=0 pd=0 as=0 ps=0 w=0.42 l=0.15
X3141 sky130_fd_sc_hd__mux2_1_81/a_76_199# V3R181 sky130_fd_sc_hd__mux2_1_81/a_218_47# VGND sky130_fd_pr__nfet_01v8 ad=0 pd=0 as=0.1386 ps=1.5 w=0.42 l=0.15
X3142 sky130_fd_sc_hd__mux2_1_81/a_218_47# V3R044 VGND VGND sky130_fd_pr__nfet_01v8 ad=0 pd=0 as=0 ps=0 w=0.42 l=0.15
X3143 VDPWR sky130_fd_sc_hd__mux2_1_81/a_76_199# V3R127 VDPWR sky130_fd_pr__pfet_01v8_hvt ad=0 pd=0 as=0.26 ps=2.52 w=1 l=0.15
X3144 VGND sky130_fd_sc_hd__mux2_1_81/a_76_199# V3R127 VGND sky130_fd_pr__nfet_01v8 ad=0 pd=0 as=0.169 ps=1.82 w=0.65 l=0.15
X3145 VDPWR sky130_fd_sc_hd__mux2_1_70/a_505_21# sky130_fd_sc_hd__mux2_1_70/a_535_374# VDPWR sky130_fd_pr__pfet_01v8_hvt ad=0 pd=0 as=0.0882 ps=1.26 w=0.42 l=0.15
X3146 sky130_fd_sc_hd__mux2_1_70/a_505_21# V3R061 VDPWR VDPWR sky130_fd_pr__pfet_01v8_hvt ad=0.1176 pd=1.4 as=0 ps=0 w=0.42 l=0.15
X3147 sky130_fd_sc_hd__mux2_1_70/a_218_374# V3R061 VDPWR VDPWR sky130_fd_pr__pfet_01v8_hvt ad=0.1533 pd=1.57 as=0 ps=0 w=0.42 l=0.15
X3148 VGND sky130_fd_sc_hd__mux2_1_70/a_505_21# sky130_fd_sc_hd__mux2_1_70/a_439_47# VGND sky130_fd_pr__nfet_01v8 ad=0 pd=0 as=0.1386 ps=1.5 w=0.42 l=0.15
X3149 sky130_fd_sc_hd__mux2_1_70/a_76_199# V3R153 sky130_fd_sc_hd__mux2_1_70/a_218_374# VDPWR sky130_fd_pr__pfet_01v8_hvt ad=0.3864 pd=2.68 as=0 ps=0 w=0.42 l=0.15
X3150 sky130_fd_sc_hd__mux2_1_70/a_505_21# V3R061 VGND VGND sky130_fd_pr__nfet_01v8 ad=0.1092 pd=1.36 as=0 ps=0 w=0.42 l=0.15
X3151 sky130_fd_sc_hd__mux2_1_70/a_439_47# V3R153 sky130_fd_sc_hd__mux2_1_70/a_76_199# VGND sky130_fd_pr__nfet_01v8 ad=0 pd=0 as=0.1995 ps=1.79 w=0.42 l=0.15
X3152 sky130_fd_sc_hd__mux2_1_70/a_535_374# V3R152 sky130_fd_sc_hd__mux2_1_70/a_76_199# VDPWR sky130_fd_pr__pfet_01v8_hvt ad=0 pd=0 as=0 ps=0 w=0.42 l=0.15
X3153 sky130_fd_sc_hd__mux2_1_70/a_76_199# V3R152 sky130_fd_sc_hd__mux2_1_70/a_218_47# VGND sky130_fd_pr__nfet_01v8 ad=0 pd=0 as=0.1386 ps=1.5 w=0.42 l=0.15
X3154 sky130_fd_sc_hd__mux2_1_70/a_218_47# V3R061 VGND VGND sky130_fd_pr__nfet_01v8 ad=0 pd=0 as=0 ps=0 w=0.42 l=0.15
X3155 VDPWR sky130_fd_sc_hd__mux2_1_70/a_76_199# V3R097 VDPWR sky130_fd_pr__pfet_01v8_hvt ad=0 pd=0 as=0.26 ps=2.52 w=1 l=0.15
X3156 VGND sky130_fd_sc_hd__mux2_1_70/a_76_199# V3R097 VGND sky130_fd_pr__nfet_01v8 ad=0 pd=0 as=0.169 ps=1.82 w=0.65 l=0.15
X3157 VDPWR sky130_fd_sc_hd__buf_4_20/a_27_47# V3R057 VDPWR sky130_fd_pr__pfet_01v8_hvt ad=0 pd=0 as=0.54 ps=5.08 w=1 l=0.15
X3158 V3R057 sky130_fd_sc_hd__buf_4_20/a_27_47# VDPWR VDPWR sky130_fd_pr__pfet_01v8_hvt ad=0 pd=0 as=0 ps=0 w=1 l=0.15
X3159 VDPWR sky130_fd_sc_hd__buf_4_20/a_27_47# V3R057 VDPWR sky130_fd_pr__pfet_01v8_hvt ad=0 pd=0 as=0 ps=0 w=1 l=0.15
X3160 V3R057 sky130_fd_sc_hd__buf_4_20/a_27_47# VDPWR VDPWR sky130_fd_pr__pfet_01v8_hvt ad=0 pd=0 as=0 ps=0 w=1 l=0.15
X3161 V3R057 sky130_fd_sc_hd__buf_4_20/a_27_47# VGND VGND sky130_fd_pr__nfet_01v8 ad=0.351 pd=3.68 as=0 ps=0 w=0.65 l=0.15
X3162 V3R057 sky130_fd_sc_hd__buf_4_20/a_27_47# VGND VGND sky130_fd_pr__nfet_01v8 ad=0 pd=0 as=0 ps=0 w=0.65 l=0.15
X3163 VGND sky130_fd_sc_hd__buf_4_20/a_27_47# V3R057 VGND sky130_fd_pr__nfet_01v8 ad=0 pd=0 as=0 ps=0 w=0.65 l=0.15
X3164 VGND sky130_fd_sc_hd__buf_4_20/a_27_47# V3R057 VGND sky130_fd_pr__nfet_01v8 ad=0 pd=0 as=0 ps=0 w=0.65 l=0.15
X3165 VDPWR V3R054 sky130_fd_sc_hd__buf_4_20/a_27_47# VDPWR sky130_fd_pr__pfet_01v8_hvt ad=0 pd=0 as=0.26 ps=2.52 w=1 l=0.15
X3166 VGND V3R054 sky130_fd_sc_hd__buf_4_20/a_27_47# VGND sky130_fd_pr__nfet_01v8 ad=0 pd=0 as=0.169 ps=1.82 w=0.65 l=0.15
X3167 VGND V3R281 sky130_fd_sc_hd__or2_1_0/a_68_297# VGND sky130_fd_pr__nfet_01v8 ad=0.10025 pd=0.985 as=0.0567 ps=0.69 w=0.42 l=0.15
X3168 sky130_fd_sc_hd__or2_1_0/a_68_297# V3R280 VGND VGND sky130_fd_pr__nfet_01v8 ad=0.0567 pd=0.69 as=0.1092 ps=1.36 w=0.42 l=0.15
X3169 V3R282 sky130_fd_sc_hd__or2_1_0/a_68_297# VGND VGND sky130_fd_pr__nfet_01v8 ad=0.169 pd=1.82 as=0.10025 ps=0.985 w=0.65 l=0.15
X3170 VDPWR V3R281 sky130_fd_sc_hd__or2_1_0/a_150_297# VDPWR sky130_fd_pr__pfet_01v8_hvt ad=0.14575 pd=1.335 as=0.0441 ps=0.63 w=0.42 l=0.15
X3171 V3R282 sky130_fd_sc_hd__or2_1_0/a_68_297# VDPWR VDPWR sky130_fd_pr__pfet_01v8_hvt ad=0.34 pd=2.68 as=0.14575 ps=1.335 w=1 l=0.15
X3172 sky130_fd_sc_hd__or2_1_0/a_150_297# V3R280 sky130_fd_sc_hd__or2_1_0/a_68_297# VDPWR sky130_fd_pr__pfet_01v8_hvt ad=0.0441 pd=0.63 as=0.1092 ps=1.36 w=0.42 l=0.15
X3173 VDPWR sky130_fd_sc_hd__buf_4_2/a_27_47# V3R082 VDPWR sky130_fd_pr__pfet_01v8_hvt ad=0 pd=0 as=0.54 ps=5.08 w=1 l=0.15
X3174 V3R082 sky130_fd_sc_hd__buf_4_2/a_27_47# VDPWR VDPWR sky130_fd_pr__pfet_01v8_hvt ad=0 pd=0 as=0 ps=0 w=1 l=0.15
X3175 VDPWR sky130_fd_sc_hd__buf_4_2/a_27_47# V3R082 VDPWR sky130_fd_pr__pfet_01v8_hvt ad=0 pd=0 as=0 ps=0 w=1 l=0.15
X3176 V3R082 sky130_fd_sc_hd__buf_4_2/a_27_47# VDPWR VDPWR sky130_fd_pr__pfet_01v8_hvt ad=0 pd=0 as=0 ps=0 w=1 l=0.15
X3177 V3R082 sky130_fd_sc_hd__buf_4_2/a_27_47# VGND VGND sky130_fd_pr__nfet_01v8 ad=0.351 pd=3.68 as=0 ps=0 w=0.65 l=0.15
X3178 V3R082 sky130_fd_sc_hd__buf_4_2/a_27_47# VGND VGND sky130_fd_pr__nfet_01v8 ad=0 pd=0 as=0 ps=0 w=0.65 l=0.15
X3179 VGND sky130_fd_sc_hd__buf_4_2/a_27_47# V3R082 VGND sky130_fd_pr__nfet_01v8 ad=0 pd=0 as=0 ps=0 w=0.65 l=0.15
X3180 VGND sky130_fd_sc_hd__buf_4_2/a_27_47# V3R082 VGND sky130_fd_pr__nfet_01v8 ad=0 pd=0 as=0 ps=0 w=0.65 l=0.15
X3181 VDPWR V3R080 sky130_fd_sc_hd__buf_4_2/a_27_47# VDPWR sky130_fd_pr__pfet_01v8_hvt ad=0 pd=0 as=0.26 ps=2.52 w=1 l=0.15
X3182 VGND V3R080 sky130_fd_sc_hd__buf_4_2/a_27_47# VGND sky130_fd_pr__nfet_01v8 ad=0 pd=0 as=0.169 ps=1.82 w=0.65 l=0.15
X3183 sky130_fd_sc_hd__or2b_1_3/a_219_297# sky130_fd_sc_hd__or2b_1_3/a_27_53# VGND VGND sky130_fd_pr__nfet_01v8 ad=0.1134 pd=1.38 as=0 ps=0 w=0.42 l=0.15
X3184 VGND V3R008 sky130_fd_sc_hd__or2b_1_3/a_27_53# VGND sky130_fd_pr__nfet_01v8 ad=0 pd=0 as=0.1092 ps=1.36 w=0.42 l=0.15
X3185 VDPWR V3R036 sky130_fd_sc_hd__or2b_1_3/a_301_297# VDPWR sky130_fd_pr__pfet_01v8_hvt ad=0 pd=0 as=0.0882 ps=1.26 w=0.42 l=0.15
X3186 V3R231 sky130_fd_sc_hd__or2b_1_3/a_219_297# VGND VGND sky130_fd_pr__nfet_01v8 ad=0.1755 pd=1.84 as=0 ps=0 w=0.65 l=0.15
X3187 sky130_fd_sc_hd__or2b_1_3/a_301_297# sky130_fd_sc_hd__or2b_1_3/a_27_53# sky130_fd_sc_hd__or2b_1_3/a_219_297# VDPWR sky130_fd_pr__pfet_01v8_hvt ad=0 pd=0 as=0.1092 ps=1.36 w=0.42 l=0.15
X3188 V3R231 sky130_fd_sc_hd__or2b_1_3/a_219_297# VDPWR VDPWR sky130_fd_pr__pfet_01v8_hvt ad=0.27 pd=2.54 as=0 ps=0 w=1 l=0.15
X3189 sky130_fd_sc_hd__or2b_1_3/a_27_53# V3R008 VDPWR VDPWR sky130_fd_pr__pfet_01v8_hvt ad=0.1176 pd=1.4 as=0 ps=0 w=0.42 l=0.15
X3190 VGND V3R036 sky130_fd_sc_hd__or2b_1_3/a_219_297# VGND sky130_fd_pr__nfet_01v8 ad=0 pd=0 as=0 ps=0 w=0.42 l=0.15
X3191 VDPWR V3R008 sky130_fd_sc_hd__and2_1_5/a_59_75# VDPWR sky130_fd_pr__pfet_01v8_hvt ad=0 pd=0 as=0.1134 ps=1.38 w=0.42 l=0.15
X3192 V3R235 sky130_fd_sc_hd__and2_1_5/a_59_75# VDPWR VDPWR sky130_fd_pr__pfet_01v8_hvt ad=0.475 pd=2.95 as=0 ps=0 w=1 l=0.15
X3193 VGND V3R008 sky130_fd_sc_hd__and2_1_5/a_145_75# VGND sky130_fd_pr__nfet_01v8 ad=0 pd=0 as=0.1134 ps=1.38 w=0.42 l=0.15
X3194 sky130_fd_sc_hd__and2_1_5/a_59_75# V3R040 VDPWR VDPWR sky130_fd_pr__pfet_01v8_hvt ad=0 pd=0 as=0 ps=0 w=0.42 l=0.15
X3195 V3R235 sky130_fd_sc_hd__and2_1_5/a_59_75# VGND VGND sky130_fd_pr__nfet_01v8 ad=0.182 pd=1.86 as=0 ps=0 w=0.65 l=0.15
X3196 sky130_fd_sc_hd__and2_1_5/a_145_75# V3R040 sky130_fd_sc_hd__and2_1_5/a_59_75# VGND sky130_fd_pr__nfet_01v8 ad=0 pd=0 as=0.1176 ps=1.4 w=0.42 l=0.15
X3197 sky130_fd_sc_hd__dfrtp_1_8/a_805_47# sky130_fd_sc_hd__dfrtp_1_8/a_761_289# sky130_fd_sc_hd__dfrtp_1_8/a_639_47# VGND sky130_fd_pr__nfet_01v8 ad=0.0882 pd=1.26 as=0.2802 ps=2.2 w=0.42 l=0.15
X3198 sky130_fd_sc_hd__dfrtp_1_8/a_1217_47# sky130_fd_sc_hd__dfrtp_1_8/a_27_47# sky130_fd_sc_hd__dfrtp_1_8/a_1108_47# VGND sky130_fd_pr__special_nfet_01v8 ad=0.1338 pd=1.5 as=0.1422 ps=1.51 w=0.36 l=0.15
X3199 sky130_fd_sc_hd__dfrtp_1_8/a_1283_21# sky130_fd_sc_hd__dfrtp_1_8/a_1108_47# sky130_fd_sc_hd__dfrtp_1_8/a_1462_47# VGND sky130_fd_pr__nfet_01v8 ad=0.1092 pd=1.36 as=0.1281 ps=1.45 w=0.42 l=0.15
X3200 sky130_fd_sc_hd__dfrtp_1_8/a_651_413# sky130_fd_sc_hd__dfrtp_1_8/a_27_47# sky130_fd_sc_hd__dfrtp_1_8/a_543_47# VDPWR sky130_fd_pr__pfet_01v8_hvt ad=0.3402 pd=3.3 as=0.1449 ps=1.53 w=0.42 l=0.15
X3201 sky130_fd_sc_hd__dfrtp_1_8/a_1108_47# sky130_fd_sc_hd__dfrtp_1_8/a_193_47# sky130_fd_sc_hd__dfrtp_1_8/a_761_289# VGND sky130_fd_pr__special_nfet_01v8 ad=0 pd=0 as=0.1998 ps=1.97 w=0.36 l=0.15
X3202 VGND V3R303 sky130_fd_sc_hd__dfrtp_1_8/a_805_47# VGND sky130_fd_pr__nfet_01v8 ad=0 pd=0 as=0 ps=0 w=0.42 l=0.15
X3203 V3R051 sky130_fd_sc_hd__dfrtp_1_8/a_1283_21# VDPWR VDPWR sky130_fd_pr__pfet_01v8_hvt ad=0.26 pd=2.52 as=0 ps=0 w=1 l=0.15
X3204 VDPWR V3R084 sky130_fd_sc_hd__dfrtp_1_8/a_27_47# VDPWR sky130_fd_pr__pfet_01v8_hvt ad=0 pd=0 as=0.1664 ps=1.8 w=0.64 l=0.15
X3205 sky130_fd_sc_hd__dfrtp_1_8/a_448_47# V3R196 VDPWR VDPWR sky130_fd_pr__pfet_01v8_hvt ad=0.1302 pd=1.46 as=0 ps=0 w=0.42 l=0.15
X3206 sky130_fd_sc_hd__dfrtp_1_8/a_761_289# sky130_fd_sc_hd__dfrtp_1_8/a_543_47# VGND VGND sky130_fd_pr__nfet_01v8 ad=0 pd=0 as=0 ps=0 w=0.64 l=0.15
X3207 sky130_fd_sc_hd__dfrtp_1_8/a_193_47# sky130_fd_sc_hd__dfrtp_1_8/a_27_47# VGND VGND sky130_fd_pr__nfet_01v8 ad=0.1092 pd=1.36 as=0 ps=0 w=0.42 l=0.15
X3208 sky130_fd_sc_hd__dfrtp_1_8/a_1108_47# sky130_fd_sc_hd__dfrtp_1_8/a_27_47# sky130_fd_sc_hd__dfrtp_1_8/a_761_289# VDPWR sky130_fd_pr__pfet_01v8_hvt ad=0.1176 pd=1.4 as=0.2583 ps=2.37 w=0.42 l=0.15
X3209 sky130_fd_sc_hd__dfrtp_1_8/a_1462_47# V3R303 VGND VGND sky130_fd_pr__nfet_01v8 ad=0 pd=0 as=0 ps=0 w=0.42 l=0.15
X3210 sky130_fd_sc_hd__dfrtp_1_8/a_543_47# sky130_fd_sc_hd__dfrtp_1_8/a_27_47# sky130_fd_sc_hd__dfrtp_1_8/a_448_47# VGND sky130_fd_pr__special_nfet_01v8 ad=0.1188 pd=1.38 as=0.132 ps=1.49 w=0.36 l=0.15
X3211 sky130_fd_sc_hd__dfrtp_1_8/a_543_47# sky130_fd_sc_hd__dfrtp_1_8/a_193_47# sky130_fd_sc_hd__dfrtp_1_8/a_448_47# VDPWR sky130_fd_pr__pfet_01v8_hvt ad=0 pd=0 as=0 ps=0 w=0.42 l=0.15
X3212 sky130_fd_sc_hd__dfrtp_1_8/a_448_47# V3R196 VGND VGND sky130_fd_pr__nfet_01v8 ad=0 pd=0 as=0 ps=0 w=0.42 l=0.15
X3213 VDPWR sky130_fd_sc_hd__dfrtp_1_8/a_1283_21# sky130_fd_sc_hd__dfrtp_1_8/a_1270_413# VDPWR sky130_fd_pr__pfet_01v8_hvt ad=0 pd=0 as=0.1134 ps=1.38 w=0.42 l=0.15
X3214 VDPWR sky130_fd_sc_hd__dfrtp_1_8/a_1108_47# sky130_fd_sc_hd__dfrtp_1_8/a_1283_21# VDPWR sky130_fd_pr__pfet_01v8_hvt ad=0 pd=0 as=0.1134 ps=1.38 w=0.42 l=0.15
X3215 sky130_fd_sc_hd__dfrtp_1_8/a_1270_413# sky130_fd_sc_hd__dfrtp_1_8/a_193_47# sky130_fd_sc_hd__dfrtp_1_8/a_1108_47# VDPWR sky130_fd_pr__pfet_01v8_hvt ad=0 pd=0 as=0 ps=0 w=0.42 l=0.15
X3216 sky130_fd_sc_hd__dfrtp_1_8/a_193_47# sky130_fd_sc_hd__dfrtp_1_8/a_27_47# VDPWR VDPWR sky130_fd_pr__pfet_01v8_hvt ad=0.1664 pd=1.8 as=0 ps=0 w=0.64 l=0.15
X3217 sky130_fd_sc_hd__dfrtp_1_8/a_1283_21# V3R303 VDPWR VDPWR sky130_fd_pr__pfet_01v8_hvt ad=0 pd=0 as=0 ps=0 w=0.42 l=0.15
X3218 VDPWR sky130_fd_sc_hd__dfrtp_1_8/a_761_289# sky130_fd_sc_hd__dfrtp_1_8/a_651_413# VDPWR sky130_fd_pr__pfet_01v8_hvt ad=0 pd=0 as=0 ps=0 w=0.42 l=0.15
X3219 V3R051 sky130_fd_sc_hd__dfrtp_1_8/a_1283_21# VGND VGND sky130_fd_pr__nfet_01v8 ad=0.169 pd=1.82 as=0 ps=0 w=0.65 l=0.15
X3220 sky130_fd_sc_hd__dfrtp_1_8/a_639_47# sky130_fd_sc_hd__dfrtp_1_8/a_193_47# sky130_fd_sc_hd__dfrtp_1_8/a_543_47# VGND sky130_fd_pr__special_nfet_01v8 ad=0 pd=0 as=0 ps=0 w=0.36 l=0.15
X3221 VGND sky130_fd_sc_hd__dfrtp_1_8/a_1283_21# sky130_fd_sc_hd__dfrtp_1_8/a_1217_47# VGND sky130_fd_pr__nfet_01v8 ad=0 pd=0 as=0 ps=0 w=0.42 l=0.15
X3222 sky130_fd_sc_hd__dfrtp_1_8/a_651_413# V3R303 VDPWR VDPWR sky130_fd_pr__pfet_01v8_hvt ad=0 pd=0 as=0 ps=0 w=0.42 l=0.15
X3223 VGND V3R084 sky130_fd_sc_hd__dfrtp_1_8/a_27_47# VGND sky130_fd_pr__nfet_01v8 ad=0 pd=0 as=0.1092 ps=1.36 w=0.42 l=0.15
X3224 sky130_fd_sc_hd__dfrtp_1_8/a_761_289# sky130_fd_sc_hd__dfrtp_1_8/a_543_47# VDPWR VDPWR sky130_fd_pr__pfet_01v8_hvt ad=0 pd=0 as=0 ps=0 w=0.84 l=0.15
X3225 VDPWR sky130_fd_sc_hd__mux2_1_93/a_505_21# sky130_fd_sc_hd__mux2_1_93/a_535_374# VDPWR sky130_fd_pr__pfet_01v8_hvt ad=0 pd=0 as=0.0882 ps=1.26 w=0.42 l=0.15
X3226 sky130_fd_sc_hd__mux2_1_93/a_505_21# V3R044 VDPWR VDPWR sky130_fd_pr__pfet_01v8_hvt ad=0.1176 pd=1.4 as=0 ps=0 w=0.42 l=0.15
X3227 sky130_fd_sc_hd__mux2_1_93/a_218_374# V3R044 VDPWR VDPWR sky130_fd_pr__pfet_01v8_hvt ad=0.1533 pd=1.57 as=0 ps=0 w=0.42 l=0.15
X3228 VGND sky130_fd_sc_hd__mux2_1_93/a_505_21# sky130_fd_sc_hd__mux2_1_93/a_439_47# VGND sky130_fd_pr__nfet_01v8 ad=0 pd=0 as=0.1386 ps=1.5 w=0.42 l=0.15
X3229 sky130_fd_sc_hd__mux2_1_93/a_76_199# V3R038 sky130_fd_sc_hd__mux2_1_93/a_218_374# VDPWR sky130_fd_pr__pfet_01v8_hvt ad=0.3864 pd=2.68 as=0 ps=0 w=0.42 l=0.15
X3230 sky130_fd_sc_hd__mux2_1_93/a_505_21# V3R044 VGND VGND sky130_fd_pr__nfet_01v8 ad=0.1092 pd=1.36 as=0 ps=0 w=0.42 l=0.15
X3231 sky130_fd_sc_hd__mux2_1_93/a_439_47# V3R038 sky130_fd_sc_hd__mux2_1_93/a_76_199# VGND sky130_fd_pr__nfet_01v8 ad=0 pd=0 as=0.1995 ps=1.79 w=0.42 l=0.15
X3232 sky130_fd_sc_hd__mux2_1_93/a_535_374# V3R177 sky130_fd_sc_hd__mux2_1_93/a_76_199# VDPWR sky130_fd_pr__pfet_01v8_hvt ad=0 pd=0 as=0 ps=0 w=0.42 l=0.15
X3233 sky130_fd_sc_hd__mux2_1_93/a_76_199# V3R177 sky130_fd_sc_hd__mux2_1_93/a_218_47# VGND sky130_fd_pr__nfet_01v8 ad=0 pd=0 as=0.1386 ps=1.5 w=0.42 l=0.15
X3234 sky130_fd_sc_hd__mux2_1_93/a_218_47# V3R044 VGND VGND sky130_fd_pr__nfet_01v8 ad=0 pd=0 as=0 ps=0 w=0.42 l=0.15
X3235 VDPWR sky130_fd_sc_hd__mux2_1_93/a_76_199# V3R123 VDPWR sky130_fd_pr__pfet_01v8_hvt ad=0 pd=0 as=0.26 ps=2.52 w=1 l=0.15
X3236 VGND sky130_fd_sc_hd__mux2_1_93/a_76_199# V3R123 VGND sky130_fd_pr__nfet_01v8 ad=0 pd=0 as=0.169 ps=1.82 w=0.65 l=0.15
X3237 VDPWR sky130_fd_sc_hd__mux2_1_82/a_505_21# sky130_fd_sc_hd__mux2_1_82/a_535_374# VDPWR sky130_fd_pr__pfet_01v8_hvt ad=0 pd=0 as=0.0882 ps=1.26 w=0.42 l=0.15
X3238 sky130_fd_sc_hd__mux2_1_82/a_505_21# V3R241 VDPWR VDPWR sky130_fd_pr__pfet_01v8_hvt ad=0.1176 pd=1.4 as=0 ps=0 w=0.42 l=0.15
X3239 sky130_fd_sc_hd__mux2_1_82/a_218_374# V3R241 VDPWR VDPWR sky130_fd_pr__pfet_01v8_hvt ad=0.1533 pd=1.57 as=0 ps=0 w=0.42 l=0.15
X3240 VGND sky130_fd_sc_hd__mux2_1_82/a_505_21# sky130_fd_sc_hd__mux2_1_82/a_439_47# VGND sky130_fd_pr__nfet_01v8 ad=0 pd=0 as=0.1386 ps=1.5 w=0.42 l=0.15
X3241 sky130_fd_sc_hd__mux2_1_82/a_76_199# V3R066 sky130_fd_sc_hd__mux2_1_82/a_218_374# VDPWR sky130_fd_pr__pfet_01v8_hvt ad=0.3864 pd=2.68 as=0 ps=0 w=0.42 l=0.15
X3242 sky130_fd_sc_hd__mux2_1_82/a_505_21# V3R241 VGND VGND sky130_fd_pr__nfet_01v8 ad=0.1092 pd=1.36 as=0 ps=0 w=0.42 l=0.15
X3243 sky130_fd_sc_hd__mux2_1_82/a_439_47# V3R066 sky130_fd_sc_hd__mux2_1_82/a_76_199# VGND sky130_fd_pr__nfet_01v8 ad=0 pd=0 as=0.1995 ps=1.79 w=0.42 l=0.15
X3244 sky130_fd_sc_hd__mux2_1_82/a_535_374# V3R067 sky130_fd_sc_hd__mux2_1_82/a_76_199# VDPWR sky130_fd_pr__pfet_01v8_hvt ad=0 pd=0 as=0 ps=0 w=0.42 l=0.15
X3245 sky130_fd_sc_hd__mux2_1_82/a_76_199# V3R067 sky130_fd_sc_hd__mux2_1_82/a_218_47# VGND sky130_fd_pr__nfet_01v8 ad=0 pd=0 as=0.1386 ps=1.5 w=0.42 l=0.15
X3246 sky130_fd_sc_hd__mux2_1_82/a_218_47# V3R241 VGND VGND sky130_fd_pr__nfet_01v8 ad=0 pd=0 as=0 ps=0 w=0.42 l=0.15
X3247 VDPWR sky130_fd_sc_hd__mux2_1_82/a_76_199# V3R191 VDPWR sky130_fd_pr__pfet_01v8_hvt ad=0 pd=0 as=0.26 ps=2.52 w=1 l=0.15
X3248 VGND sky130_fd_sc_hd__mux2_1_82/a_76_199# V3R191 VGND sky130_fd_pr__nfet_01v8 ad=0 pd=0 as=0.169 ps=1.82 w=0.65 l=0.15
X3249 VDPWR sky130_fd_sc_hd__mux2_1_71/a_505_21# sky130_fd_sc_hd__mux2_1_71/a_535_374# VDPWR sky130_fd_pr__pfet_01v8_hvt ad=0 pd=0 as=0.0882 ps=1.26 w=0.42 l=0.15
X3250 sky130_fd_sc_hd__mux2_1_71/a_505_21# V3R044 VDPWR VDPWR sky130_fd_pr__pfet_01v8_hvt ad=0.1176 pd=1.4 as=0 ps=0 w=0.42 l=0.15
X3251 sky130_fd_sc_hd__mux2_1_71/a_218_374# V3R044 VDPWR VDPWR sky130_fd_pr__pfet_01v8_hvt ad=0.1533 pd=1.57 as=0 ps=0 w=0.42 l=0.15
X3252 VGND sky130_fd_sc_hd__mux2_1_71/a_505_21# sky130_fd_sc_hd__mux2_1_71/a_439_47# VGND sky130_fd_pr__nfet_01v8 ad=0 pd=0 as=0.1386 ps=1.5 w=0.42 l=0.15
X3253 sky130_fd_sc_hd__mux2_1_71/a_76_199# V3R013 sky130_fd_sc_hd__mux2_1_71/a_218_374# VDPWR sky130_fd_pr__pfet_01v8_hvt ad=0.3864 pd=2.68 as=0 ps=0 w=0.42 l=0.15
X3254 sky130_fd_sc_hd__mux2_1_71/a_505_21# V3R044 VGND VGND sky130_fd_pr__nfet_01v8 ad=0.1092 pd=1.36 as=0 ps=0 w=0.42 l=0.15
X3255 sky130_fd_sc_hd__mux2_1_71/a_439_47# V3R013 sky130_fd_sc_hd__mux2_1_71/a_76_199# VGND sky130_fd_pr__nfet_01v8 ad=0 pd=0 as=0.1995 ps=1.79 w=0.42 l=0.15
X3256 sky130_fd_sc_hd__mux2_1_71/a_535_374# V3R152 sky130_fd_sc_hd__mux2_1_71/a_76_199# VDPWR sky130_fd_pr__pfet_01v8_hvt ad=0 pd=0 as=0 ps=0 w=0.42 l=0.15
X3257 sky130_fd_sc_hd__mux2_1_71/a_76_199# V3R152 sky130_fd_sc_hd__mux2_1_71/a_218_47# VGND sky130_fd_pr__nfet_01v8 ad=0 pd=0 as=0.1386 ps=1.5 w=0.42 l=0.15
X3258 sky130_fd_sc_hd__mux2_1_71/a_218_47# V3R044 VGND VGND sky130_fd_pr__nfet_01v8 ad=0 pd=0 as=0 ps=0 w=0.42 l=0.15
X3259 VDPWR sky130_fd_sc_hd__mux2_1_71/a_76_199# V3R129 VDPWR sky130_fd_pr__pfet_01v8_hvt ad=0 pd=0 as=0.26 ps=2.52 w=1 l=0.15
X3260 VGND sky130_fd_sc_hd__mux2_1_71/a_76_199# V3R129 VGND sky130_fd_pr__nfet_01v8 ad=0 pd=0 as=0.169 ps=1.82 w=0.65 l=0.15
X3261 VDPWR sky130_fd_sc_hd__mux2_1_60/a_505_21# sky130_fd_sc_hd__mux2_1_60/a_535_374# VDPWR sky130_fd_pr__pfet_01v8_hvt ad=0 pd=0 as=0.0882 ps=1.26 w=0.42 l=0.15
X3262 sky130_fd_sc_hd__mux2_1_60/a_505_21# V3R240 VDPWR VDPWR sky130_fd_pr__pfet_01v8_hvt ad=0.1176 pd=1.4 as=0 ps=0 w=0.42 l=0.15
X3263 sky130_fd_sc_hd__mux2_1_60/a_218_374# V3R240 VDPWR VDPWR sky130_fd_pr__pfet_01v8_hvt ad=0.1533 pd=1.57 as=0 ps=0 w=0.42 l=0.15
X3264 VGND sky130_fd_sc_hd__mux2_1_60/a_505_21# sky130_fd_sc_hd__mux2_1_60/a_439_47# VGND sky130_fd_pr__nfet_01v8 ad=0 pd=0 as=0.1386 ps=1.5 w=0.42 l=0.15
X3265 sky130_fd_sc_hd__mux2_1_60/a_76_199# V3R004 sky130_fd_sc_hd__mux2_1_60/a_218_374# VDPWR sky130_fd_pr__pfet_01v8_hvt ad=0.3864 pd=2.68 as=0 ps=0 w=0.42 l=0.15
X3266 sky130_fd_sc_hd__mux2_1_60/a_505_21# V3R240 VGND VGND sky130_fd_pr__nfet_01v8 ad=0.1092 pd=1.36 as=0 ps=0 w=0.42 l=0.15
X3267 sky130_fd_sc_hd__mux2_1_60/a_439_47# V3R004 sky130_fd_sc_hd__mux2_1_60/a_76_199# VGND sky130_fd_pr__nfet_01v8 ad=0 pd=0 as=0.1995 ps=1.79 w=0.42 l=0.15
X3268 sky130_fd_sc_hd__mux2_1_60/a_535_374# V3R264 sky130_fd_sc_hd__mux2_1_60/a_76_199# VDPWR sky130_fd_pr__pfet_01v8_hvt ad=0 pd=0 as=0 ps=0 w=0.42 l=0.15
X3269 sky130_fd_sc_hd__mux2_1_60/a_76_199# V3R264 sky130_fd_sc_hd__mux2_1_60/a_218_47# VGND sky130_fd_pr__nfet_01v8 ad=0 pd=0 as=0.1386 ps=1.5 w=0.42 l=0.15
X3270 sky130_fd_sc_hd__mux2_1_60/a_218_47# V3R240 VGND VGND sky130_fd_pr__nfet_01v8 ad=0 pd=0 as=0 ps=0 w=0.42 l=0.15
X3271 VDPWR sky130_fd_sc_hd__mux2_1_60/a_76_199# V3R188 VDPWR sky130_fd_pr__pfet_01v8_hvt ad=0 pd=0 as=0.26 ps=2.52 w=1 l=0.15
X3272 VGND sky130_fd_sc_hd__mux2_1_60/a_76_199# V3R188 VGND sky130_fd_pr__nfet_01v8 ad=0 pd=0 as=0.169 ps=1.82 w=0.65 l=0.15
X3273 VDPWR sky130_fd_sc_hd__buf_4_10/a_27_47# V3R061 VDPWR sky130_fd_pr__pfet_01v8_hvt ad=0 pd=0 as=0.54 ps=5.08 w=1 l=0.15
X3274 V3R061 sky130_fd_sc_hd__buf_4_10/a_27_47# VDPWR VDPWR sky130_fd_pr__pfet_01v8_hvt ad=0 pd=0 as=0 ps=0 w=1 l=0.15
X3275 VDPWR sky130_fd_sc_hd__buf_4_10/a_27_47# V3R061 VDPWR sky130_fd_pr__pfet_01v8_hvt ad=0 pd=0 as=0 ps=0 w=1 l=0.15
X3276 V3R061 sky130_fd_sc_hd__buf_4_10/a_27_47# VDPWR VDPWR sky130_fd_pr__pfet_01v8_hvt ad=0 pd=0 as=0 ps=0 w=1 l=0.15
X3277 V3R061 sky130_fd_sc_hd__buf_4_10/a_27_47# VGND VGND sky130_fd_pr__nfet_01v8 ad=0.351 pd=3.68 as=0 ps=0 w=0.65 l=0.15
X3278 V3R061 sky130_fd_sc_hd__buf_4_10/a_27_47# VGND VGND sky130_fd_pr__nfet_01v8 ad=0 pd=0 as=0 ps=0 w=0.65 l=0.15
X3279 VGND sky130_fd_sc_hd__buf_4_10/a_27_47# V3R061 VGND sky130_fd_pr__nfet_01v8 ad=0 pd=0 as=0 ps=0 w=0.65 l=0.15
X3280 VGND sky130_fd_sc_hd__buf_4_10/a_27_47# V3R061 VGND sky130_fd_pr__nfet_01v8 ad=0 pd=0 as=0 ps=0 w=0.65 l=0.15
X3281 VDPWR V3R060 sky130_fd_sc_hd__buf_4_10/a_27_47# VDPWR sky130_fd_pr__pfet_01v8_hvt ad=0 pd=0 as=0.26 ps=2.52 w=1 l=0.15
X3282 VGND V3R060 sky130_fd_sc_hd__buf_4_10/a_27_47# VGND sky130_fd_pr__nfet_01v8 ad=0 pd=0 as=0.169 ps=1.82 w=0.65 l=0.15
X3283 VDPWR sky130_fd_sc_hd__buf_4_21/a_27_47# V3R008 VDPWR sky130_fd_pr__pfet_01v8_hvt ad=0 pd=0 as=0.54 ps=5.08 w=1 l=0.15
X3284 V3R008 sky130_fd_sc_hd__buf_4_21/a_27_47# VDPWR VDPWR sky130_fd_pr__pfet_01v8_hvt ad=0 pd=0 as=0 ps=0 w=1 l=0.15
X3285 VDPWR sky130_fd_sc_hd__buf_4_21/a_27_47# V3R008 VDPWR sky130_fd_pr__pfet_01v8_hvt ad=0 pd=0 as=0 ps=0 w=1 l=0.15
X3286 V3R008 sky130_fd_sc_hd__buf_4_21/a_27_47# VDPWR VDPWR sky130_fd_pr__pfet_01v8_hvt ad=0 pd=0 as=0 ps=0 w=1 l=0.15
X3287 V3R008 sky130_fd_sc_hd__buf_4_21/a_27_47# VGND VGND sky130_fd_pr__nfet_01v8 ad=0.351 pd=3.68 as=0 ps=0 w=0.65 l=0.15
X3288 V3R008 sky130_fd_sc_hd__buf_4_21/a_27_47# VGND VGND sky130_fd_pr__nfet_01v8 ad=0 pd=0 as=0 ps=0 w=0.65 l=0.15
X3289 VGND sky130_fd_sc_hd__buf_4_21/a_27_47# V3R008 VGND sky130_fd_pr__nfet_01v8 ad=0 pd=0 as=0 ps=0 w=0.65 l=0.15
X3290 VGND sky130_fd_sc_hd__buf_4_21/a_27_47# V3R008 VGND sky130_fd_pr__nfet_01v8 ad=0 pd=0 as=0 ps=0 w=0.65 l=0.15
X3291 VDPWR V3R007 sky130_fd_sc_hd__buf_4_21/a_27_47# VDPWR sky130_fd_pr__pfet_01v8_hvt ad=0 pd=0 as=0.26 ps=2.52 w=1 l=0.15
X3292 VGND V3R007 sky130_fd_sc_hd__buf_4_21/a_27_47# VGND sky130_fd_pr__nfet_01v8 ad=0 pd=0 as=0.169 ps=1.82 w=0.65 l=0.15
X3293 VGND V3R273 sky130_fd_sc_hd__or2_1_1/a_68_297# VGND sky130_fd_pr__nfet_01v8 ad=0 pd=0 as=0.1134 ps=1.38 w=0.42 l=0.15
X3294 sky130_fd_sc_hd__or2_1_1/a_68_297# V3R272 VGND VGND sky130_fd_pr__nfet_01v8 ad=0 pd=0 as=0 ps=0 w=0.42 l=0.15
X3295 V3R274 sky130_fd_sc_hd__or2_1_1/a_68_297# VGND VGND sky130_fd_pr__nfet_01v8 ad=0.169 pd=1.82 as=0 ps=0 w=0.65 l=0.15
X3296 VDPWR V3R273 sky130_fd_sc_hd__or2_1_1/a_150_297# VDPWR sky130_fd_pr__pfet_01v8_hvt ad=0 pd=0 as=0.0882 ps=1.26 w=0.42 l=0.15
X3297 V3R274 sky130_fd_sc_hd__or2_1_1/a_68_297# VDPWR VDPWR sky130_fd_pr__pfet_01v8_hvt ad=0.34 pd=2.68 as=0 ps=0 w=1 l=0.15
X3298 sky130_fd_sc_hd__or2_1_1/a_150_297# V3R272 sky130_fd_sc_hd__or2_1_1/a_68_297# VDPWR sky130_fd_pr__pfet_01v8_hvt ad=0 pd=0 as=0.1092 ps=1.36 w=0.42 l=0.15
X3299 VDPWR sky130_fd_sc_hd__buf_4_3/a_27_47# V3R056 VDPWR sky130_fd_pr__pfet_01v8_hvt ad=0 pd=0 as=0.54 ps=5.08 w=1 l=0.15
X3300 V3R056 sky130_fd_sc_hd__buf_4_3/a_27_47# VDPWR VDPWR sky130_fd_pr__pfet_01v8_hvt ad=0 pd=0 as=0 ps=0 w=1 l=0.15
X3301 VDPWR sky130_fd_sc_hd__buf_4_3/a_27_47# V3R056 VDPWR sky130_fd_pr__pfet_01v8_hvt ad=0 pd=0 as=0 ps=0 w=1 l=0.15
X3302 V3R056 sky130_fd_sc_hd__buf_4_3/a_27_47# VDPWR VDPWR sky130_fd_pr__pfet_01v8_hvt ad=0 pd=0 as=0 ps=0 w=1 l=0.15
X3303 V3R056 sky130_fd_sc_hd__buf_4_3/a_27_47# VGND VGND sky130_fd_pr__nfet_01v8 ad=0.351 pd=3.68 as=0 ps=0 w=0.65 l=0.15
X3304 V3R056 sky130_fd_sc_hd__buf_4_3/a_27_47# VGND VGND sky130_fd_pr__nfet_01v8 ad=0 pd=0 as=0 ps=0 w=0.65 l=0.15
X3305 VGND sky130_fd_sc_hd__buf_4_3/a_27_47# V3R056 VGND sky130_fd_pr__nfet_01v8 ad=0 pd=0 as=0 ps=0 w=0.65 l=0.15
X3306 VGND sky130_fd_sc_hd__buf_4_3/a_27_47# V3R056 VGND sky130_fd_pr__nfet_01v8 ad=0 pd=0 as=0 ps=0 w=0.65 l=0.15
X3307 VDPWR V3R054 sky130_fd_sc_hd__buf_4_3/a_27_47# VDPWR sky130_fd_pr__pfet_01v8_hvt ad=0 pd=0 as=0.26 ps=2.52 w=1 l=0.15
X3308 VGND V3R054 sky130_fd_sc_hd__buf_4_3/a_27_47# VGND sky130_fd_pr__nfet_01v8 ad=0 pd=0 as=0.169 ps=1.82 w=0.65 l=0.15
X3309 VDPWR V3R008 sky130_fd_sc_hd__and2_1_6/a_59_75# VDPWR sky130_fd_pr__pfet_01v8_hvt ad=0 pd=0 as=0.1134 ps=1.38 w=0.42 l=0.15
X3310 V3R234 sky130_fd_sc_hd__and2_1_6/a_59_75# VDPWR VDPWR sky130_fd_pr__pfet_01v8_hvt ad=0.475 pd=2.95 as=0 ps=0 w=1 l=0.15
X3311 VGND V3R008 sky130_fd_sc_hd__and2_1_6/a_145_75# VGND sky130_fd_pr__nfet_01v8 ad=0 pd=0 as=0.1134 ps=1.38 w=0.42 l=0.15
X3312 sky130_fd_sc_hd__and2_1_6/a_59_75# V3R039 VDPWR VDPWR sky130_fd_pr__pfet_01v8_hvt ad=0 pd=0 as=0 ps=0 w=0.42 l=0.15
X3313 V3R234 sky130_fd_sc_hd__and2_1_6/a_59_75# VGND VGND sky130_fd_pr__nfet_01v8 ad=0.182 pd=1.86 as=0 ps=0 w=0.65 l=0.15
X3314 sky130_fd_sc_hd__and2_1_6/a_145_75# V3R039 sky130_fd_sc_hd__and2_1_6/a_59_75# VGND sky130_fd_pr__nfet_01v8 ad=0 pd=0 as=0.1176 ps=1.4 w=0.42 l=0.15
X3315 sky130_fd_sc_hd__dfrtp_1_9/a_805_47# sky130_fd_sc_hd__dfrtp_1_9/a_761_289# sky130_fd_sc_hd__dfrtp_1_9/a_639_47# VGND sky130_fd_pr__nfet_01v8 ad=0.0882 pd=1.26 as=0.2802 ps=2.2 w=0.42 l=0.15
X3316 sky130_fd_sc_hd__dfrtp_1_9/a_1217_47# sky130_fd_sc_hd__dfrtp_1_9/a_27_47# sky130_fd_sc_hd__dfrtp_1_9/a_1108_47# VGND sky130_fd_pr__special_nfet_01v8 ad=0.1338 pd=1.5 as=0.1422 ps=1.51 w=0.36 l=0.15
X3317 sky130_fd_sc_hd__dfrtp_1_9/a_1283_21# sky130_fd_sc_hd__dfrtp_1_9/a_1108_47# sky130_fd_sc_hd__dfrtp_1_9/a_1462_47# VGND sky130_fd_pr__nfet_01v8 ad=0.1092 pd=1.36 as=0.1281 ps=1.45 w=0.42 l=0.15
X3318 sky130_fd_sc_hd__dfrtp_1_9/a_651_413# sky130_fd_sc_hd__dfrtp_1_9/a_27_47# sky130_fd_sc_hd__dfrtp_1_9/a_543_47# VDPWR sky130_fd_pr__pfet_01v8_hvt ad=0.3402 pd=3.3 as=0.1449 ps=1.53 w=0.42 l=0.15
X3319 sky130_fd_sc_hd__dfrtp_1_9/a_1108_47# sky130_fd_sc_hd__dfrtp_1_9/a_193_47# sky130_fd_sc_hd__dfrtp_1_9/a_761_289# VGND sky130_fd_pr__special_nfet_01v8 ad=0 pd=0 as=0.1998 ps=1.97 w=0.36 l=0.15
X3320 VGND V3R303 sky130_fd_sc_hd__dfrtp_1_9/a_805_47# VGND sky130_fd_pr__nfet_01v8 ad=0 pd=0 as=0 ps=0 w=0.42 l=0.15
X3321 V3R050 sky130_fd_sc_hd__dfrtp_1_9/a_1283_21# VDPWR VDPWR sky130_fd_pr__pfet_01v8_hvt ad=0.26 pd=2.52 as=0 ps=0 w=1 l=0.15
X3322 VDPWR V3R084 sky130_fd_sc_hd__dfrtp_1_9/a_27_47# VDPWR sky130_fd_pr__pfet_01v8_hvt ad=0 pd=0 as=0.1664 ps=1.8 w=0.64 l=0.15
X3323 sky130_fd_sc_hd__dfrtp_1_9/a_448_47# V3R195 VDPWR VDPWR sky130_fd_pr__pfet_01v8_hvt ad=0.1302 pd=1.46 as=0 ps=0 w=0.42 l=0.15
X3324 sky130_fd_sc_hd__dfrtp_1_9/a_761_289# sky130_fd_sc_hd__dfrtp_1_9/a_543_47# VGND VGND sky130_fd_pr__nfet_01v8 ad=0 pd=0 as=0 ps=0 w=0.64 l=0.15
X3325 sky130_fd_sc_hd__dfrtp_1_9/a_193_47# sky130_fd_sc_hd__dfrtp_1_9/a_27_47# VGND VGND sky130_fd_pr__nfet_01v8 ad=0.1092 pd=1.36 as=0 ps=0 w=0.42 l=0.15
X3326 sky130_fd_sc_hd__dfrtp_1_9/a_1108_47# sky130_fd_sc_hd__dfrtp_1_9/a_27_47# sky130_fd_sc_hd__dfrtp_1_9/a_761_289# VDPWR sky130_fd_pr__pfet_01v8_hvt ad=0.1176 pd=1.4 as=0.2583 ps=2.37 w=0.42 l=0.15
X3327 sky130_fd_sc_hd__dfrtp_1_9/a_1462_47# V3R303 VGND VGND sky130_fd_pr__nfet_01v8 ad=0 pd=0 as=0 ps=0 w=0.42 l=0.15
X3328 sky130_fd_sc_hd__dfrtp_1_9/a_543_47# sky130_fd_sc_hd__dfrtp_1_9/a_27_47# sky130_fd_sc_hd__dfrtp_1_9/a_448_47# VGND sky130_fd_pr__special_nfet_01v8 ad=0.1188 pd=1.38 as=0.132 ps=1.49 w=0.36 l=0.15
X3329 sky130_fd_sc_hd__dfrtp_1_9/a_543_47# sky130_fd_sc_hd__dfrtp_1_9/a_193_47# sky130_fd_sc_hd__dfrtp_1_9/a_448_47# VDPWR sky130_fd_pr__pfet_01v8_hvt ad=0 pd=0 as=0 ps=0 w=0.42 l=0.15
X3330 sky130_fd_sc_hd__dfrtp_1_9/a_448_47# V3R195 VGND VGND sky130_fd_pr__nfet_01v8 ad=0 pd=0 as=0 ps=0 w=0.42 l=0.15
X3331 VDPWR sky130_fd_sc_hd__dfrtp_1_9/a_1283_21# sky130_fd_sc_hd__dfrtp_1_9/a_1270_413# VDPWR sky130_fd_pr__pfet_01v8_hvt ad=0 pd=0 as=0.1134 ps=1.38 w=0.42 l=0.15
X3332 VDPWR sky130_fd_sc_hd__dfrtp_1_9/a_1108_47# sky130_fd_sc_hd__dfrtp_1_9/a_1283_21# VDPWR sky130_fd_pr__pfet_01v8_hvt ad=0 pd=0 as=0.1134 ps=1.38 w=0.42 l=0.15
X3333 sky130_fd_sc_hd__dfrtp_1_9/a_1270_413# sky130_fd_sc_hd__dfrtp_1_9/a_193_47# sky130_fd_sc_hd__dfrtp_1_9/a_1108_47# VDPWR sky130_fd_pr__pfet_01v8_hvt ad=0 pd=0 as=0 ps=0 w=0.42 l=0.15
X3334 sky130_fd_sc_hd__dfrtp_1_9/a_193_47# sky130_fd_sc_hd__dfrtp_1_9/a_27_47# VDPWR VDPWR sky130_fd_pr__pfet_01v8_hvt ad=0.1664 pd=1.8 as=0 ps=0 w=0.64 l=0.15
X3335 sky130_fd_sc_hd__dfrtp_1_9/a_1283_21# V3R303 VDPWR VDPWR sky130_fd_pr__pfet_01v8_hvt ad=0 pd=0 as=0 ps=0 w=0.42 l=0.15
X3336 VDPWR sky130_fd_sc_hd__dfrtp_1_9/a_761_289# sky130_fd_sc_hd__dfrtp_1_9/a_651_413# VDPWR sky130_fd_pr__pfet_01v8_hvt ad=0 pd=0 as=0 ps=0 w=0.42 l=0.15
X3337 V3R050 sky130_fd_sc_hd__dfrtp_1_9/a_1283_21# VGND VGND sky130_fd_pr__nfet_01v8 ad=0.169 pd=1.82 as=0 ps=0 w=0.65 l=0.15
X3338 sky130_fd_sc_hd__dfrtp_1_9/a_639_47# sky130_fd_sc_hd__dfrtp_1_9/a_193_47# sky130_fd_sc_hd__dfrtp_1_9/a_543_47# VGND sky130_fd_pr__special_nfet_01v8 ad=0 pd=0 as=0 ps=0 w=0.36 l=0.15
X3339 VGND sky130_fd_sc_hd__dfrtp_1_9/a_1283_21# sky130_fd_sc_hd__dfrtp_1_9/a_1217_47# VGND sky130_fd_pr__nfet_01v8 ad=0 pd=0 as=0 ps=0 w=0.42 l=0.15
X3340 sky130_fd_sc_hd__dfrtp_1_9/a_651_413# V3R303 VDPWR VDPWR sky130_fd_pr__pfet_01v8_hvt ad=0 pd=0 as=0 ps=0 w=0.42 l=0.15
X3341 VGND V3R084 sky130_fd_sc_hd__dfrtp_1_9/a_27_47# VGND sky130_fd_pr__nfet_01v8 ad=0 pd=0 as=0.1092 ps=1.36 w=0.42 l=0.15
X3342 sky130_fd_sc_hd__dfrtp_1_9/a_761_289# sky130_fd_sc_hd__dfrtp_1_9/a_543_47# VDPWR VDPWR sky130_fd_pr__pfet_01v8_hvt ad=0 pd=0 as=0 ps=0 w=0.84 l=0.15
X3343 VDPWR sky130_fd_sc_hd__mux2_1_83/a_505_21# sky130_fd_sc_hd__mux2_1_83/a_535_374# VDPWR sky130_fd_pr__pfet_01v8_hvt ad=0 pd=0 as=0.0882 ps=1.26 w=0.42 l=0.15
X3344 sky130_fd_sc_hd__mux2_1_83/a_505_21# V3R008 VDPWR VDPWR sky130_fd_pr__pfet_01v8_hvt ad=0.1176 pd=1.4 as=0 ps=0 w=0.42 l=0.15
X3345 sky130_fd_sc_hd__mux2_1_83/a_218_374# V3R008 VDPWR VDPWR sky130_fd_pr__pfet_01v8_hvt ad=0.1533 pd=1.57 as=0 ps=0 w=0.42 l=0.15
X3346 VGND sky130_fd_sc_hd__mux2_1_83/a_505_21# sky130_fd_sc_hd__mux2_1_83/a_439_47# VGND sky130_fd_pr__nfet_01v8 ad=0 pd=0 as=0.1386 ps=1.5 w=0.42 l=0.15
X3347 sky130_fd_sc_hd__mux2_1_83/a_76_199# V3R243 sky130_fd_sc_hd__mux2_1_83/a_218_374# VDPWR sky130_fd_pr__pfet_01v8_hvt ad=0.3864 pd=2.68 as=0 ps=0 w=0.42 l=0.15
X3348 sky130_fd_sc_hd__mux2_1_83/a_505_21# V3R008 VGND VGND sky130_fd_pr__nfet_01v8 ad=0.1092 pd=1.36 as=0 ps=0 w=0.42 l=0.15
X3349 sky130_fd_sc_hd__mux2_1_83/a_439_47# V3R243 sky130_fd_sc_hd__mux2_1_83/a_76_199# VGND sky130_fd_pr__nfet_01v8 ad=0 pd=0 as=0.1995 ps=1.79 w=0.42 l=0.15
X3350 sky130_fd_sc_hd__mux2_1_83/a_535_374# V3R042 sky130_fd_sc_hd__mux2_1_83/a_76_199# VDPWR sky130_fd_pr__pfet_01v8_hvt ad=0 pd=0 as=0 ps=0 w=0.42 l=0.15
X3351 sky130_fd_sc_hd__mux2_1_83/a_76_199# V3R042 sky130_fd_sc_hd__mux2_1_83/a_218_47# VGND sky130_fd_pr__nfet_01v8 ad=0 pd=0 as=0.1386 ps=1.5 w=0.42 l=0.15
X3352 sky130_fd_sc_hd__mux2_1_83/a_218_47# V3R008 VGND VGND sky130_fd_pr__nfet_01v8 ad=0 pd=0 as=0 ps=0 w=0.42 l=0.15
X3353 VDPWR sky130_fd_sc_hd__mux2_1_83/a_76_199# V3R237 VDPWR sky130_fd_pr__pfet_01v8_hvt ad=0 pd=0 as=0.26 ps=2.52 w=1 l=0.15
X3354 VGND sky130_fd_sc_hd__mux2_1_83/a_76_199# V3R237 VGND sky130_fd_pr__nfet_01v8 ad=0 pd=0 as=0.169 ps=1.82 w=0.65 l=0.15
X3355 VDPWR sky130_fd_sc_hd__mux2_1_72/a_505_21# sky130_fd_sc_hd__mux2_1_72/a_535_374# VDPWR sky130_fd_pr__pfet_01v8_hvt ad=0 pd=0 as=0.0882 ps=1.26 w=0.42 l=0.15
X3356 sky130_fd_sc_hd__mux2_1_72/a_505_21# V3R061 VDPWR VDPWR sky130_fd_pr__pfet_01v8_hvt ad=0.1176 pd=1.4 as=0 ps=0 w=0.42 l=0.15
X3357 sky130_fd_sc_hd__mux2_1_72/a_218_374# V3R061 VDPWR VDPWR sky130_fd_pr__pfet_01v8_hvt ad=0.1533 pd=1.57 as=0 ps=0 w=0.42 l=0.15
X3358 VGND sky130_fd_sc_hd__mux2_1_72/a_505_21# sky130_fd_sc_hd__mux2_1_72/a_439_47# VGND sky130_fd_pr__nfet_01v8 ad=0 pd=0 as=0.1386 ps=1.5 w=0.42 l=0.15
X3359 sky130_fd_sc_hd__mux2_1_72/a_76_199# V3R152 sky130_fd_sc_hd__mux2_1_72/a_218_374# VDPWR sky130_fd_pr__pfet_01v8_hvt ad=0.3864 pd=2.68 as=0 ps=0 w=0.42 l=0.15
X3360 sky130_fd_sc_hd__mux2_1_72/a_505_21# V3R061 VGND VGND sky130_fd_pr__nfet_01v8 ad=0.1092 pd=1.36 as=0 ps=0 w=0.42 l=0.15
X3361 sky130_fd_sc_hd__mux2_1_72/a_439_47# V3R152 sky130_fd_sc_hd__mux2_1_72/a_76_199# VGND sky130_fd_pr__nfet_01v8 ad=0 pd=0 as=0.1995 ps=1.79 w=0.42 l=0.15
X3362 sky130_fd_sc_hd__mux2_1_72/a_535_374# V3R151 sky130_fd_sc_hd__mux2_1_72/a_76_199# VDPWR sky130_fd_pr__pfet_01v8_hvt ad=0 pd=0 as=0 ps=0 w=0.42 l=0.15
X3363 sky130_fd_sc_hd__mux2_1_72/a_76_199# V3R151 sky130_fd_sc_hd__mux2_1_72/a_218_47# VGND sky130_fd_pr__nfet_01v8 ad=0 pd=0 as=0.1386 ps=1.5 w=0.42 l=0.15
X3364 sky130_fd_sc_hd__mux2_1_72/a_218_47# V3R061 VGND VGND sky130_fd_pr__nfet_01v8 ad=0 pd=0 as=0 ps=0 w=0.42 l=0.15
X3365 VDPWR sky130_fd_sc_hd__mux2_1_72/a_76_199# V3R096 VDPWR sky130_fd_pr__pfet_01v8_hvt ad=0 pd=0 as=0.26 ps=2.52 w=1 l=0.15
X3366 VGND sky130_fd_sc_hd__mux2_1_72/a_76_199# V3R096 VGND sky130_fd_pr__nfet_01v8 ad=0 pd=0 as=0.169 ps=1.82 w=0.65 l=0.15
X3367 VDPWR sky130_fd_sc_hd__mux2_1_50/a_505_21# sky130_fd_sc_hd__mux2_1_50/a_535_374# VDPWR sky130_fd_pr__pfet_01v8_hvt ad=0 pd=0 as=0.0882 ps=1.26 w=0.42 l=0.15
X3368 sky130_fd_sc_hd__mux2_1_50/a_505_21# V3R045 VDPWR VDPWR sky130_fd_pr__pfet_01v8_hvt ad=0.1176 pd=1.4 as=0 ps=0 w=0.42 l=0.15
X3369 sky130_fd_sc_hd__mux2_1_50/a_218_374# V3R045 VDPWR VDPWR sky130_fd_pr__pfet_01v8_hvt ad=0.1533 pd=1.57 as=0 ps=0 w=0.42 l=0.15
X3370 VGND sky130_fd_sc_hd__mux2_1_50/a_505_21# sky130_fd_sc_hd__mux2_1_50/a_439_47# VGND sky130_fd_pr__nfet_01v8 ad=0 pd=0 as=0.1386 ps=1.5 w=0.42 l=0.15
X3371 sky130_fd_sc_hd__mux2_1_50/a_76_199# V3R019 sky130_fd_sc_hd__mux2_1_50/a_218_374# VDPWR sky130_fd_pr__pfet_01v8_hvt ad=0.3864 pd=2.68 as=0 ps=0 w=0.42 l=0.15
X3372 sky130_fd_sc_hd__mux2_1_50/a_505_21# V3R045 VGND VGND sky130_fd_pr__nfet_01v8 ad=0.1092 pd=1.36 as=0 ps=0 w=0.42 l=0.15
X3373 sky130_fd_sc_hd__mux2_1_50/a_439_47# V3R019 sky130_fd_sc_hd__mux2_1_50/a_76_199# VGND sky130_fd_pr__nfet_01v8 ad=0 pd=0 as=0.1995 ps=1.79 w=0.42 l=0.15
X3374 sky130_fd_sc_hd__mux2_1_50/a_535_374# V3R158 sky130_fd_sc_hd__mux2_1_50/a_76_199# VDPWR sky130_fd_pr__pfet_01v8_hvt ad=0 pd=0 as=0 ps=0 w=0.42 l=0.15
X3375 sky130_fd_sc_hd__mux2_1_50/a_76_199# V3R158 sky130_fd_sc_hd__mux2_1_50/a_218_47# VGND sky130_fd_pr__nfet_01v8 ad=0 pd=0 as=0.1386 ps=1.5 w=0.42 l=0.15
X3376 sky130_fd_sc_hd__mux2_1_50/a_218_47# V3R045 VGND VGND sky130_fd_pr__nfet_01v8 ad=0 pd=0 as=0 ps=0 w=0.42 l=0.15
X3377 VDPWR sky130_fd_sc_hd__mux2_1_50/a_76_199# V3R135 VDPWR sky130_fd_pr__pfet_01v8_hvt ad=0 pd=0 as=0.26 ps=2.52 w=1 l=0.15
X3378 VGND sky130_fd_sc_hd__mux2_1_50/a_76_199# V3R135 VGND sky130_fd_pr__nfet_01v8 ad=0 pd=0 as=0.169 ps=1.82 w=0.65 l=0.15
X3379 VDPWR sky130_fd_sc_hd__mux2_1_94/a_505_21# sky130_fd_sc_hd__mux2_1_94/a_535_374# VDPWR sky130_fd_pr__pfet_01v8_hvt ad=0 pd=0 as=0.0882 ps=1.26 w=0.42 l=0.15
X3380 sky130_fd_sc_hd__mux2_1_94/a_505_21# V3R061 VDPWR VDPWR sky130_fd_pr__pfet_01v8_hvt ad=0.1176 pd=1.4 as=0 ps=0 w=0.42 l=0.15
X3381 sky130_fd_sc_hd__mux2_1_94/a_218_374# V3R061 VDPWR VDPWR sky130_fd_pr__pfet_01v8_hvt ad=0.1533 pd=1.57 as=0 ps=0 w=0.42 l=0.15
X3382 VGND sky130_fd_sc_hd__mux2_1_94/a_505_21# sky130_fd_sc_hd__mux2_1_94/a_439_47# VGND sky130_fd_pr__nfet_01v8 ad=0 pd=0 as=0.1386 ps=1.5 w=0.42 l=0.15
X3383 sky130_fd_sc_hd__mux2_1_94/a_76_199# V3R176 sky130_fd_sc_hd__mux2_1_94/a_218_374# VDPWR sky130_fd_pr__pfet_01v8_hvt ad=0.3864 pd=2.68 as=0 ps=0 w=0.42 l=0.15
X3384 sky130_fd_sc_hd__mux2_1_94/a_505_21# V3R061 VGND VGND sky130_fd_pr__nfet_01v8 ad=0.1092 pd=1.36 as=0 ps=0 w=0.42 l=0.15
X3385 sky130_fd_sc_hd__mux2_1_94/a_439_47# V3R176 sky130_fd_sc_hd__mux2_1_94/a_76_199# VGND sky130_fd_pr__nfet_01v8 ad=0 pd=0 as=0.1995 ps=1.79 w=0.42 l=0.15
X3386 sky130_fd_sc_hd__mux2_1_94/a_535_374# V3R175 sky130_fd_sc_hd__mux2_1_94/a_76_199# VDPWR sky130_fd_pr__pfet_01v8_hvt ad=0 pd=0 as=0 ps=0 w=0.42 l=0.15
X3387 sky130_fd_sc_hd__mux2_1_94/a_76_199# V3R175 sky130_fd_sc_hd__mux2_1_94/a_218_47# VGND sky130_fd_pr__nfet_01v8 ad=0 pd=0 as=0.1386 ps=1.5 w=0.42 l=0.15
X3388 sky130_fd_sc_hd__mux2_1_94/a_218_47# V3R061 VGND VGND sky130_fd_pr__nfet_01v8 ad=0 pd=0 as=0 ps=0 w=0.42 l=0.15
X3389 VDPWR sky130_fd_sc_hd__mux2_1_94/a_76_199# V3R089 VDPWR sky130_fd_pr__pfet_01v8_hvt ad=0 pd=0 as=0.26 ps=2.52 w=1 l=0.15
X3390 VGND sky130_fd_sc_hd__mux2_1_94/a_76_199# V3R089 VGND sky130_fd_pr__nfet_01v8 ad=0 pd=0 as=0.169 ps=1.82 w=0.65 l=0.15
X3391 VDPWR sky130_fd_sc_hd__mux2_1_61/a_505_21# sky130_fd_sc_hd__mux2_1_61/a_535_374# VDPWR sky130_fd_pr__pfet_01v8_hvt ad=0 pd=0 as=0.0882 ps=1.26 w=0.42 l=0.15
X3392 sky130_fd_sc_hd__mux2_1_61/a_505_21# V3R061 VDPWR VDPWR sky130_fd_pr__pfet_01v8_hvt ad=0.1176 pd=1.4 as=0 ps=0 w=0.42 l=0.15
X3393 sky130_fd_sc_hd__mux2_1_61/a_218_374# V3R061 VDPWR VDPWR sky130_fd_pr__pfet_01v8_hvt ad=0.1533 pd=1.57 as=0 ps=0 w=0.42 l=0.15
X3394 VGND sky130_fd_sc_hd__mux2_1_61/a_505_21# sky130_fd_sc_hd__mux2_1_61/a_439_47# VGND sky130_fd_pr__nfet_01v8 ad=0 pd=0 as=0.1386 ps=1.5 w=0.42 l=0.15
X3395 sky130_fd_sc_hd__mux2_1_61/a_76_199# V3R154 sky130_fd_sc_hd__mux2_1_61/a_218_374# VDPWR sky130_fd_pr__pfet_01v8_hvt ad=0.3864 pd=2.68 as=0 ps=0 w=0.42 l=0.15
X3396 sky130_fd_sc_hd__mux2_1_61/a_505_21# V3R061 VGND VGND sky130_fd_pr__nfet_01v8 ad=0.1092 pd=1.36 as=0 ps=0 w=0.42 l=0.15
X3397 sky130_fd_sc_hd__mux2_1_61/a_439_47# V3R154 sky130_fd_sc_hd__mux2_1_61/a_76_199# VGND sky130_fd_pr__nfet_01v8 ad=0 pd=0 as=0.1995 ps=1.79 w=0.42 l=0.15
X3398 sky130_fd_sc_hd__mux2_1_61/a_535_374# V3R153 sky130_fd_sc_hd__mux2_1_61/a_76_199# VDPWR sky130_fd_pr__pfet_01v8_hvt ad=0 pd=0 as=0 ps=0 w=0.42 l=0.15
X3399 sky130_fd_sc_hd__mux2_1_61/a_76_199# V3R153 sky130_fd_sc_hd__mux2_1_61/a_218_47# VGND sky130_fd_pr__nfet_01v8 ad=0 pd=0 as=0.1386 ps=1.5 w=0.42 l=0.15
X3400 sky130_fd_sc_hd__mux2_1_61/a_218_47# V3R061 VGND VGND sky130_fd_pr__nfet_01v8 ad=0 pd=0 as=0 ps=0 w=0.42 l=0.15
X3401 VDPWR sky130_fd_sc_hd__mux2_1_61/a_76_199# V3R098 VDPWR sky130_fd_pr__pfet_01v8_hvt ad=0 pd=0 as=0.26 ps=2.52 w=1 l=0.15
X3402 VGND sky130_fd_sc_hd__mux2_1_61/a_76_199# V3R098 VGND sky130_fd_pr__nfet_01v8 ad=0 pd=0 as=0.169 ps=1.82 w=0.65 l=0.15
X3403 VDPWR sky130_fd_sc_hd__buf_4_22/a_27_47# V3R085 VDPWR sky130_fd_pr__pfet_01v8_hvt ad=0 pd=0 as=0.54 ps=5.08 w=1 l=0.15
X3404 V3R085 sky130_fd_sc_hd__buf_4_22/a_27_47# VDPWR VDPWR sky130_fd_pr__pfet_01v8_hvt ad=0 pd=0 as=0 ps=0 w=1 l=0.15
X3405 VDPWR sky130_fd_sc_hd__buf_4_22/a_27_47# V3R085 VDPWR sky130_fd_pr__pfet_01v8_hvt ad=0 pd=0 as=0 ps=0 w=1 l=0.15
X3406 V3R085 sky130_fd_sc_hd__buf_4_22/a_27_47# VDPWR VDPWR sky130_fd_pr__pfet_01v8_hvt ad=0 pd=0 as=0 ps=0 w=1 l=0.15
X3407 V3R085 sky130_fd_sc_hd__buf_4_22/a_27_47# VGND VGND sky130_fd_pr__nfet_01v8 ad=0.351 pd=3.68 as=0 ps=0 w=0.65 l=0.15
X3408 V3R085 sky130_fd_sc_hd__buf_4_22/a_27_47# VGND VGND sky130_fd_pr__nfet_01v8 ad=0 pd=0 as=0 ps=0 w=0.65 l=0.15
X3409 VGND sky130_fd_sc_hd__buf_4_22/a_27_47# V3R085 VGND sky130_fd_pr__nfet_01v8 ad=0 pd=0 as=0 ps=0 w=0.65 l=0.15
X3410 VGND sky130_fd_sc_hd__buf_4_22/a_27_47# V3R085 VGND sky130_fd_pr__nfet_01v8 ad=0 pd=0 as=0 ps=0 w=0.65 l=0.15
X3411 VDPWR V3R080 sky130_fd_sc_hd__buf_4_22/a_27_47# VDPWR sky130_fd_pr__pfet_01v8_hvt ad=0 pd=0 as=0.26 ps=2.52 w=1 l=0.15
X3412 VGND V3R080 sky130_fd_sc_hd__buf_4_22/a_27_47# VGND sky130_fd_pr__nfet_01v8 ad=0 pd=0 as=0.169 ps=1.82 w=0.65 l=0.15
X3413 VDPWR sky130_fd_sc_hd__buf_4_11/a_27_47# V3R062 VDPWR sky130_fd_pr__pfet_01v8_hvt ad=0 pd=0 as=0.54 ps=5.08 w=1 l=0.15
X3414 V3R062 sky130_fd_sc_hd__buf_4_11/a_27_47# VDPWR VDPWR sky130_fd_pr__pfet_01v8_hvt ad=0 pd=0 as=0 ps=0 w=1 l=0.15
X3415 VDPWR sky130_fd_sc_hd__buf_4_11/a_27_47# V3R062 VDPWR sky130_fd_pr__pfet_01v8_hvt ad=0 pd=0 as=0 ps=0 w=1 l=0.15
X3416 V3R062 sky130_fd_sc_hd__buf_4_11/a_27_47# VDPWR VDPWR sky130_fd_pr__pfet_01v8_hvt ad=0 pd=0 as=0 ps=0 w=1 l=0.15
X3417 V3R062 sky130_fd_sc_hd__buf_4_11/a_27_47# VGND VGND sky130_fd_pr__nfet_01v8 ad=0.351 pd=3.68 as=0 ps=0 w=0.65 l=0.15
X3418 V3R062 sky130_fd_sc_hd__buf_4_11/a_27_47# VGND VGND sky130_fd_pr__nfet_01v8 ad=0 pd=0 as=0 ps=0 w=0.65 l=0.15
X3419 VGND sky130_fd_sc_hd__buf_4_11/a_27_47# V3R062 VGND sky130_fd_pr__nfet_01v8 ad=0 pd=0 as=0 ps=0 w=0.65 l=0.15
X3420 VGND sky130_fd_sc_hd__buf_4_11/a_27_47# V3R062 VGND sky130_fd_pr__nfet_01v8 ad=0 pd=0 as=0 ps=0 w=0.65 l=0.15
X3421 VDPWR V3R060 sky130_fd_sc_hd__buf_4_11/a_27_47# VDPWR sky130_fd_pr__pfet_01v8_hvt ad=0 pd=0 as=0.26 ps=2.52 w=1 l=0.15
X3422 VGND V3R060 sky130_fd_sc_hd__buf_4_11/a_27_47# VGND sky130_fd_pr__nfet_01v8 ad=0 pd=0 as=0.169 ps=1.82 w=0.65 l=0.15
X3423 VGND V3R275 sky130_fd_sc_hd__or2_1_2/a_68_297# VGND sky130_fd_pr__nfet_01v8 ad=0 pd=0 as=0.1134 ps=1.38 w=0.42 l=0.15
X3424 sky130_fd_sc_hd__or2_1_2/a_68_297# V3R274 VGND VGND sky130_fd_pr__nfet_01v8 ad=0 pd=0 as=0 ps=0 w=0.42 l=0.15
X3425 V3R276 sky130_fd_sc_hd__or2_1_2/a_68_297# VGND VGND sky130_fd_pr__nfet_01v8 ad=0.169 pd=1.82 as=0 ps=0 w=0.65 l=0.15
X3426 VDPWR V3R275 sky130_fd_sc_hd__or2_1_2/a_150_297# VDPWR sky130_fd_pr__pfet_01v8_hvt ad=0 pd=0 as=0.0882 ps=1.26 w=0.42 l=0.15
X3427 V3R276 sky130_fd_sc_hd__or2_1_2/a_68_297# VDPWR VDPWR sky130_fd_pr__pfet_01v8_hvt ad=0.34 pd=2.68 as=0 ps=0 w=1 l=0.15
X3428 sky130_fd_sc_hd__or2_1_2/a_150_297# V3R274 sky130_fd_sc_hd__or2_1_2/a_68_297# VDPWR sky130_fd_pr__pfet_01v8_hvt ad=0 pd=0 as=0.1092 ps=1.36 w=0.42 l=0.15
X3429 VDPWR sky130_fd_sc_hd__buf_4_4/a_27_47# V3R081 VDPWR sky130_fd_pr__pfet_01v8_hvt ad=0 pd=0 as=0.54 ps=5.08 w=1 l=0.15
X3430 V3R081 sky130_fd_sc_hd__buf_4_4/a_27_47# VDPWR VDPWR sky130_fd_pr__pfet_01v8_hvt ad=0 pd=0 as=0 ps=0 w=1 l=0.15
X3431 VDPWR sky130_fd_sc_hd__buf_4_4/a_27_47# V3R081 VDPWR sky130_fd_pr__pfet_01v8_hvt ad=0 pd=0 as=0 ps=0 w=1 l=0.15
X3432 V3R081 sky130_fd_sc_hd__buf_4_4/a_27_47# VDPWR VDPWR sky130_fd_pr__pfet_01v8_hvt ad=0 pd=0 as=0 ps=0 w=1 l=0.15
X3433 V3R081 sky130_fd_sc_hd__buf_4_4/a_27_47# VGND VGND sky130_fd_pr__nfet_01v8 ad=0.351 pd=3.68 as=0 ps=0 w=0.65 l=0.15
X3434 V3R081 sky130_fd_sc_hd__buf_4_4/a_27_47# VGND VGND sky130_fd_pr__nfet_01v8 ad=0 pd=0 as=0 ps=0 w=0.65 l=0.15
X3435 VGND sky130_fd_sc_hd__buf_4_4/a_27_47# V3R081 VGND sky130_fd_pr__nfet_01v8 ad=0 pd=0 as=0 ps=0 w=0.65 l=0.15
X3436 VGND sky130_fd_sc_hd__buf_4_4/a_27_47# V3R081 VGND sky130_fd_pr__nfet_01v8 ad=0 pd=0 as=0 ps=0 w=0.65 l=0.15
X3437 VDPWR V3R080 sky130_fd_sc_hd__buf_4_4/a_27_47# VDPWR sky130_fd_pr__pfet_01v8_hvt ad=0 pd=0 as=0.26 ps=2.52 w=1 l=0.15
X3438 VGND V3R080 sky130_fd_sc_hd__buf_4_4/a_27_47# VGND sky130_fd_pr__nfet_01v8 ad=0 pd=0 as=0.169 ps=1.82 w=0.65 l=0.15
X3439 VDPWR V3R008 sky130_fd_sc_hd__and2_1_7/a_59_75# VDPWR sky130_fd_pr__pfet_01v8_hvt ad=0 pd=0 as=0.1134 ps=1.38 w=0.42 l=0.15
X3440 V3R233 sky130_fd_sc_hd__and2_1_7/a_59_75# VDPWR VDPWR sky130_fd_pr__pfet_01v8_hvt ad=0.475 pd=2.95 as=0 ps=0 w=1 l=0.15
X3441 VGND V3R008 sky130_fd_sc_hd__and2_1_7/a_145_75# VGND sky130_fd_pr__nfet_01v8 ad=0 pd=0 as=0.1134 ps=1.38 w=0.42 l=0.15
X3442 sky130_fd_sc_hd__and2_1_7/a_59_75# V3R038 VDPWR VDPWR sky130_fd_pr__pfet_01v8_hvt ad=0 pd=0 as=0 ps=0 w=0.42 l=0.15
X3443 V3R233 sky130_fd_sc_hd__and2_1_7/a_59_75# VGND VGND sky130_fd_pr__nfet_01v8 ad=0.182 pd=1.86 as=0 ps=0 w=0.65 l=0.15
X3444 sky130_fd_sc_hd__and2_1_7/a_145_75# V3R038 sky130_fd_sc_hd__and2_1_7/a_59_75# VGND sky130_fd_pr__nfet_01v8 ad=0 pd=0 as=0.1176 ps=1.4 w=0.42 l=0.15
X3445 VDPWR sky130_fd_sc_hd__mux2_1_62/a_505_21# sky130_fd_sc_hd__mux2_1_62/a_535_374# VDPWR sky130_fd_pr__pfet_01v8_hvt ad=0 pd=0 as=0.0882 ps=1.26 w=0.42 l=0.15
X3446 sky130_fd_sc_hd__mux2_1_62/a_505_21# V3R044 VDPWR VDPWR sky130_fd_pr__pfet_01v8_hvt ad=0.1176 pd=1.4 as=0 ps=0 w=0.42 l=0.15
X3447 sky130_fd_sc_hd__mux2_1_62/a_218_374# V3R044 VDPWR VDPWR sky130_fd_pr__pfet_01v8_hvt ad=0.1533 pd=1.57 as=0 ps=0 w=0.42 l=0.15
X3448 VGND sky130_fd_sc_hd__mux2_1_62/a_505_21# sky130_fd_sc_hd__mux2_1_62/a_439_47# VGND sky130_fd_pr__nfet_01v8 ad=0 pd=0 as=0.1386 ps=1.5 w=0.42 l=0.15
X3449 sky130_fd_sc_hd__mux2_1_62/a_76_199# V3R014 sky130_fd_sc_hd__mux2_1_62/a_218_374# VDPWR sky130_fd_pr__pfet_01v8_hvt ad=0.3864 pd=2.68 as=0 ps=0 w=0.42 l=0.15
X3450 sky130_fd_sc_hd__mux2_1_62/a_505_21# V3R044 VGND VGND sky130_fd_pr__nfet_01v8 ad=0.1092 pd=1.36 as=0 ps=0 w=0.42 l=0.15
X3451 sky130_fd_sc_hd__mux2_1_62/a_439_47# V3R014 sky130_fd_sc_hd__mux2_1_62/a_76_199# VGND sky130_fd_pr__nfet_01v8 ad=0 pd=0 as=0.1995 ps=1.79 w=0.42 l=0.15
X3452 sky130_fd_sc_hd__mux2_1_62/a_535_374# V3R153 sky130_fd_sc_hd__mux2_1_62/a_76_199# VDPWR sky130_fd_pr__pfet_01v8_hvt ad=0 pd=0 as=0 ps=0 w=0.42 l=0.15
X3453 sky130_fd_sc_hd__mux2_1_62/a_76_199# V3R153 sky130_fd_sc_hd__mux2_1_62/a_218_47# VGND sky130_fd_pr__nfet_01v8 ad=0 pd=0 as=0.1386 ps=1.5 w=0.42 l=0.15
X3454 sky130_fd_sc_hd__mux2_1_62/a_218_47# V3R044 VGND VGND sky130_fd_pr__nfet_01v8 ad=0 pd=0 as=0 ps=0 w=0.42 l=0.15
X3455 VDPWR sky130_fd_sc_hd__mux2_1_62/a_76_199# V3R130 VDPWR sky130_fd_pr__pfet_01v8_hvt ad=0 pd=0 as=0.26 ps=2.52 w=1 l=0.15
X3456 VGND sky130_fd_sc_hd__mux2_1_62/a_76_199# V3R130 VGND sky130_fd_pr__nfet_01v8 ad=0 pd=0 as=0.169 ps=1.82 w=0.65 l=0.15
X3457 VDPWR sky130_fd_sc_hd__mux2_1_51/a_505_21# sky130_fd_sc_hd__mux2_1_51/a_535_374# VDPWR sky130_fd_pr__pfet_01v8_hvt ad=0 pd=0 as=0.0882 ps=1.26 w=0.42 l=0.15
X3458 sky130_fd_sc_hd__mux2_1_51/a_505_21# V3R009 VDPWR VDPWR sky130_fd_pr__pfet_01v8_hvt ad=0.1176 pd=1.4 as=0 ps=0 w=0.42 l=0.15
X3459 sky130_fd_sc_hd__mux2_1_51/a_218_374# V3R009 VDPWR VDPWR sky130_fd_pr__pfet_01v8_hvt ad=0.1533 pd=1.57 as=0 ps=0 w=0.42 l=0.15
X3460 VGND sky130_fd_sc_hd__mux2_1_51/a_505_21# sky130_fd_sc_hd__mux2_1_51/a_439_47# VGND sky130_fd_pr__nfet_01v8 ad=0 pd=0 as=0.1386 ps=1.5 w=0.42 l=0.15
X3461 sky130_fd_sc_hd__mux2_1_51/a_76_199# V3R251 sky130_fd_sc_hd__mux2_1_51/a_218_374# VDPWR sky130_fd_pr__pfet_01v8_hvt ad=0.3864 pd=2.68 as=0 ps=0 w=0.42 l=0.15
X3462 sky130_fd_sc_hd__mux2_1_51/a_505_21# V3R009 VGND VGND sky130_fd_pr__nfet_01v8 ad=0.1092 pd=1.36 as=0 ps=0 w=0.42 l=0.15
X3463 sky130_fd_sc_hd__mux2_1_51/a_439_47# V3R251 sky130_fd_sc_hd__mux2_1_51/a_76_199# VGND sky130_fd_pr__nfet_01v8 ad=0 pd=0 as=0.1995 ps=1.79 w=0.42 l=0.15
X3464 sky130_fd_sc_hd__mux2_1_51/a_535_374# V3R019 sky130_fd_sc_hd__mux2_1_51/a_76_199# VDPWR sky130_fd_pr__pfet_01v8_hvt ad=0 pd=0 as=0 ps=0 w=0.42 l=0.15
X3465 sky130_fd_sc_hd__mux2_1_51/a_76_199# V3R019 sky130_fd_sc_hd__mux2_1_51/a_218_47# VGND sky130_fd_pr__nfet_01v8 ad=0 pd=0 as=0.1386 ps=1.5 w=0.42 l=0.15
X3466 sky130_fd_sc_hd__mux2_1_51/a_218_47# V3R009 VGND VGND sky130_fd_pr__nfet_01v8 ad=0 pd=0 as=0 ps=0 w=0.42 l=0.15
X3467 VDPWR sky130_fd_sc_hd__mux2_1_51/a_76_199# V3R214 VDPWR sky130_fd_pr__pfet_01v8_hvt ad=0 pd=0 as=0.26 ps=2.52 w=1 l=0.15
X3468 VGND sky130_fd_sc_hd__mux2_1_51/a_76_199# V3R214 VGND sky130_fd_pr__nfet_01v8 ad=0 pd=0 as=0.169 ps=1.82 w=0.65 l=0.15
X3469 VDPWR sky130_fd_sc_hd__mux2_1_40/a_505_21# sky130_fd_sc_hd__mux2_1_40/a_535_374# VDPWR sky130_fd_pr__pfet_01v8_hvt ad=0 pd=0 as=0.0882 ps=1.26 w=0.42 l=0.15
X3470 sky130_fd_sc_hd__mux2_1_40/a_505_21# V3R009 VDPWR VDPWR sky130_fd_pr__pfet_01v8_hvt ad=0.1176 pd=1.4 as=0 ps=0 w=0.42 l=0.15
X3471 sky130_fd_sc_hd__mux2_1_40/a_218_374# V3R009 VDPWR VDPWR sky130_fd_pr__pfet_01v8_hvt ad=0.1533 pd=1.57 as=0 ps=0 w=0.42 l=0.15
X3472 VGND sky130_fd_sc_hd__mux2_1_40/a_505_21# sky130_fd_sc_hd__mux2_1_40/a_439_47# VGND sky130_fd_pr__nfet_01v8 ad=0 pd=0 as=0.1386 ps=1.5 w=0.42 l=0.15
X3473 sky130_fd_sc_hd__mux2_1_40/a_76_199# V3R000 sky130_fd_sc_hd__mux2_1_40/a_218_374# VDPWR sky130_fd_pr__pfet_01v8_hvt ad=0.3864 pd=2.68 as=0 ps=0 w=0.42 l=0.15
X3474 sky130_fd_sc_hd__mux2_1_40/a_505_21# V3R009 VGND VGND sky130_fd_pr__nfet_01v8 ad=0.1092 pd=1.36 as=0 ps=0 w=0.42 l=0.15
X3475 sky130_fd_sc_hd__mux2_1_40/a_439_47# V3R000 sky130_fd_sc_hd__mux2_1_40/a_76_199# VGND sky130_fd_pr__nfet_01v8 ad=0 pd=0 as=0.1995 ps=1.79 w=0.42 l=0.15
X3476 sky130_fd_sc_hd__mux2_1_40/a_535_374# V3R023 sky130_fd_sc_hd__mux2_1_40/a_76_199# VDPWR sky130_fd_pr__pfet_01v8_hvt ad=0 pd=0 as=0 ps=0 w=0.42 l=0.15
X3477 sky130_fd_sc_hd__mux2_1_40/a_76_199# V3R023 sky130_fd_sc_hd__mux2_1_40/a_218_47# VGND sky130_fd_pr__nfet_01v8 ad=0 pd=0 as=0.1386 ps=1.5 w=0.42 l=0.15
X3478 sky130_fd_sc_hd__mux2_1_40/a_218_47# V3R009 VGND VGND sky130_fd_pr__nfet_01v8 ad=0 pd=0 as=0 ps=0 w=0.42 l=0.15
X3479 VDPWR sky130_fd_sc_hd__mux2_1_40/a_76_199# V3R218 VDPWR sky130_fd_pr__pfet_01v8_hvt ad=0 pd=0 as=0.26 ps=2.52 w=1 l=0.15
X3480 VGND sky130_fd_sc_hd__mux2_1_40/a_76_199# V3R218 VGND sky130_fd_pr__nfet_01v8 ad=0 pd=0 as=0.169 ps=1.82 w=0.65 l=0.15
X3481 VDPWR sky130_fd_sc_hd__mux2_1_84/a_505_21# sky130_fd_sc_hd__mux2_1_84/a_535_374# VDPWR sky130_fd_pr__pfet_01v8_hvt ad=0 pd=0 as=0.0882 ps=1.26 w=0.42 l=0.15
X3482 sky130_fd_sc_hd__mux2_1_84/a_505_21# V3R008 VDPWR VDPWR sky130_fd_pr__pfet_01v8_hvt ad=0.1176 pd=1.4 as=0 ps=0 w=0.42 l=0.15
X3483 sky130_fd_sc_hd__mux2_1_84/a_218_374# V3R008 VDPWR VDPWR sky130_fd_pr__pfet_01v8_hvt ad=0.1533 pd=1.57 as=0 ps=0 w=0.42 l=0.15
X3484 VGND sky130_fd_sc_hd__mux2_1_84/a_505_21# sky130_fd_sc_hd__mux2_1_84/a_439_47# VGND sky130_fd_pr__nfet_01v8 ad=0 pd=0 as=0.1386 ps=1.5 w=0.42 l=0.15
X3485 sky130_fd_sc_hd__mux2_1_84/a_76_199# V3R001 sky130_fd_sc_hd__mux2_1_84/a_218_374# VDPWR sky130_fd_pr__pfet_01v8_hvt ad=0.3864 pd=2.68 as=0 ps=0 w=0.42 l=0.15
X3486 sky130_fd_sc_hd__mux2_1_84/a_505_21# V3R008 VGND VGND sky130_fd_pr__nfet_01v8 ad=0.1092 pd=1.36 as=0 ps=0 w=0.42 l=0.15
X3487 sky130_fd_sc_hd__mux2_1_84/a_439_47# V3R001 sky130_fd_sc_hd__mux2_1_84/a_76_199# VGND sky130_fd_pr__nfet_01v8 ad=0 pd=0 as=0.1995 ps=1.79 w=0.42 l=0.15
X3488 sky130_fd_sc_hd__mux2_1_84/a_535_374# V3R041 sky130_fd_sc_hd__mux2_1_84/a_76_199# VDPWR sky130_fd_pr__pfet_01v8_hvt ad=0 pd=0 as=0 ps=0 w=0.42 l=0.15
X3489 sky130_fd_sc_hd__mux2_1_84/a_76_199# V3R041 sky130_fd_sc_hd__mux2_1_84/a_218_47# VGND sky130_fd_pr__nfet_01v8 ad=0 pd=0 as=0.1386 ps=1.5 w=0.42 l=0.15
X3490 sky130_fd_sc_hd__mux2_1_84/a_218_47# V3R008 VGND VGND sky130_fd_pr__nfet_01v8 ad=0 pd=0 as=0 ps=0 w=0.42 l=0.15
X3491 VDPWR sky130_fd_sc_hd__mux2_1_84/a_76_199# V3R236 VDPWR sky130_fd_pr__pfet_01v8_hvt ad=0 pd=0 as=0.26 ps=2.52 w=1 l=0.15
X3492 VGND sky130_fd_sc_hd__mux2_1_84/a_76_199# V3R236 VGND sky130_fd_pr__nfet_01v8 ad=0 pd=0 as=0.169 ps=1.82 w=0.65 l=0.15
X3493 VDPWR sky130_fd_sc_hd__mux2_1_95/a_505_21# sky130_fd_sc_hd__mux2_1_95/a_535_374# VDPWR sky130_fd_pr__pfet_01v8_hvt ad=0 pd=0 as=0.0882 ps=1.26 w=0.42 l=0.15
X3494 sky130_fd_sc_hd__mux2_1_95/a_505_21# V3R044 VDPWR VDPWR sky130_fd_pr__pfet_01v8_hvt ad=0.1176 pd=1.4 as=0 ps=0 w=0.42 l=0.15
X3495 sky130_fd_sc_hd__mux2_1_95/a_218_374# V3R044 VDPWR VDPWR sky130_fd_pr__pfet_01v8_hvt ad=0.1533 pd=1.57 as=0 ps=0 w=0.42 l=0.15
X3496 VGND sky130_fd_sc_hd__mux2_1_95/a_505_21# sky130_fd_sc_hd__mux2_1_95/a_439_47# VGND sky130_fd_pr__nfet_01v8 ad=0 pd=0 as=0.1386 ps=1.5 w=0.42 l=0.15
X3497 sky130_fd_sc_hd__mux2_1_95/a_76_199# V3R036 sky130_fd_sc_hd__mux2_1_95/a_218_374# VDPWR sky130_fd_pr__pfet_01v8_hvt ad=0.3864 pd=2.68 as=0 ps=0 w=0.42 l=0.15
X3498 sky130_fd_sc_hd__mux2_1_95/a_505_21# V3R044 VGND VGND sky130_fd_pr__nfet_01v8 ad=0.1092 pd=1.36 as=0 ps=0 w=0.42 l=0.15
X3499 sky130_fd_sc_hd__mux2_1_95/a_439_47# V3R036 sky130_fd_sc_hd__mux2_1_95/a_76_199# VGND sky130_fd_pr__nfet_01v8 ad=0 pd=0 as=0.1995 ps=1.79 w=0.42 l=0.15
X3500 sky130_fd_sc_hd__mux2_1_95/a_535_374# V3R175 sky130_fd_sc_hd__mux2_1_95/a_76_199# VDPWR sky130_fd_pr__pfet_01v8_hvt ad=0 pd=0 as=0 ps=0 w=0.42 l=0.15
X3501 sky130_fd_sc_hd__mux2_1_95/a_76_199# V3R175 sky130_fd_sc_hd__mux2_1_95/a_218_47# VGND sky130_fd_pr__nfet_01v8 ad=0 pd=0 as=0.1386 ps=1.5 w=0.42 l=0.15
X3502 sky130_fd_sc_hd__mux2_1_95/a_218_47# V3R044 VGND VGND sky130_fd_pr__nfet_01v8 ad=0 pd=0 as=0 ps=0 w=0.42 l=0.15
X3503 VDPWR sky130_fd_sc_hd__mux2_1_95/a_76_199# V3R121 VDPWR sky130_fd_pr__pfet_01v8_hvt ad=0 pd=0 as=0.26 ps=2.52 w=1 l=0.15
X3504 VGND sky130_fd_sc_hd__mux2_1_95/a_76_199# V3R121 VGND sky130_fd_pr__nfet_01v8 ad=0 pd=0 as=0.169 ps=1.82 w=0.65 l=0.15
X3505 VDPWR sky130_fd_sc_hd__mux2_1_73/a_505_21# sky130_fd_sc_hd__mux2_1_73/a_535_374# VDPWR sky130_fd_pr__pfet_01v8_hvt ad=0 pd=0 as=0.0882 ps=1.26 w=0.42 l=0.15
X3506 sky130_fd_sc_hd__mux2_1_73/a_505_21# V3R044 VDPWR VDPWR sky130_fd_pr__pfet_01v8_hvt ad=0.1176 pd=1.4 as=0 ps=0 w=0.42 l=0.15
X3507 sky130_fd_sc_hd__mux2_1_73/a_218_374# V3R044 VDPWR VDPWR sky130_fd_pr__pfet_01v8_hvt ad=0.1533 pd=1.57 as=0 ps=0 w=0.42 l=0.15
X3508 VGND sky130_fd_sc_hd__mux2_1_73/a_505_21# sky130_fd_sc_hd__mux2_1_73/a_439_47# VGND sky130_fd_pr__nfet_01v8 ad=0 pd=0 as=0.1386 ps=1.5 w=0.42 l=0.15
X3509 sky130_fd_sc_hd__mux2_1_73/a_76_199# V3R012 sky130_fd_sc_hd__mux2_1_73/a_218_374# VDPWR sky130_fd_pr__pfet_01v8_hvt ad=0.3864 pd=2.68 as=0 ps=0 w=0.42 l=0.15
X3510 sky130_fd_sc_hd__mux2_1_73/a_505_21# V3R044 VGND VGND sky130_fd_pr__nfet_01v8 ad=0.1092 pd=1.36 as=0 ps=0 w=0.42 l=0.15
X3511 sky130_fd_sc_hd__mux2_1_73/a_439_47# V3R012 sky130_fd_sc_hd__mux2_1_73/a_76_199# VGND sky130_fd_pr__nfet_01v8 ad=0 pd=0 as=0.1995 ps=1.79 w=0.42 l=0.15
X3512 sky130_fd_sc_hd__mux2_1_73/a_535_374# V3R151 sky130_fd_sc_hd__mux2_1_73/a_76_199# VDPWR sky130_fd_pr__pfet_01v8_hvt ad=0 pd=0 as=0 ps=0 w=0.42 l=0.15
X3513 sky130_fd_sc_hd__mux2_1_73/a_76_199# V3R151 sky130_fd_sc_hd__mux2_1_73/a_218_47# VGND sky130_fd_pr__nfet_01v8 ad=0 pd=0 as=0.1386 ps=1.5 w=0.42 l=0.15
X3514 sky130_fd_sc_hd__mux2_1_73/a_218_47# V3R044 VGND VGND sky130_fd_pr__nfet_01v8 ad=0 pd=0 as=0 ps=0 w=0.42 l=0.15
X3515 VDPWR sky130_fd_sc_hd__mux2_1_73/a_76_199# V3R128 VDPWR sky130_fd_pr__pfet_01v8_hvt ad=0 pd=0 as=0.26 ps=2.52 w=1 l=0.15
X3516 VGND sky130_fd_sc_hd__mux2_1_73/a_76_199# V3R128 VGND sky130_fd_pr__nfet_01v8 ad=0 pd=0 as=0.169 ps=1.82 w=0.65 l=0.15
X3517 VDPWR sky130_fd_sc_hd__buf_4_23/a_27_47# V3R063 VDPWR sky130_fd_pr__pfet_01v8_hvt ad=0 pd=0 as=0.54 ps=5.08 w=1 l=0.15
X3518 V3R063 sky130_fd_sc_hd__buf_4_23/a_27_47# VDPWR VDPWR sky130_fd_pr__pfet_01v8_hvt ad=0 pd=0 as=0 ps=0 w=1 l=0.15
X3519 VDPWR sky130_fd_sc_hd__buf_4_23/a_27_47# V3R063 VDPWR sky130_fd_pr__pfet_01v8_hvt ad=0 pd=0 as=0 ps=0 w=1 l=0.15
X3520 V3R063 sky130_fd_sc_hd__buf_4_23/a_27_47# VDPWR VDPWR sky130_fd_pr__pfet_01v8_hvt ad=0 pd=0 as=0 ps=0 w=1 l=0.15
X3521 V3R063 sky130_fd_sc_hd__buf_4_23/a_27_47# VGND VGND sky130_fd_pr__nfet_01v8 ad=0.351 pd=3.68 as=0 ps=0 w=0.65 l=0.15
X3522 V3R063 sky130_fd_sc_hd__buf_4_23/a_27_47# VGND VGND sky130_fd_pr__nfet_01v8 ad=0 pd=0 as=0 ps=0 w=0.65 l=0.15
X3523 VGND sky130_fd_sc_hd__buf_4_23/a_27_47# V3R063 VGND sky130_fd_pr__nfet_01v8 ad=0 pd=0 as=0 ps=0 w=0.65 l=0.15
X3524 VGND sky130_fd_sc_hd__buf_4_23/a_27_47# V3R063 VGND sky130_fd_pr__nfet_01v8 ad=0 pd=0 as=0 ps=0 w=0.65 l=0.15
X3525 VDPWR V3R060 sky130_fd_sc_hd__buf_4_23/a_27_47# VDPWR sky130_fd_pr__pfet_01v8_hvt ad=0 pd=0 as=0.26 ps=2.52 w=1 l=0.15
X3526 VGND V3R060 sky130_fd_sc_hd__buf_4_23/a_27_47# VGND sky130_fd_pr__nfet_01v8 ad=0 pd=0 as=0.169 ps=1.82 w=0.65 l=0.15
X3527 VDPWR sky130_fd_sc_hd__buf_4_12/a_27_47# V3R009 VDPWR sky130_fd_pr__pfet_01v8_hvt ad=0 pd=0 as=0.54 ps=5.08 w=1 l=0.15
X3528 V3R009 sky130_fd_sc_hd__buf_4_12/a_27_47# VDPWR VDPWR sky130_fd_pr__pfet_01v8_hvt ad=0 pd=0 as=0 ps=0 w=1 l=0.15
X3529 VDPWR sky130_fd_sc_hd__buf_4_12/a_27_47# V3R009 VDPWR sky130_fd_pr__pfet_01v8_hvt ad=0 pd=0 as=0 ps=0 w=1 l=0.15
X3530 V3R009 sky130_fd_sc_hd__buf_4_12/a_27_47# VDPWR VDPWR sky130_fd_pr__pfet_01v8_hvt ad=0 pd=0 as=0 ps=0 w=1 l=0.15
X3531 V3R009 sky130_fd_sc_hd__buf_4_12/a_27_47# VGND VGND sky130_fd_pr__nfet_01v8 ad=0.351 pd=3.68 as=0 ps=0 w=0.65 l=0.15
X3532 V3R009 sky130_fd_sc_hd__buf_4_12/a_27_47# VGND VGND sky130_fd_pr__nfet_01v8 ad=0 pd=0 as=0 ps=0 w=0.65 l=0.15
X3533 VGND sky130_fd_sc_hd__buf_4_12/a_27_47# V3R009 VGND sky130_fd_pr__nfet_01v8 ad=0 pd=0 as=0 ps=0 w=0.65 l=0.15
X3534 VGND sky130_fd_sc_hd__buf_4_12/a_27_47# V3R009 VGND sky130_fd_pr__nfet_01v8 ad=0 pd=0 as=0 ps=0 w=0.65 l=0.15
X3535 VDPWR V3R007 sky130_fd_sc_hd__buf_4_12/a_27_47# VDPWR sky130_fd_pr__pfet_01v8_hvt ad=0 pd=0 as=0.26 ps=2.52 w=1 l=0.15
X3536 VGND V3R007 sky130_fd_sc_hd__buf_4_12/a_27_47# VGND sky130_fd_pr__nfet_01v8 ad=0 pd=0 as=0.169 ps=1.82 w=0.65 l=0.15
X3537 VGND V3R285 sky130_fd_sc_hd__or2_1_3/a_68_297# VGND sky130_fd_pr__nfet_01v8 ad=0 pd=0 as=0.1134 ps=1.38 w=0.42 l=0.15
X3538 sky130_fd_sc_hd__or2_1_3/a_68_297# V3R269 VGND VGND sky130_fd_pr__nfet_01v8 ad=0 pd=0 as=0 ps=0 w=0.42 l=0.15
X3539 V3R286 sky130_fd_sc_hd__or2_1_3/a_68_297# VGND VGND sky130_fd_pr__nfet_01v8 ad=0.169 pd=1.82 as=0 ps=0 w=0.65 l=0.15
X3540 VDPWR V3R285 sky130_fd_sc_hd__or2_1_3/a_150_297# VDPWR sky130_fd_pr__pfet_01v8_hvt ad=0 pd=0 as=0.0882 ps=1.26 w=0.42 l=0.15
X3541 V3R286 sky130_fd_sc_hd__or2_1_3/a_68_297# VDPWR VDPWR sky130_fd_pr__pfet_01v8_hvt ad=0.34 pd=2.68 as=0 ps=0 w=1 l=0.15
X3542 sky130_fd_sc_hd__or2_1_3/a_150_297# V3R269 sky130_fd_sc_hd__or2_1_3/a_68_297# VDPWR sky130_fd_pr__pfet_01v8_hvt ad=0 pd=0 as=0.1092 ps=1.36 w=0.42 l=0.15
X3543 VDPWR sky130_fd_sc_hd__buf_4_5/a_27_47# V3R302 VDPWR sky130_fd_pr__pfet_01v8_hvt ad=0 pd=0 as=0.54 ps=5.08 w=1 l=0.15
X3544 V3R302 sky130_fd_sc_hd__buf_4_5/a_27_47# VDPWR VDPWR sky130_fd_pr__pfet_01v8_hvt ad=0 pd=0 as=0 ps=0 w=1 l=0.15
X3545 VDPWR sky130_fd_sc_hd__buf_4_5/a_27_47# V3R302 VDPWR sky130_fd_pr__pfet_01v8_hvt ad=0 pd=0 as=0 ps=0 w=1 l=0.15
X3546 V3R302 sky130_fd_sc_hd__buf_4_5/a_27_47# VDPWR VDPWR sky130_fd_pr__pfet_01v8_hvt ad=0 pd=0 as=0 ps=0 w=1 l=0.15
X3547 V3R302 sky130_fd_sc_hd__buf_4_5/a_27_47# VGND VGND sky130_fd_pr__nfet_01v8 ad=0.351 pd=3.68 as=0 ps=0 w=0.65 l=0.15
X3548 V3R302 sky130_fd_sc_hd__buf_4_5/a_27_47# VGND VGND sky130_fd_pr__nfet_01v8 ad=0 pd=0 as=0 ps=0 w=0.65 l=0.15
X3549 VGND sky130_fd_sc_hd__buf_4_5/a_27_47# V3R302 VGND sky130_fd_pr__nfet_01v8 ad=0 pd=0 as=0 ps=0 w=0.65 l=0.15
X3550 VGND sky130_fd_sc_hd__buf_4_5/a_27_47# V3R302 VGND sky130_fd_pr__nfet_01v8 ad=0 pd=0 as=0 ps=0 w=0.65 l=0.15
X3551 VDPWR V3R297 sky130_fd_sc_hd__buf_4_5/a_27_47# VDPWR sky130_fd_pr__pfet_01v8_hvt ad=0 pd=0 as=0.26 ps=2.52 w=1 l=0.15
X3552 VGND V3R297 sky130_fd_sc_hd__buf_4_5/a_27_47# VGND sky130_fd_pr__nfet_01v8 ad=0 pd=0 as=0.169 ps=1.82 w=0.65 l=0.15
X3553 VDPWR V3R008 sky130_fd_sc_hd__and2_1_8/a_59_75# VDPWR sky130_fd_pr__pfet_01v8_hvt ad=0 pd=0 as=0.1134 ps=1.38 w=0.42 l=0.15
X3554 V3R232 sky130_fd_sc_hd__and2_1_8/a_59_75# VDPWR VDPWR sky130_fd_pr__pfet_01v8_hvt ad=0.475 pd=2.95 as=0 ps=0 w=1 l=0.15
X3555 VGND V3R008 sky130_fd_sc_hd__and2_1_8/a_145_75# VGND sky130_fd_pr__nfet_01v8 ad=0 pd=0 as=0.1134 ps=1.38 w=0.42 l=0.15
X3556 sky130_fd_sc_hd__and2_1_8/a_59_75# V3R037 VDPWR VDPWR sky130_fd_pr__pfet_01v8_hvt ad=0 pd=0 as=0 ps=0 w=0.42 l=0.15
X3557 V3R232 sky130_fd_sc_hd__and2_1_8/a_59_75# VGND VGND sky130_fd_pr__nfet_01v8 ad=0.182 pd=1.86 as=0 ps=0 w=0.65 l=0.15
X3558 sky130_fd_sc_hd__and2_1_8/a_145_75# V3R037 sky130_fd_sc_hd__and2_1_8/a_59_75# VGND sky130_fd_pr__nfet_01v8 ad=0 pd=0 as=0.1176 ps=1.4 w=0.42 l=0.15
X3559 VDPWR sky130_fd_sc_hd__mux2_1_74/a_505_21# sky130_fd_sc_hd__mux2_1_74/a_535_374# VDPWR sky130_fd_pr__pfet_01v8_hvt ad=0 pd=0 as=0.0882 ps=1.26 w=0.42 l=0.15
X3560 sky130_fd_sc_hd__mux2_1_74/a_505_21# V3R240 VDPWR VDPWR sky130_fd_pr__pfet_01v8_hvt ad=0.1176 pd=1.4 as=0 ps=0 w=0.42 l=0.15
X3561 sky130_fd_sc_hd__mux2_1_74/a_218_374# V3R240 VDPWR VDPWR sky130_fd_pr__pfet_01v8_hvt ad=0.1533 pd=1.57 as=0 ps=0 w=0.42 l=0.15
X3562 VGND sky130_fd_sc_hd__mux2_1_74/a_505_21# sky130_fd_sc_hd__mux2_1_74/a_439_47# VGND sky130_fd_pr__nfet_01v8 ad=0 pd=0 as=0.1386 ps=1.5 w=0.42 l=0.15
X3563 sky130_fd_sc_hd__mux2_1_74/a_76_199# V3R005 sky130_fd_sc_hd__mux2_1_74/a_218_374# VDPWR sky130_fd_pr__pfet_01v8_hvt ad=0.3864 pd=2.68 as=0 ps=0 w=0.42 l=0.15
X3564 sky130_fd_sc_hd__mux2_1_74/a_505_21# V3R240 VGND VGND sky130_fd_pr__nfet_01v8 ad=0.1092 pd=1.36 as=0 ps=0 w=0.42 l=0.15
X3565 sky130_fd_sc_hd__mux2_1_74/a_439_47# V3R005 sky130_fd_sc_hd__mux2_1_74/a_76_199# VGND sky130_fd_pr__nfet_01v8 ad=0 pd=0 as=0.1995 ps=1.79 w=0.42 l=0.15
X3566 sky130_fd_sc_hd__mux2_1_74/a_535_374# V3R265 sky130_fd_sc_hd__mux2_1_74/a_76_199# VDPWR sky130_fd_pr__pfet_01v8_hvt ad=0 pd=0 as=0 ps=0 w=0.42 l=0.15
X3567 sky130_fd_sc_hd__mux2_1_74/a_76_199# V3R265 sky130_fd_sc_hd__mux2_1_74/a_218_47# VGND sky130_fd_pr__nfet_01v8 ad=0 pd=0 as=0.1386 ps=1.5 w=0.42 l=0.15
X3568 sky130_fd_sc_hd__mux2_1_74/a_218_47# V3R240 VGND VGND sky130_fd_pr__nfet_01v8 ad=0 pd=0 as=0 ps=0 w=0.42 l=0.15
X3569 VDPWR sky130_fd_sc_hd__mux2_1_74/a_76_199# V3R189 VDPWR sky130_fd_pr__pfet_01v8_hvt ad=0 pd=0 as=0.26 ps=2.52 w=1 l=0.15
X3570 VGND sky130_fd_sc_hd__mux2_1_74/a_76_199# V3R189 VGND sky130_fd_pr__nfet_01v8 ad=0 pd=0 as=0.169 ps=1.82 w=0.65 l=0.15
X3571 VDPWR sky130_fd_sc_hd__mux2_1_63/a_505_21# sky130_fd_sc_hd__mux2_1_63/a_535_374# VDPWR sky130_fd_pr__pfet_01v8_hvt ad=0 pd=0 as=0.0882 ps=1.26 w=0.42 l=0.15
X3572 sky130_fd_sc_hd__mux2_1_63/a_505_21# V3R061 VDPWR VDPWR sky130_fd_pr__pfet_01v8_hvt ad=0.1176 pd=1.4 as=0 ps=0 w=0.42 l=0.15
X3573 sky130_fd_sc_hd__mux2_1_63/a_218_374# V3R061 VDPWR VDPWR sky130_fd_pr__pfet_01v8_hvt ad=0.1533 pd=1.57 as=0 ps=0 w=0.42 l=0.15
X3574 VGND sky130_fd_sc_hd__mux2_1_63/a_505_21# sky130_fd_sc_hd__mux2_1_63/a_439_47# VGND sky130_fd_pr__nfet_01v8 ad=0 pd=0 as=0.1386 ps=1.5 w=0.42 l=0.15
X3575 sky130_fd_sc_hd__mux2_1_63/a_76_199# V3R155 sky130_fd_sc_hd__mux2_1_63/a_218_374# VDPWR sky130_fd_pr__pfet_01v8_hvt ad=0.3864 pd=2.68 as=0 ps=0 w=0.42 l=0.15
X3576 sky130_fd_sc_hd__mux2_1_63/a_505_21# V3R061 VGND VGND sky130_fd_pr__nfet_01v8 ad=0.1092 pd=1.36 as=0 ps=0 w=0.42 l=0.15
X3577 sky130_fd_sc_hd__mux2_1_63/a_439_47# V3R155 sky130_fd_sc_hd__mux2_1_63/a_76_199# VGND sky130_fd_pr__nfet_01v8 ad=0 pd=0 as=0.1995 ps=1.79 w=0.42 l=0.15
X3578 sky130_fd_sc_hd__mux2_1_63/a_535_374# V3R154 sky130_fd_sc_hd__mux2_1_63/a_76_199# VDPWR sky130_fd_pr__pfet_01v8_hvt ad=0 pd=0 as=0 ps=0 w=0.42 l=0.15
X3579 sky130_fd_sc_hd__mux2_1_63/a_76_199# V3R154 sky130_fd_sc_hd__mux2_1_63/a_218_47# VGND sky130_fd_pr__nfet_01v8 ad=0 pd=0 as=0.1386 ps=1.5 w=0.42 l=0.15
X3580 sky130_fd_sc_hd__mux2_1_63/a_218_47# V3R061 VGND VGND sky130_fd_pr__nfet_01v8 ad=0 pd=0 as=0 ps=0 w=0.42 l=0.15
X3581 VDPWR sky130_fd_sc_hd__mux2_1_63/a_76_199# V3R099 VDPWR sky130_fd_pr__pfet_01v8_hvt ad=0 pd=0 as=0.26 ps=2.52 w=1 l=0.15
X3582 VGND sky130_fd_sc_hd__mux2_1_63/a_76_199# V3R099 VGND sky130_fd_pr__nfet_01v8 ad=0 pd=0 as=0.169 ps=1.82 w=0.65 l=0.15
X3583 VDPWR sky130_fd_sc_hd__mux2_1_52/a_505_21# sky130_fd_sc_hd__mux2_1_52/a_535_374# VDPWR sky130_fd_pr__pfet_01v8_hvt ad=0 pd=0 as=0.0882 ps=1.26 w=0.42 l=0.15
X3584 sky130_fd_sc_hd__mux2_1_52/a_505_21# V3R009 VDPWR VDPWR sky130_fd_pr__pfet_01v8_hvt ad=0.1176 pd=1.4 as=0 ps=0 w=0.42 l=0.15
X3585 sky130_fd_sc_hd__mux2_1_52/a_218_374# V3R009 VDPWR VDPWR sky130_fd_pr__pfet_01v8_hvt ad=0.1533 pd=1.57 as=0 ps=0 w=0.42 l=0.15
X3586 VGND sky130_fd_sc_hd__mux2_1_52/a_505_21# sky130_fd_sc_hd__mux2_1_52/a_439_47# VGND sky130_fd_pr__nfet_01v8 ad=0 pd=0 as=0.1386 ps=1.5 w=0.42 l=0.15
X3587 sky130_fd_sc_hd__mux2_1_52/a_76_199# V3R000 sky130_fd_sc_hd__mux2_1_52/a_218_374# VDPWR sky130_fd_pr__pfet_01v8_hvt ad=0.3864 pd=2.68 as=0 ps=0 w=0.42 l=0.15
X3588 sky130_fd_sc_hd__mux2_1_52/a_505_21# V3R009 VGND VGND sky130_fd_pr__nfet_01v8 ad=0.1092 pd=1.36 as=0 ps=0 w=0.42 l=0.15
X3589 sky130_fd_sc_hd__mux2_1_52/a_439_47# V3R000 sky130_fd_sc_hd__mux2_1_52/a_76_199# VGND sky130_fd_pr__nfet_01v8 ad=0 pd=0 as=0.1995 ps=1.79 w=0.42 l=0.15
X3590 sky130_fd_sc_hd__mux2_1_52/a_535_374# V3R018 sky130_fd_sc_hd__mux2_1_52/a_76_199# VDPWR sky130_fd_pr__pfet_01v8_hvt ad=0 pd=0 as=0 ps=0 w=0.42 l=0.15
X3591 sky130_fd_sc_hd__mux2_1_52/a_76_199# V3R018 sky130_fd_sc_hd__mux2_1_52/a_218_47# VGND sky130_fd_pr__nfet_01v8 ad=0 pd=0 as=0.1386 ps=1.5 w=0.42 l=0.15
X3592 sky130_fd_sc_hd__mux2_1_52/a_218_47# V3R009 VGND VGND sky130_fd_pr__nfet_01v8 ad=0 pd=0 as=0 ps=0 w=0.42 l=0.15
X3593 VDPWR sky130_fd_sc_hd__mux2_1_52/a_76_199# V3R213 VDPWR sky130_fd_pr__pfet_01v8_hvt ad=0 pd=0 as=0.26 ps=2.52 w=1 l=0.15
X3594 VGND sky130_fd_sc_hd__mux2_1_52/a_76_199# V3R213 VGND sky130_fd_pr__nfet_01v8 ad=0 pd=0 as=0.169 ps=1.82 w=0.65 l=0.15
X3595 VDPWR sky130_fd_sc_hd__mux2_1_30/a_505_21# sky130_fd_sc_hd__mux2_1_30/a_535_374# VDPWR sky130_fd_pr__pfet_01v8_hvt ad=0 pd=0 as=0.0882 ps=1.26 w=0.42 l=0.15
X3596 sky130_fd_sc_hd__mux2_1_30/a_505_21# V3R062 VDPWR VDPWR sky130_fd_pr__pfet_01v8_hvt ad=0.1176 pd=1.4 as=0 ps=0 w=0.42 l=0.15
X3597 sky130_fd_sc_hd__mux2_1_30/a_218_374# V3R062 VDPWR VDPWR sky130_fd_pr__pfet_01v8_hvt ad=0.1533 pd=1.57 as=0 ps=0 w=0.42 l=0.15
X3598 VGND sky130_fd_sc_hd__mux2_1_30/a_505_21# sky130_fd_sc_hd__mux2_1_30/a_439_47# VGND sky130_fd_pr__nfet_01v8 ad=0 pd=0 as=0.1386 ps=1.5 w=0.42 l=0.15
X3599 sky130_fd_sc_hd__mux2_1_30/a_76_199# V3R165 sky130_fd_sc_hd__mux2_1_30/a_218_374# VDPWR sky130_fd_pr__pfet_01v8_hvt ad=0.3864 pd=2.68 as=0 ps=0 w=0.42 l=0.15
X3600 sky130_fd_sc_hd__mux2_1_30/a_505_21# V3R062 VGND VGND sky130_fd_pr__nfet_01v8 ad=0.1092 pd=1.36 as=0 ps=0 w=0.42 l=0.15
X3601 sky130_fd_sc_hd__mux2_1_30/a_439_47# V3R165 sky130_fd_sc_hd__mux2_1_30/a_76_199# VGND sky130_fd_pr__nfet_01v8 ad=0 pd=0 as=0.1995 ps=1.79 w=0.42 l=0.15
X3602 sky130_fd_sc_hd__mux2_1_30/a_535_374# V3R164 sky130_fd_sc_hd__mux2_1_30/a_76_199# VDPWR sky130_fd_pr__pfet_01v8_hvt ad=0 pd=0 as=0 ps=0 w=0.42 l=0.15
X3603 sky130_fd_sc_hd__mux2_1_30/a_76_199# V3R164 sky130_fd_sc_hd__mux2_1_30/a_218_47# VGND sky130_fd_pr__nfet_01v8 ad=0 pd=0 as=0.1386 ps=1.5 w=0.42 l=0.15
X3604 sky130_fd_sc_hd__mux2_1_30/a_218_47# V3R062 VGND VGND sky130_fd_pr__nfet_01v8 ad=0 pd=0 as=0 ps=0 w=0.42 l=0.15
X3605 VDPWR sky130_fd_sc_hd__mux2_1_30/a_76_199# V3R108 VDPWR sky130_fd_pr__pfet_01v8_hvt ad=0 pd=0 as=0.26 ps=2.52 w=1 l=0.15
X3606 VGND sky130_fd_sc_hd__mux2_1_30/a_76_199# V3R108 VGND sky130_fd_pr__nfet_01v8 ad=0 pd=0 as=0.169 ps=1.82 w=0.65 l=0.15
X3607 VDPWR sky130_fd_sc_hd__mux2_1_85/a_505_21# sky130_fd_sc_hd__mux2_1_85/a_535_374# VDPWR sky130_fd_pr__pfet_01v8_hvt ad=0 pd=0 as=0.0882 ps=1.26 w=0.42 l=0.15
X3608 sky130_fd_sc_hd__mux2_1_85/a_505_21# V3R061 VDPWR VDPWR sky130_fd_pr__pfet_01v8_hvt ad=0.1176 pd=1.4 as=0 ps=0 w=0.42 l=0.15
X3609 sky130_fd_sc_hd__mux2_1_85/a_218_374# V3R061 VDPWR VDPWR sky130_fd_pr__pfet_01v8_hvt ad=0.1533 pd=1.57 as=0 ps=0 w=0.42 l=0.15
X3610 VGND sky130_fd_sc_hd__mux2_1_85/a_505_21# sky130_fd_sc_hd__mux2_1_85/a_439_47# VGND sky130_fd_pr__nfet_01v8 ad=0 pd=0 as=0.1386 ps=1.5 w=0.42 l=0.15
X3611 sky130_fd_sc_hd__mux2_1_85/a_76_199# V3R180 sky130_fd_sc_hd__mux2_1_85/a_218_374# VDPWR sky130_fd_pr__pfet_01v8_hvt ad=0.3864 pd=2.68 as=0 ps=0 w=0.42 l=0.15
X3612 sky130_fd_sc_hd__mux2_1_85/a_505_21# V3R061 VGND VGND sky130_fd_pr__nfet_01v8 ad=0.1092 pd=1.36 as=0 ps=0 w=0.42 l=0.15
X3613 sky130_fd_sc_hd__mux2_1_85/a_439_47# V3R180 sky130_fd_sc_hd__mux2_1_85/a_76_199# VGND sky130_fd_pr__nfet_01v8 ad=0 pd=0 as=0.1995 ps=1.79 w=0.42 l=0.15
X3614 sky130_fd_sc_hd__mux2_1_85/a_535_374# V3R179 sky130_fd_sc_hd__mux2_1_85/a_76_199# VDPWR sky130_fd_pr__pfet_01v8_hvt ad=0 pd=0 as=0 ps=0 w=0.42 l=0.15
X3615 sky130_fd_sc_hd__mux2_1_85/a_76_199# V3R179 sky130_fd_sc_hd__mux2_1_85/a_218_47# VGND sky130_fd_pr__nfet_01v8 ad=0 pd=0 as=0.1386 ps=1.5 w=0.42 l=0.15
X3616 sky130_fd_sc_hd__mux2_1_85/a_218_47# V3R061 VGND VGND sky130_fd_pr__nfet_01v8 ad=0 pd=0 as=0 ps=0 w=0.42 l=0.15
X3617 VDPWR sky130_fd_sc_hd__mux2_1_85/a_76_199# V3R093 VDPWR sky130_fd_pr__pfet_01v8_hvt ad=0 pd=0 as=0.26 ps=2.52 w=1 l=0.15
X3618 VGND sky130_fd_sc_hd__mux2_1_85/a_76_199# V3R093 VGND sky130_fd_pr__nfet_01v8 ad=0 pd=0 as=0.169 ps=1.82 w=0.65 l=0.15
X3619 VDPWR sky130_fd_sc_hd__mux2_1_41/a_505_21# sky130_fd_sc_hd__mux2_1_41/a_535_374# VDPWR sky130_fd_pr__pfet_01v8_hvt ad=0 pd=0 as=0.0882 ps=1.26 w=0.42 l=0.15
X3620 sky130_fd_sc_hd__mux2_1_41/a_505_21# V3R062 VDPWR VDPWR sky130_fd_pr__pfet_01v8_hvt ad=0.1176 pd=1.4 as=0 ps=0 w=0.42 l=0.15
X3621 sky130_fd_sc_hd__mux2_1_41/a_218_374# V3R062 VDPWR VDPWR sky130_fd_pr__pfet_01v8_hvt ad=0.1533 pd=1.57 as=0 ps=0 w=0.42 l=0.15
X3622 VGND sky130_fd_sc_hd__mux2_1_41/a_505_21# sky130_fd_sc_hd__mux2_1_41/a_439_47# VGND sky130_fd_pr__nfet_01v8 ad=0 pd=0 as=0.1386 ps=1.5 w=0.42 l=0.15
X3623 sky130_fd_sc_hd__mux2_1_41/a_76_199# V3R162 sky130_fd_sc_hd__mux2_1_41/a_218_374# VDPWR sky130_fd_pr__pfet_01v8_hvt ad=0.3864 pd=2.68 as=0 ps=0 w=0.42 l=0.15
X3624 sky130_fd_sc_hd__mux2_1_41/a_505_21# V3R062 VGND VGND sky130_fd_pr__nfet_01v8 ad=0.1092 pd=1.36 as=0 ps=0 w=0.42 l=0.15
X3625 sky130_fd_sc_hd__mux2_1_41/a_439_47# V3R162 sky130_fd_sc_hd__mux2_1_41/a_76_199# VGND sky130_fd_pr__nfet_01v8 ad=0 pd=0 as=0.1995 ps=1.79 w=0.42 l=0.15
X3626 sky130_fd_sc_hd__mux2_1_41/a_535_374# V3R160 sky130_fd_sc_hd__mux2_1_41/a_76_199# VDPWR sky130_fd_pr__pfet_01v8_hvt ad=0 pd=0 as=0 ps=0 w=0.42 l=0.15
X3627 sky130_fd_sc_hd__mux2_1_41/a_76_199# V3R160 sky130_fd_sc_hd__mux2_1_41/a_218_47# VGND sky130_fd_pr__nfet_01v8 ad=0 pd=0 as=0.1386 ps=1.5 w=0.42 l=0.15
X3628 sky130_fd_sc_hd__mux2_1_41/a_218_47# V3R062 VGND VGND sky130_fd_pr__nfet_01v8 ad=0 pd=0 as=0 ps=0 w=0.42 l=0.15
X3629 VDPWR sky130_fd_sc_hd__mux2_1_41/a_76_199# V3R105 VDPWR sky130_fd_pr__pfet_01v8_hvt ad=0 pd=0 as=0.26 ps=2.52 w=1 l=0.15
X3630 VGND sky130_fd_sc_hd__mux2_1_41/a_76_199# V3R105 VGND sky130_fd_pr__nfet_01v8 ad=0 pd=0 as=0.169 ps=1.82 w=0.65 l=0.15
X3631 VDPWR sky130_fd_sc_hd__mux2_1_96/a_505_21# sky130_fd_sc_hd__mux2_1_96/a_535_374# VDPWR sky130_fd_pr__pfet_01v8_hvt ad=0 pd=0 as=0.0882 ps=1.26 w=0.42 l=0.15
X3632 sky130_fd_sc_hd__mux2_1_96/a_505_21# V3R061 VDPWR VDPWR sky130_fd_pr__pfet_01v8_hvt ad=0.1176 pd=1.4 as=0 ps=0 w=0.42 l=0.15
X3633 sky130_fd_sc_hd__mux2_1_96/a_218_374# V3R061 VDPWR VDPWR sky130_fd_pr__pfet_01v8_hvt ad=0.1533 pd=1.57 as=0 ps=0 w=0.42 l=0.15
X3634 VGND sky130_fd_sc_hd__mux2_1_96/a_505_21# sky130_fd_sc_hd__mux2_1_96/a_439_47# VGND sky130_fd_pr__nfet_01v8 ad=0 pd=0 as=0.1386 ps=1.5 w=0.42 l=0.15
X3635 sky130_fd_sc_hd__mux2_1_96/a_76_199# V3R175 sky130_fd_sc_hd__mux2_1_96/a_218_374# VDPWR sky130_fd_pr__pfet_01v8_hvt ad=0.3864 pd=2.68 as=0 ps=0 w=0.42 l=0.15
X3636 sky130_fd_sc_hd__mux2_1_96/a_505_21# V3R061 VGND VGND sky130_fd_pr__nfet_01v8 ad=0.1092 pd=1.36 as=0 ps=0 w=0.42 l=0.15
X3637 sky130_fd_sc_hd__mux2_1_96/a_439_47# V3R175 sky130_fd_sc_hd__mux2_1_96/a_76_199# VGND sky130_fd_pr__nfet_01v8 ad=0 pd=0 as=0.1995 ps=1.79 w=0.42 l=0.15
X3638 sky130_fd_sc_hd__mux2_1_96/a_535_374# V3R172 sky130_fd_sc_hd__mux2_1_96/a_76_199# VDPWR sky130_fd_pr__pfet_01v8_hvt ad=0 pd=0 as=0 ps=0 w=0.42 l=0.15
X3639 sky130_fd_sc_hd__mux2_1_96/a_76_199# V3R172 sky130_fd_sc_hd__mux2_1_96/a_218_47# VGND sky130_fd_pr__nfet_01v8 ad=0 pd=0 as=0.1386 ps=1.5 w=0.42 l=0.15
X3640 sky130_fd_sc_hd__mux2_1_96/a_218_47# V3R061 VGND VGND sky130_fd_pr__nfet_01v8 ad=0 pd=0 as=0 ps=0 w=0.42 l=0.15
X3641 VDPWR sky130_fd_sc_hd__mux2_1_96/a_76_199# V3R088 VDPWR sky130_fd_pr__pfet_01v8_hvt ad=0 pd=0 as=0.26 ps=2.52 w=1 l=0.15
X3642 VGND sky130_fd_sc_hd__mux2_1_96/a_76_199# V3R088 VGND sky130_fd_pr__nfet_01v8 ad=0 pd=0 as=0.169 ps=1.82 w=0.65 l=0.15
X3643 VDPWR sky130_fd_sc_hd__buf_4_13/a_27_47# V3R304 VDPWR sky130_fd_pr__pfet_01v8_hvt ad=0 pd=0 as=0.54 ps=5.08 w=1 l=0.15
X3644 V3R304 sky130_fd_sc_hd__buf_4_13/a_27_47# VDPWR VDPWR sky130_fd_pr__pfet_01v8_hvt ad=0 pd=0 as=0 ps=0 w=1 l=0.15
X3645 VDPWR sky130_fd_sc_hd__buf_4_13/a_27_47# V3R304 VDPWR sky130_fd_pr__pfet_01v8_hvt ad=0 pd=0 as=0 ps=0 w=1 l=0.15
X3646 V3R304 sky130_fd_sc_hd__buf_4_13/a_27_47# VDPWR VDPWR sky130_fd_pr__pfet_01v8_hvt ad=0 pd=0 as=0 ps=0 w=1 l=0.15
X3647 V3R304 sky130_fd_sc_hd__buf_4_13/a_27_47# VGND VGND sky130_fd_pr__nfet_01v8 ad=0.351 pd=3.68 as=0 ps=0 w=0.65 l=0.15
X3648 V3R304 sky130_fd_sc_hd__buf_4_13/a_27_47# VGND VGND sky130_fd_pr__nfet_01v8 ad=0 pd=0 as=0 ps=0 w=0.65 l=0.15
X3649 VGND sky130_fd_sc_hd__buf_4_13/a_27_47# V3R304 VGND sky130_fd_pr__nfet_01v8 ad=0 pd=0 as=0 ps=0 w=0.65 l=0.15
X3650 VGND sky130_fd_sc_hd__buf_4_13/a_27_47# V3R304 VGND sky130_fd_pr__nfet_01v8 ad=0 pd=0 as=0 ps=0 w=0.65 l=0.15
X3651 VDPWR V3R297 sky130_fd_sc_hd__buf_4_13/a_27_47# VDPWR sky130_fd_pr__pfet_01v8_hvt ad=0 pd=0 as=0.26 ps=2.52 w=1 l=0.15
X3652 VGND V3R297 sky130_fd_sc_hd__buf_4_13/a_27_47# VGND sky130_fd_pr__nfet_01v8 ad=0 pd=0 as=0.169 ps=1.82 w=0.65 l=0.15
X3653 VGND V3R248 sky130_fd_sc_hd__or2_1_4/a_68_297# VGND sky130_fd_pr__nfet_01v8 ad=0 pd=0 as=0.1134 ps=1.38 w=0.42 l=0.15
X3654 sky130_fd_sc_hd__or2_1_4/a_68_297# V3R247 VGND VGND sky130_fd_pr__nfet_01v8 ad=0 pd=0 as=0 ps=0 w=0.42 l=0.15
X3655 V3R249 sky130_fd_sc_hd__or2_1_4/a_68_297# VGND VGND sky130_fd_pr__nfet_01v8 ad=0.169 pd=1.82 as=0 ps=0 w=0.65 l=0.15
X3656 VDPWR V3R248 sky130_fd_sc_hd__or2_1_4/a_150_297# VDPWR sky130_fd_pr__pfet_01v8_hvt ad=0 pd=0 as=0.0882 ps=1.26 w=0.42 l=0.15
X3657 V3R249 sky130_fd_sc_hd__or2_1_4/a_68_297# VDPWR VDPWR sky130_fd_pr__pfet_01v8_hvt ad=0.34 pd=2.68 as=0 ps=0 w=1 l=0.15
X3658 sky130_fd_sc_hd__or2_1_4/a_150_297# V3R247 sky130_fd_sc_hd__or2_1_4/a_68_297# VDPWR sky130_fd_pr__pfet_01v8_hvt ad=0 pd=0 as=0.1092 ps=1.36 w=0.42 l=0.15
X3659 VDPWR sky130_fd_sc_hd__buf_4_6/a_27_47# V3R084 VDPWR sky130_fd_pr__pfet_01v8_hvt ad=0 pd=0 as=0.54 ps=5.08 w=1 l=0.15
X3660 V3R084 sky130_fd_sc_hd__buf_4_6/a_27_47# VDPWR VDPWR sky130_fd_pr__pfet_01v8_hvt ad=0 pd=0 as=0 ps=0 w=1 l=0.15
X3661 VDPWR sky130_fd_sc_hd__buf_4_6/a_27_47# V3R084 VDPWR sky130_fd_pr__pfet_01v8_hvt ad=0 pd=0 as=0 ps=0 w=1 l=0.15
X3662 V3R084 sky130_fd_sc_hd__buf_4_6/a_27_47# VDPWR VDPWR sky130_fd_pr__pfet_01v8_hvt ad=0 pd=0 as=0 ps=0 w=1 l=0.15
X3663 V3R084 sky130_fd_sc_hd__buf_4_6/a_27_47# VGND VGND sky130_fd_pr__nfet_01v8 ad=0.351 pd=3.68 as=0 ps=0 w=0.65 l=0.15
X3664 V3R084 sky130_fd_sc_hd__buf_4_6/a_27_47# VGND VGND sky130_fd_pr__nfet_01v8 ad=0 pd=0 as=0 ps=0 w=0.65 l=0.15
X3665 VGND sky130_fd_sc_hd__buf_4_6/a_27_47# V3R084 VGND sky130_fd_pr__nfet_01v8 ad=0 pd=0 as=0 ps=0 w=0.65 l=0.15
X3666 VGND sky130_fd_sc_hd__buf_4_6/a_27_47# V3R084 VGND sky130_fd_pr__nfet_01v8 ad=0 pd=0 as=0 ps=0 w=0.65 l=0.15
X3667 VDPWR V3R080 sky130_fd_sc_hd__buf_4_6/a_27_47# VDPWR sky130_fd_pr__pfet_01v8_hvt ad=0 pd=0 as=0.26 ps=2.52 w=1 l=0.15
X3668 VGND V3R080 sky130_fd_sc_hd__buf_4_6/a_27_47# VGND sky130_fd_pr__nfet_01v8 ad=0 pd=0 as=0.169 ps=1.82 w=0.65 l=0.15
X3669 VDPWR V3R008 sky130_fd_sc_hd__and2_1_9/a_59_75# VDPWR sky130_fd_pr__pfet_01v8_hvt ad=0 pd=0 as=0.1134 ps=1.38 w=0.42 l=0.15
X3670 V3R228 sky130_fd_sc_hd__and2_1_9/a_59_75# VDPWR VDPWR sky130_fd_pr__pfet_01v8_hvt ad=0.475 pd=2.95 as=0 ps=0 w=1 l=0.15
X3671 VGND V3R008 sky130_fd_sc_hd__and2_1_9/a_145_75# VGND sky130_fd_pr__nfet_01v8 ad=0 pd=0 as=0.1134 ps=1.38 w=0.42 l=0.15
X3672 sky130_fd_sc_hd__and2_1_9/a_59_75# V3R033 VDPWR VDPWR sky130_fd_pr__pfet_01v8_hvt ad=0 pd=0 as=0 ps=0 w=0.42 l=0.15
X3673 V3R228 sky130_fd_sc_hd__and2_1_9/a_59_75# VGND VGND sky130_fd_pr__nfet_01v8 ad=0.182 pd=1.86 as=0 ps=0 w=0.65 l=0.15
X3674 sky130_fd_sc_hd__and2_1_9/a_145_75# V3R033 sky130_fd_sc_hd__and2_1_9/a_59_75# VGND sky130_fd_pr__nfet_01v8 ad=0 pd=0 as=0.1176 ps=1.4 w=0.42 l=0.15
X3675 VDPWR sky130_fd_sc_hd__mux2_1_97/a_505_21# sky130_fd_sc_hd__mux2_1_97/a_535_374# VDPWR sky130_fd_pr__pfet_01v8_hvt ad=0 pd=0 as=0.0882 ps=1.26 w=0.42 l=0.15
X3676 sky130_fd_sc_hd__mux2_1_97/a_505_21# V3R044 VDPWR VDPWR sky130_fd_pr__pfet_01v8_hvt ad=0.1176 pd=1.4 as=0 ps=0 w=0.42 l=0.15
X3677 sky130_fd_sc_hd__mux2_1_97/a_218_374# V3R044 VDPWR VDPWR sky130_fd_pr__pfet_01v8_hvt ad=0.1533 pd=1.57 as=0 ps=0 w=0.42 l=0.15
X3678 VGND sky130_fd_sc_hd__mux2_1_97/a_505_21# sky130_fd_sc_hd__mux2_1_97/a_439_47# VGND sky130_fd_pr__nfet_01v8 ad=0 pd=0 as=0.1386 ps=1.5 w=0.42 l=0.15
X3679 sky130_fd_sc_hd__mux2_1_97/a_76_199# V3R033 sky130_fd_sc_hd__mux2_1_97/a_218_374# VDPWR sky130_fd_pr__pfet_01v8_hvt ad=0.3864 pd=2.68 as=0 ps=0 w=0.42 l=0.15
X3680 sky130_fd_sc_hd__mux2_1_97/a_505_21# V3R044 VGND VGND sky130_fd_pr__nfet_01v8 ad=0.1092 pd=1.36 as=0 ps=0 w=0.42 l=0.15
X3681 sky130_fd_sc_hd__mux2_1_97/a_439_47# V3R033 sky130_fd_sc_hd__mux2_1_97/a_76_199# VGND sky130_fd_pr__nfet_01v8 ad=0 pd=0 as=0.1995 ps=1.79 w=0.42 l=0.15
X3682 sky130_fd_sc_hd__mux2_1_97/a_535_374# V3R172 sky130_fd_sc_hd__mux2_1_97/a_76_199# VDPWR sky130_fd_pr__pfet_01v8_hvt ad=0 pd=0 as=0 ps=0 w=0.42 l=0.15
X3683 sky130_fd_sc_hd__mux2_1_97/a_76_199# V3R172 sky130_fd_sc_hd__mux2_1_97/a_218_47# VGND sky130_fd_pr__nfet_01v8 ad=0 pd=0 as=0.1386 ps=1.5 w=0.42 l=0.15
X3684 sky130_fd_sc_hd__mux2_1_97/a_218_47# V3R044 VGND VGND sky130_fd_pr__nfet_01v8 ad=0 pd=0 as=0 ps=0 w=0.42 l=0.15
X3685 VDPWR sky130_fd_sc_hd__mux2_1_97/a_76_199# V3R120 VDPWR sky130_fd_pr__pfet_01v8_hvt ad=0 pd=0 as=0.26 ps=2.52 w=1 l=0.15
X3686 VGND sky130_fd_sc_hd__mux2_1_97/a_76_199# V3R120 VGND sky130_fd_pr__nfet_01v8 ad=0 pd=0 as=0.169 ps=1.82 w=0.65 l=0.15
X3687 VDPWR sky130_fd_sc_hd__mux2_1_86/a_505_21# sky130_fd_sc_hd__mux2_1_86/a_535_374# VDPWR sky130_fd_pr__pfet_01v8_hvt ad=0 pd=0 as=0.0882 ps=1.26 w=0.42 l=0.15
X3688 sky130_fd_sc_hd__mux2_1_86/a_505_21# V3R044 VDPWR VDPWR sky130_fd_pr__pfet_01v8_hvt ad=0.1176 pd=1.4 as=0 ps=0 w=0.42 l=0.15
X3689 sky130_fd_sc_hd__mux2_1_86/a_218_374# V3R044 VDPWR VDPWR sky130_fd_pr__pfet_01v8_hvt ad=0.1533 pd=1.57 as=0 ps=0 w=0.42 l=0.15
X3690 VGND sky130_fd_sc_hd__mux2_1_86/a_505_21# sky130_fd_sc_hd__mux2_1_86/a_439_47# VGND sky130_fd_pr__nfet_01v8 ad=0 pd=0 as=0.1386 ps=1.5 w=0.42 l=0.15
X3691 sky130_fd_sc_hd__mux2_1_86/a_76_199# V3R040 sky130_fd_sc_hd__mux2_1_86/a_218_374# VDPWR sky130_fd_pr__pfet_01v8_hvt ad=0.3864 pd=2.68 as=0 ps=0 w=0.42 l=0.15
X3692 sky130_fd_sc_hd__mux2_1_86/a_505_21# V3R044 VGND VGND sky130_fd_pr__nfet_01v8 ad=0.1092 pd=1.36 as=0 ps=0 w=0.42 l=0.15
X3693 sky130_fd_sc_hd__mux2_1_86/a_439_47# V3R040 sky130_fd_sc_hd__mux2_1_86/a_76_199# VGND sky130_fd_pr__nfet_01v8 ad=0 pd=0 as=0.1995 ps=1.79 w=0.42 l=0.15
X3694 sky130_fd_sc_hd__mux2_1_86/a_535_374# V3R179 sky130_fd_sc_hd__mux2_1_86/a_76_199# VDPWR sky130_fd_pr__pfet_01v8_hvt ad=0 pd=0 as=0 ps=0 w=0.42 l=0.15
X3695 sky130_fd_sc_hd__mux2_1_86/a_76_199# V3R179 sky130_fd_sc_hd__mux2_1_86/a_218_47# VGND sky130_fd_pr__nfet_01v8 ad=0 pd=0 as=0.1386 ps=1.5 w=0.42 l=0.15
X3696 sky130_fd_sc_hd__mux2_1_86/a_218_47# V3R044 VGND VGND sky130_fd_pr__nfet_01v8 ad=0 pd=0 as=0 ps=0 w=0.42 l=0.15
X3697 VDPWR sky130_fd_sc_hd__mux2_1_86/a_76_199# V3R125 VDPWR sky130_fd_pr__pfet_01v8_hvt ad=0 pd=0 as=0.26 ps=2.52 w=1 l=0.15
X3698 VGND sky130_fd_sc_hd__mux2_1_86/a_76_199# V3R125 VGND sky130_fd_pr__nfet_01v8 ad=0 pd=0 as=0.169 ps=1.82 w=0.65 l=0.15
X3699 VDPWR sky130_fd_sc_hd__mux2_1_75/a_505_21# sky130_fd_sc_hd__mux2_1_75/a_535_374# VDPWR sky130_fd_pr__pfet_01v8_hvt ad=0 pd=0 as=0.0882 ps=1.26 w=0.42 l=0.15
X3700 sky130_fd_sc_hd__mux2_1_75/a_505_21# V3R008 VDPWR VDPWR sky130_fd_pr__pfet_01v8_hvt ad=0.1176 pd=1.4 as=0 ps=0 w=0.42 l=0.15
X3701 sky130_fd_sc_hd__mux2_1_75/a_218_374# V3R008 VDPWR VDPWR sky130_fd_pr__pfet_01v8_hvt ad=0.1533 pd=1.57 as=0 ps=0 w=0.42 l=0.15
X3702 VGND sky130_fd_sc_hd__mux2_1_75/a_505_21# sky130_fd_sc_hd__mux2_1_75/a_439_47# VGND sky130_fd_pr__nfet_01v8 ad=0 pd=0 as=0.1386 ps=1.5 w=0.42 l=0.15
X3703 sky130_fd_sc_hd__mux2_1_75/a_76_199# V3R250 sky130_fd_sc_hd__mux2_1_75/a_218_374# VDPWR sky130_fd_pr__pfet_01v8_hvt ad=0.3864 pd=2.68 as=0 ps=0 w=0.42 l=0.15
X3704 sky130_fd_sc_hd__mux2_1_75/a_505_21# V3R008 VGND VGND sky130_fd_pr__nfet_01v8 ad=0.1092 pd=1.36 as=0 ps=0 w=0.42 l=0.15
X3705 sky130_fd_sc_hd__mux2_1_75/a_439_47# V3R250 sky130_fd_sc_hd__mux2_1_75/a_76_199# VGND sky130_fd_pr__nfet_01v8 ad=0 pd=0 as=0.1995 ps=1.79 w=0.42 l=0.15
X3706 sky130_fd_sc_hd__mux2_1_75/a_535_374# V3R013 sky130_fd_sc_hd__mux2_1_75/a_76_199# VDPWR sky130_fd_pr__pfet_01v8_hvt ad=0 pd=0 as=0 ps=0 w=0.42 l=0.15
X3707 sky130_fd_sc_hd__mux2_1_75/a_76_199# V3R013 sky130_fd_sc_hd__mux2_1_75/a_218_47# VGND sky130_fd_pr__nfet_01v8 ad=0 pd=0 as=0.1386 ps=1.5 w=0.42 l=0.15
X3708 sky130_fd_sc_hd__mux2_1_75/a_218_47# V3R008 VGND VGND sky130_fd_pr__nfet_01v8 ad=0 pd=0 as=0 ps=0 w=0.42 l=0.15
X3709 VDPWR sky130_fd_sc_hd__mux2_1_75/a_76_199# V3R208 VDPWR sky130_fd_pr__pfet_01v8_hvt ad=0 pd=0 as=0.26 ps=2.52 w=1 l=0.15
X3710 VGND sky130_fd_sc_hd__mux2_1_75/a_76_199# V3R208 VGND sky130_fd_pr__nfet_01v8 ad=0 pd=0 as=0.169 ps=1.82 w=0.65 l=0.15
X3711 VDPWR sky130_fd_sc_hd__mux2_1_64/a_505_21# sky130_fd_sc_hd__mux2_1_64/a_535_374# VDPWR sky130_fd_pr__pfet_01v8_hvt ad=0 pd=0 as=0.0882 ps=1.26 w=0.42 l=0.15
X3712 sky130_fd_sc_hd__mux2_1_64/a_505_21# V3R044 VDPWR VDPWR sky130_fd_pr__pfet_01v8_hvt ad=0.1176 pd=1.4 as=0 ps=0 w=0.42 l=0.15
X3713 sky130_fd_sc_hd__mux2_1_64/a_218_374# V3R044 VDPWR VDPWR sky130_fd_pr__pfet_01v8_hvt ad=0.1533 pd=1.57 as=0 ps=0 w=0.42 l=0.15
X3714 VGND sky130_fd_sc_hd__mux2_1_64/a_505_21# sky130_fd_sc_hd__mux2_1_64/a_439_47# VGND sky130_fd_pr__nfet_01v8 ad=0 pd=0 as=0.1386 ps=1.5 w=0.42 l=0.15
X3715 sky130_fd_sc_hd__mux2_1_64/a_76_199# V3R015 sky130_fd_sc_hd__mux2_1_64/a_218_374# VDPWR sky130_fd_pr__pfet_01v8_hvt ad=0.3864 pd=2.68 as=0 ps=0 w=0.42 l=0.15
X3716 sky130_fd_sc_hd__mux2_1_64/a_505_21# V3R044 VGND VGND sky130_fd_pr__nfet_01v8 ad=0.1092 pd=1.36 as=0 ps=0 w=0.42 l=0.15
X3717 sky130_fd_sc_hd__mux2_1_64/a_439_47# V3R015 sky130_fd_sc_hd__mux2_1_64/a_76_199# VGND sky130_fd_pr__nfet_01v8 ad=0 pd=0 as=0.1995 ps=1.79 w=0.42 l=0.15
X3718 sky130_fd_sc_hd__mux2_1_64/a_535_374# V3R154 sky130_fd_sc_hd__mux2_1_64/a_76_199# VDPWR sky130_fd_pr__pfet_01v8_hvt ad=0 pd=0 as=0 ps=0 w=0.42 l=0.15
X3719 sky130_fd_sc_hd__mux2_1_64/a_76_199# V3R154 sky130_fd_sc_hd__mux2_1_64/a_218_47# VGND sky130_fd_pr__nfet_01v8 ad=0 pd=0 as=0.1386 ps=1.5 w=0.42 l=0.15
X3720 sky130_fd_sc_hd__mux2_1_64/a_218_47# V3R044 VGND VGND sky130_fd_pr__nfet_01v8 ad=0 pd=0 as=0 ps=0 w=0.42 l=0.15
X3721 VDPWR sky130_fd_sc_hd__mux2_1_64/a_76_199# V3R131 VDPWR sky130_fd_pr__pfet_01v8_hvt ad=0 pd=0 as=0.26 ps=2.52 w=1 l=0.15
X3722 VGND sky130_fd_sc_hd__mux2_1_64/a_76_199# V3R131 VGND sky130_fd_pr__nfet_01v8 ad=0 pd=0 as=0.169 ps=1.82 w=0.65 l=0.15
X3723 VDPWR sky130_fd_sc_hd__mux2_1_53/a_505_21# sky130_fd_sc_hd__mux2_1_53/a_535_374# VDPWR sky130_fd_pr__pfet_01v8_hvt ad=0 pd=0 as=0.0882 ps=1.26 w=0.42 l=0.15
X3724 sky130_fd_sc_hd__mux2_1_53/a_505_21# V3R053 VDPWR VDPWR sky130_fd_pr__pfet_01v8_hvt ad=0.1176 pd=1.4 as=0 ps=0 w=0.42 l=0.15
X3725 sky130_fd_sc_hd__mux2_1_53/a_218_374# V3R053 VDPWR VDPWR sky130_fd_pr__pfet_01v8_hvt ad=0.1533 pd=1.57 as=0 ps=0 w=0.42 l=0.15
X3726 VGND sky130_fd_sc_hd__mux2_1_53/a_505_21# sky130_fd_sc_hd__mux2_1_53/a_439_47# VGND sky130_fd_pr__nfet_01v8 ad=0 pd=0 as=0.1386 ps=1.5 w=0.42 l=0.15
X3727 sky130_fd_sc_hd__mux2_1_53/a_76_199# V3R286 sky130_fd_sc_hd__mux2_1_53/a_218_374# VDPWR sky130_fd_pr__pfet_01v8_hvt ad=0.3864 pd=2.68 as=0 ps=0 w=0.42 l=0.15
X3728 sky130_fd_sc_hd__mux2_1_53/a_505_21# V3R053 VGND VGND sky130_fd_pr__nfet_01v8 ad=0.1092 pd=1.36 as=0 ps=0 w=0.42 l=0.15
X3729 sky130_fd_sc_hd__mux2_1_53/a_439_47# V3R286 sky130_fd_sc_hd__mux2_1_53/a_76_199# VGND sky130_fd_pr__nfet_01v8 ad=0 pd=0 as=0.1995 ps=1.79 w=0.42 l=0.15
X3730 sky130_fd_sc_hd__mux2_1_53/a_535_374# V3R268 sky130_fd_sc_hd__mux2_1_53/a_76_199# VDPWR sky130_fd_pr__pfet_01v8_hvt ad=0 pd=0 as=0 ps=0 w=0.42 l=0.15
X3731 sky130_fd_sc_hd__mux2_1_53/a_76_199# V3R268 sky130_fd_sc_hd__mux2_1_53/a_218_47# VGND sky130_fd_pr__nfet_01v8 ad=0 pd=0 as=0.1386 ps=1.5 w=0.42 l=0.15
X3732 sky130_fd_sc_hd__mux2_1_53/a_218_47# V3R053 VGND VGND sky130_fd_pr__nfet_01v8 ad=0 pd=0 as=0 ps=0 w=0.42 l=0.15
X3733 VDPWR sky130_fd_sc_hd__mux2_1_53/a_76_199# V3R261 VDPWR sky130_fd_pr__pfet_01v8_hvt ad=0 pd=0 as=0.26 ps=2.52 w=1 l=0.15
X3734 VGND sky130_fd_sc_hd__mux2_1_53/a_76_199# V3R261 VGND sky130_fd_pr__nfet_01v8 ad=0 pd=0 as=0.169 ps=1.82 w=0.65 l=0.15
X3735 VDPWR sky130_fd_sc_hd__mux2_1_42/a_505_21# sky130_fd_sc_hd__mux2_1_42/a_535_374# VDPWR sky130_fd_pr__pfet_01v8_hvt ad=0 pd=0 as=0.0882 ps=1.26 w=0.42 l=0.15
X3736 sky130_fd_sc_hd__mux2_1_42/a_505_21# V3R045 VDPWR VDPWR sky130_fd_pr__pfet_01v8_hvt ad=0.1176 pd=1.4 as=0 ps=0 w=0.42 l=0.15
X3737 sky130_fd_sc_hd__mux2_1_42/a_218_374# V3R045 VDPWR VDPWR sky130_fd_pr__pfet_01v8_hvt ad=0.1533 pd=1.57 as=0 ps=0 w=0.42 l=0.15
X3738 VGND sky130_fd_sc_hd__mux2_1_42/a_505_21# sky130_fd_sc_hd__mux2_1_42/a_439_47# VGND sky130_fd_pr__nfet_01v8 ad=0 pd=0 as=0.1386 ps=1.5 w=0.42 l=0.15
X3739 sky130_fd_sc_hd__mux2_1_42/a_76_199# V3R021 sky130_fd_sc_hd__mux2_1_42/a_218_374# VDPWR sky130_fd_pr__pfet_01v8_hvt ad=0.3864 pd=2.68 as=0 ps=0 w=0.42 l=0.15
X3740 sky130_fd_sc_hd__mux2_1_42/a_505_21# V3R045 VGND VGND sky130_fd_pr__nfet_01v8 ad=0.1092 pd=1.36 as=0 ps=0 w=0.42 l=0.15
X3741 sky130_fd_sc_hd__mux2_1_42/a_439_47# V3R021 sky130_fd_sc_hd__mux2_1_42/a_76_199# VGND sky130_fd_pr__nfet_01v8 ad=0 pd=0 as=0.1995 ps=1.79 w=0.42 l=0.15
X3742 sky130_fd_sc_hd__mux2_1_42/a_535_374# V3R160 sky130_fd_sc_hd__mux2_1_42/a_76_199# VDPWR sky130_fd_pr__pfet_01v8_hvt ad=0 pd=0 as=0 ps=0 w=0.42 l=0.15
X3743 sky130_fd_sc_hd__mux2_1_42/a_76_199# V3R160 sky130_fd_sc_hd__mux2_1_42/a_218_47# VGND sky130_fd_pr__nfet_01v8 ad=0 pd=0 as=0.1386 ps=1.5 w=0.42 l=0.15
X3744 sky130_fd_sc_hd__mux2_1_42/a_218_47# V3R045 VGND VGND sky130_fd_pr__nfet_01v8 ad=0 pd=0 as=0 ps=0 w=0.42 l=0.15
X3745 VDPWR sky130_fd_sc_hd__mux2_1_42/a_76_199# V3R137 VDPWR sky130_fd_pr__pfet_01v8_hvt ad=0 pd=0 as=0.26 ps=2.52 w=1 l=0.15
X3746 VGND sky130_fd_sc_hd__mux2_1_42/a_76_199# V3R137 VGND sky130_fd_pr__nfet_01v8 ad=0 pd=0 as=0.169 ps=1.82 w=0.65 l=0.15
X3747 VDPWR sky130_fd_sc_hd__mux2_1_31/a_505_21# sky130_fd_sc_hd__mux2_1_31/a_535_374# VDPWR sky130_fd_pr__pfet_01v8_hvt ad=0 pd=0 as=0.0882 ps=1.26 w=0.42 l=0.15
X3748 sky130_fd_sc_hd__mux2_1_31/a_505_21# V3R045 VDPWR VDPWR sky130_fd_pr__pfet_01v8_hvt ad=0.1176 pd=1.4 as=0 ps=0 w=0.42 l=0.15
X3749 sky130_fd_sc_hd__mux2_1_31/a_218_374# V3R045 VDPWR VDPWR sky130_fd_pr__pfet_01v8_hvt ad=0.1533 pd=1.57 as=0 ps=0 w=0.42 l=0.15
X3750 VGND sky130_fd_sc_hd__mux2_1_31/a_505_21# sky130_fd_sc_hd__mux2_1_31/a_439_47# VGND sky130_fd_pr__nfet_01v8 ad=0 pd=0 as=0.1386 ps=1.5 w=0.42 l=0.15
X3751 sky130_fd_sc_hd__mux2_1_31/a_76_199# V3R025 sky130_fd_sc_hd__mux2_1_31/a_218_374# VDPWR sky130_fd_pr__pfet_01v8_hvt ad=0.3864 pd=2.68 as=0 ps=0 w=0.42 l=0.15
X3752 sky130_fd_sc_hd__mux2_1_31/a_505_21# V3R045 VGND VGND sky130_fd_pr__nfet_01v8 ad=0.1092 pd=1.36 as=0 ps=0 w=0.42 l=0.15
X3753 sky130_fd_sc_hd__mux2_1_31/a_439_47# V3R025 sky130_fd_sc_hd__mux2_1_31/a_76_199# VGND sky130_fd_pr__nfet_01v8 ad=0 pd=0 as=0.1995 ps=1.79 w=0.42 l=0.15
X3754 sky130_fd_sc_hd__mux2_1_31/a_535_374# V3R164 sky130_fd_sc_hd__mux2_1_31/a_76_199# VDPWR sky130_fd_pr__pfet_01v8_hvt ad=0 pd=0 as=0 ps=0 w=0.42 l=0.15
X3755 sky130_fd_sc_hd__mux2_1_31/a_76_199# V3R164 sky130_fd_sc_hd__mux2_1_31/a_218_47# VGND sky130_fd_pr__nfet_01v8 ad=0 pd=0 as=0.1386 ps=1.5 w=0.42 l=0.15
X3756 sky130_fd_sc_hd__mux2_1_31/a_218_47# V3R045 VGND VGND sky130_fd_pr__nfet_01v8 ad=0 pd=0 as=0 ps=0 w=0.42 l=0.15
X3757 VDPWR sky130_fd_sc_hd__mux2_1_31/a_76_199# V3R140 VDPWR sky130_fd_pr__pfet_01v8_hvt ad=0 pd=0 as=0.26 ps=2.52 w=1 l=0.15
X3758 VGND sky130_fd_sc_hd__mux2_1_31/a_76_199# V3R140 VGND sky130_fd_pr__nfet_01v8 ad=0 pd=0 as=0.169 ps=1.82 w=0.65 l=0.15
X3759 VDPWR sky130_fd_sc_hd__mux2_1_20/a_505_21# sky130_fd_sc_hd__mux2_1_20/a_535_374# VDPWR sky130_fd_pr__pfet_01v8_hvt ad=0 pd=0 as=0.0882 ps=1.26 w=0.42 l=0.15
X3760 sky130_fd_sc_hd__mux2_1_20/a_505_21# V3R009 VDPWR VDPWR sky130_fd_pr__pfet_01v8_hvt ad=0.1176 pd=1.4 as=0 ps=0 w=0.42 l=0.15
X3761 sky130_fd_sc_hd__mux2_1_20/a_218_374# V3R009 VDPWR VDPWR sky130_fd_pr__pfet_01v8_hvt ad=0.1533 pd=1.57 as=0 ps=0 w=0.42 l=0.15
X3762 VGND sky130_fd_sc_hd__mux2_1_20/a_505_21# sky130_fd_sc_hd__mux2_1_20/a_439_47# VGND sky130_fd_pr__nfet_01v8 ad=0 pd=0 as=0.1386 ps=1.5 w=0.42 l=0.15
X3763 sky130_fd_sc_hd__mux2_1_20/a_76_199# V3R251 sky130_fd_sc_hd__mux2_1_20/a_218_374# VDPWR sky130_fd_pr__pfet_01v8_hvt ad=0.3864 pd=2.68 as=0 ps=0 w=0.42 l=0.15
X3764 sky130_fd_sc_hd__mux2_1_20/a_505_21# V3R009 VGND VGND sky130_fd_pr__nfet_01v8 ad=0.1092 pd=1.36 as=0 ps=0 w=0.42 l=0.15
X3765 sky130_fd_sc_hd__mux2_1_20/a_439_47# V3R251 sky130_fd_sc_hd__mux2_1_20/a_76_199# VGND sky130_fd_pr__nfet_01v8 ad=0 pd=0 as=0.1995 ps=1.79 w=0.42 l=0.15
X3766 sky130_fd_sc_hd__mux2_1_20/a_535_374# V3R029 sky130_fd_sc_hd__mux2_1_20/a_76_199# VDPWR sky130_fd_pr__pfet_01v8_hvt ad=0 pd=0 as=0 ps=0 w=0.42 l=0.15
X3767 sky130_fd_sc_hd__mux2_1_20/a_76_199# V3R029 sky130_fd_sc_hd__mux2_1_20/a_218_47# VGND sky130_fd_pr__nfet_01v8 ad=0 pd=0 as=0.1386 ps=1.5 w=0.42 l=0.15
X3768 sky130_fd_sc_hd__mux2_1_20/a_218_47# V3R009 VGND VGND sky130_fd_pr__nfet_01v8 ad=0 pd=0 as=0 ps=0 w=0.42 l=0.15
X3769 VDPWR sky130_fd_sc_hd__mux2_1_20/a_76_199# V3R224 VDPWR sky130_fd_pr__pfet_01v8_hvt ad=0 pd=0 as=0.26 ps=2.52 w=1 l=0.15
X3770 VGND sky130_fd_sc_hd__mux2_1_20/a_76_199# V3R224 VGND sky130_fd_pr__nfet_01v8 ad=0 pd=0 as=0.169 ps=1.82 w=0.65 l=0.15
X3771 VDPWR sky130_fd_sc_hd__buf_4_14/a_27_47# V3R045 VDPWR sky130_fd_pr__pfet_01v8_hvt ad=0 pd=0 as=0.54 ps=5.08 w=1 l=0.15
X3772 V3R045 sky130_fd_sc_hd__buf_4_14/a_27_47# VDPWR VDPWR sky130_fd_pr__pfet_01v8_hvt ad=0 pd=0 as=0 ps=0 w=1 l=0.15
X3773 VDPWR sky130_fd_sc_hd__buf_4_14/a_27_47# V3R045 VDPWR sky130_fd_pr__pfet_01v8_hvt ad=0 pd=0 as=0 ps=0 w=1 l=0.15
X3774 V3R045 sky130_fd_sc_hd__buf_4_14/a_27_47# VDPWR VDPWR sky130_fd_pr__pfet_01v8_hvt ad=0 pd=0 as=0 ps=0 w=1 l=0.15
X3775 V3R045 sky130_fd_sc_hd__buf_4_14/a_27_47# VGND VGND sky130_fd_pr__nfet_01v8 ad=0.351 pd=3.68 as=0 ps=0 w=0.65 l=0.15
X3776 V3R045 sky130_fd_sc_hd__buf_4_14/a_27_47# VGND VGND sky130_fd_pr__nfet_01v8 ad=0 pd=0 as=0 ps=0 w=0.65 l=0.15
X3777 VGND sky130_fd_sc_hd__buf_4_14/a_27_47# V3R045 VGND sky130_fd_pr__nfet_01v8 ad=0 pd=0 as=0 ps=0 w=0.65 l=0.15
X3778 VGND sky130_fd_sc_hd__buf_4_14/a_27_47# V3R045 VGND sky130_fd_pr__nfet_01v8 ad=0 pd=0 as=0 ps=0 w=0.65 l=0.15
X3779 VDPWR V3R043 sky130_fd_sc_hd__buf_4_14/a_27_47# VDPWR sky130_fd_pr__pfet_01v8_hvt ad=0 pd=0 as=0.26 ps=2.52 w=1 l=0.15
X3780 VGND V3R043 sky130_fd_sc_hd__buf_4_14/a_27_47# VGND sky130_fd_pr__nfet_01v8 ad=0 pd=0 as=0.169 ps=1.82 w=0.65 l=0.15
X3781 VGND V3R241 sky130_fd_sc_hd__or2_1_5/a_68_297# VGND sky130_fd_pr__nfet_01v8 ad=0 pd=0 as=0.1134 ps=1.38 w=0.42 l=0.15
X3782 sky130_fd_sc_hd__or2_1_5/a_68_297# V3R046 VGND VGND sky130_fd_pr__nfet_01v8 ad=0 pd=0 as=0 ps=0 w=0.42 l=0.15
X3783 V3R242 sky130_fd_sc_hd__or2_1_5/a_68_297# VGND VGND sky130_fd_pr__nfet_01v8 ad=0.169 pd=1.82 as=0 ps=0 w=0.65 l=0.15
X3784 VDPWR V3R241 sky130_fd_sc_hd__or2_1_5/a_150_297# VDPWR sky130_fd_pr__pfet_01v8_hvt ad=0 pd=0 as=0.0882 ps=1.26 w=0.42 l=0.15
X3785 V3R242 sky130_fd_sc_hd__or2_1_5/a_68_297# VDPWR VDPWR sky130_fd_pr__pfet_01v8_hvt ad=0.34 pd=2.68 as=0 ps=0 w=1 l=0.15
X3786 sky130_fd_sc_hd__or2_1_5/a_150_297# V3R046 sky130_fd_sc_hd__or2_1_5/a_68_297# VDPWR sky130_fd_pr__pfet_01v8_hvt ad=0 pd=0 as=0.1092 ps=1.36 w=0.42 l=0.15
X3787 VDPWR V3R064 sky130_fd_sc_hd__and2b_1_0/a_207_413# VDPWR sky130_fd_pr__pfet_01v8_hvt ad=0 pd=0 as=0.1218 ps=1.42 w=0.42 l=0.15
X3788 V3R043 sky130_fd_sc_hd__and2b_1_0/a_207_413# VDPWR VDPWR sky130_fd_pr__pfet_01v8_hvt ad=0.26 pd=2.52 as=0 ps=0 w=1 l=0.15
X3789 sky130_fd_sc_hd__and2b_1_0/a_297_47# sky130_fd_sc_hd__and2b_1_0/a_27_413# sky130_fd_sc_hd__and2b_1_0/a_207_413# VGND sky130_fd_pr__nfet_01v8 ad=0.1008 pd=1.32 as=0.1092 ps=1.36 w=0.42 l=0.15
X3790 V3R043 sky130_fd_sc_hd__and2b_1_0/a_207_413# VGND VGND sky130_fd_pr__nfet_01v8 ad=0.169 pd=1.82 as=0 ps=0 w=0.65 l=0.15
X3791 sky130_fd_sc_hd__and2b_1_0/a_207_413# sky130_fd_sc_hd__and2b_1_0/a_27_413# VDPWR VDPWR sky130_fd_pr__pfet_01v8_hvt ad=0 pd=0 as=0 ps=0 w=0.42 l=0.15
X3792 VDPWR V3R269 sky130_fd_sc_hd__and2b_1_0/a_27_413# VDPWR sky130_fd_pr__pfet_01v8_hvt ad=0 pd=0 as=0.1092 ps=1.36 w=0.42 l=0.15
X3793 VGND V3R064 sky130_fd_sc_hd__and2b_1_0/a_297_47# VGND sky130_fd_pr__nfet_01v8 ad=0 pd=0 as=0 ps=0 w=0.42 l=0.15
X3794 sky130_fd_sc_hd__and2b_1_0/a_27_413# V3R269 VGND VGND sky130_fd_pr__nfet_01v8 ad=0.1092 pd=1.36 as=0 ps=0 w=0.42 l=0.15
X3795 VDPWR sky130_fd_sc_hd__buf_4_7/a_27_47# V3R299 VDPWR sky130_fd_pr__pfet_01v8_hvt ad=0 pd=0 as=0.54 ps=5.08 w=1 l=0.15
X3796 V3R299 sky130_fd_sc_hd__buf_4_7/a_27_47# VDPWR VDPWR sky130_fd_pr__pfet_01v8_hvt ad=0 pd=0 as=0 ps=0 w=1 l=0.15
X3797 VDPWR sky130_fd_sc_hd__buf_4_7/a_27_47# V3R299 VDPWR sky130_fd_pr__pfet_01v8_hvt ad=0 pd=0 as=0 ps=0 w=1 l=0.15
X3798 V3R299 sky130_fd_sc_hd__buf_4_7/a_27_47# VDPWR VDPWR sky130_fd_pr__pfet_01v8_hvt ad=0 pd=0 as=0 ps=0 w=1 l=0.15
X3799 V3R299 sky130_fd_sc_hd__buf_4_7/a_27_47# VGND VGND sky130_fd_pr__nfet_01v8 ad=0.351 pd=3.68 as=0 ps=0 w=0.65 l=0.15
X3800 V3R299 sky130_fd_sc_hd__buf_4_7/a_27_47# VGND VGND sky130_fd_pr__nfet_01v8 ad=0 pd=0 as=0 ps=0 w=0.65 l=0.15
X3801 VGND sky130_fd_sc_hd__buf_4_7/a_27_47# V3R299 VGND sky130_fd_pr__nfet_01v8 ad=0 pd=0 as=0 ps=0 w=0.65 l=0.15
X3802 VGND sky130_fd_sc_hd__buf_4_7/a_27_47# V3R299 VGND sky130_fd_pr__nfet_01v8 ad=0 pd=0 as=0 ps=0 w=0.65 l=0.15
X3803 VDPWR V3R297 sky130_fd_sc_hd__buf_4_7/a_27_47# VDPWR sky130_fd_pr__pfet_01v8_hvt ad=0 pd=0 as=0.26 ps=2.52 w=1 l=0.15
X3804 VGND V3R297 sky130_fd_sc_hd__buf_4_7/a_27_47# VGND sky130_fd_pr__nfet_01v8 ad=0 pd=0 as=0.169 ps=1.82 w=0.65 l=0.15
X3805 VDPWR sky130_fd_sc_hd__mux2_1_10/a_505_21# sky130_fd_sc_hd__mux2_1_10/a_535_374# VDPWR sky130_fd_pr__pfet_01v8_hvt ad=0 pd=0 as=0.0882 ps=1.26 w=0.42 l=0.15
X3806 sky130_fd_sc_hd__mux2_1_10/a_505_21# V3R045 VDPWR VDPWR sky130_fd_pr__pfet_01v8_hvt ad=0.1176 pd=1.4 as=0 ps=0 w=0.42 l=0.15
X3807 sky130_fd_sc_hd__mux2_1_10/a_218_374# V3R045 VDPWR VDPWR sky130_fd_pr__pfet_01v8_hvt ad=0.1533 pd=1.57 as=0 ps=0 w=0.42 l=0.15
X3808 VGND sky130_fd_sc_hd__mux2_1_10/a_505_21# sky130_fd_sc_hd__mux2_1_10/a_439_47# VGND sky130_fd_pr__nfet_01v8 ad=0 pd=0 as=0.1386 ps=1.5 w=0.42 l=0.15
X3809 sky130_fd_sc_hd__mux2_1_10/a_76_199# V3R032 sky130_fd_sc_hd__mux2_1_10/a_218_374# VDPWR sky130_fd_pr__pfet_01v8_hvt ad=0.3864 pd=2.68 as=0 ps=0 w=0.42 l=0.15
X3810 sky130_fd_sc_hd__mux2_1_10/a_505_21# V3R045 VGND VGND sky130_fd_pr__nfet_01v8 ad=0.1092 pd=1.36 as=0 ps=0 w=0.42 l=0.15
X3811 sky130_fd_sc_hd__mux2_1_10/a_439_47# V3R032 sky130_fd_sc_hd__mux2_1_10/a_76_199# VGND sky130_fd_pr__nfet_01v8 ad=0 pd=0 as=0.1995 ps=1.79 w=0.42 l=0.15
X3812 sky130_fd_sc_hd__mux2_1_10/a_535_374# V3R171 sky130_fd_sc_hd__mux2_1_10/a_76_199# VDPWR sky130_fd_pr__pfet_01v8_hvt ad=0 pd=0 as=0 ps=0 w=0.42 l=0.15
X3813 sky130_fd_sc_hd__mux2_1_10/a_76_199# V3R171 sky130_fd_sc_hd__mux2_1_10/a_218_47# VGND sky130_fd_pr__nfet_01v8 ad=0 pd=0 as=0.1386 ps=1.5 w=0.42 l=0.15
X3814 sky130_fd_sc_hd__mux2_1_10/a_218_47# V3R045 VGND VGND sky130_fd_pr__nfet_01v8 ad=0 pd=0 as=0 ps=0 w=0.42 l=0.15
X3815 VDPWR sky130_fd_sc_hd__mux2_1_10/a_76_199# V3R147 VDPWR sky130_fd_pr__pfet_01v8_hvt ad=0 pd=0 as=0.26 ps=2.52 w=1 l=0.15
X3816 VGND sky130_fd_sc_hd__mux2_1_10/a_76_199# V3R147 VGND sky130_fd_pr__nfet_01v8 ad=0 pd=0 as=0.169 ps=1.82 w=0.65 l=0.15
X3817 VDPWR sky130_fd_sc_hd__mux2_1_21/a_505_21# sky130_fd_sc_hd__mux2_1_21/a_535_374# VDPWR sky130_fd_pr__pfet_01v8_hvt ad=0 pd=0 as=0.0882 ps=1.26 w=0.42 l=0.15
X3818 sky130_fd_sc_hd__mux2_1_21/a_505_21# V3R062 VDPWR VDPWR sky130_fd_pr__pfet_01v8_hvt ad=0.1176 pd=1.4 as=0 ps=0 w=0.42 l=0.15
X3819 sky130_fd_sc_hd__mux2_1_21/a_218_374# V3R062 VDPWR VDPWR sky130_fd_pr__pfet_01v8_hvt ad=0.1533 pd=1.57 as=0 ps=0 w=0.42 l=0.15
X3820 VGND sky130_fd_sc_hd__mux2_1_21/a_505_21# sky130_fd_sc_hd__mux2_1_21/a_439_47# VGND sky130_fd_pr__nfet_01v8 ad=0 pd=0 as=0.1386 ps=1.5 w=0.42 l=0.15
X3821 sky130_fd_sc_hd__mux2_1_21/a_76_199# V3R167 sky130_fd_sc_hd__mux2_1_21/a_218_374# VDPWR sky130_fd_pr__pfet_01v8_hvt ad=0.3864 pd=2.68 as=0 ps=0 w=0.42 l=0.15
X3822 sky130_fd_sc_hd__mux2_1_21/a_505_21# V3R062 VGND VGND sky130_fd_pr__nfet_01v8 ad=0.1092 pd=1.36 as=0 ps=0 w=0.42 l=0.15
X3823 sky130_fd_sc_hd__mux2_1_21/a_439_47# V3R167 sky130_fd_sc_hd__mux2_1_21/a_76_199# VGND sky130_fd_pr__nfet_01v8 ad=0 pd=0 as=0.1995 ps=1.79 w=0.42 l=0.15
X3824 sky130_fd_sc_hd__mux2_1_21/a_535_374# V3R166 sky130_fd_sc_hd__mux2_1_21/a_76_199# VDPWR sky130_fd_pr__pfet_01v8_hvt ad=0 pd=0 as=0 ps=0 w=0.42 l=0.15
X3825 sky130_fd_sc_hd__mux2_1_21/a_76_199# V3R166 sky130_fd_sc_hd__mux2_1_21/a_218_47# VGND sky130_fd_pr__nfet_01v8 ad=0 pd=0 as=0.1386 ps=1.5 w=0.42 l=0.15
X3826 sky130_fd_sc_hd__mux2_1_21/a_218_47# V3R062 VGND VGND sky130_fd_pr__nfet_01v8 ad=0 pd=0 as=0 ps=0 w=0.42 l=0.15
X3827 VDPWR sky130_fd_sc_hd__mux2_1_21/a_76_199# V3R110 VDPWR sky130_fd_pr__pfet_01v8_hvt ad=0 pd=0 as=0.26 ps=2.52 w=1 l=0.15
X3828 VGND sky130_fd_sc_hd__mux2_1_21/a_76_199# V3R110 VGND sky130_fd_pr__nfet_01v8 ad=0 pd=0 as=0.169 ps=1.82 w=0.65 l=0.15
X3829 VDPWR sky130_fd_sc_hd__mux2_1_98/a_505_21# sky130_fd_sc_hd__mux2_1_98/a_535_374# VDPWR sky130_fd_pr__pfet_01v8_hvt ad=0 pd=0 as=0.0882 ps=1.26 w=0.42 l=0.15
X3830 sky130_fd_sc_hd__mux2_1_98/a_505_21# V3R240 VDPWR VDPWR sky130_fd_pr__pfet_01v8_hvt ad=0.1176 pd=1.4 as=0 ps=0 w=0.42 l=0.15
X3831 sky130_fd_sc_hd__mux2_1_98/a_218_374# V3R240 VDPWR VDPWR sky130_fd_pr__pfet_01v8_hvt ad=0.1533 pd=1.57 as=0 ps=0 w=0.42 l=0.15
X3832 VGND sky130_fd_sc_hd__mux2_1_98/a_505_21# sky130_fd_sc_hd__mux2_1_98/a_439_47# VGND sky130_fd_pr__nfet_01v8 ad=0 pd=0 as=0.1386 ps=1.5 w=0.42 l=0.15
X3833 sky130_fd_sc_hd__mux2_1_98/a_76_199# V3R003 sky130_fd_sc_hd__mux2_1_98/a_218_374# VDPWR sky130_fd_pr__pfet_01v8_hvt ad=0.3864 pd=2.68 as=0 ps=0 w=0.42 l=0.15
X3834 sky130_fd_sc_hd__mux2_1_98/a_505_21# V3R240 VGND VGND sky130_fd_pr__nfet_01v8 ad=0.1092 pd=1.36 as=0 ps=0 w=0.42 l=0.15
X3835 sky130_fd_sc_hd__mux2_1_98/a_439_47# V3R003 sky130_fd_sc_hd__mux2_1_98/a_76_199# VGND sky130_fd_pr__nfet_01v8 ad=0 pd=0 as=0.1995 ps=1.79 w=0.42 l=0.15
X3836 sky130_fd_sc_hd__mux2_1_98/a_535_374# V3R263 sky130_fd_sc_hd__mux2_1_98/a_76_199# VDPWR sky130_fd_pr__pfet_01v8_hvt ad=0 pd=0 as=0 ps=0 w=0.42 l=0.15
X3837 sky130_fd_sc_hd__mux2_1_98/a_76_199# V3R263 sky130_fd_sc_hd__mux2_1_98/a_218_47# VGND sky130_fd_pr__nfet_01v8 ad=0 pd=0 as=0.1386 ps=1.5 w=0.42 l=0.15
X3838 sky130_fd_sc_hd__mux2_1_98/a_218_47# V3R240 VGND VGND sky130_fd_pr__nfet_01v8 ad=0 pd=0 as=0 ps=0 w=0.42 l=0.15
X3839 VDPWR sky130_fd_sc_hd__mux2_1_98/a_76_199# V3R187 VDPWR sky130_fd_pr__pfet_01v8_hvt ad=0 pd=0 as=0.26 ps=2.52 w=1 l=0.15
X3840 VGND sky130_fd_sc_hd__mux2_1_98/a_76_199# V3R187 VGND sky130_fd_pr__nfet_01v8 ad=0 pd=0 as=0.169 ps=1.82 w=0.65 l=0.15
X3841 VDPWR sky130_fd_sc_hd__mux2_1_87/a_505_21# sky130_fd_sc_hd__mux2_1_87/a_535_374# VDPWR sky130_fd_pr__pfet_01v8_hvt ad=0 pd=0 as=0.0882 ps=1.26 w=0.42 l=0.15
X3842 sky130_fd_sc_hd__mux2_1_87/a_505_21# V3R061 VDPWR VDPWR sky130_fd_pr__pfet_01v8_hvt ad=0.1176 pd=1.4 as=0 ps=0 w=0.42 l=0.15
X3843 sky130_fd_sc_hd__mux2_1_87/a_218_374# V3R061 VDPWR VDPWR sky130_fd_pr__pfet_01v8_hvt ad=0.1533 pd=1.57 as=0 ps=0 w=0.42 l=0.15
X3844 VGND sky130_fd_sc_hd__mux2_1_87/a_505_21# sky130_fd_sc_hd__mux2_1_87/a_439_47# VGND sky130_fd_pr__nfet_01v8 ad=0 pd=0 as=0.1386 ps=1.5 w=0.42 l=0.15
X3845 sky130_fd_sc_hd__mux2_1_87/a_76_199# V3R179 sky130_fd_sc_hd__mux2_1_87/a_218_374# VDPWR sky130_fd_pr__pfet_01v8_hvt ad=0.3864 pd=2.68 as=0 ps=0 w=0.42 l=0.15
X3846 sky130_fd_sc_hd__mux2_1_87/a_505_21# V3R061 VGND VGND sky130_fd_pr__nfet_01v8 ad=0.1092 pd=1.36 as=0 ps=0 w=0.42 l=0.15
X3847 sky130_fd_sc_hd__mux2_1_87/a_439_47# V3R179 sky130_fd_sc_hd__mux2_1_87/a_76_199# VGND sky130_fd_pr__nfet_01v8 ad=0 pd=0 as=0.1995 ps=1.79 w=0.42 l=0.15
X3848 sky130_fd_sc_hd__mux2_1_87/a_535_374# V3R178 sky130_fd_sc_hd__mux2_1_87/a_76_199# VDPWR sky130_fd_pr__pfet_01v8_hvt ad=0 pd=0 as=0 ps=0 w=0.42 l=0.15
X3849 sky130_fd_sc_hd__mux2_1_87/a_76_199# V3R178 sky130_fd_sc_hd__mux2_1_87/a_218_47# VGND sky130_fd_pr__nfet_01v8 ad=0 pd=0 as=0.1386 ps=1.5 w=0.42 l=0.15
X3850 sky130_fd_sc_hd__mux2_1_87/a_218_47# V3R061 VGND VGND sky130_fd_pr__nfet_01v8 ad=0 pd=0 as=0 ps=0 w=0.42 l=0.15
X3851 VDPWR sky130_fd_sc_hd__mux2_1_87/a_76_199# V3R092 VDPWR sky130_fd_pr__pfet_01v8_hvt ad=0 pd=0 as=0.26 ps=2.52 w=1 l=0.15
X3852 VGND sky130_fd_sc_hd__mux2_1_87/a_76_199# V3R092 VGND sky130_fd_pr__nfet_01v8 ad=0 pd=0 as=0.169 ps=1.82 w=0.65 l=0.15
X3853 VDPWR sky130_fd_sc_hd__mux2_1_76/a_505_21# sky130_fd_sc_hd__mux2_1_76/a_535_374# VDPWR sky130_fd_pr__pfet_01v8_hvt ad=0 pd=0 as=0.0882 ps=1.26 w=0.42 l=0.15
X3854 sky130_fd_sc_hd__mux2_1_76/a_505_21# V3R008 VDPWR VDPWR sky130_fd_pr__pfet_01v8_hvt ad=0.1176 pd=1.4 as=0 ps=0 w=0.42 l=0.15
X3855 sky130_fd_sc_hd__mux2_1_76/a_218_374# V3R008 VDPWR VDPWR sky130_fd_pr__pfet_01v8_hvt ad=0.1533 pd=1.57 as=0 ps=0 w=0.42 l=0.15
X3856 VGND sky130_fd_sc_hd__mux2_1_76/a_505_21# sky130_fd_sc_hd__mux2_1_76/a_439_47# VGND sky130_fd_pr__nfet_01v8 ad=0 pd=0 as=0.1386 ps=1.5 w=0.42 l=0.15
X3857 sky130_fd_sc_hd__mux2_1_76/a_76_199# V3R001 sky130_fd_sc_hd__mux2_1_76/a_218_374# VDPWR sky130_fd_pr__pfet_01v8_hvt ad=0.3864 pd=2.68 as=0 ps=0 w=0.42 l=0.15
X3858 sky130_fd_sc_hd__mux2_1_76/a_505_21# V3R008 VGND VGND sky130_fd_pr__nfet_01v8 ad=0.1092 pd=1.36 as=0 ps=0 w=0.42 l=0.15
X3859 sky130_fd_sc_hd__mux2_1_76/a_439_47# V3R001 sky130_fd_sc_hd__mux2_1_76/a_76_199# VGND sky130_fd_pr__nfet_01v8 ad=0 pd=0 as=0.1995 ps=1.79 w=0.42 l=0.15
X3860 sky130_fd_sc_hd__mux2_1_76/a_535_374# V3R012 sky130_fd_sc_hd__mux2_1_76/a_76_199# VDPWR sky130_fd_pr__pfet_01v8_hvt ad=0 pd=0 as=0 ps=0 w=0.42 l=0.15
X3861 sky130_fd_sc_hd__mux2_1_76/a_76_199# V3R012 sky130_fd_sc_hd__mux2_1_76/a_218_47# VGND sky130_fd_pr__nfet_01v8 ad=0 pd=0 as=0.1386 ps=1.5 w=0.42 l=0.15
X3862 sky130_fd_sc_hd__mux2_1_76/a_218_47# V3R008 VGND VGND sky130_fd_pr__nfet_01v8 ad=0 pd=0 as=0 ps=0 w=0.42 l=0.15
X3863 VDPWR sky130_fd_sc_hd__mux2_1_76/a_76_199# V3R207 VDPWR sky130_fd_pr__pfet_01v8_hvt ad=0 pd=0 as=0.26 ps=2.52 w=1 l=0.15
X3864 VGND sky130_fd_sc_hd__mux2_1_76/a_76_199# V3R207 VGND sky130_fd_pr__nfet_01v8 ad=0 pd=0 as=0.169 ps=1.82 w=0.65 l=0.15
X3865 VDPWR sky130_fd_sc_hd__mux2_1_65/a_505_21# sky130_fd_sc_hd__mux2_1_65/a_535_374# VDPWR sky130_fd_pr__pfet_01v8_hvt ad=0 pd=0 as=0.0882 ps=1.26 w=0.42 l=0.15
X3866 sky130_fd_sc_hd__mux2_1_65/a_505_21# V3R242 VDPWR VDPWR sky130_fd_pr__pfet_01v8_hvt ad=0.1176 pd=1.4 as=0 ps=0 w=0.42 l=0.15
X3867 sky130_fd_sc_hd__mux2_1_65/a_218_374# V3R242 VDPWR VDPWR sky130_fd_pr__pfet_01v8_hvt ad=0.1533 pd=1.57 as=0 ps=0 w=0.42 l=0.15
X3868 VGND sky130_fd_sc_hd__mux2_1_65/a_505_21# sky130_fd_sc_hd__mux2_1_65/a_439_47# VGND sky130_fd_pr__nfet_01v8 ad=0 pd=0 as=0.1386 ps=1.5 w=0.42 l=0.15
X3869 sky130_fd_sc_hd__mux2_1_65/a_76_199# V3R064 sky130_fd_sc_hd__mux2_1_65/a_218_374# VDPWR sky130_fd_pr__pfet_01v8_hvt ad=0.3864 pd=2.68 as=0 ps=0 w=0.42 l=0.15
X3870 sky130_fd_sc_hd__mux2_1_65/a_505_21# V3R242 VGND VGND sky130_fd_pr__nfet_01v8 ad=0.1092 pd=1.36 as=0 ps=0 w=0.42 l=0.15
X3871 sky130_fd_sc_hd__mux2_1_65/a_439_47# V3R064 sky130_fd_sc_hd__mux2_1_65/a_76_199# VGND sky130_fd_pr__nfet_01v8 ad=0 pd=0 as=0.1995 ps=1.79 w=0.42 l=0.15
X3872 sky130_fd_sc_hd__mux2_1_65/a_535_374# V3R241 sky130_fd_sc_hd__mux2_1_65/a_76_199# VDPWR sky130_fd_pr__pfet_01v8_hvt ad=0 pd=0 as=0 ps=0 w=0.42 l=0.15
X3873 sky130_fd_sc_hd__mux2_1_65/a_76_199# V3R241 sky130_fd_sc_hd__mux2_1_65/a_218_47# VGND sky130_fd_pr__nfet_01v8 ad=0 pd=0 as=0.1386 ps=1.5 w=0.42 l=0.15
X3874 sky130_fd_sc_hd__mux2_1_65/a_218_47# V3R242 VGND VGND sky130_fd_pr__nfet_01v8 ad=0 pd=0 as=0 ps=0 w=0.42 l=0.15
X3875 VDPWR sky130_fd_sc_hd__mux2_1_65/a_76_199# V3R192 VDPWR sky130_fd_pr__pfet_01v8_hvt ad=0 pd=0 as=0.26 ps=2.52 w=1 l=0.15
X3876 VGND sky130_fd_sc_hd__mux2_1_65/a_76_199# V3R192 VGND sky130_fd_pr__nfet_01v8 ad=0 pd=0 as=0.169 ps=1.82 w=0.65 l=0.15
X3877 VDPWR sky130_fd_sc_hd__mux2_1_43/a_505_21# sky130_fd_sc_hd__mux2_1_43/a_535_374# VDPWR sky130_fd_pr__pfet_01v8_hvt ad=0 pd=0 as=0.0882 ps=1.26 w=0.42 l=0.15
X3878 sky130_fd_sc_hd__mux2_1_43/a_505_21# V3R062 VDPWR VDPWR sky130_fd_pr__pfet_01v8_hvt ad=0.1176 pd=1.4 as=0 ps=0 w=0.42 l=0.15
X3879 sky130_fd_sc_hd__mux2_1_43/a_218_374# V3R062 VDPWR VDPWR sky130_fd_pr__pfet_01v8_hvt ad=0.1533 pd=1.57 as=0 ps=0 w=0.42 l=0.15
X3880 VGND sky130_fd_sc_hd__mux2_1_43/a_505_21# sky130_fd_sc_hd__mux2_1_43/a_439_47# VGND sky130_fd_pr__nfet_01v8 ad=0 pd=0 as=0.1386 ps=1.5 w=0.42 l=0.15
X3881 sky130_fd_sc_hd__mux2_1_43/a_76_199# V3R160 sky130_fd_sc_hd__mux2_1_43/a_218_374# VDPWR sky130_fd_pr__pfet_01v8_hvt ad=0.3864 pd=2.68 as=0 ps=0 w=0.42 l=0.15
X3882 sky130_fd_sc_hd__mux2_1_43/a_505_21# V3R062 VGND VGND sky130_fd_pr__nfet_01v8 ad=0.1092 pd=1.36 as=0 ps=0 w=0.42 l=0.15
X3883 sky130_fd_sc_hd__mux2_1_43/a_439_47# V3R160 sky130_fd_sc_hd__mux2_1_43/a_76_199# VGND sky130_fd_pr__nfet_01v8 ad=0 pd=0 as=0.1995 ps=1.79 w=0.42 l=0.15
X3884 sky130_fd_sc_hd__mux2_1_43/a_535_374# V3R159 sky130_fd_sc_hd__mux2_1_43/a_76_199# VDPWR sky130_fd_pr__pfet_01v8_hvt ad=0 pd=0 as=0 ps=0 w=0.42 l=0.15
X3885 sky130_fd_sc_hd__mux2_1_43/a_76_199# V3R159 sky130_fd_sc_hd__mux2_1_43/a_218_47# VGND sky130_fd_pr__nfet_01v8 ad=0 pd=0 as=0.1386 ps=1.5 w=0.42 l=0.15
X3886 sky130_fd_sc_hd__mux2_1_43/a_218_47# V3R062 VGND VGND sky130_fd_pr__nfet_01v8 ad=0 pd=0 as=0 ps=0 w=0.42 l=0.15
X3887 VDPWR sky130_fd_sc_hd__mux2_1_43/a_76_199# V3R104 VDPWR sky130_fd_pr__pfet_01v8_hvt ad=0 pd=0 as=0.26 ps=2.52 w=1 l=0.15
X3888 VGND sky130_fd_sc_hd__mux2_1_43/a_76_199# V3R104 VGND sky130_fd_pr__nfet_01v8 ad=0 pd=0 as=0.169 ps=1.82 w=0.65 l=0.15
X3889 VDPWR sky130_fd_sc_hd__mux2_1_32/a_505_21# sky130_fd_sc_hd__mux2_1_32/a_535_374# VDPWR sky130_fd_pr__pfet_01v8_hvt ad=0 pd=0 as=0.0882 ps=1.26 w=0.42 l=0.15
X3890 sky130_fd_sc_hd__mux2_1_32/a_505_21# V3R288 VDPWR VDPWR sky130_fd_pr__pfet_01v8_hvt ad=0.1176 pd=1.4 as=0 ps=0 w=0.42 l=0.15
X3891 sky130_fd_sc_hd__mux2_1_32/a_218_374# V3R288 VDPWR VDPWR sky130_fd_pr__pfet_01v8_hvt ad=0.1533 pd=1.57 as=0 ps=0 w=0.42 l=0.15
X3892 VGND sky130_fd_sc_hd__mux2_1_32/a_505_21# sky130_fd_sc_hd__mux2_1_32/a_439_47# VGND sky130_fd_pr__nfet_01v8 ad=0 pd=0 as=0.1386 ps=1.5 w=0.42 l=0.15
X3893 sky130_fd_sc_hd__mux2_1_32/a_76_199# V3R002 sky130_fd_sc_hd__mux2_1_32/a_218_374# VDPWR sky130_fd_pr__pfet_01v8_hvt ad=0.3864 pd=2.68 as=0 ps=0 w=0.42 l=0.15
X3894 sky130_fd_sc_hd__mux2_1_32/a_505_21# V3R288 VGND VGND sky130_fd_pr__nfet_01v8 ad=0.1092 pd=1.36 as=0 ps=0 w=0.42 l=0.15
X3895 sky130_fd_sc_hd__mux2_1_32/a_439_47# V3R002 sky130_fd_sc_hd__mux2_1_32/a_76_199# VGND sky130_fd_pr__nfet_01v8 ad=0 pd=0 as=0.1995 ps=1.79 w=0.42 l=0.15
X3896 sky130_fd_sc_hd__mux2_1_32/a_535_374# V3R052 sky130_fd_sc_hd__mux2_1_32/a_76_199# VDPWR sky130_fd_pr__pfet_01v8_hvt ad=0 pd=0 as=0 ps=0 w=0.42 l=0.15
X3897 sky130_fd_sc_hd__mux2_1_32/a_76_199# V3R052 sky130_fd_sc_hd__mux2_1_32/a_218_47# VGND sky130_fd_pr__nfet_01v8 ad=0 pd=0 as=0.1386 ps=1.5 w=0.42 l=0.15
X3898 sky130_fd_sc_hd__mux2_1_32/a_218_47# V3R288 VGND VGND sky130_fd_pr__nfet_01v8 ad=0 pd=0 as=0 ps=0 w=0.42 l=0.15
X3899 VDPWR sky130_fd_sc_hd__mux2_1_32/a_76_199# V3R185 VDPWR sky130_fd_pr__pfet_01v8_hvt ad=0 pd=0 as=0.26 ps=2.52 w=1 l=0.15
X3900 VGND sky130_fd_sc_hd__mux2_1_32/a_76_199# V3R185 VGND sky130_fd_pr__nfet_01v8 ad=0 pd=0 as=0.169 ps=1.82 w=0.65 l=0.15
X3901 VDPWR sky130_fd_sc_hd__mux2_1_54/a_505_21# sky130_fd_sc_hd__mux2_1_54/a_535_374# VDPWR sky130_fd_pr__pfet_01v8_hvt ad=0 pd=0 as=0.0882 ps=1.26 w=0.42 l=0.15
X3902 sky130_fd_sc_hd__mux2_1_54/a_505_21# V3R061 VDPWR VDPWR sky130_fd_pr__pfet_01v8_hvt ad=0.1176 pd=1.4 as=0 ps=0 w=0.42 l=0.15
X3903 sky130_fd_sc_hd__mux2_1_54/a_218_374# V3R061 VDPWR VDPWR sky130_fd_pr__pfet_01v8_hvt ad=0.1533 pd=1.57 as=0 ps=0 w=0.42 l=0.15
X3904 VGND sky130_fd_sc_hd__mux2_1_54/a_505_21# sky130_fd_sc_hd__mux2_1_54/a_439_47# VGND sky130_fd_pr__nfet_01v8 ad=0 pd=0 as=0.1386 ps=1.5 w=0.42 l=0.15
X3905 sky130_fd_sc_hd__mux2_1_54/a_76_199# V3R157 sky130_fd_sc_hd__mux2_1_54/a_218_374# VDPWR sky130_fd_pr__pfet_01v8_hvt ad=0.3864 pd=2.68 as=0 ps=0 w=0.42 l=0.15
X3906 sky130_fd_sc_hd__mux2_1_54/a_505_21# V3R061 VGND VGND sky130_fd_pr__nfet_01v8 ad=0.1092 pd=1.36 as=0 ps=0 w=0.42 l=0.15
X3907 sky130_fd_sc_hd__mux2_1_54/a_439_47# V3R157 sky130_fd_sc_hd__mux2_1_54/a_76_199# VGND sky130_fd_pr__nfet_01v8 ad=0 pd=0 as=0.1995 ps=1.79 w=0.42 l=0.15
X3908 sky130_fd_sc_hd__mux2_1_54/a_535_374# V3R156 sky130_fd_sc_hd__mux2_1_54/a_76_199# VDPWR sky130_fd_pr__pfet_01v8_hvt ad=0 pd=0 as=0 ps=0 w=0.42 l=0.15
X3909 sky130_fd_sc_hd__mux2_1_54/a_76_199# V3R156 sky130_fd_sc_hd__mux2_1_54/a_218_47# VGND sky130_fd_pr__nfet_01v8 ad=0 pd=0 as=0.1386 ps=1.5 w=0.42 l=0.15
X3910 sky130_fd_sc_hd__mux2_1_54/a_218_47# V3R061 VGND VGND sky130_fd_pr__nfet_01v8 ad=0 pd=0 as=0 ps=0 w=0.42 l=0.15
X3911 VDPWR sky130_fd_sc_hd__mux2_1_54/a_76_199# V3R101 VDPWR sky130_fd_pr__pfet_01v8_hvt ad=0 pd=0 as=0.26 ps=2.52 w=1 l=0.15
X3912 VGND sky130_fd_sc_hd__mux2_1_54/a_76_199# V3R101 VGND sky130_fd_pr__nfet_01v8 ad=0 pd=0 as=0.169 ps=1.82 w=0.65 l=0.15
X3913 VDPWR sky130_fd_sc_hd__buf_4_15/a_27_47# V3R298 VDPWR sky130_fd_pr__pfet_01v8_hvt ad=0 pd=0 as=0.54 ps=5.08 w=1 l=0.15
X3914 V3R298 sky130_fd_sc_hd__buf_4_15/a_27_47# VDPWR VDPWR sky130_fd_pr__pfet_01v8_hvt ad=0 pd=0 as=0 ps=0 w=1 l=0.15
X3915 VDPWR sky130_fd_sc_hd__buf_4_15/a_27_47# V3R298 VDPWR sky130_fd_pr__pfet_01v8_hvt ad=0 pd=0 as=0 ps=0 w=1 l=0.15
X3916 V3R298 sky130_fd_sc_hd__buf_4_15/a_27_47# VDPWR VDPWR sky130_fd_pr__pfet_01v8_hvt ad=0 pd=0 as=0 ps=0 w=1 l=0.15
X3917 V3R298 sky130_fd_sc_hd__buf_4_15/a_27_47# VGND VGND sky130_fd_pr__nfet_01v8 ad=0.351 pd=3.68 as=0 ps=0 w=0.65 l=0.15
X3918 V3R298 sky130_fd_sc_hd__buf_4_15/a_27_47# VGND VGND sky130_fd_pr__nfet_01v8 ad=0 pd=0 as=0 ps=0 w=0.65 l=0.15
X3919 VGND sky130_fd_sc_hd__buf_4_15/a_27_47# V3R298 VGND sky130_fd_pr__nfet_01v8 ad=0 pd=0 as=0 ps=0 w=0.65 l=0.15
X3920 VGND sky130_fd_sc_hd__buf_4_15/a_27_47# V3R298 VGND sky130_fd_pr__nfet_01v8 ad=0 pd=0 as=0 ps=0 w=0.65 l=0.15
X3921 VDPWR V3R297 sky130_fd_sc_hd__buf_4_15/a_27_47# VDPWR sky130_fd_pr__pfet_01v8_hvt ad=0 pd=0 as=0.26 ps=2.52 w=1 l=0.15
X3922 VGND V3R297 sky130_fd_sc_hd__buf_4_15/a_27_47# VGND sky130_fd_pr__nfet_01v8 ad=0 pd=0 as=0.169 ps=1.82 w=0.65 l=0.15
X3923 VGND V3R271 sky130_fd_sc_hd__or2_1_6/a_68_297# VGND sky130_fd_pr__nfet_01v8 ad=0 pd=0 as=0.1134 ps=1.38 w=0.42 l=0.15
X3924 sky130_fd_sc_hd__or2_1_6/a_68_297# V3R270 VGND VGND sky130_fd_pr__nfet_01v8 ad=0 pd=0 as=0 ps=0 w=0.42 l=0.15
X3925 V3R272 sky130_fd_sc_hd__or2_1_6/a_68_297# VGND VGND sky130_fd_pr__nfet_01v8 ad=0.169 pd=1.82 as=0 ps=0 w=0.65 l=0.15
X3926 VDPWR V3R271 sky130_fd_sc_hd__or2_1_6/a_150_297# VDPWR sky130_fd_pr__pfet_01v8_hvt ad=0 pd=0 as=0.0882 ps=1.26 w=0.42 l=0.15
X3927 V3R272 sky130_fd_sc_hd__or2_1_6/a_68_297# VDPWR VDPWR sky130_fd_pr__pfet_01v8_hvt ad=0.34 pd=2.68 as=0 ps=0 w=1 l=0.15
X3928 sky130_fd_sc_hd__or2_1_6/a_150_297# V3R270 sky130_fd_sc_hd__or2_1_6/a_68_297# VDPWR sky130_fd_pr__pfet_01v8_hvt ad=0 pd=0 as=0.1092 ps=1.36 w=0.42 l=0.15
X3929 VDPWR V3R292 sky130_fd_sc_hd__and2b_1_1/a_207_413# VDPWR sky130_fd_pr__pfet_01v8_hvt ad=0 pd=0 as=0.1218 ps=1.42 w=0.42 l=0.15
X3930 V3R268 sky130_fd_sc_hd__and2b_1_1/a_207_413# VDPWR VDPWR sky130_fd_pr__pfet_01v8_hvt ad=0.26 pd=2.52 as=0 ps=0 w=1 l=0.15
X3931 sky130_fd_sc_hd__and2b_1_1/a_297_47# sky130_fd_sc_hd__and2b_1_1/a_27_413# sky130_fd_sc_hd__and2b_1_1/a_207_413# VGND sky130_fd_pr__nfet_01v8 ad=0.1008 pd=1.32 as=0.1092 ps=1.36 w=0.42 l=0.15
X3932 V3R268 sky130_fd_sc_hd__and2b_1_1/a_207_413# VGND VGND sky130_fd_pr__nfet_01v8 ad=0.169 pd=1.82 as=0 ps=0 w=0.65 l=0.15
X3933 sky130_fd_sc_hd__and2b_1_1/a_207_413# sky130_fd_sc_hd__and2b_1_1/a_27_413# VDPWR VDPWR sky130_fd_pr__pfet_01v8_hvt ad=0 pd=0 as=0 ps=0 w=0.42 l=0.15
X3934 VDPWR V3R291 sky130_fd_sc_hd__and2b_1_1/a_27_413# VDPWR sky130_fd_pr__pfet_01v8_hvt ad=0 pd=0 as=0.1092 ps=1.36 w=0.42 l=0.15
X3935 VGND V3R292 sky130_fd_sc_hd__and2b_1_1/a_297_47# VGND sky130_fd_pr__nfet_01v8 ad=0 pd=0 as=0 ps=0 w=0.42 l=0.15
X3936 sky130_fd_sc_hd__and2b_1_1/a_27_413# V3R291 VGND VGND sky130_fd_pr__nfet_01v8 ad=0.1092 pd=1.36 as=0 ps=0 w=0.42 l=0.15
X3937 VDPWR sky130_fd_sc_hd__buf_4_8/a_27_47# V3R055 VDPWR sky130_fd_pr__pfet_01v8_hvt ad=0 pd=0 as=0.54 ps=5.08 w=1 l=0.15
X3938 V3R055 sky130_fd_sc_hd__buf_4_8/a_27_47# VDPWR VDPWR sky130_fd_pr__pfet_01v8_hvt ad=0 pd=0 as=0 ps=0 w=1 l=0.15
X3939 VDPWR sky130_fd_sc_hd__buf_4_8/a_27_47# V3R055 VDPWR sky130_fd_pr__pfet_01v8_hvt ad=0 pd=0 as=0 ps=0 w=1 l=0.15
X3940 V3R055 sky130_fd_sc_hd__buf_4_8/a_27_47# VDPWR VDPWR sky130_fd_pr__pfet_01v8_hvt ad=0 pd=0 as=0 ps=0 w=1 l=0.15
X3941 V3R055 sky130_fd_sc_hd__buf_4_8/a_27_47# VGND VGND sky130_fd_pr__nfet_01v8 ad=0.351 pd=3.68 as=0 ps=0 w=0.65 l=0.15
X3942 V3R055 sky130_fd_sc_hd__buf_4_8/a_27_47# VGND VGND sky130_fd_pr__nfet_01v8 ad=0 pd=0 as=0 ps=0 w=0.65 l=0.15
X3943 VGND sky130_fd_sc_hd__buf_4_8/a_27_47# V3R055 VGND sky130_fd_pr__nfet_01v8 ad=0 pd=0 as=0 ps=0 w=0.65 l=0.15
X3944 VGND sky130_fd_sc_hd__buf_4_8/a_27_47# V3R055 VGND sky130_fd_pr__nfet_01v8 ad=0 pd=0 as=0 ps=0 w=0.65 l=0.15
X3945 VDPWR V3R054 sky130_fd_sc_hd__buf_4_8/a_27_47# VDPWR sky130_fd_pr__pfet_01v8_hvt ad=0 pd=0 as=0.26 ps=2.52 w=1 l=0.15
X3946 VGND V3R054 sky130_fd_sc_hd__buf_4_8/a_27_47# VGND sky130_fd_pr__nfet_01v8 ad=0 pd=0 as=0.169 ps=1.82 w=0.65 l=0.15
X3947 VDPWR sky130_fd_sc_hd__mux2_1_11/a_505_21# sky130_fd_sc_hd__mux2_1_11/a_535_374# VDPWR sky130_fd_pr__pfet_01v8_hvt ad=0 pd=0 as=0.0882 ps=1.26 w=0.42 l=0.15
X3948 sky130_fd_sc_hd__mux2_1_11/a_505_21# V3R288 VDPWR VDPWR sky130_fd_pr__pfet_01v8_hvt ad=0.1176 pd=1.4 as=0 ps=0 w=0.42 l=0.15
X3949 sky130_fd_sc_hd__mux2_1_11/a_218_374# V3R288 VDPWR VDPWR sky130_fd_pr__pfet_01v8_hvt ad=0.1533 pd=1.57 as=0 ps=0 w=0.42 l=0.15
X3950 VGND sky130_fd_sc_hd__mux2_1_11/a_505_21# sky130_fd_sc_hd__mux2_1_11/a_439_47# VGND sky130_fd_pr__nfet_01v8 ad=0 pd=0 as=0.1386 ps=1.5 w=0.42 l=0.15
X3951 sky130_fd_sc_hd__mux2_1_11/a_76_199# V3R010 sky130_fd_sc_hd__mux2_1_11/a_218_374# VDPWR sky130_fd_pr__pfet_01v8_hvt ad=0.3864 pd=2.68 as=0 ps=0 w=0.42 l=0.15
X3952 sky130_fd_sc_hd__mux2_1_11/a_505_21# V3R288 VGND VGND sky130_fd_pr__nfet_01v8 ad=0.1092 pd=1.36 as=0 ps=0 w=0.42 l=0.15
X3953 sky130_fd_sc_hd__mux2_1_11/a_439_47# V3R010 sky130_fd_sc_hd__mux2_1_11/a_76_199# VGND sky130_fd_pr__nfet_01v8 ad=0 pd=0 as=0.1995 ps=1.79 w=0.42 l=0.15
X3954 sky130_fd_sc_hd__mux2_1_11/a_535_374# V3R204 sky130_fd_sc_hd__mux2_1_11/a_76_199# VDPWR sky130_fd_pr__pfet_01v8_hvt ad=0 pd=0 as=0 ps=0 w=0.42 l=0.15
X3955 sky130_fd_sc_hd__mux2_1_11/a_76_199# V3R204 sky130_fd_sc_hd__mux2_1_11/a_218_47# VGND sky130_fd_pr__nfet_01v8 ad=0 pd=0 as=0.1386 ps=1.5 w=0.42 l=0.15
X3956 sky130_fd_sc_hd__mux2_1_11/a_218_47# V3R288 VGND VGND sky130_fd_pr__nfet_01v8 ad=0 pd=0 as=0 ps=0 w=0.42 l=0.15
X3957 VDPWR sky130_fd_sc_hd__mux2_1_11/a_76_199# V3R186 VDPWR sky130_fd_pr__pfet_01v8_hvt ad=0 pd=0 as=0.26 ps=2.52 w=1 l=0.15
X3958 VGND sky130_fd_sc_hd__mux2_1_11/a_76_199# V3R186 VGND sky130_fd_pr__nfet_01v8 ad=0 pd=0 as=0.169 ps=1.82 w=0.65 l=0.15
X3959 VDPWR sky130_fd_sc_hd__mux2_1_44/a_505_21# sky130_fd_sc_hd__mux2_1_44/a_535_374# VDPWR sky130_fd_pr__pfet_01v8_hvt ad=0 pd=0 as=0.0882 ps=1.26 w=0.42 l=0.15
X3960 sky130_fd_sc_hd__mux2_1_44/a_505_21# V3R045 VDPWR VDPWR sky130_fd_pr__pfet_01v8_hvt ad=0.1176 pd=1.4 as=0 ps=0 w=0.42 l=0.15
X3961 sky130_fd_sc_hd__mux2_1_44/a_218_374# V3R045 VDPWR VDPWR sky130_fd_pr__pfet_01v8_hvt ad=0.1533 pd=1.57 as=0 ps=0 w=0.42 l=0.15
X3962 VGND sky130_fd_sc_hd__mux2_1_44/a_505_21# sky130_fd_sc_hd__mux2_1_44/a_439_47# VGND sky130_fd_pr__nfet_01v8 ad=0 pd=0 as=0.1386 ps=1.5 w=0.42 l=0.15
X3963 sky130_fd_sc_hd__mux2_1_44/a_76_199# V3R020 sky130_fd_sc_hd__mux2_1_44/a_218_374# VDPWR sky130_fd_pr__pfet_01v8_hvt ad=0.3864 pd=2.68 as=0 ps=0 w=0.42 l=0.15
X3964 sky130_fd_sc_hd__mux2_1_44/a_505_21# V3R045 VGND VGND sky130_fd_pr__nfet_01v8 ad=0.1092 pd=1.36 as=0 ps=0 w=0.42 l=0.15
X3965 sky130_fd_sc_hd__mux2_1_44/a_439_47# V3R020 sky130_fd_sc_hd__mux2_1_44/a_76_199# VGND sky130_fd_pr__nfet_01v8 ad=0 pd=0 as=0.1995 ps=1.79 w=0.42 l=0.15
X3966 sky130_fd_sc_hd__mux2_1_44/a_535_374# V3R159 sky130_fd_sc_hd__mux2_1_44/a_76_199# VDPWR sky130_fd_pr__pfet_01v8_hvt ad=0 pd=0 as=0 ps=0 w=0.42 l=0.15
X3967 sky130_fd_sc_hd__mux2_1_44/a_76_199# V3R159 sky130_fd_sc_hd__mux2_1_44/a_218_47# VGND sky130_fd_pr__nfet_01v8 ad=0 pd=0 as=0.1386 ps=1.5 w=0.42 l=0.15
X3968 sky130_fd_sc_hd__mux2_1_44/a_218_47# V3R045 VGND VGND sky130_fd_pr__nfet_01v8 ad=0 pd=0 as=0 ps=0 w=0.42 l=0.15
X3969 VDPWR sky130_fd_sc_hd__mux2_1_44/a_76_199# V3R136 VDPWR sky130_fd_pr__pfet_01v8_hvt ad=0 pd=0 as=0.26 ps=2.52 w=1 l=0.15
X3970 VGND sky130_fd_sc_hd__mux2_1_44/a_76_199# V3R136 VGND sky130_fd_pr__nfet_01v8 ad=0 pd=0 as=0.169 ps=1.82 w=0.65 l=0.15
X3971 VDPWR sky130_fd_sc_hd__mux2_1_33/a_505_21# sky130_fd_sc_hd__mux2_1_33/a_535_374# VDPWR sky130_fd_pr__pfet_01v8_hvt ad=0 pd=0 as=0.0882 ps=1.26 w=0.42 l=0.15
X3972 sky130_fd_sc_hd__mux2_1_33/a_505_21# V3R009 VDPWR VDPWR sky130_fd_pr__pfet_01v8_hvt ad=0.1176 pd=1.4 as=0 ps=0 w=0.42 l=0.15
X3973 sky130_fd_sc_hd__mux2_1_33/a_218_374# V3R009 VDPWR VDPWR sky130_fd_pr__pfet_01v8_hvt ad=0.1533 pd=1.57 as=0 ps=0 w=0.42 l=0.15
X3974 VGND sky130_fd_sc_hd__mux2_1_33/a_505_21# sky130_fd_sc_hd__mux2_1_33/a_439_47# VGND sky130_fd_pr__nfet_01v8 ad=0 pd=0 as=0.1386 ps=1.5 w=0.42 l=0.15
X3975 sky130_fd_sc_hd__mux2_1_33/a_76_199# V3R251 sky130_fd_sc_hd__mux2_1_33/a_218_374# VDPWR sky130_fd_pr__pfet_01v8_hvt ad=0.3864 pd=2.68 as=0 ps=0 w=0.42 l=0.15
X3976 sky130_fd_sc_hd__mux2_1_33/a_505_21# V3R009 VGND VGND sky130_fd_pr__nfet_01v8 ad=0.1092 pd=1.36 as=0 ps=0 w=0.42 l=0.15
X3977 sky130_fd_sc_hd__mux2_1_33/a_439_47# V3R251 sky130_fd_sc_hd__mux2_1_33/a_76_199# VGND sky130_fd_pr__nfet_01v8 ad=0 pd=0 as=0.1995 ps=1.79 w=0.42 l=0.15
X3978 sky130_fd_sc_hd__mux2_1_33/a_535_374# V3R026 sky130_fd_sc_hd__mux2_1_33/a_76_199# VDPWR sky130_fd_pr__pfet_01v8_hvt ad=0 pd=0 as=0 ps=0 w=0.42 l=0.15
X3979 sky130_fd_sc_hd__mux2_1_33/a_76_199# V3R026 sky130_fd_sc_hd__mux2_1_33/a_218_47# VGND sky130_fd_pr__nfet_01v8 ad=0 pd=0 as=0.1386 ps=1.5 w=0.42 l=0.15
X3980 sky130_fd_sc_hd__mux2_1_33/a_218_47# V3R009 VGND VGND sky130_fd_pr__nfet_01v8 ad=0 pd=0 as=0 ps=0 w=0.42 l=0.15
X3981 VDPWR sky130_fd_sc_hd__mux2_1_33/a_76_199# V3R221 VDPWR sky130_fd_pr__pfet_01v8_hvt ad=0 pd=0 as=0.26 ps=2.52 w=1 l=0.15
X3982 VGND sky130_fd_sc_hd__mux2_1_33/a_76_199# V3R221 VGND sky130_fd_pr__nfet_01v8 ad=0 pd=0 as=0.169 ps=1.82 w=0.65 l=0.15
X3983 VDPWR sky130_fd_sc_hd__mux2_1_22/a_505_21# sky130_fd_sc_hd__mux2_1_22/a_535_374# VDPWR sky130_fd_pr__pfet_01v8_hvt ad=0 pd=0 as=0.0882 ps=1.26 w=0.42 l=0.15
X3984 sky130_fd_sc_hd__mux2_1_22/a_505_21# V3R045 VDPWR VDPWR sky130_fd_pr__pfet_01v8_hvt ad=0.1176 pd=1.4 as=0 ps=0 w=0.42 l=0.15
X3985 sky130_fd_sc_hd__mux2_1_22/a_218_374# V3R045 VDPWR VDPWR sky130_fd_pr__pfet_01v8_hvt ad=0.1533 pd=1.57 as=0 ps=0 w=0.42 l=0.15
X3986 VGND sky130_fd_sc_hd__mux2_1_22/a_505_21# sky130_fd_sc_hd__mux2_1_22/a_439_47# VGND sky130_fd_pr__nfet_01v8 ad=0 pd=0 as=0.1386 ps=1.5 w=0.42 l=0.15
X3987 sky130_fd_sc_hd__mux2_1_22/a_76_199# V3R027 sky130_fd_sc_hd__mux2_1_22/a_218_374# VDPWR sky130_fd_pr__pfet_01v8_hvt ad=0.3864 pd=2.68 as=0 ps=0 w=0.42 l=0.15
X3988 sky130_fd_sc_hd__mux2_1_22/a_505_21# V3R045 VGND VGND sky130_fd_pr__nfet_01v8 ad=0.1092 pd=1.36 as=0 ps=0 w=0.42 l=0.15
X3989 sky130_fd_sc_hd__mux2_1_22/a_439_47# V3R027 sky130_fd_sc_hd__mux2_1_22/a_76_199# VGND sky130_fd_pr__nfet_01v8 ad=0 pd=0 as=0.1995 ps=1.79 w=0.42 l=0.15
X3990 sky130_fd_sc_hd__mux2_1_22/a_535_374# V3R166 sky130_fd_sc_hd__mux2_1_22/a_76_199# VDPWR sky130_fd_pr__pfet_01v8_hvt ad=0 pd=0 as=0 ps=0 w=0.42 l=0.15
X3991 sky130_fd_sc_hd__mux2_1_22/a_76_199# V3R166 sky130_fd_sc_hd__mux2_1_22/a_218_47# VGND sky130_fd_pr__nfet_01v8 ad=0 pd=0 as=0.1386 ps=1.5 w=0.42 l=0.15
X3992 sky130_fd_sc_hd__mux2_1_22/a_218_47# V3R045 VGND VGND sky130_fd_pr__nfet_01v8 ad=0 pd=0 as=0 ps=0 w=0.42 l=0.15
X3993 VDPWR sky130_fd_sc_hd__mux2_1_22/a_76_199# V3R142 VDPWR sky130_fd_pr__pfet_01v8_hvt ad=0 pd=0 as=0.26 ps=2.52 w=1 l=0.15
X3994 VGND sky130_fd_sc_hd__mux2_1_22/a_76_199# V3R142 VGND sky130_fd_pr__nfet_01v8 ad=0 pd=0 as=0.169 ps=1.82 w=0.65 l=0.15
X3995 VDPWR sky130_fd_sc_hd__mux2_1_99/a_505_21# sky130_fd_sc_hd__mux2_1_99/a_535_374# VDPWR sky130_fd_pr__pfet_01v8_hvt ad=0 pd=0 as=0.0882 ps=1.26 w=0.42 l=0.15
X3996 sky130_fd_sc_hd__mux2_1_99/a_505_21# V3R002 VDPWR VDPWR sky130_fd_pr__pfet_01v8_hvt ad=0.1176 pd=1.4 as=0 ps=0 w=0.42 l=0.15
X3997 sky130_fd_sc_hd__mux2_1_99/a_218_374# V3R002 VDPWR VDPWR sky130_fd_pr__pfet_01v8_hvt ad=0.1533 pd=1.57 as=0 ps=0 w=0.42 l=0.15
X3998 VGND sky130_fd_sc_hd__mux2_1_99/a_505_21# sky130_fd_sc_hd__mux2_1_99/a_439_47# VGND sky130_fd_pr__nfet_01v8 ad=0 pd=0 as=0.1386 ps=1.5 w=0.42 l=0.15
X3999 sky130_fd_sc_hd__mux2_1_99/a_76_199# V3R252 sky130_fd_sc_hd__mux2_1_99/a_218_374# VDPWR sky130_fd_pr__pfet_01v8_hvt ad=0.3864 pd=2.68 as=0 ps=0 w=0.42 l=0.15
X4000 sky130_fd_sc_hd__mux2_1_99/a_505_21# V3R002 VGND VGND sky130_fd_pr__nfet_01v8 ad=0.1092 pd=1.36 as=0 ps=0 w=0.42 l=0.15
X4001 sky130_fd_sc_hd__mux2_1_99/a_439_47# V3R252 sky130_fd_sc_hd__mux2_1_99/a_76_199# VGND sky130_fd_pr__nfet_01v8 ad=0 pd=0 as=0.1995 ps=1.79 w=0.42 l=0.15
X4002 sky130_fd_sc_hd__mux2_1_99/a_535_374# V3R244 sky130_fd_sc_hd__mux2_1_99/a_76_199# VDPWR sky130_fd_pr__pfet_01v8_hvt ad=0 pd=0 as=0 ps=0 w=0.42 l=0.15
X4003 sky130_fd_sc_hd__mux2_1_99/a_76_199# V3R244 sky130_fd_sc_hd__mux2_1_99/a_218_47# VGND sky130_fd_pr__nfet_01v8 ad=0 pd=0 as=0.1386 ps=1.5 w=0.42 l=0.15
X4004 sky130_fd_sc_hd__mux2_1_99/a_218_47# V3R002 VGND VGND sky130_fd_pr__nfet_01v8 ad=0 pd=0 as=0 ps=0 w=0.42 l=0.15
X4005 VDPWR sky130_fd_sc_hd__mux2_1_99/a_76_199# V3R253 VDPWR sky130_fd_pr__pfet_01v8_hvt ad=0 pd=0 as=0.26 ps=2.52 w=1 l=0.15
X4006 VGND sky130_fd_sc_hd__mux2_1_99/a_76_199# V3R253 VGND sky130_fd_pr__nfet_01v8 ad=0 pd=0 as=0.169 ps=1.82 w=0.65 l=0.15
X4007 VDPWR sky130_fd_sc_hd__mux2_1_88/a_505_21# sky130_fd_sc_hd__mux2_1_88/a_535_374# VDPWR sky130_fd_pr__pfet_01v8_hvt ad=0 pd=0 as=0.0882 ps=1.26 w=0.42 l=0.15
X4008 sky130_fd_sc_hd__mux2_1_88/a_505_21# V3R044 VDPWR VDPWR sky130_fd_pr__pfet_01v8_hvt ad=0.1176 pd=1.4 as=0 ps=0 w=0.42 l=0.15
X4009 sky130_fd_sc_hd__mux2_1_88/a_218_374# V3R044 VDPWR VDPWR sky130_fd_pr__pfet_01v8_hvt ad=0.1533 pd=1.57 as=0 ps=0 w=0.42 l=0.15
X4010 VGND sky130_fd_sc_hd__mux2_1_88/a_505_21# sky130_fd_sc_hd__mux2_1_88/a_439_47# VGND sky130_fd_pr__nfet_01v8 ad=0 pd=0 as=0.1386 ps=1.5 w=0.42 l=0.15
X4011 sky130_fd_sc_hd__mux2_1_88/a_76_199# V3R039 sky130_fd_sc_hd__mux2_1_88/a_218_374# VDPWR sky130_fd_pr__pfet_01v8_hvt ad=0.3864 pd=2.68 as=0 ps=0 w=0.42 l=0.15
X4012 sky130_fd_sc_hd__mux2_1_88/a_505_21# V3R044 VGND VGND sky130_fd_pr__nfet_01v8 ad=0.1092 pd=1.36 as=0 ps=0 w=0.42 l=0.15
X4013 sky130_fd_sc_hd__mux2_1_88/a_439_47# V3R039 sky130_fd_sc_hd__mux2_1_88/a_76_199# VGND sky130_fd_pr__nfet_01v8 ad=0 pd=0 as=0.1995 ps=1.79 w=0.42 l=0.15
X4014 sky130_fd_sc_hd__mux2_1_88/a_535_374# V3R178 sky130_fd_sc_hd__mux2_1_88/a_76_199# VDPWR sky130_fd_pr__pfet_01v8_hvt ad=0 pd=0 as=0 ps=0 w=0.42 l=0.15
X4015 sky130_fd_sc_hd__mux2_1_88/a_76_199# V3R178 sky130_fd_sc_hd__mux2_1_88/a_218_47# VGND sky130_fd_pr__nfet_01v8 ad=0 pd=0 as=0.1386 ps=1.5 w=0.42 l=0.15
X4016 sky130_fd_sc_hd__mux2_1_88/a_218_47# V3R044 VGND VGND sky130_fd_pr__nfet_01v8 ad=0 pd=0 as=0 ps=0 w=0.42 l=0.15
X4017 VDPWR sky130_fd_sc_hd__mux2_1_88/a_76_199# V3R124 VDPWR sky130_fd_pr__pfet_01v8_hvt ad=0 pd=0 as=0.26 ps=2.52 w=1 l=0.15
X4018 VGND sky130_fd_sc_hd__mux2_1_88/a_76_199# V3R124 VGND sky130_fd_pr__nfet_01v8 ad=0 pd=0 as=0.169 ps=1.82 w=0.65 l=0.15
X4019 VDPWR sky130_fd_sc_hd__mux2_1_77/a_505_21# sky130_fd_sc_hd__mux2_1_77/a_535_374# VDPWR sky130_fd_pr__pfet_01v8_hvt ad=0 pd=0 as=0.0882 ps=1.26 w=0.42 l=0.15
X4020 sky130_fd_sc_hd__mux2_1_77/a_505_21# V3R002 VDPWR VDPWR sky130_fd_pr__pfet_01v8_hvt ad=0.1176 pd=1.4 as=0 ps=0 w=0.42 l=0.15
X4021 sky130_fd_sc_hd__mux2_1_77/a_218_374# V3R002 VDPWR VDPWR sky130_fd_pr__pfet_01v8_hvt ad=0.1533 pd=1.57 as=0 ps=0 w=0.42 l=0.15
X4022 VGND sky130_fd_sc_hd__mux2_1_77/a_505_21# sky130_fd_sc_hd__mux2_1_77/a_439_47# VGND sky130_fd_pr__nfet_01v8 ad=0 pd=0 as=0.1386 ps=1.5 w=0.42 l=0.15
X4023 sky130_fd_sc_hd__mux2_1_77/a_76_199# V3R257 sky130_fd_sc_hd__mux2_1_77/a_218_374# VDPWR sky130_fd_pr__pfet_01v8_hvt ad=0.3864 pd=2.68 as=0 ps=0 w=0.42 l=0.15
X4024 sky130_fd_sc_hd__mux2_1_77/a_505_21# V3R002 VGND VGND sky130_fd_pr__nfet_01v8 ad=0.1092 pd=1.36 as=0 ps=0 w=0.42 l=0.15
X4025 sky130_fd_sc_hd__mux2_1_77/a_439_47# V3R257 sky130_fd_sc_hd__mux2_1_77/a_76_199# VGND sky130_fd_pr__nfet_01v8 ad=0 pd=0 as=0.1995 ps=1.79 w=0.42 l=0.15
X4026 sky130_fd_sc_hd__mux2_1_77/a_535_374# V3R245 sky130_fd_sc_hd__mux2_1_77/a_76_199# VDPWR sky130_fd_pr__pfet_01v8_hvt ad=0 pd=0 as=0 ps=0 w=0.42 l=0.15
X4027 sky130_fd_sc_hd__mux2_1_77/a_76_199# V3R245 sky130_fd_sc_hd__mux2_1_77/a_218_47# VGND sky130_fd_pr__nfet_01v8 ad=0 pd=0 as=0.1386 ps=1.5 w=0.42 l=0.15
X4028 sky130_fd_sc_hd__mux2_1_77/a_218_47# V3R002 VGND VGND sky130_fd_pr__nfet_01v8 ad=0 pd=0 as=0 ps=0 w=0.42 l=0.15
X4029 VDPWR sky130_fd_sc_hd__mux2_1_77/a_76_199# V3R258 VDPWR sky130_fd_pr__pfet_01v8_hvt ad=0 pd=0 as=0.26 ps=2.52 w=1 l=0.15
X4030 VGND sky130_fd_sc_hd__mux2_1_77/a_76_199# V3R258 VGND sky130_fd_pr__nfet_01v8 ad=0 pd=0 as=0.169 ps=1.82 w=0.65 l=0.15
X4031 VDPWR sky130_fd_sc_hd__mux2_1_66/a_505_21# sky130_fd_sc_hd__mux2_1_66/a_535_374# VDPWR sky130_fd_pr__pfet_01v8_hvt ad=0 pd=0 as=0.0882 ps=1.26 w=0.42 l=0.15
X4032 sky130_fd_sc_hd__mux2_1_66/a_505_21# V3R288 VDPWR VDPWR sky130_fd_pr__pfet_01v8_hvt ad=0.1176 pd=1.4 as=0 ps=0 w=0.42 l=0.15
X4033 sky130_fd_sc_hd__mux2_1_66/a_218_374# V3R288 VDPWR VDPWR sky130_fd_pr__pfet_01v8_hvt ad=0.1533 pd=1.57 as=0 ps=0 w=0.42 l=0.15
X4034 VGND sky130_fd_sc_hd__mux2_1_66/a_505_21# sky130_fd_sc_hd__mux2_1_66/a_439_47# VGND sky130_fd_pr__nfet_01v8 ad=0 pd=0 as=0.1386 ps=1.5 w=0.42 l=0.15
X4035 sky130_fd_sc_hd__mux2_1_66/a_76_199# V3R001 sky130_fd_sc_hd__mux2_1_66/a_218_374# VDPWR sky130_fd_pr__pfet_01v8_hvt ad=0.3864 pd=2.68 as=0 ps=0 w=0.42 l=0.15
X4036 sky130_fd_sc_hd__mux2_1_66/a_505_21# V3R288 VGND VGND sky130_fd_pr__nfet_01v8 ad=0.1092 pd=1.36 as=0 ps=0 w=0.42 l=0.15
X4037 sky130_fd_sc_hd__mux2_1_66/a_439_47# V3R001 sky130_fd_sc_hd__mux2_1_66/a_76_199# VGND sky130_fd_pr__nfet_01v8 ad=0 pd=0 as=0.1995 ps=1.79 w=0.42 l=0.15
X4038 sky130_fd_sc_hd__mux2_1_66/a_535_374# V3R051 sky130_fd_sc_hd__mux2_1_66/a_76_199# VDPWR sky130_fd_pr__pfet_01v8_hvt ad=0 pd=0 as=0 ps=0 w=0.42 l=0.15
X4039 sky130_fd_sc_hd__mux2_1_66/a_76_199# V3R051 sky130_fd_sc_hd__mux2_1_66/a_218_47# VGND sky130_fd_pr__nfet_01v8 ad=0 pd=0 as=0.1386 ps=1.5 w=0.42 l=0.15
X4040 sky130_fd_sc_hd__mux2_1_66/a_218_47# V3R288 VGND VGND sky130_fd_pr__nfet_01v8 ad=0 pd=0 as=0 ps=0 w=0.42 l=0.15
X4041 VDPWR sky130_fd_sc_hd__mux2_1_66/a_76_199# V3R184 VDPWR sky130_fd_pr__pfet_01v8_hvt ad=0 pd=0 as=0.26 ps=2.52 w=1 l=0.15
X4042 VGND sky130_fd_sc_hd__mux2_1_66/a_76_199# V3R184 VGND sky130_fd_pr__nfet_01v8 ad=0 pd=0 as=0.169 ps=1.82 w=0.65 l=0.15
X4043 VDPWR sky130_fd_sc_hd__mux2_1_55/a_505_21# sky130_fd_sc_hd__mux2_1_55/a_535_374# VDPWR sky130_fd_pr__pfet_01v8_hvt ad=0 pd=0 as=0.0882 ps=1.26 w=0.42 l=0.15
X4044 sky130_fd_sc_hd__mux2_1_55/a_505_21# V3R044 VDPWR VDPWR sky130_fd_pr__pfet_01v8_hvt ad=0.1176 pd=1.4 as=0 ps=0 w=0.42 l=0.15
X4045 sky130_fd_sc_hd__mux2_1_55/a_218_374# V3R044 VDPWR VDPWR sky130_fd_pr__pfet_01v8_hvt ad=0.1533 pd=1.57 as=0 ps=0 w=0.42 l=0.15
X4046 VGND sky130_fd_sc_hd__mux2_1_55/a_505_21# sky130_fd_sc_hd__mux2_1_55/a_439_47# VGND sky130_fd_pr__nfet_01v8 ad=0 pd=0 as=0.1386 ps=1.5 w=0.42 l=0.15
X4047 sky130_fd_sc_hd__mux2_1_55/a_76_199# V3R017 sky130_fd_sc_hd__mux2_1_55/a_218_374# VDPWR sky130_fd_pr__pfet_01v8_hvt ad=0.3864 pd=2.68 as=0 ps=0 w=0.42 l=0.15
X4048 sky130_fd_sc_hd__mux2_1_55/a_505_21# V3R044 VGND VGND sky130_fd_pr__nfet_01v8 ad=0.1092 pd=1.36 as=0 ps=0 w=0.42 l=0.15
X4049 sky130_fd_sc_hd__mux2_1_55/a_439_47# V3R017 sky130_fd_sc_hd__mux2_1_55/a_76_199# VGND sky130_fd_pr__nfet_01v8 ad=0 pd=0 as=0.1995 ps=1.79 w=0.42 l=0.15
X4050 sky130_fd_sc_hd__mux2_1_55/a_535_374# V3R156 sky130_fd_sc_hd__mux2_1_55/a_76_199# VDPWR sky130_fd_pr__pfet_01v8_hvt ad=0 pd=0 as=0 ps=0 w=0.42 l=0.15
X4051 sky130_fd_sc_hd__mux2_1_55/a_76_199# V3R156 sky130_fd_sc_hd__mux2_1_55/a_218_47# VGND sky130_fd_pr__nfet_01v8 ad=0 pd=0 as=0.1386 ps=1.5 w=0.42 l=0.15
X4052 sky130_fd_sc_hd__mux2_1_55/a_218_47# V3R044 VGND VGND sky130_fd_pr__nfet_01v8 ad=0 pd=0 as=0 ps=0 w=0.42 l=0.15
X4053 VDPWR sky130_fd_sc_hd__mux2_1_55/a_76_199# V3R133 VDPWR sky130_fd_pr__pfet_01v8_hvt ad=0 pd=0 as=0.26 ps=2.52 w=1 l=0.15
X4054 VGND sky130_fd_sc_hd__mux2_1_55/a_76_199# V3R133 VGND sky130_fd_pr__nfet_01v8 ad=0 pd=0 as=0.169 ps=1.82 w=0.65 l=0.15
X4055 VDPWR sky130_fd_sc_hd__buf_4_16/a_27_47# V3R046 VDPWR sky130_fd_pr__pfet_01v8_hvt ad=0 pd=0 as=0.54 ps=5.08 w=1 l=0.15
X4056 V3R046 sky130_fd_sc_hd__buf_4_16/a_27_47# VDPWR VDPWR sky130_fd_pr__pfet_01v8_hvt ad=0 pd=0 as=0 ps=0 w=1 l=0.15
X4057 VDPWR sky130_fd_sc_hd__buf_4_16/a_27_47# V3R046 VDPWR sky130_fd_pr__pfet_01v8_hvt ad=0 pd=0 as=0 ps=0 w=1 l=0.15
X4058 V3R046 sky130_fd_sc_hd__buf_4_16/a_27_47# VDPWR VDPWR sky130_fd_pr__pfet_01v8_hvt ad=0 pd=0 as=0 ps=0 w=1 l=0.15
X4059 V3R046 sky130_fd_sc_hd__buf_4_16/a_27_47# VGND VGND sky130_fd_pr__nfet_01v8 ad=0.351 pd=3.68 as=0 ps=0 w=0.65 l=0.15
X4060 V3R046 sky130_fd_sc_hd__buf_4_16/a_27_47# VGND VGND sky130_fd_pr__nfet_01v8 ad=0 pd=0 as=0 ps=0 w=0.65 l=0.15
X4061 VGND sky130_fd_sc_hd__buf_4_16/a_27_47# V3R046 VGND sky130_fd_pr__nfet_01v8 ad=0 pd=0 as=0 ps=0 w=0.65 l=0.15
X4062 VGND sky130_fd_sc_hd__buf_4_16/a_27_47# V3R046 VGND sky130_fd_pr__nfet_01v8 ad=0 pd=0 as=0 ps=0 w=0.65 l=0.15
X4063 VDPWR V3R043 sky130_fd_sc_hd__buf_4_16/a_27_47# VDPWR sky130_fd_pr__pfet_01v8_hvt ad=0 pd=0 as=0.26 ps=2.52 w=1 l=0.15
X4064 VGND V3R043 sky130_fd_sc_hd__buf_4_16/a_27_47# VGND sky130_fd_pr__nfet_01v8 ad=0 pd=0 as=0.169 ps=1.82 w=0.65 l=0.15
X4065 VGND V3R001 sky130_fd_sc_hd__or2_1_7/a_68_297# VGND sky130_fd_pr__nfet_01v8 ad=0 pd=0 as=0.1134 ps=1.38 w=0.42 l=0.15
X4066 sky130_fd_sc_hd__or2_1_7/a_68_297# V3R000 VGND VGND sky130_fd_pr__nfet_01v8 ad=0 pd=0 as=0 ps=0 w=0.42 l=0.15
X4067 V3R252 sky130_fd_sc_hd__or2_1_7/a_68_297# VGND VGND sky130_fd_pr__nfet_01v8 ad=0.169 pd=1.82 as=0 ps=0 w=0.65 l=0.15
X4068 VDPWR V3R001 sky130_fd_sc_hd__or2_1_7/a_150_297# VDPWR sky130_fd_pr__pfet_01v8_hvt ad=0 pd=0 as=0.0882 ps=1.26 w=0.42 l=0.15
X4069 V3R252 sky130_fd_sc_hd__or2_1_7/a_68_297# VDPWR VDPWR sky130_fd_pr__pfet_01v8_hvt ad=0.34 pd=2.68 as=0 ps=0 w=1 l=0.15
X4070 sky130_fd_sc_hd__or2_1_7/a_150_297# V3R000 sky130_fd_sc_hd__or2_1_7/a_68_297# VDPWR sky130_fd_pr__pfet_01v8_hvt ad=0 pd=0 as=0.1092 ps=1.36 w=0.42 l=0.15
X4071 VDPWR V3R203 sky130_fd_sc_hd__and2b_1_2/a_207_413# VDPWR sky130_fd_pr__pfet_01v8_hvt ad=0 pd=0 as=0.1218 ps=1.42 w=0.42 l=0.15
X4072 V3R295 sky130_fd_sc_hd__and2b_1_2/a_207_413# VDPWR VDPWR sky130_fd_pr__pfet_01v8_hvt ad=0.26 pd=2.52 as=0 ps=0 w=1 l=0.15
X4073 sky130_fd_sc_hd__and2b_1_2/a_297_47# sky130_fd_sc_hd__and2b_1_2/a_27_413# sky130_fd_sc_hd__and2b_1_2/a_207_413# VGND sky130_fd_pr__nfet_01v8 ad=0.1008 pd=1.32 as=0.1092 ps=1.36 w=0.42 l=0.15
X4074 V3R295 sky130_fd_sc_hd__and2b_1_2/a_207_413# VGND VGND sky130_fd_pr__nfet_01v8 ad=0.169 pd=1.82 as=0 ps=0 w=0.65 l=0.15
X4075 sky130_fd_sc_hd__and2b_1_2/a_207_413# sky130_fd_sc_hd__and2b_1_2/a_27_413# VDPWR VDPWR sky130_fd_pr__pfet_01v8_hvt ad=0 pd=0 as=0 ps=0 w=0.42 l=0.15
X4076 VDPWR V3R292 sky130_fd_sc_hd__and2b_1_2/a_27_413# VDPWR sky130_fd_pr__pfet_01v8_hvt ad=0 pd=0 as=0.1092 ps=1.36 w=0.42 l=0.15
X4077 VGND V3R203 sky130_fd_sc_hd__and2b_1_2/a_297_47# VGND sky130_fd_pr__nfet_01v8 ad=0 pd=0 as=0 ps=0 w=0.42 l=0.15
X4078 sky130_fd_sc_hd__and2b_1_2/a_27_413# V3R292 VGND VGND sky130_fd_pr__nfet_01v8 ad=0.1092 pd=1.36 as=0 ps=0 w=0.42 l=0.15
X4079 VDPWR sky130_fd_sc_hd__buf_4_9/a_27_47# V3R083 VDPWR sky130_fd_pr__pfet_01v8_hvt ad=0 pd=0 as=0.54 ps=5.08 w=1 l=0.15
X4080 V3R083 sky130_fd_sc_hd__buf_4_9/a_27_47# VDPWR VDPWR sky130_fd_pr__pfet_01v8_hvt ad=0 pd=0 as=0 ps=0 w=1 l=0.15
X4081 VDPWR sky130_fd_sc_hd__buf_4_9/a_27_47# V3R083 VDPWR sky130_fd_pr__pfet_01v8_hvt ad=0 pd=0 as=0 ps=0 w=1 l=0.15
X4082 V3R083 sky130_fd_sc_hd__buf_4_9/a_27_47# VDPWR VDPWR sky130_fd_pr__pfet_01v8_hvt ad=0 pd=0 as=0 ps=0 w=1 l=0.15
X4083 V3R083 sky130_fd_sc_hd__buf_4_9/a_27_47# VGND VGND sky130_fd_pr__nfet_01v8 ad=0.351 pd=3.68 as=0 ps=0 w=0.65 l=0.15
X4084 V3R083 sky130_fd_sc_hd__buf_4_9/a_27_47# VGND VGND sky130_fd_pr__nfet_01v8 ad=0 pd=0 as=0 ps=0 w=0.65 l=0.15
X4085 VGND sky130_fd_sc_hd__buf_4_9/a_27_47# V3R083 VGND sky130_fd_pr__nfet_01v8 ad=0 pd=0 as=0 ps=0 w=0.65 l=0.15
X4086 VGND sky130_fd_sc_hd__buf_4_9/a_27_47# V3R083 VGND sky130_fd_pr__nfet_01v8 ad=0 pd=0 as=0 ps=0 w=0.65 l=0.15
X4087 VDPWR V3R080 sky130_fd_sc_hd__buf_4_9/a_27_47# VDPWR sky130_fd_pr__pfet_01v8_hvt ad=0 pd=0 as=0.26 ps=2.52 w=1 l=0.15
X4088 VGND V3R080 sky130_fd_sc_hd__buf_4_9/a_27_47# VGND sky130_fd_pr__nfet_01v8 ad=0 pd=0 as=0.169 ps=1.82 w=0.65 l=0.15
X4089 VDPWR sky130_fd_sc_hd__mux2_1_12/a_505_21# sky130_fd_sc_hd__mux2_1_12/a_535_374# VDPWR sky130_fd_pr__pfet_01v8_hvt ad=0 pd=0 as=0.0882 ps=1.26 w=0.42 l=0.15
X4090 sky130_fd_sc_hd__mux2_1_12/a_505_21# V3R009 VDPWR VDPWR sky130_fd_pr__pfet_01v8_hvt ad=0.1176 pd=1.4 as=0 ps=0 w=0.42 l=0.15
X4091 sky130_fd_sc_hd__mux2_1_12/a_218_374# V3R009 VDPWR VDPWR sky130_fd_pr__pfet_01v8_hvt ad=0.1533 pd=1.57 as=0 ps=0 w=0.42 l=0.15
X4092 VGND sky130_fd_sc_hd__mux2_1_12/a_505_21# sky130_fd_sc_hd__mux2_1_12/a_439_47# VGND sky130_fd_pr__nfet_01v8 ad=0 pd=0 as=0.1386 ps=1.5 w=0.42 l=0.15
X4093 sky130_fd_sc_hd__mux2_1_12/a_76_199# V3R256 sky130_fd_sc_hd__mux2_1_12/a_218_374# VDPWR sky130_fd_pr__pfet_01v8_hvt ad=0.3864 pd=2.68 as=0 ps=0 w=0.42 l=0.15
X4094 sky130_fd_sc_hd__mux2_1_12/a_505_21# V3R009 VGND VGND sky130_fd_pr__nfet_01v8 ad=0.1092 pd=1.36 as=0 ps=0 w=0.42 l=0.15
X4095 sky130_fd_sc_hd__mux2_1_12/a_439_47# V3R256 sky130_fd_sc_hd__mux2_1_12/a_76_199# VGND sky130_fd_pr__nfet_01v8 ad=0 pd=0 as=0.1995 ps=1.79 w=0.42 l=0.15
X4096 sky130_fd_sc_hd__mux2_1_12/a_535_374# V3R032 sky130_fd_sc_hd__mux2_1_12/a_76_199# VDPWR sky130_fd_pr__pfet_01v8_hvt ad=0 pd=0 as=0 ps=0 w=0.42 l=0.15
X4097 sky130_fd_sc_hd__mux2_1_12/a_76_199# V3R032 sky130_fd_sc_hd__mux2_1_12/a_218_47# VGND sky130_fd_pr__nfet_01v8 ad=0 pd=0 as=0.1386 ps=1.5 w=0.42 l=0.15
X4098 sky130_fd_sc_hd__mux2_1_12/a_218_47# V3R009 VGND VGND sky130_fd_pr__nfet_01v8 ad=0 pd=0 as=0 ps=0 w=0.42 l=0.15
X4099 VDPWR sky130_fd_sc_hd__mux2_1_12/a_76_199# V3R227 VDPWR sky130_fd_pr__pfet_01v8_hvt ad=0 pd=0 as=0.26 ps=2.52 w=1 l=0.15
X4100 VGND sky130_fd_sc_hd__mux2_1_12/a_76_199# V3R227 VGND sky130_fd_pr__nfet_01v8 ad=0 pd=0 as=0.169 ps=1.82 w=0.65 l=0.15
X4101 VDPWR sky130_fd_sc_hd__mux2_1_67/a_505_21# sky130_fd_sc_hd__mux2_1_67/a_535_374# VDPWR sky130_fd_pr__pfet_01v8_hvt ad=0 pd=0 as=0.0882 ps=1.26 w=0.42 l=0.15
X4102 sky130_fd_sc_hd__mux2_1_67/a_505_21# V3R008 VDPWR VDPWR sky130_fd_pr__pfet_01v8_hvt ad=0.1176 pd=1.4 as=0 ps=0 w=0.42 l=0.15
X4103 sky130_fd_sc_hd__mux2_1_67/a_218_374# V3R008 VDPWR VDPWR sky130_fd_pr__pfet_01v8_hvt ad=0.1533 pd=1.57 as=0 ps=0 w=0.42 l=0.15
X4104 VGND sky130_fd_sc_hd__mux2_1_67/a_505_21# sky130_fd_sc_hd__mux2_1_67/a_439_47# VGND sky130_fd_pr__nfet_01v8 ad=0 pd=0 as=0.1386 ps=1.5 w=0.42 l=0.15
X4105 sky130_fd_sc_hd__mux2_1_67/a_76_199# V3R243 sky130_fd_sc_hd__mux2_1_67/a_218_374# VDPWR sky130_fd_pr__pfet_01v8_hvt ad=0.3864 pd=2.68 as=0 ps=0 w=0.42 l=0.15
X4106 sky130_fd_sc_hd__mux2_1_67/a_505_21# V3R008 VGND VGND sky130_fd_pr__nfet_01v8 ad=0.1092 pd=1.36 as=0 ps=0 w=0.42 l=0.15
X4107 sky130_fd_sc_hd__mux2_1_67/a_439_47# V3R243 sky130_fd_sc_hd__mux2_1_67/a_76_199# VGND sky130_fd_pr__nfet_01v8 ad=0 pd=0 as=0.1995 ps=1.79 w=0.42 l=0.15
X4108 sky130_fd_sc_hd__mux2_1_67/a_535_374# V3R015 sky130_fd_sc_hd__mux2_1_67/a_76_199# VDPWR sky130_fd_pr__pfet_01v8_hvt ad=0 pd=0 as=0 ps=0 w=0.42 l=0.15
X4109 sky130_fd_sc_hd__mux2_1_67/a_76_199# V3R015 sky130_fd_sc_hd__mux2_1_67/a_218_47# VGND sky130_fd_pr__nfet_01v8 ad=0 pd=0 as=0.1386 ps=1.5 w=0.42 l=0.15
X4110 sky130_fd_sc_hd__mux2_1_67/a_218_47# V3R008 VGND VGND sky130_fd_pr__nfet_01v8 ad=0 pd=0 as=0 ps=0 w=0.42 l=0.15
X4111 VDPWR sky130_fd_sc_hd__mux2_1_67/a_76_199# V3R210 VDPWR sky130_fd_pr__pfet_01v8_hvt ad=0 pd=0 as=0.26 ps=2.52 w=1 l=0.15
X4112 VGND sky130_fd_sc_hd__mux2_1_67/a_76_199# V3R210 VGND sky130_fd_pr__nfet_01v8 ad=0 pd=0 as=0.169 ps=1.82 w=0.65 l=0.15
X4113 VDPWR sky130_fd_sc_hd__mux2_1_56/a_505_21# sky130_fd_sc_hd__mux2_1_56/a_535_374# VDPWR sky130_fd_pr__pfet_01v8_hvt ad=0 pd=0 as=0.0882 ps=1.26 w=0.42 l=0.15
X4114 sky130_fd_sc_hd__mux2_1_56/a_505_21# V3R061 VDPWR VDPWR sky130_fd_pr__pfet_01v8_hvt ad=0.1176 pd=1.4 as=0 ps=0 w=0.42 l=0.15
X4115 sky130_fd_sc_hd__mux2_1_56/a_218_374# V3R061 VDPWR VDPWR sky130_fd_pr__pfet_01v8_hvt ad=0.1533 pd=1.57 as=0 ps=0 w=0.42 l=0.15
X4116 VGND sky130_fd_sc_hd__mux2_1_56/a_505_21# sky130_fd_sc_hd__mux2_1_56/a_439_47# VGND sky130_fd_pr__nfet_01v8 ad=0 pd=0 as=0.1386 ps=1.5 w=0.42 l=0.15
X4117 sky130_fd_sc_hd__mux2_1_56/a_76_199# V3R156 sky130_fd_sc_hd__mux2_1_56/a_218_374# VDPWR sky130_fd_pr__pfet_01v8_hvt ad=0.3864 pd=2.68 as=0 ps=0 w=0.42 l=0.15
X4118 sky130_fd_sc_hd__mux2_1_56/a_505_21# V3R061 VGND VGND sky130_fd_pr__nfet_01v8 ad=0.1092 pd=1.36 as=0 ps=0 w=0.42 l=0.15
X4119 sky130_fd_sc_hd__mux2_1_56/a_439_47# V3R156 sky130_fd_sc_hd__mux2_1_56/a_76_199# VGND sky130_fd_pr__nfet_01v8 ad=0 pd=0 as=0.1995 ps=1.79 w=0.42 l=0.15
X4120 sky130_fd_sc_hd__mux2_1_56/a_535_374# V3R155 sky130_fd_sc_hd__mux2_1_56/a_76_199# VDPWR sky130_fd_pr__pfet_01v8_hvt ad=0 pd=0 as=0 ps=0 w=0.42 l=0.15
X4121 sky130_fd_sc_hd__mux2_1_56/a_76_199# V3R155 sky130_fd_sc_hd__mux2_1_56/a_218_47# VGND sky130_fd_pr__nfet_01v8 ad=0 pd=0 as=0.1386 ps=1.5 w=0.42 l=0.15
X4122 sky130_fd_sc_hd__mux2_1_56/a_218_47# V3R061 VGND VGND sky130_fd_pr__nfet_01v8 ad=0 pd=0 as=0 ps=0 w=0.42 l=0.15
X4123 VDPWR sky130_fd_sc_hd__mux2_1_56/a_76_199# V3R100 VDPWR sky130_fd_pr__pfet_01v8_hvt ad=0 pd=0 as=0.26 ps=2.52 w=1 l=0.15
X4124 VGND sky130_fd_sc_hd__mux2_1_56/a_76_199# V3R100 VGND sky130_fd_pr__nfet_01v8 ad=0 pd=0 as=0.169 ps=1.82 w=0.65 l=0.15
X4125 VDPWR sky130_fd_sc_hd__mux2_1_45/a_505_21# sky130_fd_sc_hd__mux2_1_45/a_535_374# VDPWR sky130_fd_pr__pfet_01v8_hvt ad=0 pd=0 as=0.0882 ps=1.26 w=0.42 l=0.15
X4126 sky130_fd_sc_hd__mux2_1_45/a_505_21# V3R009 VDPWR VDPWR sky130_fd_pr__pfet_01v8_hvt ad=0.1176 pd=1.4 as=0 ps=0 w=0.42 l=0.15
X4127 sky130_fd_sc_hd__mux2_1_45/a_218_374# V3R009 VDPWR VDPWR sky130_fd_pr__pfet_01v8_hvt ad=0.1533 pd=1.57 as=0 ps=0 w=0.42 l=0.15
X4128 VGND sky130_fd_sc_hd__mux2_1_45/a_505_21# sky130_fd_sc_hd__mux2_1_45/a_439_47# VGND sky130_fd_pr__nfet_01v8 ad=0 pd=0 as=0.1386 ps=1.5 w=0.42 l=0.15
X4129 sky130_fd_sc_hd__mux2_1_45/a_76_199# V3R254 sky130_fd_sc_hd__mux2_1_45/a_218_374# VDPWR sky130_fd_pr__pfet_01v8_hvt ad=0.3864 pd=2.68 as=0 ps=0 w=0.42 l=0.15
X4130 sky130_fd_sc_hd__mux2_1_45/a_505_21# V3R009 VGND VGND sky130_fd_pr__nfet_01v8 ad=0.1092 pd=1.36 as=0 ps=0 w=0.42 l=0.15
X4131 sky130_fd_sc_hd__mux2_1_45/a_439_47# V3R254 sky130_fd_sc_hd__mux2_1_45/a_76_199# VGND sky130_fd_pr__nfet_01v8 ad=0 pd=0 as=0.1995 ps=1.79 w=0.42 l=0.15
X4132 sky130_fd_sc_hd__mux2_1_45/a_535_374# V3R021 sky130_fd_sc_hd__mux2_1_45/a_76_199# VDPWR sky130_fd_pr__pfet_01v8_hvt ad=0 pd=0 as=0 ps=0 w=0.42 l=0.15
X4133 sky130_fd_sc_hd__mux2_1_45/a_76_199# V3R021 sky130_fd_sc_hd__mux2_1_45/a_218_47# VGND sky130_fd_pr__nfet_01v8 ad=0 pd=0 as=0.1386 ps=1.5 w=0.42 l=0.15
X4134 sky130_fd_sc_hd__mux2_1_45/a_218_47# V3R009 VGND VGND sky130_fd_pr__nfet_01v8 ad=0 pd=0 as=0 ps=0 w=0.42 l=0.15
X4135 VDPWR sky130_fd_sc_hd__mux2_1_45/a_76_199# V3R216 VDPWR sky130_fd_pr__pfet_01v8_hvt ad=0 pd=0 as=0.26 ps=2.52 w=1 l=0.15
X4136 VGND sky130_fd_sc_hd__mux2_1_45/a_76_199# V3R216 VGND sky130_fd_pr__nfet_01v8 ad=0 pd=0 as=0.169 ps=1.82 w=0.65 l=0.15
X4137 VDPWR sky130_fd_sc_hd__mux2_1_34/a_505_21# sky130_fd_sc_hd__mux2_1_34/a_535_374# VDPWR sky130_fd_pr__pfet_01v8_hvt ad=0 pd=0 as=0.0882 ps=1.26 w=0.42 l=0.15
X4138 sky130_fd_sc_hd__mux2_1_34/a_505_21# V3R009 VDPWR VDPWR sky130_fd_pr__pfet_01v8_hvt ad=0.1176 pd=1.4 as=0 ps=0 w=0.42 l=0.15
X4139 sky130_fd_sc_hd__mux2_1_34/a_218_374# V3R009 VDPWR VDPWR sky130_fd_pr__pfet_01v8_hvt ad=0.1533 pd=1.57 as=0 ps=0 w=0.42 l=0.15
X4140 VGND sky130_fd_sc_hd__mux2_1_34/a_505_21# sky130_fd_sc_hd__mux2_1_34/a_439_47# VGND sky130_fd_pr__nfet_01v8 ad=0 pd=0 as=0.1386 ps=1.5 w=0.42 l=0.15
X4141 sky130_fd_sc_hd__mux2_1_34/a_76_199# V3R000 sky130_fd_sc_hd__mux2_1_34/a_218_374# VDPWR sky130_fd_pr__pfet_01v8_hvt ad=0.3864 pd=2.68 as=0 ps=0 w=0.42 l=0.15
X4142 sky130_fd_sc_hd__mux2_1_34/a_505_21# V3R009 VGND VGND sky130_fd_pr__nfet_01v8 ad=0.1092 pd=1.36 as=0 ps=0 w=0.42 l=0.15
X4143 sky130_fd_sc_hd__mux2_1_34/a_439_47# V3R000 sky130_fd_sc_hd__mux2_1_34/a_76_199# VGND sky130_fd_pr__nfet_01v8 ad=0 pd=0 as=0.1995 ps=1.79 w=0.42 l=0.15
X4144 sky130_fd_sc_hd__mux2_1_34/a_535_374# V3R025 sky130_fd_sc_hd__mux2_1_34/a_76_199# VDPWR sky130_fd_pr__pfet_01v8_hvt ad=0 pd=0 as=0 ps=0 w=0.42 l=0.15
X4145 sky130_fd_sc_hd__mux2_1_34/a_76_199# V3R025 sky130_fd_sc_hd__mux2_1_34/a_218_47# VGND sky130_fd_pr__nfet_01v8 ad=0 pd=0 as=0.1386 ps=1.5 w=0.42 l=0.15
X4146 sky130_fd_sc_hd__mux2_1_34/a_218_47# V3R009 VGND VGND sky130_fd_pr__nfet_01v8 ad=0 pd=0 as=0 ps=0 w=0.42 l=0.15
X4147 VDPWR sky130_fd_sc_hd__mux2_1_34/a_76_199# V3R220 VDPWR sky130_fd_pr__pfet_01v8_hvt ad=0 pd=0 as=0.26 ps=2.52 w=1 l=0.15
X4148 VGND sky130_fd_sc_hd__mux2_1_34/a_76_199# V3R220 VGND sky130_fd_pr__nfet_01v8 ad=0 pd=0 as=0.169 ps=1.82 w=0.65 l=0.15
X4149 VDPWR sky130_fd_sc_hd__mux2_1_23/a_505_21# sky130_fd_sc_hd__mux2_1_23/a_535_374# VDPWR sky130_fd_pr__pfet_01v8_hvt ad=0 pd=0 as=0.0882 ps=1.26 w=0.42 l=0.15
X4150 sky130_fd_sc_hd__mux2_1_23/a_505_21# V3R062 VDPWR VDPWR sky130_fd_pr__pfet_01v8_hvt ad=0.1176 pd=1.4 as=0 ps=0 w=0.42 l=0.15
X4151 sky130_fd_sc_hd__mux2_1_23/a_218_374# V3R062 VDPWR VDPWR sky130_fd_pr__pfet_01v8_hvt ad=0.1533 pd=1.57 as=0 ps=0 w=0.42 l=0.15
X4152 VGND sky130_fd_sc_hd__mux2_1_23/a_505_21# sky130_fd_sc_hd__mux2_1_23/a_439_47# VGND sky130_fd_pr__nfet_01v8 ad=0 pd=0 as=0.1386 ps=1.5 w=0.42 l=0.15
X4153 sky130_fd_sc_hd__mux2_1_23/a_76_199# V3R168 sky130_fd_sc_hd__mux2_1_23/a_218_374# VDPWR sky130_fd_pr__pfet_01v8_hvt ad=0.3864 pd=2.68 as=0 ps=0 w=0.42 l=0.15
X4154 sky130_fd_sc_hd__mux2_1_23/a_505_21# V3R062 VGND VGND sky130_fd_pr__nfet_01v8 ad=0.1092 pd=1.36 as=0 ps=0 w=0.42 l=0.15
X4155 sky130_fd_sc_hd__mux2_1_23/a_439_47# V3R168 sky130_fd_sc_hd__mux2_1_23/a_76_199# VGND sky130_fd_pr__nfet_01v8 ad=0 pd=0 as=0.1995 ps=1.79 w=0.42 l=0.15
X4156 sky130_fd_sc_hd__mux2_1_23/a_535_374# V3R167 sky130_fd_sc_hd__mux2_1_23/a_76_199# VDPWR sky130_fd_pr__pfet_01v8_hvt ad=0 pd=0 as=0 ps=0 w=0.42 l=0.15
X4157 sky130_fd_sc_hd__mux2_1_23/a_76_199# V3R167 sky130_fd_sc_hd__mux2_1_23/a_218_47# VGND sky130_fd_pr__nfet_01v8 ad=0 pd=0 as=0.1386 ps=1.5 w=0.42 l=0.15
X4158 sky130_fd_sc_hd__mux2_1_23/a_218_47# V3R062 VGND VGND sky130_fd_pr__nfet_01v8 ad=0 pd=0 as=0 ps=0 w=0.42 l=0.15
X4159 VDPWR sky130_fd_sc_hd__mux2_1_23/a_76_199# V3R111 VDPWR sky130_fd_pr__pfet_01v8_hvt ad=0 pd=0 as=0.26 ps=2.52 w=1 l=0.15
X4160 VGND sky130_fd_sc_hd__mux2_1_23/a_76_199# V3R111 VGND sky130_fd_pr__nfet_01v8 ad=0 pd=0 as=0.169 ps=1.82 w=0.65 l=0.15
X4161 VDPWR sky130_fd_sc_hd__mux2_1_89/a_505_21# sky130_fd_sc_hd__mux2_1_89/a_535_374# VDPWR sky130_fd_pr__pfet_01v8_hvt ad=0 pd=0 as=0.0882 ps=1.26 w=0.42 l=0.15
X4162 sky130_fd_sc_hd__mux2_1_89/a_505_21# V3R240 VDPWR VDPWR sky130_fd_pr__pfet_01v8_hvt ad=0.1176 pd=1.4 as=0 ps=0 w=0.42 l=0.15
X4163 sky130_fd_sc_hd__mux2_1_89/a_218_374# V3R240 VDPWR VDPWR sky130_fd_pr__pfet_01v8_hvt ad=0.1533 pd=1.57 as=0 ps=0 w=0.42 l=0.15
X4164 VGND sky130_fd_sc_hd__mux2_1_89/a_505_21# sky130_fd_sc_hd__mux2_1_89/a_439_47# VGND sky130_fd_pr__nfet_01v8 ad=0 pd=0 as=0.1386 ps=1.5 w=0.42 l=0.15
X4165 sky130_fd_sc_hd__mux2_1_89/a_76_199# V3R006 sky130_fd_sc_hd__mux2_1_89/a_218_374# VDPWR sky130_fd_pr__pfet_01v8_hvt ad=0.3864 pd=2.68 as=0 ps=0 w=0.42 l=0.15
X4166 sky130_fd_sc_hd__mux2_1_89/a_505_21# V3R240 VGND VGND sky130_fd_pr__nfet_01v8 ad=0.1092 pd=1.36 as=0 ps=0 w=0.42 l=0.15
X4167 sky130_fd_sc_hd__mux2_1_89/a_439_47# V3R006 sky130_fd_sc_hd__mux2_1_89/a_76_199# VGND sky130_fd_pr__nfet_01v8 ad=0 pd=0 as=0.1995 ps=1.79 w=0.42 l=0.15
X4168 sky130_fd_sc_hd__mux2_1_89/a_535_374# V3R266 sky130_fd_sc_hd__mux2_1_89/a_76_199# VDPWR sky130_fd_pr__pfet_01v8_hvt ad=0 pd=0 as=0 ps=0 w=0.42 l=0.15
X4169 sky130_fd_sc_hd__mux2_1_89/a_76_199# V3R266 sky130_fd_sc_hd__mux2_1_89/a_218_47# VGND sky130_fd_pr__nfet_01v8 ad=0 pd=0 as=0.1386 ps=1.5 w=0.42 l=0.15
X4170 sky130_fd_sc_hd__mux2_1_89/a_218_47# V3R240 VGND VGND sky130_fd_pr__nfet_01v8 ad=0 pd=0 as=0 ps=0 w=0.42 l=0.15
X4171 VDPWR sky130_fd_sc_hd__mux2_1_89/a_76_199# V3R190 VDPWR sky130_fd_pr__pfet_01v8_hvt ad=0 pd=0 as=0.26 ps=2.52 w=1 l=0.15
X4172 VGND sky130_fd_sc_hd__mux2_1_89/a_76_199# V3R190 VGND sky130_fd_pr__nfet_01v8 ad=0 pd=0 as=0.169 ps=1.82 w=0.65 l=0.15
X4173 VDPWR sky130_fd_sc_hd__mux2_1_78/a_505_21# sky130_fd_sc_hd__mux2_1_78/a_535_374# VDPWR sky130_fd_pr__pfet_01v8_hvt ad=0 pd=0 as=0.0882 ps=1.26 w=0.42 l=0.15
X4174 sky130_fd_sc_hd__mux2_1_78/a_505_21# V3R061 VDPWR VDPWR sky130_fd_pr__pfet_01v8_hvt ad=0.1176 pd=1.4 as=0 ps=0 w=0.42 l=0.15
X4175 sky130_fd_sc_hd__mux2_1_78/a_218_374# V3R061 VDPWR VDPWR sky130_fd_pr__pfet_01v8_hvt ad=0.1533 pd=1.57 as=0 ps=0 w=0.42 l=0.15
X4176 VGND sky130_fd_sc_hd__mux2_1_78/a_505_21# sky130_fd_sc_hd__mux2_1_78/a_439_47# VGND sky130_fd_pr__nfet_01v8 ad=0 pd=0 as=0.1386 ps=1.5 w=0.42 l=0.15
X4177 sky130_fd_sc_hd__mux2_1_78/a_76_199# V3R181 sky130_fd_sc_hd__mux2_1_78/a_218_374# VDPWR sky130_fd_pr__pfet_01v8_hvt ad=0.3864 pd=2.68 as=0 ps=0 w=0.42 l=0.15
X4178 sky130_fd_sc_hd__mux2_1_78/a_505_21# V3R061 VGND VGND sky130_fd_pr__nfet_01v8 ad=0.1092 pd=1.36 as=0 ps=0 w=0.42 l=0.15
X4179 sky130_fd_sc_hd__mux2_1_78/a_439_47# V3R181 sky130_fd_sc_hd__mux2_1_78/a_76_199# VGND sky130_fd_pr__nfet_01v8 ad=0 pd=0 as=0.1995 ps=1.79 w=0.42 l=0.15
X4180 sky130_fd_sc_hd__mux2_1_78/a_535_374# V3R180 sky130_fd_sc_hd__mux2_1_78/a_76_199# VDPWR sky130_fd_pr__pfet_01v8_hvt ad=0 pd=0 as=0 ps=0 w=0.42 l=0.15
X4181 sky130_fd_sc_hd__mux2_1_78/a_76_199# V3R180 sky130_fd_sc_hd__mux2_1_78/a_218_47# VGND sky130_fd_pr__nfet_01v8 ad=0 pd=0 as=0.1386 ps=1.5 w=0.42 l=0.15
X4182 sky130_fd_sc_hd__mux2_1_78/a_218_47# V3R061 VGND VGND sky130_fd_pr__nfet_01v8 ad=0 pd=0 as=0 ps=0 w=0.42 l=0.15
X4183 VDPWR sky130_fd_sc_hd__mux2_1_78/a_76_199# V3R094 VDPWR sky130_fd_pr__pfet_01v8_hvt ad=0 pd=0 as=0.26 ps=2.52 w=1 l=0.15
X4184 VGND sky130_fd_sc_hd__mux2_1_78/a_76_199# V3R094 VGND sky130_fd_pr__nfet_01v8 ad=0 pd=0 as=0.169 ps=1.82 w=0.65 l=0.15
X4185 VDPWR sky130_fd_sc_hd__buf_4_17/a_27_47# V3R300 VDPWR sky130_fd_pr__pfet_01v8_hvt ad=0 pd=0 as=0.54 ps=5.08 w=1 l=0.15
X4186 V3R300 sky130_fd_sc_hd__buf_4_17/a_27_47# VDPWR VDPWR sky130_fd_pr__pfet_01v8_hvt ad=0 pd=0 as=0 ps=0 w=1 l=0.15
X4187 VDPWR sky130_fd_sc_hd__buf_4_17/a_27_47# V3R300 VDPWR sky130_fd_pr__pfet_01v8_hvt ad=0 pd=0 as=0 ps=0 w=1 l=0.15
X4188 V3R300 sky130_fd_sc_hd__buf_4_17/a_27_47# VDPWR VDPWR sky130_fd_pr__pfet_01v8_hvt ad=0 pd=0 as=0 ps=0 w=1 l=0.15
X4189 V3R300 sky130_fd_sc_hd__buf_4_17/a_27_47# VGND VGND sky130_fd_pr__nfet_01v8 ad=0.351 pd=3.68 as=0 ps=0 w=0.65 l=0.15
X4190 V3R300 sky130_fd_sc_hd__buf_4_17/a_27_47# VGND VGND sky130_fd_pr__nfet_01v8 ad=0 pd=0 as=0 ps=0 w=0.65 l=0.15
X4191 VGND sky130_fd_sc_hd__buf_4_17/a_27_47# V3R300 VGND sky130_fd_pr__nfet_01v8 ad=0 pd=0 as=0 ps=0 w=0.65 l=0.15
X4192 VGND sky130_fd_sc_hd__buf_4_17/a_27_47# V3R300 VGND sky130_fd_pr__nfet_01v8 ad=0 pd=0 as=0 ps=0 w=0.65 l=0.15
X4193 VDPWR V3R297 sky130_fd_sc_hd__buf_4_17/a_27_47# VDPWR sky130_fd_pr__pfet_01v8_hvt ad=0 pd=0 as=0.26 ps=2.52 w=1 l=0.15
X4194 VGND V3R297 sky130_fd_sc_hd__buf_4_17/a_27_47# VGND sky130_fd_pr__nfet_01v8 ad=0 pd=0 as=0.169 ps=1.82 w=0.65 l=0.15
X4195 VGND V3R278 sky130_fd_sc_hd__or2_1_8/a_68_297# VGND sky130_fd_pr__nfet_01v8 ad=0 pd=0 as=0.1134 ps=1.38 w=0.42 l=0.15
X4196 sky130_fd_sc_hd__or2_1_8/a_68_297# V3R277 VGND VGND sky130_fd_pr__nfet_01v8 ad=0 pd=0 as=0 ps=0 w=0.42 l=0.15
X4197 V3R279 sky130_fd_sc_hd__or2_1_8/a_68_297# VGND VGND sky130_fd_pr__nfet_01v8 ad=0.169 pd=1.82 as=0 ps=0 w=0.65 l=0.15
X4198 VDPWR V3R278 sky130_fd_sc_hd__or2_1_8/a_150_297# VDPWR sky130_fd_pr__pfet_01v8_hvt ad=0 pd=0 as=0.0882 ps=1.26 w=0.42 l=0.15
X4199 V3R279 sky130_fd_sc_hd__or2_1_8/a_68_297# VDPWR VDPWR sky130_fd_pr__pfet_01v8_hvt ad=0.34 pd=2.68 as=0 ps=0 w=1 l=0.15
X4200 sky130_fd_sc_hd__or2_1_8/a_150_297# V3R277 sky130_fd_sc_hd__or2_1_8/a_68_297# VDPWR sky130_fd_pr__pfet_01v8_hvt ad=0 pd=0 as=0.1092 ps=1.36 w=0.42 l=0.15
X4201 VDPWR V3R000 sky130_fd_sc_hd__and2b_1_3/a_207_413# VDPWR sky130_fd_pr__pfet_01v8_hvt ad=0 pd=0 as=0.1218 ps=1.42 w=0.42 l=0.15
X4202 V3R247 sky130_fd_sc_hd__and2b_1_3/a_207_413# VDPWR VDPWR sky130_fd_pr__pfet_01v8_hvt ad=0.26 pd=2.52 as=0 ps=0 w=1 l=0.15
X4203 sky130_fd_sc_hd__and2b_1_3/a_297_47# sky130_fd_sc_hd__and2b_1_3/a_27_413# sky130_fd_sc_hd__and2b_1_3/a_207_413# VGND sky130_fd_pr__nfet_01v8 ad=0.1008 pd=1.32 as=0.1092 ps=1.36 w=0.42 l=0.15
X4204 V3R247 sky130_fd_sc_hd__and2b_1_3/a_207_413# VGND VGND sky130_fd_pr__nfet_01v8 ad=0.169 pd=1.82 as=0 ps=0 w=0.65 l=0.15
X4205 sky130_fd_sc_hd__and2b_1_3/a_207_413# sky130_fd_sc_hd__and2b_1_3/a_27_413# VDPWR VDPWR sky130_fd_pr__pfet_01v8_hvt ad=0 pd=0 as=0 ps=0 w=0.42 l=0.15
X4206 VDPWR V3R001 sky130_fd_sc_hd__and2b_1_3/a_27_413# VDPWR sky130_fd_pr__pfet_01v8_hvt ad=0 pd=0 as=0.1092 ps=1.36 w=0.42 l=0.15
X4207 VGND V3R000 sky130_fd_sc_hd__and2b_1_3/a_297_47# VGND sky130_fd_pr__nfet_01v8 ad=0 pd=0 as=0 ps=0 w=0.42 l=0.15
X4208 sky130_fd_sc_hd__and2b_1_3/a_27_413# V3R001 VGND VGND sky130_fd_pr__nfet_01v8 ad=0.1092 pd=1.36 as=0 ps=0 w=0.42 l=0.15
X4209 VDPWR sky130_fd_sc_hd__mux2_1_13/a_505_21# sky130_fd_sc_hd__mux2_1_13/a_535_374# VDPWR sky130_fd_pr__pfet_01v8_hvt ad=0 pd=0 as=0.0882 ps=1.26 w=0.42 l=0.15
X4210 sky130_fd_sc_hd__mux2_1_13/a_505_21# V3R009 VDPWR VDPWR sky130_fd_pr__pfet_01v8_hvt ad=0.1176 pd=1.4 as=0 ps=0 w=0.42 l=0.15
X4211 sky130_fd_sc_hd__mux2_1_13/a_218_374# V3R009 VDPWR VDPWR sky130_fd_pr__pfet_01v8_hvt ad=0.1533 pd=1.57 as=0 ps=0 w=0.42 l=0.15
X4212 VGND sky130_fd_sc_hd__mux2_1_13/a_505_21# sky130_fd_sc_hd__mux2_1_13/a_439_47# VGND sky130_fd_pr__nfet_01v8 ad=0 pd=0 as=0.1386 ps=1.5 w=0.42 l=0.15
X4213 sky130_fd_sc_hd__mux2_1_13/a_76_199# V3R251 sky130_fd_sc_hd__mux2_1_13/a_218_374# VDPWR sky130_fd_pr__pfet_01v8_hvt ad=0.3864 pd=2.68 as=0 ps=0 w=0.42 l=0.15
X4214 sky130_fd_sc_hd__mux2_1_13/a_505_21# V3R009 VGND VGND sky130_fd_pr__nfet_01v8 ad=0.1092 pd=1.36 as=0 ps=0 w=0.42 l=0.15
X4215 sky130_fd_sc_hd__mux2_1_13/a_439_47# V3R251 sky130_fd_sc_hd__mux2_1_13/a_76_199# VGND sky130_fd_pr__nfet_01v8 ad=0 pd=0 as=0.1995 ps=1.79 w=0.42 l=0.15
X4216 sky130_fd_sc_hd__mux2_1_13/a_535_374# V3R031 sky130_fd_sc_hd__mux2_1_13/a_76_199# VDPWR sky130_fd_pr__pfet_01v8_hvt ad=0 pd=0 as=0 ps=0 w=0.42 l=0.15
X4217 sky130_fd_sc_hd__mux2_1_13/a_76_199# V3R031 sky130_fd_sc_hd__mux2_1_13/a_218_47# VGND sky130_fd_pr__nfet_01v8 ad=0 pd=0 as=0.1386 ps=1.5 w=0.42 l=0.15
X4218 sky130_fd_sc_hd__mux2_1_13/a_218_47# V3R009 VGND VGND sky130_fd_pr__nfet_01v8 ad=0 pd=0 as=0 ps=0 w=0.42 l=0.15
X4219 VDPWR sky130_fd_sc_hd__mux2_1_13/a_76_199# V3R226 VDPWR sky130_fd_pr__pfet_01v8_hvt ad=0 pd=0 as=0.26 ps=2.52 w=1 l=0.15
X4220 VGND sky130_fd_sc_hd__mux2_1_13/a_76_199# V3R226 VGND sky130_fd_pr__nfet_01v8 ad=0 pd=0 as=0.169 ps=1.82 w=0.65 l=0.15
X4221 VDPWR sky130_fd_sc_hd__mux2_1_79/a_505_21# sky130_fd_sc_hd__mux2_1_79/a_535_374# VDPWR sky130_fd_pr__pfet_01v8_hvt ad=0 pd=0 as=0.0882 ps=1.26 w=0.42 l=0.15
X4222 sky130_fd_sc_hd__mux2_1_79/a_505_21# V3R044 VDPWR VDPWR sky130_fd_pr__pfet_01v8_hvt ad=0.1176 pd=1.4 as=0 ps=0 w=0.42 l=0.15
X4223 sky130_fd_sc_hd__mux2_1_79/a_218_374# V3R044 VDPWR VDPWR sky130_fd_pr__pfet_01v8_hvt ad=0.1533 pd=1.57 as=0 ps=0 w=0.42 l=0.15
X4224 VGND sky130_fd_sc_hd__mux2_1_79/a_505_21# sky130_fd_sc_hd__mux2_1_79/a_439_47# VGND sky130_fd_pr__nfet_01v8 ad=0 pd=0 as=0.1386 ps=1.5 w=0.42 l=0.15
X4225 sky130_fd_sc_hd__mux2_1_79/a_76_199# V3R041 sky130_fd_sc_hd__mux2_1_79/a_218_374# VDPWR sky130_fd_pr__pfet_01v8_hvt ad=0.3864 pd=2.68 as=0 ps=0 w=0.42 l=0.15
X4226 sky130_fd_sc_hd__mux2_1_79/a_505_21# V3R044 VGND VGND sky130_fd_pr__nfet_01v8 ad=0.1092 pd=1.36 as=0 ps=0 w=0.42 l=0.15
X4227 sky130_fd_sc_hd__mux2_1_79/a_439_47# V3R041 sky130_fd_sc_hd__mux2_1_79/a_76_199# VGND sky130_fd_pr__nfet_01v8 ad=0 pd=0 as=0.1995 ps=1.79 w=0.42 l=0.15
X4228 sky130_fd_sc_hd__mux2_1_79/a_535_374# V3R180 sky130_fd_sc_hd__mux2_1_79/a_76_199# VDPWR sky130_fd_pr__pfet_01v8_hvt ad=0 pd=0 as=0 ps=0 w=0.42 l=0.15
X4229 sky130_fd_sc_hd__mux2_1_79/a_76_199# V3R180 sky130_fd_sc_hd__mux2_1_79/a_218_47# VGND sky130_fd_pr__nfet_01v8 ad=0 pd=0 as=0.1386 ps=1.5 w=0.42 l=0.15
X4230 sky130_fd_sc_hd__mux2_1_79/a_218_47# V3R044 VGND VGND sky130_fd_pr__nfet_01v8 ad=0 pd=0 as=0 ps=0 w=0.42 l=0.15
X4231 VDPWR sky130_fd_sc_hd__mux2_1_79/a_76_199# V3R126 VDPWR sky130_fd_pr__pfet_01v8_hvt ad=0 pd=0 as=0.26 ps=2.52 w=1 l=0.15
X4232 VGND sky130_fd_sc_hd__mux2_1_79/a_76_199# V3R126 VGND sky130_fd_pr__nfet_01v8 ad=0 pd=0 as=0.169 ps=1.82 w=0.65 l=0.15
X4233 VDPWR sky130_fd_sc_hd__mux2_1_68/a_505_21# sky130_fd_sc_hd__mux2_1_68/a_535_374# VDPWR sky130_fd_pr__pfet_01v8_hvt ad=0 pd=0 as=0.0882 ps=1.26 w=0.42 l=0.15
X4234 sky130_fd_sc_hd__mux2_1_68/a_505_21# V3R008 VDPWR VDPWR sky130_fd_pr__pfet_01v8_hvt ad=0.1176 pd=1.4 as=0 ps=0 w=0.42 l=0.15
X4235 sky130_fd_sc_hd__mux2_1_68/a_218_374# V3R008 VDPWR VDPWR sky130_fd_pr__pfet_01v8_hvt ad=0.1533 pd=1.57 as=0 ps=0 w=0.42 l=0.15
X4236 VGND sky130_fd_sc_hd__mux2_1_68/a_505_21# sky130_fd_sc_hd__mux2_1_68/a_439_47# VGND sky130_fd_pr__nfet_01v8 ad=0 pd=0 as=0.1386 ps=1.5 w=0.42 l=0.15
X4237 sky130_fd_sc_hd__mux2_1_68/a_76_199# V3R001 sky130_fd_sc_hd__mux2_1_68/a_218_374# VDPWR sky130_fd_pr__pfet_01v8_hvt ad=0.3864 pd=2.68 as=0 ps=0 w=0.42 l=0.15
X4238 sky130_fd_sc_hd__mux2_1_68/a_505_21# V3R008 VGND VGND sky130_fd_pr__nfet_01v8 ad=0.1092 pd=1.36 as=0 ps=0 w=0.42 l=0.15
X4239 sky130_fd_sc_hd__mux2_1_68/a_439_47# V3R001 sky130_fd_sc_hd__mux2_1_68/a_76_199# VGND sky130_fd_pr__nfet_01v8 ad=0 pd=0 as=0.1995 ps=1.79 w=0.42 l=0.15
X4240 sky130_fd_sc_hd__mux2_1_68/a_535_374# V3R014 sky130_fd_sc_hd__mux2_1_68/a_76_199# VDPWR sky130_fd_pr__pfet_01v8_hvt ad=0 pd=0 as=0 ps=0 w=0.42 l=0.15
X4241 sky130_fd_sc_hd__mux2_1_68/a_76_199# V3R014 sky130_fd_sc_hd__mux2_1_68/a_218_47# VGND sky130_fd_pr__nfet_01v8 ad=0 pd=0 as=0.1386 ps=1.5 w=0.42 l=0.15
X4242 sky130_fd_sc_hd__mux2_1_68/a_218_47# V3R008 VGND VGND sky130_fd_pr__nfet_01v8 ad=0 pd=0 as=0 ps=0 w=0.42 l=0.15
X4243 VDPWR sky130_fd_sc_hd__mux2_1_68/a_76_199# V3R209 VDPWR sky130_fd_pr__pfet_01v8_hvt ad=0 pd=0 as=0.26 ps=2.52 w=1 l=0.15
X4244 VGND sky130_fd_sc_hd__mux2_1_68/a_76_199# V3R209 VGND sky130_fd_pr__nfet_01v8 ad=0 pd=0 as=0.169 ps=1.82 w=0.65 l=0.15
X4245 VDPWR sky130_fd_sc_hd__mux2_1_57/a_505_21# sky130_fd_sc_hd__mux2_1_57/a_535_374# VDPWR sky130_fd_pr__pfet_01v8_hvt ad=0 pd=0 as=0.0882 ps=1.26 w=0.42 l=0.15
X4246 sky130_fd_sc_hd__mux2_1_57/a_505_21# V3R044 VDPWR VDPWR sky130_fd_pr__pfet_01v8_hvt ad=0.1176 pd=1.4 as=0 ps=0 w=0.42 l=0.15
X4247 sky130_fd_sc_hd__mux2_1_57/a_218_374# V3R044 VDPWR VDPWR sky130_fd_pr__pfet_01v8_hvt ad=0.1533 pd=1.57 as=0 ps=0 w=0.42 l=0.15
X4248 VGND sky130_fd_sc_hd__mux2_1_57/a_505_21# sky130_fd_sc_hd__mux2_1_57/a_439_47# VGND sky130_fd_pr__nfet_01v8 ad=0 pd=0 as=0.1386 ps=1.5 w=0.42 l=0.15
X4249 sky130_fd_sc_hd__mux2_1_57/a_76_199# V3R016 sky130_fd_sc_hd__mux2_1_57/a_218_374# VDPWR sky130_fd_pr__pfet_01v8_hvt ad=0.3864 pd=2.68 as=0 ps=0 w=0.42 l=0.15
X4250 sky130_fd_sc_hd__mux2_1_57/a_505_21# V3R044 VGND VGND sky130_fd_pr__nfet_01v8 ad=0.1092 pd=1.36 as=0 ps=0 w=0.42 l=0.15
X4251 sky130_fd_sc_hd__mux2_1_57/a_439_47# V3R016 sky130_fd_sc_hd__mux2_1_57/a_76_199# VGND sky130_fd_pr__nfet_01v8 ad=0 pd=0 as=0.1995 ps=1.79 w=0.42 l=0.15
X4252 sky130_fd_sc_hd__mux2_1_57/a_535_374# V3R155 sky130_fd_sc_hd__mux2_1_57/a_76_199# VDPWR sky130_fd_pr__pfet_01v8_hvt ad=0 pd=0 as=0 ps=0 w=0.42 l=0.15
X4253 sky130_fd_sc_hd__mux2_1_57/a_76_199# V3R155 sky130_fd_sc_hd__mux2_1_57/a_218_47# VGND sky130_fd_pr__nfet_01v8 ad=0 pd=0 as=0.1386 ps=1.5 w=0.42 l=0.15
X4254 sky130_fd_sc_hd__mux2_1_57/a_218_47# V3R044 VGND VGND sky130_fd_pr__nfet_01v8 ad=0 pd=0 as=0 ps=0 w=0.42 l=0.15
X4255 VDPWR sky130_fd_sc_hd__mux2_1_57/a_76_199# V3R132 VDPWR sky130_fd_pr__pfet_01v8_hvt ad=0 pd=0 as=0.26 ps=2.52 w=1 l=0.15
X4256 VGND sky130_fd_sc_hd__mux2_1_57/a_76_199# V3R132 VGND sky130_fd_pr__nfet_01v8 ad=0 pd=0 as=0.169 ps=1.82 w=0.65 l=0.15
X4257 VDPWR sky130_fd_sc_hd__mux2_1_46/a_505_21# sky130_fd_sc_hd__mux2_1_46/a_535_374# VDPWR sky130_fd_pr__pfet_01v8_hvt ad=0 pd=0 as=0.0882 ps=1.26 w=0.42 l=0.15
X4258 sky130_fd_sc_hd__mux2_1_46/a_505_21# V3R009 VDPWR VDPWR sky130_fd_pr__pfet_01v8_hvt ad=0.1176 pd=1.4 as=0 ps=0 w=0.42 l=0.15
X4259 sky130_fd_sc_hd__mux2_1_46/a_218_374# V3R009 VDPWR VDPWR sky130_fd_pr__pfet_01v8_hvt ad=0.1533 pd=1.57 as=0 ps=0 w=0.42 l=0.15
X4260 VGND sky130_fd_sc_hd__mux2_1_46/a_505_21# sky130_fd_sc_hd__mux2_1_46/a_439_47# VGND sky130_fd_pr__nfet_01v8 ad=0 pd=0 as=0.1386 ps=1.5 w=0.42 l=0.15
X4261 sky130_fd_sc_hd__mux2_1_46/a_76_199# V3R000 sky130_fd_sc_hd__mux2_1_46/a_218_374# VDPWR sky130_fd_pr__pfet_01v8_hvt ad=0.3864 pd=2.68 as=0 ps=0 w=0.42 l=0.15
X4262 sky130_fd_sc_hd__mux2_1_46/a_505_21# V3R009 VGND VGND sky130_fd_pr__nfet_01v8 ad=0.1092 pd=1.36 as=0 ps=0 w=0.42 l=0.15
X4263 sky130_fd_sc_hd__mux2_1_46/a_439_47# V3R000 sky130_fd_sc_hd__mux2_1_46/a_76_199# VGND sky130_fd_pr__nfet_01v8 ad=0 pd=0 as=0.1995 ps=1.79 w=0.42 l=0.15
X4264 sky130_fd_sc_hd__mux2_1_46/a_535_374# V3R020 sky130_fd_sc_hd__mux2_1_46/a_76_199# VDPWR sky130_fd_pr__pfet_01v8_hvt ad=0 pd=0 as=0 ps=0 w=0.42 l=0.15
X4265 sky130_fd_sc_hd__mux2_1_46/a_76_199# V3R020 sky130_fd_sc_hd__mux2_1_46/a_218_47# VGND sky130_fd_pr__nfet_01v8 ad=0 pd=0 as=0.1386 ps=1.5 w=0.42 l=0.15
X4266 sky130_fd_sc_hd__mux2_1_46/a_218_47# V3R009 VGND VGND sky130_fd_pr__nfet_01v8 ad=0 pd=0 as=0 ps=0 w=0.42 l=0.15
X4267 VDPWR sky130_fd_sc_hd__mux2_1_46/a_76_199# V3R215 VDPWR sky130_fd_pr__pfet_01v8_hvt ad=0 pd=0 as=0.26 ps=2.52 w=1 l=0.15
X4268 VGND sky130_fd_sc_hd__mux2_1_46/a_76_199# V3R215 VGND sky130_fd_pr__nfet_01v8 ad=0 pd=0 as=0.169 ps=1.82 w=0.65 l=0.15
X4269 VDPWR sky130_fd_sc_hd__mux2_1_24/a_505_21# sky130_fd_sc_hd__mux2_1_24/a_535_374# VDPWR sky130_fd_pr__pfet_01v8_hvt ad=0 pd=0 as=0.0882 ps=1.26 w=0.42 l=0.15
X4270 sky130_fd_sc_hd__mux2_1_24/a_505_21# V3R045 VDPWR VDPWR sky130_fd_pr__pfet_01v8_hvt ad=0.1176 pd=1.4 as=0 ps=0 w=0.42 l=0.15
X4271 sky130_fd_sc_hd__mux2_1_24/a_218_374# V3R045 VDPWR VDPWR sky130_fd_pr__pfet_01v8_hvt ad=0.1533 pd=1.57 as=0 ps=0 w=0.42 l=0.15
X4272 VGND sky130_fd_sc_hd__mux2_1_24/a_505_21# sky130_fd_sc_hd__mux2_1_24/a_439_47# VGND sky130_fd_pr__nfet_01v8 ad=0 pd=0 as=0.1386 ps=1.5 w=0.42 l=0.15
X4273 sky130_fd_sc_hd__mux2_1_24/a_76_199# V3R028 sky130_fd_sc_hd__mux2_1_24/a_218_374# VDPWR sky130_fd_pr__pfet_01v8_hvt ad=0.3864 pd=2.68 as=0 ps=0 w=0.42 l=0.15
X4274 sky130_fd_sc_hd__mux2_1_24/a_505_21# V3R045 VGND VGND sky130_fd_pr__nfet_01v8 ad=0.1092 pd=1.36 as=0 ps=0 w=0.42 l=0.15
X4275 sky130_fd_sc_hd__mux2_1_24/a_439_47# V3R028 sky130_fd_sc_hd__mux2_1_24/a_76_199# VGND sky130_fd_pr__nfet_01v8 ad=0 pd=0 as=0.1995 ps=1.79 w=0.42 l=0.15
X4276 sky130_fd_sc_hd__mux2_1_24/a_535_374# V3R167 sky130_fd_sc_hd__mux2_1_24/a_76_199# VDPWR sky130_fd_pr__pfet_01v8_hvt ad=0 pd=0 as=0 ps=0 w=0.42 l=0.15
X4277 sky130_fd_sc_hd__mux2_1_24/a_76_199# V3R167 sky130_fd_sc_hd__mux2_1_24/a_218_47# VGND sky130_fd_pr__nfet_01v8 ad=0 pd=0 as=0.1386 ps=1.5 w=0.42 l=0.15
X4278 sky130_fd_sc_hd__mux2_1_24/a_218_47# V3R045 VGND VGND sky130_fd_pr__nfet_01v8 ad=0 pd=0 as=0 ps=0 w=0.42 l=0.15
X4279 VDPWR sky130_fd_sc_hd__mux2_1_24/a_76_199# V3R143 VDPWR sky130_fd_pr__pfet_01v8_hvt ad=0 pd=0 as=0.26 ps=2.52 w=1 l=0.15
X4280 VGND sky130_fd_sc_hd__mux2_1_24/a_76_199# V3R143 VGND sky130_fd_pr__nfet_01v8 ad=0 pd=0 as=0.169 ps=1.82 w=0.65 l=0.15
X4281 VDPWR sky130_fd_sc_hd__mux2_1_35/a_505_21# sky130_fd_sc_hd__mux2_1_35/a_535_374# VDPWR sky130_fd_pr__pfet_01v8_hvt ad=0 pd=0 as=0.0882 ps=1.26 w=0.42 l=0.15
X4282 sky130_fd_sc_hd__mux2_1_35/a_505_21# V3R062 VDPWR VDPWR sky130_fd_pr__pfet_01v8_hvt ad=0.1176 pd=1.4 as=0 ps=0 w=0.42 l=0.15
X4283 sky130_fd_sc_hd__mux2_1_35/a_218_374# V3R062 VDPWR VDPWR sky130_fd_pr__pfet_01v8_hvt ad=0.1533 pd=1.57 as=0 ps=0 w=0.42 l=0.15
X4284 VGND sky130_fd_sc_hd__mux2_1_35/a_505_21# sky130_fd_sc_hd__mux2_1_35/a_439_47# VGND sky130_fd_pr__nfet_01v8 ad=0 pd=0 as=0.1386 ps=1.5 w=0.42 l=0.15
X4285 sky130_fd_sc_hd__mux2_1_35/a_76_199# V3R163 sky130_fd_sc_hd__mux2_1_35/a_218_374# VDPWR sky130_fd_pr__pfet_01v8_hvt ad=0.3864 pd=2.68 as=0 ps=0 w=0.42 l=0.15
X4286 sky130_fd_sc_hd__mux2_1_35/a_505_21# V3R062 VGND VGND sky130_fd_pr__nfet_01v8 ad=0.1092 pd=1.36 as=0 ps=0 w=0.42 l=0.15
X4287 sky130_fd_sc_hd__mux2_1_35/a_439_47# V3R163 sky130_fd_sc_hd__mux2_1_35/a_76_199# VGND sky130_fd_pr__nfet_01v8 ad=0 pd=0 as=0.1995 ps=1.79 w=0.42 l=0.15
X4288 sky130_fd_sc_hd__mux2_1_35/a_535_374# V3R162 sky130_fd_sc_hd__mux2_1_35/a_76_199# VDPWR sky130_fd_pr__pfet_01v8_hvt ad=0 pd=0 as=0 ps=0 w=0.42 l=0.15
X4289 sky130_fd_sc_hd__mux2_1_35/a_76_199# V3R162 sky130_fd_sc_hd__mux2_1_35/a_218_47# VGND sky130_fd_pr__nfet_01v8 ad=0 pd=0 as=0.1386 ps=1.5 w=0.42 l=0.15
X4290 sky130_fd_sc_hd__mux2_1_35/a_218_47# V3R062 VGND VGND sky130_fd_pr__nfet_01v8 ad=0 pd=0 as=0 ps=0 w=0.42 l=0.15
X4291 VDPWR sky130_fd_sc_hd__mux2_1_35/a_76_199# V3R106 VDPWR sky130_fd_pr__pfet_01v8_hvt ad=0 pd=0 as=0.26 ps=2.52 w=1 l=0.15
X4292 VGND sky130_fd_sc_hd__mux2_1_35/a_76_199# V3R106 VGND sky130_fd_pr__nfet_01v8 ad=0 pd=0 as=0.169 ps=1.82 w=0.65 l=0.15
X4293 VDPWR sky130_fd_sc_hd__buf_4_18/a_27_47# V3R044 VDPWR sky130_fd_pr__pfet_01v8_hvt ad=0 pd=0 as=0.54 ps=5.08 w=1 l=0.15
X4294 V3R044 sky130_fd_sc_hd__buf_4_18/a_27_47# VDPWR VDPWR sky130_fd_pr__pfet_01v8_hvt ad=0 pd=0 as=0 ps=0 w=1 l=0.15
X4295 VDPWR sky130_fd_sc_hd__buf_4_18/a_27_47# V3R044 VDPWR sky130_fd_pr__pfet_01v8_hvt ad=0 pd=0 as=0 ps=0 w=1 l=0.15
X4296 V3R044 sky130_fd_sc_hd__buf_4_18/a_27_47# VDPWR VDPWR sky130_fd_pr__pfet_01v8_hvt ad=0 pd=0 as=0 ps=0 w=1 l=0.15
X4297 V3R044 sky130_fd_sc_hd__buf_4_18/a_27_47# VGND VGND sky130_fd_pr__nfet_01v8 ad=0.351 pd=3.68 as=0 ps=0 w=0.65 l=0.15
X4298 V3R044 sky130_fd_sc_hd__buf_4_18/a_27_47# VGND VGND sky130_fd_pr__nfet_01v8 ad=0 pd=0 as=0 ps=0 w=0.65 l=0.15
X4299 VGND sky130_fd_sc_hd__buf_4_18/a_27_47# V3R044 VGND sky130_fd_pr__nfet_01v8 ad=0 pd=0 as=0 ps=0 w=0.65 l=0.15
X4300 VGND sky130_fd_sc_hd__buf_4_18/a_27_47# V3R044 VGND sky130_fd_pr__nfet_01v8 ad=0 pd=0 as=0 ps=0 w=0.65 l=0.15
X4301 VDPWR V3R043 sky130_fd_sc_hd__buf_4_18/a_27_47# VDPWR sky130_fd_pr__pfet_01v8_hvt ad=0 pd=0 as=0.26 ps=2.52 w=1 l=0.15
X4302 VGND V3R043 sky130_fd_sc_hd__buf_4_18/a_27_47# VGND sky130_fd_pr__nfet_01v8 ad=0 pd=0 as=0.169 ps=1.82 w=0.65 l=0.15
X4303 VGND V3R245 sky130_fd_sc_hd__or2_1_9/a_68_297# VGND sky130_fd_pr__nfet_01v8 ad=0 pd=0 as=0.1134 ps=1.38 w=0.42 l=0.15
X4304 sky130_fd_sc_hd__or2_1_9/a_68_297# V3R244 VGND VGND sky130_fd_pr__nfet_01v8 ad=0 pd=0 as=0 ps=0 w=0.42 l=0.15
X4305 V3R246 sky130_fd_sc_hd__or2_1_9/a_68_297# VGND VGND sky130_fd_pr__nfet_01v8 ad=0.169 pd=1.82 as=0 ps=0 w=0.65 l=0.15
X4306 VDPWR V3R245 sky130_fd_sc_hd__or2_1_9/a_150_297# VDPWR sky130_fd_pr__pfet_01v8_hvt ad=0 pd=0 as=0.0882 ps=1.26 w=0.42 l=0.15
X4307 V3R246 sky130_fd_sc_hd__or2_1_9/a_68_297# VDPWR VDPWR sky130_fd_pr__pfet_01v8_hvt ad=0.34 pd=2.68 as=0 ps=0 w=1 l=0.15
X4308 sky130_fd_sc_hd__or2_1_9/a_150_297# V3R244 sky130_fd_sc_hd__or2_1_9/a_68_297# VDPWR sky130_fd_pr__pfet_01v8_hvt ad=0 pd=0 as=0.1092 ps=1.36 w=0.42 l=0.15
X4309 VDPWR V3R203 sky130_fd_sc_hd__and2b_1_4/a_207_413# VDPWR sky130_fd_pr__pfet_01v8_hvt ad=0 pd=0 as=0.1218 ps=1.42 w=0.42 l=0.15
X4310 V3R287 sky130_fd_sc_hd__and2b_1_4/a_207_413# VDPWR VDPWR sky130_fd_pr__pfet_01v8_hvt ad=0.26 pd=2.52 as=0 ps=0 w=1 l=0.15
X4311 sky130_fd_sc_hd__and2b_1_4/a_297_47# sky130_fd_sc_hd__and2b_1_4/a_27_413# sky130_fd_sc_hd__and2b_1_4/a_207_413# VGND sky130_fd_pr__nfet_01v8 ad=0.1008 pd=1.32 as=0.1092 ps=1.36 w=0.42 l=0.15
X4312 V3R287 sky130_fd_sc_hd__and2b_1_4/a_207_413# VGND VGND sky130_fd_pr__nfet_01v8 ad=0.169 pd=1.82 as=0 ps=0 w=0.65 l=0.15
X4313 sky130_fd_sc_hd__and2b_1_4/a_207_413# sky130_fd_sc_hd__and2b_1_4/a_27_413# VDPWR VDPWR sky130_fd_pr__pfet_01v8_hvt ad=0 pd=0 as=0 ps=0 w=0.42 l=0.15
X4314 VDPWR V3R286 sky130_fd_sc_hd__and2b_1_4/a_27_413# VDPWR sky130_fd_pr__pfet_01v8_hvt ad=0 pd=0 as=0.1092 ps=1.36 w=0.42 l=0.15
X4315 VGND V3R203 sky130_fd_sc_hd__and2b_1_4/a_297_47# VGND sky130_fd_pr__nfet_01v8 ad=0 pd=0 as=0 ps=0 w=0.42 l=0.15
X4316 sky130_fd_sc_hd__and2b_1_4/a_27_413# V3R286 VGND VGND sky130_fd_pr__nfet_01v8 ad=0.1092 pd=1.36 as=0 ps=0 w=0.42 l=0.15
X4317 VDPWR sky130_fd_sc_hd__mux2_1_14/a_505_21# sky130_fd_sc_hd__mux2_1_14/a_535_374# VDPWR sky130_fd_pr__pfet_01v8_hvt ad=0 pd=0 as=0.0882 ps=1.26 w=0.42 l=0.15
X4318 sky130_fd_sc_hd__mux2_1_14/a_505_21# V3R062 VDPWR VDPWR sky130_fd_pr__pfet_01v8_hvt ad=0.1176 pd=1.4 as=0 ps=0 w=0.42 l=0.15
X4319 sky130_fd_sc_hd__mux2_1_14/a_218_374# V3R062 VDPWR VDPWR sky130_fd_pr__pfet_01v8_hvt ad=0.1533 pd=1.57 as=0 ps=0 w=0.42 l=0.15
X4320 VGND sky130_fd_sc_hd__mux2_1_14/a_505_21# sky130_fd_sc_hd__mux2_1_14/a_439_47# VGND sky130_fd_pr__nfet_01v8 ad=0 pd=0 as=0.1386 ps=1.5 w=0.42 l=0.15
X4321 sky130_fd_sc_hd__mux2_1_14/a_76_199# V3R170 sky130_fd_sc_hd__mux2_1_14/a_218_374# VDPWR sky130_fd_pr__pfet_01v8_hvt ad=0.3864 pd=2.68 as=0 ps=0 w=0.42 l=0.15
X4322 sky130_fd_sc_hd__mux2_1_14/a_505_21# V3R062 VGND VGND sky130_fd_pr__nfet_01v8 ad=0.1092 pd=1.36 as=0 ps=0 w=0.42 l=0.15
X4323 sky130_fd_sc_hd__mux2_1_14/a_439_47# V3R170 sky130_fd_sc_hd__mux2_1_14/a_76_199# VGND sky130_fd_pr__nfet_01v8 ad=0 pd=0 as=0.1995 ps=1.79 w=0.42 l=0.15
X4324 sky130_fd_sc_hd__mux2_1_14/a_535_374# V3R169 sky130_fd_sc_hd__mux2_1_14/a_76_199# VDPWR sky130_fd_pr__pfet_01v8_hvt ad=0 pd=0 as=0 ps=0 w=0.42 l=0.15
X4325 sky130_fd_sc_hd__mux2_1_14/a_76_199# V3R169 sky130_fd_sc_hd__mux2_1_14/a_218_47# VGND sky130_fd_pr__nfet_01v8 ad=0 pd=0 as=0.1386 ps=1.5 w=0.42 l=0.15
X4326 sky130_fd_sc_hd__mux2_1_14/a_218_47# V3R062 VGND VGND sky130_fd_pr__nfet_01v8 ad=0 pd=0 as=0 ps=0 w=0.42 l=0.15
X4327 VDPWR sky130_fd_sc_hd__mux2_1_14/a_76_199# V3R113 VDPWR sky130_fd_pr__pfet_01v8_hvt ad=0 pd=0 as=0.26 ps=2.52 w=1 l=0.15
X4328 VGND sky130_fd_sc_hd__mux2_1_14/a_76_199# V3R113 VGND sky130_fd_pr__nfet_01v8 ad=0 pd=0 as=0.169 ps=1.82 w=0.65 l=0.15
X4329 VDPWR sky130_fd_sc_hd__mux2_1_69/a_505_21# sky130_fd_sc_hd__mux2_1_69/a_535_374# VDPWR sky130_fd_pr__pfet_01v8_hvt ad=0 pd=0 as=0.0882 ps=1.26 w=0.42 l=0.15
X4330 sky130_fd_sc_hd__mux2_1_69/a_505_21# V3R002 VDPWR VDPWR sky130_fd_pr__pfet_01v8_hvt ad=0.1176 pd=1.4 as=0 ps=0 w=0.42 l=0.15
X4331 sky130_fd_sc_hd__mux2_1_69/a_218_374# V3R002 VDPWR VDPWR sky130_fd_pr__pfet_01v8_hvt ad=0.1533 pd=1.57 as=0 ps=0 w=0.42 l=0.15
X4332 VGND sky130_fd_sc_hd__mux2_1_69/a_505_21# sky130_fd_sc_hd__mux2_1_69/a_439_47# VGND sky130_fd_pr__nfet_01v8 ad=0 pd=0 as=0.1386 ps=1.5 w=0.42 l=0.15
X4333 sky130_fd_sc_hd__mux2_1_69/a_76_199# V3R246 sky130_fd_sc_hd__mux2_1_69/a_218_374# VDPWR sky130_fd_pr__pfet_01v8_hvt ad=0.3864 pd=2.68 as=0 ps=0 w=0.42 l=0.15
X4334 sky130_fd_sc_hd__mux2_1_69/a_505_21# V3R002 VGND VGND sky130_fd_pr__nfet_01v8 ad=0.1092 pd=1.36 as=0 ps=0 w=0.42 l=0.15
X4335 sky130_fd_sc_hd__mux2_1_69/a_439_47# V3R246 sky130_fd_sc_hd__mux2_1_69/a_76_199# VGND sky130_fd_pr__nfet_01v8 ad=0 pd=0 as=0.1995 ps=1.79 w=0.42 l=0.15
X4336 sky130_fd_sc_hd__mux2_1_69/a_535_374# V3R249 sky130_fd_sc_hd__mux2_1_69/a_76_199# VDPWR sky130_fd_pr__pfet_01v8_hvt ad=0 pd=0 as=0 ps=0 w=0.42 l=0.15
X4337 sky130_fd_sc_hd__mux2_1_69/a_76_199# V3R249 sky130_fd_sc_hd__mux2_1_69/a_218_47# VGND sky130_fd_pr__nfet_01v8 ad=0 pd=0 as=0.1386 ps=1.5 w=0.42 l=0.15
X4338 sky130_fd_sc_hd__mux2_1_69/a_218_47# V3R002 VGND VGND sky130_fd_pr__nfet_01v8 ad=0 pd=0 as=0 ps=0 w=0.42 l=0.15
X4339 VDPWR sky130_fd_sc_hd__mux2_1_69/a_76_199# V3R250 VDPWR sky130_fd_pr__pfet_01v8_hvt ad=0 pd=0 as=0.26 ps=2.52 w=1 l=0.15
X4340 VGND sky130_fd_sc_hd__mux2_1_69/a_76_199# V3R250 VGND sky130_fd_pr__nfet_01v8 ad=0 pd=0 as=0.169 ps=1.82 w=0.65 l=0.15
X4341 VDPWR sky130_fd_sc_hd__mux2_1_58/a_505_21# sky130_fd_sc_hd__mux2_1_58/a_535_374# VDPWR sky130_fd_pr__pfet_01v8_hvt ad=0 pd=0 as=0.0882 ps=1.26 w=0.42 l=0.15
X4342 sky130_fd_sc_hd__mux2_1_58/a_505_21# V3R009 VDPWR VDPWR sky130_fd_pr__pfet_01v8_hvt ad=0.1176 pd=1.4 as=0 ps=0 w=0.42 l=0.15
X4343 sky130_fd_sc_hd__mux2_1_58/a_218_374# V3R009 VDPWR VDPWR sky130_fd_pr__pfet_01v8_hvt ad=0.1533 pd=1.57 as=0 ps=0 w=0.42 l=0.15
X4344 VGND sky130_fd_sc_hd__mux2_1_58/a_505_21# sky130_fd_sc_hd__mux2_1_58/a_439_47# VGND sky130_fd_pr__nfet_01v8 ad=0 pd=0 as=0.1386 ps=1.5 w=0.42 l=0.15
X4345 sky130_fd_sc_hd__mux2_1_58/a_76_199# V3R253 sky130_fd_sc_hd__mux2_1_58/a_218_374# VDPWR sky130_fd_pr__pfet_01v8_hvt ad=0.3864 pd=2.68 as=0 ps=0 w=0.42 l=0.15
X4346 sky130_fd_sc_hd__mux2_1_58/a_505_21# V3R009 VGND VGND sky130_fd_pr__nfet_01v8 ad=0.1092 pd=1.36 as=0 ps=0 w=0.42 l=0.15
X4347 sky130_fd_sc_hd__mux2_1_58/a_439_47# V3R253 sky130_fd_sc_hd__mux2_1_58/a_76_199# VGND sky130_fd_pr__nfet_01v8 ad=0 pd=0 as=0.1995 ps=1.79 w=0.42 l=0.15
X4348 sky130_fd_sc_hd__mux2_1_58/a_535_374# V3R017 sky130_fd_sc_hd__mux2_1_58/a_76_199# VDPWR sky130_fd_pr__pfet_01v8_hvt ad=0 pd=0 as=0 ps=0 w=0.42 l=0.15
X4349 sky130_fd_sc_hd__mux2_1_58/a_76_199# V3R017 sky130_fd_sc_hd__mux2_1_58/a_218_47# VGND sky130_fd_pr__nfet_01v8 ad=0 pd=0 as=0.1386 ps=1.5 w=0.42 l=0.15
X4350 sky130_fd_sc_hd__mux2_1_58/a_218_47# V3R009 VGND VGND sky130_fd_pr__nfet_01v8 ad=0 pd=0 as=0 ps=0 w=0.42 l=0.15
X4351 VDPWR sky130_fd_sc_hd__mux2_1_58/a_76_199# V3R212 VDPWR sky130_fd_pr__pfet_01v8_hvt ad=0 pd=0 as=0.26 ps=2.52 w=1 l=0.15
X4352 VGND sky130_fd_sc_hd__mux2_1_58/a_76_199# V3R212 VGND sky130_fd_pr__nfet_01v8 ad=0 pd=0 as=0.169 ps=1.82 w=0.65 l=0.15
X4353 VDPWR sky130_fd_sc_hd__mux2_1_36/a_505_21# sky130_fd_sc_hd__mux2_1_36/a_535_374# VDPWR sky130_fd_pr__pfet_01v8_hvt ad=0 pd=0 as=0.0882 ps=1.26 w=0.42 l=0.15
X4354 sky130_fd_sc_hd__mux2_1_36/a_505_21# V3R045 VDPWR VDPWR sky130_fd_pr__pfet_01v8_hvt ad=0.1176 pd=1.4 as=0 ps=0 w=0.42 l=0.15
X4355 sky130_fd_sc_hd__mux2_1_36/a_218_374# V3R045 VDPWR VDPWR sky130_fd_pr__pfet_01v8_hvt ad=0.1533 pd=1.57 as=0 ps=0 w=0.42 l=0.15
X4356 VGND sky130_fd_sc_hd__mux2_1_36/a_505_21# sky130_fd_sc_hd__mux2_1_36/a_439_47# VGND sky130_fd_pr__nfet_01v8 ad=0 pd=0 as=0.1386 ps=1.5 w=0.42 l=0.15
X4357 sky130_fd_sc_hd__mux2_1_36/a_76_199# V3R023 sky130_fd_sc_hd__mux2_1_36/a_218_374# VDPWR sky130_fd_pr__pfet_01v8_hvt ad=0.3864 pd=2.68 as=0 ps=0 w=0.42 l=0.15
X4358 sky130_fd_sc_hd__mux2_1_36/a_505_21# V3R045 VGND VGND sky130_fd_pr__nfet_01v8 ad=0.1092 pd=1.36 as=0 ps=0 w=0.42 l=0.15
X4359 sky130_fd_sc_hd__mux2_1_36/a_439_47# V3R023 sky130_fd_sc_hd__mux2_1_36/a_76_199# VGND sky130_fd_pr__nfet_01v8 ad=0 pd=0 as=0.1995 ps=1.79 w=0.42 l=0.15
X4360 sky130_fd_sc_hd__mux2_1_36/a_535_374# V3R162 sky130_fd_sc_hd__mux2_1_36/a_76_199# VDPWR sky130_fd_pr__pfet_01v8_hvt ad=0 pd=0 as=0 ps=0 w=0.42 l=0.15
X4361 sky130_fd_sc_hd__mux2_1_36/a_76_199# V3R162 sky130_fd_sc_hd__mux2_1_36/a_218_47# VGND sky130_fd_pr__nfet_01v8 ad=0 pd=0 as=0.1386 ps=1.5 w=0.42 l=0.15
X4362 sky130_fd_sc_hd__mux2_1_36/a_218_47# V3R045 VGND VGND sky130_fd_pr__nfet_01v8 ad=0 pd=0 as=0 ps=0 w=0.42 l=0.15
X4363 VDPWR sky130_fd_sc_hd__mux2_1_36/a_76_199# V3R138 VDPWR sky130_fd_pr__pfet_01v8_hvt ad=0 pd=0 as=0.26 ps=2.52 w=1 l=0.15
X4364 VGND sky130_fd_sc_hd__mux2_1_36/a_76_199# V3R138 VGND sky130_fd_pr__nfet_01v8 ad=0 pd=0 as=0.169 ps=1.82 w=0.65 l=0.15
X4365 VDPWR sky130_fd_sc_hd__mux2_1_25/a_505_21# sky130_fd_sc_hd__mux2_1_25/a_535_374# VDPWR sky130_fd_pr__pfet_01v8_hvt ad=0 pd=0 as=0.0882 ps=1.26 w=0.42 l=0.15
X4366 sky130_fd_sc_hd__mux2_1_25/a_505_21# V3R002 VDPWR VDPWR sky130_fd_pr__pfet_01v8_hvt ad=0.1176 pd=1.4 as=0 ps=0 w=0.42 l=0.15
X4367 sky130_fd_sc_hd__mux2_1_25/a_218_374# V3R002 VDPWR VDPWR sky130_fd_pr__pfet_01v8_hvt ad=0.1533 pd=1.57 as=0 ps=0 w=0.42 l=0.15
X4368 VGND sky130_fd_sc_hd__mux2_1_25/a_505_21# sky130_fd_sc_hd__mux2_1_25/a_439_47# VGND sky130_fd_pr__nfet_01v8 ad=0 pd=0 as=0.1386 ps=1.5 w=0.42 l=0.15
X4369 sky130_fd_sc_hd__mux2_1_25/a_76_199# V3R000 sky130_fd_sc_hd__mux2_1_25/a_218_374# VDPWR sky130_fd_pr__pfet_01v8_hvt ad=0.3864 pd=2.68 as=0 ps=0 w=0.42 l=0.15
X4370 sky130_fd_sc_hd__mux2_1_25/a_505_21# V3R002 VGND VGND sky130_fd_pr__nfet_01v8 ad=0.1092 pd=1.36 as=0 ps=0 w=0.42 l=0.15
X4371 sky130_fd_sc_hd__mux2_1_25/a_439_47# V3R000 sky130_fd_sc_hd__mux2_1_25/a_76_199# VGND sky130_fd_pr__nfet_01v8 ad=0 pd=0 as=0.1995 ps=1.79 w=0.42 l=0.15
X4372 sky130_fd_sc_hd__mux2_1_25/a_535_374# V3R259 sky130_fd_sc_hd__mux2_1_25/a_76_199# VDPWR sky130_fd_pr__pfet_01v8_hvt ad=0 pd=0 as=0 ps=0 w=0.42 l=0.15
X4373 sky130_fd_sc_hd__mux2_1_25/a_76_199# V3R259 sky130_fd_sc_hd__mux2_1_25/a_218_47# VGND sky130_fd_pr__nfet_01v8 ad=0 pd=0 as=0.1386 ps=1.5 w=0.42 l=0.15
X4374 sky130_fd_sc_hd__mux2_1_25/a_218_47# V3R002 VGND VGND sky130_fd_pr__nfet_01v8 ad=0 pd=0 as=0 ps=0 w=0.42 l=0.15
X4375 VDPWR sky130_fd_sc_hd__mux2_1_25/a_76_199# V3R260 VDPWR sky130_fd_pr__pfet_01v8_hvt ad=0 pd=0 as=0.26 ps=2.52 w=1 l=0.15
X4376 VGND sky130_fd_sc_hd__mux2_1_25/a_76_199# V3R260 VGND sky130_fd_pr__nfet_01v8 ad=0 pd=0 as=0.169 ps=1.82 w=0.65 l=0.15
X4377 VDPWR sky130_fd_sc_hd__mux2_1_47/a_505_21# sky130_fd_sc_hd__mux2_1_47/a_535_374# VDPWR sky130_fd_pr__pfet_01v8_hvt ad=0 pd=0 as=0.0882 ps=1.26 w=0.42 l=0.15
X4378 sky130_fd_sc_hd__mux2_1_47/a_505_21# V3R062 VDPWR VDPWR sky130_fd_pr__pfet_01v8_hvt ad=0.1176 pd=1.4 as=0 ps=0 w=0.42 l=0.15
X4379 sky130_fd_sc_hd__mux2_1_47/a_218_374# V3R062 VDPWR VDPWR sky130_fd_pr__pfet_01v8_hvt ad=0.1533 pd=1.57 as=0 ps=0 w=0.42 l=0.15
X4380 VGND sky130_fd_sc_hd__mux2_1_47/a_505_21# sky130_fd_sc_hd__mux2_1_47/a_439_47# VGND sky130_fd_pr__nfet_01v8 ad=0 pd=0 as=0.1386 ps=1.5 w=0.42 l=0.15
X4381 sky130_fd_sc_hd__mux2_1_47/a_76_199# V3R158 sky130_fd_sc_hd__mux2_1_47/a_218_374# VDPWR sky130_fd_pr__pfet_01v8_hvt ad=0.3864 pd=2.68 as=0 ps=0 w=0.42 l=0.15
X4382 sky130_fd_sc_hd__mux2_1_47/a_505_21# V3R062 VGND VGND sky130_fd_pr__nfet_01v8 ad=0.1092 pd=1.36 as=0 ps=0 w=0.42 l=0.15
X4383 sky130_fd_sc_hd__mux2_1_47/a_439_47# V3R158 sky130_fd_sc_hd__mux2_1_47/a_76_199# VGND sky130_fd_pr__nfet_01v8 ad=0 pd=0 as=0.1995 ps=1.79 w=0.42 l=0.15
X4384 sky130_fd_sc_hd__mux2_1_47/a_535_374# V3R157 sky130_fd_sc_hd__mux2_1_47/a_76_199# VDPWR sky130_fd_pr__pfet_01v8_hvt ad=0 pd=0 as=0 ps=0 w=0.42 l=0.15
X4385 sky130_fd_sc_hd__mux2_1_47/a_76_199# V3R157 sky130_fd_sc_hd__mux2_1_47/a_218_47# VGND sky130_fd_pr__nfet_01v8 ad=0 pd=0 as=0.1386 ps=1.5 w=0.42 l=0.15
X4386 sky130_fd_sc_hd__mux2_1_47/a_218_47# V3R062 VGND VGND sky130_fd_pr__nfet_01v8 ad=0 pd=0 as=0 ps=0 w=0.42 l=0.15
X4387 VDPWR sky130_fd_sc_hd__mux2_1_47/a_76_199# V3R102 VDPWR sky130_fd_pr__pfet_01v8_hvt ad=0 pd=0 as=0.26 ps=2.52 w=1 l=0.15
X4388 VGND sky130_fd_sc_hd__mux2_1_47/a_76_199# V3R102 VGND sky130_fd_pr__nfet_01v8 ad=0 pd=0 as=0.169 ps=1.82 w=0.65 l=0.15
X4389 VDPWR sky130_fd_sc_hd__buf_4_19/a_27_47# V3R010 VDPWR sky130_fd_pr__pfet_01v8_hvt ad=0 pd=0 as=0.54 ps=5.08 w=1 l=0.15
X4390 V3R010 sky130_fd_sc_hd__buf_4_19/a_27_47# VDPWR VDPWR sky130_fd_pr__pfet_01v8_hvt ad=0 pd=0 as=0 ps=0 w=1 l=0.15
X4391 VDPWR sky130_fd_sc_hd__buf_4_19/a_27_47# V3R010 VDPWR sky130_fd_pr__pfet_01v8_hvt ad=0 pd=0 as=0 ps=0 w=1 l=0.15
X4392 V3R010 sky130_fd_sc_hd__buf_4_19/a_27_47# VDPWR VDPWR sky130_fd_pr__pfet_01v8_hvt ad=0 pd=0 as=0 ps=0 w=1 l=0.15
X4393 V3R010 sky130_fd_sc_hd__buf_4_19/a_27_47# VGND VGND sky130_fd_pr__nfet_01v8 ad=0.351 pd=3.68 as=0 ps=0 w=0.65 l=0.15
X4394 V3R010 sky130_fd_sc_hd__buf_4_19/a_27_47# VGND VGND sky130_fd_pr__nfet_01v8 ad=0 pd=0 as=0 ps=0 w=0.65 l=0.15
X4395 VGND sky130_fd_sc_hd__buf_4_19/a_27_47# V3R010 VGND sky130_fd_pr__nfet_01v8 ad=0 pd=0 as=0 ps=0 w=0.65 l=0.15
X4396 VGND sky130_fd_sc_hd__buf_4_19/a_27_47# V3R010 VGND sky130_fd_pr__nfet_01v8 ad=0 pd=0 as=0 ps=0 w=0.65 l=0.15
X4397 VDPWR V3R007 sky130_fd_sc_hd__buf_4_19/a_27_47# VDPWR sky130_fd_pr__pfet_01v8_hvt ad=0 pd=0 as=0.26 ps=2.52 w=1 l=0.15
X4398 VGND V3R007 sky130_fd_sc_hd__buf_4_19/a_27_47# VGND sky130_fd_pr__nfet_01v8 ad=0 pd=0 as=0.169 ps=1.82 w=0.65 l=0.15
X4399 VDPWR V3R006 sky130_fd_sc_hd__and2b_1_5/a_207_413# VDPWR sky130_fd_pr__pfet_01v8_hvt ad=0 pd=0 as=0.1218 ps=1.42 w=0.42 l=0.15
X4400 V3R071 sky130_fd_sc_hd__and2b_1_5/a_207_413# VDPWR VDPWR sky130_fd_pr__pfet_01v8_hvt ad=0.26 pd=2.52 as=0 ps=0 w=1 l=0.15
X4401 sky130_fd_sc_hd__and2b_1_5/a_297_47# sky130_fd_sc_hd__and2b_1_5/a_27_413# sky130_fd_sc_hd__and2b_1_5/a_207_413# VGND sky130_fd_pr__nfet_01v8 ad=0.1008 pd=1.32 as=0.1092 ps=1.36 w=0.42 l=0.15
X4402 V3R071 sky130_fd_sc_hd__and2b_1_5/a_207_413# VGND VGND sky130_fd_pr__nfet_01v8 ad=0.169 pd=1.82 as=0 ps=0 w=0.65 l=0.15
X4403 sky130_fd_sc_hd__and2b_1_5/a_207_413# sky130_fd_sc_hd__and2b_1_5/a_27_413# VDPWR VDPWR sky130_fd_pr__pfet_01v8_hvt ad=0 pd=0 as=0 ps=0 w=0.42 l=0.15
X4404 VDPWR V3R238 sky130_fd_sc_hd__and2b_1_5/a_27_413# VDPWR sky130_fd_pr__pfet_01v8_hvt ad=0 pd=0 as=0.1092 ps=1.36 w=0.42 l=0.15
X4405 VGND V3R006 sky130_fd_sc_hd__and2b_1_5/a_297_47# VGND sky130_fd_pr__nfet_01v8 ad=0 pd=0 as=0 ps=0 w=0.42 l=0.15
X4406 sky130_fd_sc_hd__and2b_1_5/a_27_413# V3R238 VGND VGND sky130_fd_pr__nfet_01v8 ad=0.1092 pd=1.36 as=0 ps=0 w=0.42 l=0.15
X4407 VDPWR sky130_fd_sc_hd__mux2_1_26/a_505_21# sky130_fd_sc_hd__mux2_1_26/a_535_374# VDPWR sky130_fd_pr__pfet_01v8_hvt ad=0 pd=0 as=0.0882 ps=1.26 w=0.42 l=0.15
X4408 sky130_fd_sc_hd__mux2_1_26/a_505_21# V3R009 VDPWR VDPWR sky130_fd_pr__pfet_01v8_hvt ad=0.1176 pd=1.4 as=0 ps=0 w=0.42 l=0.15
X4409 sky130_fd_sc_hd__mux2_1_26/a_218_374# V3R009 VDPWR VDPWR sky130_fd_pr__pfet_01v8_hvt ad=0.1533 pd=1.57 as=0 ps=0 w=0.42 l=0.15
X4410 VGND sky130_fd_sc_hd__mux2_1_26/a_505_21# sky130_fd_sc_hd__mux2_1_26/a_439_47# VGND sky130_fd_pr__nfet_01v8 ad=0 pd=0 as=0.1386 ps=1.5 w=0.42 l=0.15
X4411 sky130_fd_sc_hd__mux2_1_26/a_76_199# V3R256 sky130_fd_sc_hd__mux2_1_26/a_218_374# VDPWR sky130_fd_pr__pfet_01v8_hvt ad=0.3864 pd=2.68 as=0 ps=0 w=0.42 l=0.15
X4412 sky130_fd_sc_hd__mux2_1_26/a_505_21# V3R009 VGND VGND sky130_fd_pr__nfet_01v8 ad=0.1092 pd=1.36 as=0 ps=0 w=0.42 l=0.15
X4413 sky130_fd_sc_hd__mux2_1_26/a_439_47# V3R256 sky130_fd_sc_hd__mux2_1_26/a_76_199# VGND sky130_fd_pr__nfet_01v8 ad=0 pd=0 as=0.1995 ps=1.79 w=0.42 l=0.15
X4414 sky130_fd_sc_hd__mux2_1_26/a_535_374# V3R028 sky130_fd_sc_hd__mux2_1_26/a_76_199# VDPWR sky130_fd_pr__pfet_01v8_hvt ad=0 pd=0 as=0 ps=0 w=0.42 l=0.15
X4415 sky130_fd_sc_hd__mux2_1_26/a_76_199# V3R028 sky130_fd_sc_hd__mux2_1_26/a_218_47# VGND sky130_fd_pr__nfet_01v8 ad=0 pd=0 as=0.1386 ps=1.5 w=0.42 l=0.15
X4416 sky130_fd_sc_hd__mux2_1_26/a_218_47# V3R009 VGND VGND sky130_fd_pr__nfet_01v8 ad=0 pd=0 as=0 ps=0 w=0.42 l=0.15
X4417 VDPWR sky130_fd_sc_hd__mux2_1_26/a_76_199# V3R223 VDPWR sky130_fd_pr__pfet_01v8_hvt ad=0 pd=0 as=0.26 ps=2.52 w=1 l=0.15
X4418 VGND sky130_fd_sc_hd__mux2_1_26/a_76_199# V3R223 VGND sky130_fd_pr__nfet_01v8 ad=0 pd=0 as=0.169 ps=1.82 w=0.65 l=0.15
X4419 VDPWR sky130_fd_sc_hd__mux2_1_15/a_505_21# sky130_fd_sc_hd__mux2_1_15/a_535_374# VDPWR sky130_fd_pr__pfet_01v8_hvt ad=0 pd=0 as=0.0882 ps=1.26 w=0.42 l=0.15
X4420 sky130_fd_sc_hd__mux2_1_15/a_505_21# V3R045 VDPWR VDPWR sky130_fd_pr__pfet_01v8_hvt ad=0.1176 pd=1.4 as=0 ps=0 w=0.42 l=0.15
X4421 sky130_fd_sc_hd__mux2_1_15/a_218_374# V3R045 VDPWR VDPWR sky130_fd_pr__pfet_01v8_hvt ad=0.1533 pd=1.57 as=0 ps=0 w=0.42 l=0.15
X4422 VGND sky130_fd_sc_hd__mux2_1_15/a_505_21# sky130_fd_sc_hd__mux2_1_15/a_439_47# VGND sky130_fd_pr__nfet_01v8 ad=0 pd=0 as=0.1386 ps=1.5 w=0.42 l=0.15
X4423 sky130_fd_sc_hd__mux2_1_15/a_76_199# V3R030 sky130_fd_sc_hd__mux2_1_15/a_218_374# VDPWR sky130_fd_pr__pfet_01v8_hvt ad=0.3864 pd=2.68 as=0 ps=0 w=0.42 l=0.15
X4424 sky130_fd_sc_hd__mux2_1_15/a_505_21# V3R045 VGND VGND sky130_fd_pr__nfet_01v8 ad=0.1092 pd=1.36 as=0 ps=0 w=0.42 l=0.15
X4425 sky130_fd_sc_hd__mux2_1_15/a_439_47# V3R030 sky130_fd_sc_hd__mux2_1_15/a_76_199# VGND sky130_fd_pr__nfet_01v8 ad=0 pd=0 as=0.1995 ps=1.79 w=0.42 l=0.15
X4426 sky130_fd_sc_hd__mux2_1_15/a_535_374# V3R169 sky130_fd_sc_hd__mux2_1_15/a_76_199# VDPWR sky130_fd_pr__pfet_01v8_hvt ad=0 pd=0 as=0 ps=0 w=0.42 l=0.15
X4427 sky130_fd_sc_hd__mux2_1_15/a_76_199# V3R169 sky130_fd_sc_hd__mux2_1_15/a_218_47# VGND sky130_fd_pr__nfet_01v8 ad=0 pd=0 as=0.1386 ps=1.5 w=0.42 l=0.15
X4428 sky130_fd_sc_hd__mux2_1_15/a_218_47# V3R045 VGND VGND sky130_fd_pr__nfet_01v8 ad=0 pd=0 as=0 ps=0 w=0.42 l=0.15
X4429 VDPWR sky130_fd_sc_hd__mux2_1_15/a_76_199# V3R145 VDPWR sky130_fd_pr__pfet_01v8_hvt ad=0 pd=0 as=0.26 ps=2.52 w=1 l=0.15
X4430 VGND sky130_fd_sc_hd__mux2_1_15/a_76_199# V3R145 VGND sky130_fd_pr__nfet_01v8 ad=0 pd=0 as=0.169 ps=1.82 w=0.65 l=0.15
X4431 VDPWR sky130_fd_sc_hd__mux2_1_59/a_505_21# sky130_fd_sc_hd__mux2_1_59/a_535_374# VDPWR sky130_fd_pr__pfet_01v8_hvt ad=0 pd=0 as=0.0882 ps=1.26 w=0.42 l=0.15
X4432 sky130_fd_sc_hd__mux2_1_59/a_505_21# V3R008 VDPWR VDPWR sky130_fd_pr__pfet_01v8_hvt ad=0.1176 pd=1.4 as=0 ps=0 w=0.42 l=0.15
X4433 sky130_fd_sc_hd__mux2_1_59/a_218_374# V3R008 VDPWR VDPWR sky130_fd_pr__pfet_01v8_hvt ad=0.1533 pd=1.57 as=0 ps=0 w=0.42 l=0.15
X4434 VGND sky130_fd_sc_hd__mux2_1_59/a_505_21# sky130_fd_sc_hd__mux2_1_59/a_439_47# VGND sky130_fd_pr__nfet_01v8 ad=0 pd=0 as=0.1386 ps=1.5 w=0.42 l=0.15
X4435 sky130_fd_sc_hd__mux2_1_59/a_76_199# V3R251 sky130_fd_sc_hd__mux2_1_59/a_218_374# VDPWR sky130_fd_pr__pfet_01v8_hvt ad=0.3864 pd=2.68 as=0 ps=0 w=0.42 l=0.15
X4436 sky130_fd_sc_hd__mux2_1_59/a_505_21# V3R008 VGND VGND sky130_fd_pr__nfet_01v8 ad=0.1092 pd=1.36 as=0 ps=0 w=0.42 l=0.15
X4437 sky130_fd_sc_hd__mux2_1_59/a_439_47# V3R251 sky130_fd_sc_hd__mux2_1_59/a_76_199# VGND sky130_fd_pr__nfet_01v8 ad=0 pd=0 as=0.1995 ps=1.79 w=0.42 l=0.15
X4438 sky130_fd_sc_hd__mux2_1_59/a_535_374# V3R016 sky130_fd_sc_hd__mux2_1_59/a_76_199# VDPWR sky130_fd_pr__pfet_01v8_hvt ad=0 pd=0 as=0 ps=0 w=0.42 l=0.15
X4439 sky130_fd_sc_hd__mux2_1_59/a_76_199# V3R016 sky130_fd_sc_hd__mux2_1_59/a_218_47# VGND sky130_fd_pr__nfet_01v8 ad=0 pd=0 as=0.1386 ps=1.5 w=0.42 l=0.15
X4440 sky130_fd_sc_hd__mux2_1_59/a_218_47# V3R008 VGND VGND sky130_fd_pr__nfet_01v8 ad=0 pd=0 as=0 ps=0 w=0.42 l=0.15
X4441 VDPWR sky130_fd_sc_hd__mux2_1_59/a_76_199# V3R211 VDPWR sky130_fd_pr__pfet_01v8_hvt ad=0 pd=0 as=0.26 ps=2.52 w=1 l=0.15
X4442 VGND sky130_fd_sc_hd__mux2_1_59/a_76_199# V3R211 VGND sky130_fd_pr__nfet_01v8 ad=0 pd=0 as=0.169 ps=1.82 w=0.65 l=0.15
X4443 VDPWR sky130_fd_sc_hd__mux2_1_48/a_505_21# sky130_fd_sc_hd__mux2_1_48/a_535_374# VDPWR sky130_fd_pr__pfet_01v8_hvt ad=0 pd=0 as=0.0882 ps=1.26 w=0.42 l=0.15
X4444 sky130_fd_sc_hd__mux2_1_48/a_505_21# V3R045 VDPWR VDPWR sky130_fd_pr__pfet_01v8_hvt ad=0.1176 pd=1.4 as=0 ps=0 w=0.42 l=0.15
X4445 sky130_fd_sc_hd__mux2_1_48/a_218_374# V3R045 VDPWR VDPWR sky130_fd_pr__pfet_01v8_hvt ad=0.1533 pd=1.57 as=0 ps=0 w=0.42 l=0.15
X4446 VGND sky130_fd_sc_hd__mux2_1_48/a_505_21# sky130_fd_sc_hd__mux2_1_48/a_439_47# VGND sky130_fd_pr__nfet_01v8 ad=0 pd=0 as=0.1386 ps=1.5 w=0.42 l=0.15
X4447 sky130_fd_sc_hd__mux2_1_48/a_76_199# V3R018 sky130_fd_sc_hd__mux2_1_48/a_218_374# VDPWR sky130_fd_pr__pfet_01v8_hvt ad=0.3864 pd=2.68 as=0 ps=0 w=0.42 l=0.15
X4448 sky130_fd_sc_hd__mux2_1_48/a_505_21# V3R045 VGND VGND sky130_fd_pr__nfet_01v8 ad=0.1092 pd=1.36 as=0 ps=0 w=0.42 l=0.15
X4449 sky130_fd_sc_hd__mux2_1_48/a_439_47# V3R018 sky130_fd_sc_hd__mux2_1_48/a_76_199# VGND sky130_fd_pr__nfet_01v8 ad=0 pd=0 as=0.1995 ps=1.79 w=0.42 l=0.15
X4450 sky130_fd_sc_hd__mux2_1_48/a_535_374# V3R157 sky130_fd_sc_hd__mux2_1_48/a_76_199# VDPWR sky130_fd_pr__pfet_01v8_hvt ad=0 pd=0 as=0 ps=0 w=0.42 l=0.15
X4451 sky130_fd_sc_hd__mux2_1_48/a_76_199# V3R157 sky130_fd_sc_hd__mux2_1_48/a_218_47# VGND sky130_fd_pr__nfet_01v8 ad=0 pd=0 as=0.1386 ps=1.5 w=0.42 l=0.15
X4452 sky130_fd_sc_hd__mux2_1_48/a_218_47# V3R045 VGND VGND sky130_fd_pr__nfet_01v8 ad=0 pd=0 as=0 ps=0 w=0.42 l=0.15
X4453 VDPWR sky130_fd_sc_hd__mux2_1_48/a_76_199# V3R134 VDPWR sky130_fd_pr__pfet_01v8_hvt ad=0 pd=0 as=0.26 ps=2.52 w=1 l=0.15
X4454 VGND sky130_fd_sc_hd__mux2_1_48/a_76_199# V3R134 VGND sky130_fd_pr__nfet_01v8 ad=0 pd=0 as=0.169 ps=1.82 w=0.65 l=0.15
X4455 VDPWR sky130_fd_sc_hd__mux2_1_37/a_505_21# sky130_fd_sc_hd__mux2_1_37/a_535_374# VDPWR sky130_fd_pr__pfet_01v8_hvt ad=0 pd=0 as=0.0882 ps=1.26 w=0.42 l=0.15
X4456 sky130_fd_sc_hd__mux2_1_37/a_505_21# V3R062 VDPWR VDPWR sky130_fd_pr__pfet_01v8_hvt ad=0.1176 pd=1.4 as=0 ps=0 w=0.42 l=0.15
X4457 sky130_fd_sc_hd__mux2_1_37/a_218_374# V3R062 VDPWR VDPWR sky130_fd_pr__pfet_01v8_hvt ad=0.1533 pd=1.57 as=0 ps=0 w=0.42 l=0.15
X4458 VGND sky130_fd_sc_hd__mux2_1_37/a_505_21# sky130_fd_sc_hd__mux2_1_37/a_439_47# VGND sky130_fd_pr__nfet_01v8 ad=0 pd=0 as=0.1386 ps=1.5 w=0.42 l=0.15
X4459 sky130_fd_sc_hd__mux2_1_37/a_76_199# V3R164 sky130_fd_sc_hd__mux2_1_37/a_218_374# VDPWR sky130_fd_pr__pfet_01v8_hvt ad=0.3864 pd=2.68 as=0 ps=0 w=0.42 l=0.15
X4460 sky130_fd_sc_hd__mux2_1_37/a_505_21# V3R062 VGND VGND sky130_fd_pr__nfet_01v8 ad=0.1092 pd=1.36 as=0 ps=0 w=0.42 l=0.15
X4461 sky130_fd_sc_hd__mux2_1_37/a_439_47# V3R164 sky130_fd_sc_hd__mux2_1_37/a_76_199# VGND sky130_fd_pr__nfet_01v8 ad=0 pd=0 as=0.1995 ps=1.79 w=0.42 l=0.15
X4462 sky130_fd_sc_hd__mux2_1_37/a_535_374# V3R163 sky130_fd_sc_hd__mux2_1_37/a_76_199# VDPWR sky130_fd_pr__pfet_01v8_hvt ad=0 pd=0 as=0 ps=0 w=0.42 l=0.15
X4463 sky130_fd_sc_hd__mux2_1_37/a_76_199# V3R163 sky130_fd_sc_hd__mux2_1_37/a_218_47# VGND sky130_fd_pr__nfet_01v8 ad=0 pd=0 as=0.1386 ps=1.5 w=0.42 l=0.15
X4464 sky130_fd_sc_hd__mux2_1_37/a_218_47# V3R062 VGND VGND sky130_fd_pr__nfet_01v8 ad=0 pd=0 as=0 ps=0 w=0.42 l=0.15
X4465 VDPWR sky130_fd_sc_hd__mux2_1_37/a_76_199# V3R107 VDPWR sky130_fd_pr__pfet_01v8_hvt ad=0 pd=0 as=0.26 ps=2.52 w=1 l=0.15
X4466 VGND sky130_fd_sc_hd__mux2_1_37/a_76_199# V3R107 VGND sky130_fd_pr__nfet_01v8 ad=0 pd=0 as=0.169 ps=1.82 w=0.65 l=0.15
X4467 VDPWR V3R001 sky130_fd_sc_hd__and2b_1_6/a_207_413# VDPWR sky130_fd_pr__pfet_01v8_hvt ad=0 pd=0 as=0.1218 ps=1.42 w=0.42 l=0.15
X4468 V3R248 sky130_fd_sc_hd__and2b_1_6/a_207_413# VDPWR VDPWR sky130_fd_pr__pfet_01v8_hvt ad=0.26 pd=2.52 as=0 ps=0 w=1 l=0.15
X4469 sky130_fd_sc_hd__and2b_1_6/a_297_47# sky130_fd_sc_hd__and2b_1_6/a_27_413# sky130_fd_sc_hd__and2b_1_6/a_207_413# VGND sky130_fd_pr__nfet_01v8 ad=0.1008 pd=1.32 as=0.1092 ps=1.36 w=0.42 l=0.15
X4470 V3R248 sky130_fd_sc_hd__and2b_1_6/a_207_413# VGND VGND sky130_fd_pr__nfet_01v8 ad=0.169 pd=1.82 as=0 ps=0 w=0.65 l=0.15
X4471 sky130_fd_sc_hd__and2b_1_6/a_207_413# sky130_fd_sc_hd__and2b_1_6/a_27_413# VDPWR VDPWR sky130_fd_pr__pfet_01v8_hvt ad=0 pd=0 as=0 ps=0 w=0.42 l=0.15
X4472 VDPWR V3R000 sky130_fd_sc_hd__and2b_1_6/a_27_413# VDPWR sky130_fd_pr__pfet_01v8_hvt ad=0 pd=0 as=0.1092 ps=1.36 w=0.42 l=0.15
X4473 VGND V3R001 sky130_fd_sc_hd__and2b_1_6/a_297_47# VGND sky130_fd_pr__nfet_01v8 ad=0 pd=0 as=0 ps=0 w=0.42 l=0.15
X4474 sky130_fd_sc_hd__and2b_1_6/a_27_413# V3R000 VGND VGND sky130_fd_pr__nfet_01v8 ad=0.1092 pd=1.36 as=0 ps=0 w=0.42 l=0.15
X4475 VDPWR sky130_fd_sc_hd__mux2_1_49/a_505_21# sky130_fd_sc_hd__mux2_1_49/a_535_374# VDPWR sky130_fd_pr__pfet_01v8_hvt ad=0 pd=0 as=0.0882 ps=1.26 w=0.42 l=0.15
X4476 sky130_fd_sc_hd__mux2_1_49/a_505_21# V3R062 VDPWR VDPWR sky130_fd_pr__pfet_01v8_hvt ad=0.1176 pd=1.4 as=0 ps=0 w=0.42 l=0.15
X4477 sky130_fd_sc_hd__mux2_1_49/a_218_374# V3R062 VDPWR VDPWR sky130_fd_pr__pfet_01v8_hvt ad=0.1533 pd=1.57 as=0 ps=0 w=0.42 l=0.15
X4478 VGND sky130_fd_sc_hd__mux2_1_49/a_505_21# sky130_fd_sc_hd__mux2_1_49/a_439_47# VGND sky130_fd_pr__nfet_01v8 ad=0 pd=0 as=0.1386 ps=1.5 w=0.42 l=0.15
X4479 sky130_fd_sc_hd__mux2_1_49/a_76_199# V3R159 sky130_fd_sc_hd__mux2_1_49/a_218_374# VDPWR sky130_fd_pr__pfet_01v8_hvt ad=0.3864 pd=2.68 as=0 ps=0 w=0.42 l=0.15
X4480 sky130_fd_sc_hd__mux2_1_49/a_505_21# V3R062 VGND VGND sky130_fd_pr__nfet_01v8 ad=0.1092 pd=1.36 as=0 ps=0 w=0.42 l=0.15
X4481 sky130_fd_sc_hd__mux2_1_49/a_439_47# V3R159 sky130_fd_sc_hd__mux2_1_49/a_76_199# VGND sky130_fd_pr__nfet_01v8 ad=0 pd=0 as=0.1995 ps=1.79 w=0.42 l=0.15
X4482 sky130_fd_sc_hd__mux2_1_49/a_535_374# V3R158 sky130_fd_sc_hd__mux2_1_49/a_76_199# VDPWR sky130_fd_pr__pfet_01v8_hvt ad=0 pd=0 as=0 ps=0 w=0.42 l=0.15
X4483 sky130_fd_sc_hd__mux2_1_49/a_76_199# V3R158 sky130_fd_sc_hd__mux2_1_49/a_218_47# VGND sky130_fd_pr__nfet_01v8 ad=0 pd=0 as=0.1386 ps=1.5 w=0.42 l=0.15
X4484 sky130_fd_sc_hd__mux2_1_49/a_218_47# V3R062 VGND VGND sky130_fd_pr__nfet_01v8 ad=0 pd=0 as=0 ps=0 w=0.42 l=0.15
X4485 VDPWR sky130_fd_sc_hd__mux2_1_49/a_76_199# V3R103 VDPWR sky130_fd_pr__pfet_01v8_hvt ad=0 pd=0 as=0.26 ps=2.52 w=1 l=0.15
X4486 VGND sky130_fd_sc_hd__mux2_1_49/a_76_199# V3R103 VGND sky130_fd_pr__nfet_01v8 ad=0 pd=0 as=0.169 ps=1.82 w=0.65 l=0.15
X4487 VDPWR sky130_fd_sc_hd__mux2_1_38/a_505_21# sky130_fd_sc_hd__mux2_1_38/a_535_374# VDPWR sky130_fd_pr__pfet_01v8_hvt ad=0 pd=0 as=0.0882 ps=1.26 w=0.42 l=0.15
X4488 sky130_fd_sc_hd__mux2_1_38/a_505_21# V3R045 VDPWR VDPWR sky130_fd_pr__pfet_01v8_hvt ad=0.1176 pd=1.4 as=0 ps=0 w=0.42 l=0.15
X4489 sky130_fd_sc_hd__mux2_1_38/a_218_374# V3R045 VDPWR VDPWR sky130_fd_pr__pfet_01v8_hvt ad=0.1533 pd=1.57 as=0 ps=0 w=0.42 l=0.15
X4490 VGND sky130_fd_sc_hd__mux2_1_38/a_505_21# sky130_fd_sc_hd__mux2_1_38/a_439_47# VGND sky130_fd_pr__nfet_01v8 ad=0 pd=0 as=0.1386 ps=1.5 w=0.42 l=0.15
X4491 sky130_fd_sc_hd__mux2_1_38/a_76_199# V3R024 sky130_fd_sc_hd__mux2_1_38/a_218_374# VDPWR sky130_fd_pr__pfet_01v8_hvt ad=0.3864 pd=2.68 as=0 ps=0 w=0.42 l=0.15
X4492 sky130_fd_sc_hd__mux2_1_38/a_505_21# V3R045 VGND VGND sky130_fd_pr__nfet_01v8 ad=0.1092 pd=1.36 as=0 ps=0 w=0.42 l=0.15
X4493 sky130_fd_sc_hd__mux2_1_38/a_439_47# V3R024 sky130_fd_sc_hd__mux2_1_38/a_76_199# VGND sky130_fd_pr__nfet_01v8 ad=0 pd=0 as=0.1995 ps=1.79 w=0.42 l=0.15
X4494 sky130_fd_sc_hd__mux2_1_38/a_535_374# V3R163 sky130_fd_sc_hd__mux2_1_38/a_76_199# VDPWR sky130_fd_pr__pfet_01v8_hvt ad=0 pd=0 as=0 ps=0 w=0.42 l=0.15
X4495 sky130_fd_sc_hd__mux2_1_38/a_76_199# V3R163 sky130_fd_sc_hd__mux2_1_38/a_218_47# VGND sky130_fd_pr__nfet_01v8 ad=0 pd=0 as=0.1386 ps=1.5 w=0.42 l=0.15
X4496 sky130_fd_sc_hd__mux2_1_38/a_218_47# V3R045 VGND VGND sky130_fd_pr__nfet_01v8 ad=0 pd=0 as=0 ps=0 w=0.42 l=0.15
X4497 VDPWR sky130_fd_sc_hd__mux2_1_38/a_76_199# V3R139 VDPWR sky130_fd_pr__pfet_01v8_hvt ad=0 pd=0 as=0.26 ps=2.52 w=1 l=0.15
X4498 VGND sky130_fd_sc_hd__mux2_1_38/a_76_199# V3R139 VGND sky130_fd_pr__nfet_01v8 ad=0 pd=0 as=0.169 ps=1.82 w=0.65 l=0.15
X4499 VDPWR sky130_fd_sc_hd__mux2_1_27/a_505_21# sky130_fd_sc_hd__mux2_1_27/a_535_374# VDPWR sky130_fd_pr__pfet_01v8_hvt ad=0 pd=0 as=0.0882 ps=1.26 w=0.42 l=0.15
X4500 sky130_fd_sc_hd__mux2_1_27/a_505_21# V3R009 VDPWR VDPWR sky130_fd_pr__pfet_01v8_hvt ad=0.1176 pd=1.4 as=0 ps=0 w=0.42 l=0.15
X4501 sky130_fd_sc_hd__mux2_1_27/a_218_374# V3R009 VDPWR VDPWR sky130_fd_pr__pfet_01v8_hvt ad=0.1533 pd=1.57 as=0 ps=0 w=0.42 l=0.15
X4502 VGND sky130_fd_sc_hd__mux2_1_27/a_505_21# sky130_fd_sc_hd__mux2_1_27/a_439_47# VGND sky130_fd_pr__nfet_01v8 ad=0 pd=0 as=0.1386 ps=1.5 w=0.42 l=0.15
X4503 sky130_fd_sc_hd__mux2_1_27/a_76_199# V3R251 sky130_fd_sc_hd__mux2_1_27/a_218_374# VDPWR sky130_fd_pr__pfet_01v8_hvt ad=0.3864 pd=2.68 as=0 ps=0 w=0.42 l=0.15
X4504 sky130_fd_sc_hd__mux2_1_27/a_505_21# V3R009 VGND VGND sky130_fd_pr__nfet_01v8 ad=0.1092 pd=1.36 as=0 ps=0 w=0.42 l=0.15
X4505 sky130_fd_sc_hd__mux2_1_27/a_439_47# V3R251 sky130_fd_sc_hd__mux2_1_27/a_76_199# VGND sky130_fd_pr__nfet_01v8 ad=0 pd=0 as=0.1995 ps=1.79 w=0.42 l=0.15
X4506 sky130_fd_sc_hd__mux2_1_27/a_535_374# V3R027 sky130_fd_sc_hd__mux2_1_27/a_76_199# VDPWR sky130_fd_pr__pfet_01v8_hvt ad=0 pd=0 as=0 ps=0 w=0.42 l=0.15
X4507 sky130_fd_sc_hd__mux2_1_27/a_76_199# V3R027 sky130_fd_sc_hd__mux2_1_27/a_218_47# VGND sky130_fd_pr__nfet_01v8 ad=0 pd=0 as=0.1386 ps=1.5 w=0.42 l=0.15
X4508 sky130_fd_sc_hd__mux2_1_27/a_218_47# V3R009 VGND VGND sky130_fd_pr__nfet_01v8 ad=0 pd=0 as=0 ps=0 w=0.42 l=0.15
X4509 VDPWR sky130_fd_sc_hd__mux2_1_27/a_76_199# V3R222 VDPWR sky130_fd_pr__pfet_01v8_hvt ad=0 pd=0 as=0.26 ps=2.52 w=1 l=0.15
X4510 VGND sky130_fd_sc_hd__mux2_1_27/a_76_199# V3R222 VGND sky130_fd_pr__nfet_01v8 ad=0 pd=0 as=0.169 ps=1.82 w=0.65 l=0.15
X4511 VDPWR sky130_fd_sc_hd__mux2_1_16/a_505_21# sky130_fd_sc_hd__mux2_1_16/a_535_374# VDPWR sky130_fd_pr__pfet_01v8_hvt ad=0 pd=0 as=0.0882 ps=1.26 w=0.42 l=0.15
X4512 sky130_fd_sc_hd__mux2_1_16/a_505_21# V3R062 VDPWR VDPWR sky130_fd_pr__pfet_01v8_hvt ad=0.1176 pd=1.4 as=0 ps=0 w=0.42 l=0.15
X4513 sky130_fd_sc_hd__mux2_1_16/a_218_374# V3R062 VDPWR VDPWR sky130_fd_pr__pfet_01v8_hvt ad=0.1533 pd=1.57 as=0 ps=0 w=0.42 l=0.15
X4514 VGND sky130_fd_sc_hd__mux2_1_16/a_505_21# sky130_fd_sc_hd__mux2_1_16/a_439_47# VGND sky130_fd_pr__nfet_01v8 ad=0 pd=0 as=0.1386 ps=1.5 w=0.42 l=0.15
X4515 sky130_fd_sc_hd__mux2_1_16/a_76_199# V3R169 sky130_fd_sc_hd__mux2_1_16/a_218_374# VDPWR sky130_fd_pr__pfet_01v8_hvt ad=0.3864 pd=2.68 as=0 ps=0 w=0.42 l=0.15
X4516 sky130_fd_sc_hd__mux2_1_16/a_505_21# V3R062 VGND VGND sky130_fd_pr__nfet_01v8 ad=0.1092 pd=1.36 as=0 ps=0 w=0.42 l=0.15
X4517 sky130_fd_sc_hd__mux2_1_16/a_439_47# V3R169 sky130_fd_sc_hd__mux2_1_16/a_76_199# VGND sky130_fd_pr__nfet_01v8 ad=0 pd=0 as=0.1995 ps=1.79 w=0.42 l=0.15
X4518 sky130_fd_sc_hd__mux2_1_16/a_535_374# V3R168 sky130_fd_sc_hd__mux2_1_16/a_76_199# VDPWR sky130_fd_pr__pfet_01v8_hvt ad=0 pd=0 as=0 ps=0 w=0.42 l=0.15
X4519 sky130_fd_sc_hd__mux2_1_16/a_76_199# V3R168 sky130_fd_sc_hd__mux2_1_16/a_218_47# VGND sky130_fd_pr__nfet_01v8 ad=0 pd=0 as=0.1386 ps=1.5 w=0.42 l=0.15
X4520 sky130_fd_sc_hd__mux2_1_16/a_218_47# V3R062 VGND VGND sky130_fd_pr__nfet_01v8 ad=0 pd=0 as=0 ps=0 w=0.42 l=0.15
X4521 VDPWR sky130_fd_sc_hd__mux2_1_16/a_76_199# V3R112 VDPWR sky130_fd_pr__pfet_01v8_hvt ad=0 pd=0 as=0.26 ps=2.52 w=1 l=0.15
X4522 VGND sky130_fd_sc_hd__mux2_1_16/a_76_199# V3R112 VGND sky130_fd_pr__nfet_01v8 ad=0 pd=0 as=0.169 ps=1.82 w=0.65 l=0.15
X4523 VDPWR V3R286 sky130_fd_sc_hd__and2b_1_7/a_207_413# VDPWR sky130_fd_pr__pfet_01v8_hvt ad=0 pd=0 as=0.1218 ps=1.42 w=0.42 l=0.15
X4524 V3R239 sky130_fd_sc_hd__and2b_1_7/a_207_413# VDPWR VDPWR sky130_fd_pr__pfet_01v8_hvt ad=0.26 pd=2.52 as=0 ps=0 w=1 l=0.15
X4525 sky130_fd_sc_hd__and2b_1_7/a_297_47# sky130_fd_sc_hd__and2b_1_7/a_27_413# sky130_fd_sc_hd__and2b_1_7/a_207_413# VGND sky130_fd_pr__nfet_01v8 ad=0.1008 pd=1.32 as=0.1092 ps=1.36 w=0.42 l=0.15
X4526 V3R239 sky130_fd_sc_hd__and2b_1_7/a_207_413# VGND VGND sky130_fd_pr__nfet_01v8 ad=0.169 pd=1.82 as=0 ps=0 w=0.65 l=0.15
X4527 sky130_fd_sc_hd__and2b_1_7/a_207_413# sky130_fd_sc_hd__and2b_1_7/a_27_413# VDPWR VDPWR sky130_fd_pr__pfet_01v8_hvt ad=0 pd=0 as=0 ps=0 w=0.42 l=0.15
X4528 VDPWR V3R238 sky130_fd_sc_hd__and2b_1_7/a_27_413# VDPWR sky130_fd_pr__pfet_01v8_hvt ad=0 pd=0 as=0.1092 ps=1.36 w=0.42 l=0.15
X4529 VGND V3R286 sky130_fd_sc_hd__and2b_1_7/a_297_47# VGND sky130_fd_pr__nfet_01v8 ad=0 pd=0 as=0 ps=0 w=0.42 l=0.15
X4530 sky130_fd_sc_hd__and2b_1_7/a_27_413# V3R238 VGND VGND sky130_fd_pr__nfet_01v8 ad=0.1092 pd=1.36 as=0 ps=0 w=0.42 l=0.15
X4531 VDPWR sky130_fd_sc_hd__mux2_1_39/a_505_21# sky130_fd_sc_hd__mux2_1_39/a_535_374# VDPWR sky130_fd_pr__pfet_01v8_hvt ad=0 pd=0 as=0.0882 ps=1.26 w=0.42 l=0.15
X4532 sky130_fd_sc_hd__mux2_1_39/a_505_21# V3R009 VDPWR VDPWR sky130_fd_pr__pfet_01v8_hvt ad=0.1176 pd=1.4 as=0 ps=0 w=0.42 l=0.15
X4533 sky130_fd_sc_hd__mux2_1_39/a_218_374# V3R009 VDPWR VDPWR sky130_fd_pr__pfet_01v8_hvt ad=0.1533 pd=1.57 as=0 ps=0 w=0.42 l=0.15
X4534 VGND sky130_fd_sc_hd__mux2_1_39/a_505_21# sky130_fd_sc_hd__mux2_1_39/a_439_47# VGND sky130_fd_pr__nfet_01v8 ad=0 pd=0 as=0.1386 ps=1.5 w=0.42 l=0.15
X4535 sky130_fd_sc_hd__mux2_1_39/a_76_199# V3R251 sky130_fd_sc_hd__mux2_1_39/a_218_374# VDPWR sky130_fd_pr__pfet_01v8_hvt ad=0.3864 pd=2.68 as=0 ps=0 w=0.42 l=0.15
X4536 sky130_fd_sc_hd__mux2_1_39/a_505_21# V3R009 VGND VGND sky130_fd_pr__nfet_01v8 ad=0.1092 pd=1.36 as=0 ps=0 w=0.42 l=0.15
X4537 sky130_fd_sc_hd__mux2_1_39/a_439_47# V3R251 sky130_fd_sc_hd__mux2_1_39/a_76_199# VGND sky130_fd_pr__nfet_01v8 ad=0 pd=0 as=0.1995 ps=1.79 w=0.42 l=0.15
X4538 sky130_fd_sc_hd__mux2_1_39/a_535_374# V3R024 sky130_fd_sc_hd__mux2_1_39/a_76_199# VDPWR sky130_fd_pr__pfet_01v8_hvt ad=0 pd=0 as=0 ps=0 w=0.42 l=0.15
X4539 sky130_fd_sc_hd__mux2_1_39/a_76_199# V3R024 sky130_fd_sc_hd__mux2_1_39/a_218_47# VGND sky130_fd_pr__nfet_01v8 ad=0 pd=0 as=0.1386 ps=1.5 w=0.42 l=0.15
X4540 sky130_fd_sc_hd__mux2_1_39/a_218_47# V3R009 VGND VGND sky130_fd_pr__nfet_01v8 ad=0 pd=0 as=0 ps=0 w=0.42 l=0.15
X4541 VDPWR sky130_fd_sc_hd__mux2_1_39/a_76_199# V3R219 VDPWR sky130_fd_pr__pfet_01v8_hvt ad=0 pd=0 as=0.26 ps=2.52 w=1 l=0.15
X4542 VGND sky130_fd_sc_hd__mux2_1_39/a_76_199# V3R219 VGND sky130_fd_pr__nfet_01v8 ad=0 pd=0 as=0.169 ps=1.82 w=0.65 l=0.15
X4543 VDPWR sky130_fd_sc_hd__mux2_1_17/a_505_21# sky130_fd_sc_hd__mux2_1_17/a_535_374# VDPWR sky130_fd_pr__pfet_01v8_hvt ad=0 pd=0 as=0.0882 ps=1.26 w=0.42 l=0.15
X4544 sky130_fd_sc_hd__mux2_1_17/a_505_21# V3R045 VDPWR VDPWR sky130_fd_pr__pfet_01v8_hvt ad=0.1176 pd=1.4 as=0 ps=0 w=0.42 l=0.15
X4545 sky130_fd_sc_hd__mux2_1_17/a_218_374# V3R045 VDPWR VDPWR sky130_fd_pr__pfet_01v8_hvt ad=0.1533 pd=1.57 as=0 ps=0 w=0.42 l=0.15
X4546 VGND sky130_fd_sc_hd__mux2_1_17/a_505_21# sky130_fd_sc_hd__mux2_1_17/a_439_47# VGND sky130_fd_pr__nfet_01v8 ad=0 pd=0 as=0.1386 ps=1.5 w=0.42 l=0.15
X4547 sky130_fd_sc_hd__mux2_1_17/a_76_199# V3R029 sky130_fd_sc_hd__mux2_1_17/a_218_374# VDPWR sky130_fd_pr__pfet_01v8_hvt ad=0.3864 pd=2.68 as=0 ps=0 w=0.42 l=0.15
X4548 sky130_fd_sc_hd__mux2_1_17/a_505_21# V3R045 VGND VGND sky130_fd_pr__nfet_01v8 ad=0.1092 pd=1.36 as=0 ps=0 w=0.42 l=0.15
X4549 sky130_fd_sc_hd__mux2_1_17/a_439_47# V3R029 sky130_fd_sc_hd__mux2_1_17/a_76_199# VGND sky130_fd_pr__nfet_01v8 ad=0 pd=0 as=0.1995 ps=1.79 w=0.42 l=0.15
X4550 sky130_fd_sc_hd__mux2_1_17/a_535_374# V3R168 sky130_fd_sc_hd__mux2_1_17/a_76_199# VDPWR sky130_fd_pr__pfet_01v8_hvt ad=0 pd=0 as=0 ps=0 w=0.42 l=0.15
X4551 sky130_fd_sc_hd__mux2_1_17/a_76_199# V3R168 sky130_fd_sc_hd__mux2_1_17/a_218_47# VGND sky130_fd_pr__nfet_01v8 ad=0 pd=0 as=0.1386 ps=1.5 w=0.42 l=0.15
X4552 sky130_fd_sc_hd__mux2_1_17/a_218_47# V3R045 VGND VGND sky130_fd_pr__nfet_01v8 ad=0 pd=0 as=0 ps=0 w=0.42 l=0.15
X4553 VDPWR sky130_fd_sc_hd__mux2_1_17/a_76_199# V3R144 VDPWR sky130_fd_pr__pfet_01v8_hvt ad=0 pd=0 as=0.26 ps=2.52 w=1 l=0.15
X4554 VGND sky130_fd_sc_hd__mux2_1_17/a_76_199# V3R144 VGND sky130_fd_pr__nfet_01v8 ad=0 pd=0 as=0.169 ps=1.82 w=0.65 l=0.15
X4555 VDPWR sky130_fd_sc_hd__mux2_1_28/a_505_21# sky130_fd_sc_hd__mux2_1_28/a_535_374# VDPWR sky130_fd_pr__pfet_01v8_hvt ad=0 pd=0 as=0.0882 ps=1.26 w=0.42 l=0.15
X4556 sky130_fd_sc_hd__mux2_1_28/a_505_21# V3R062 VDPWR VDPWR sky130_fd_pr__pfet_01v8_hvt ad=0.1176 pd=1.4 as=0 ps=0 w=0.42 l=0.15
X4557 sky130_fd_sc_hd__mux2_1_28/a_218_374# V3R062 VDPWR VDPWR sky130_fd_pr__pfet_01v8_hvt ad=0.1533 pd=1.57 as=0 ps=0 w=0.42 l=0.15
X4558 VGND sky130_fd_sc_hd__mux2_1_28/a_505_21# sky130_fd_sc_hd__mux2_1_28/a_439_47# VGND sky130_fd_pr__nfet_01v8 ad=0 pd=0 as=0.1386 ps=1.5 w=0.42 l=0.15
X4559 sky130_fd_sc_hd__mux2_1_28/a_76_199# V3R166 sky130_fd_sc_hd__mux2_1_28/a_218_374# VDPWR sky130_fd_pr__pfet_01v8_hvt ad=0.3864 pd=2.68 as=0 ps=0 w=0.42 l=0.15
X4560 sky130_fd_sc_hd__mux2_1_28/a_505_21# V3R062 VGND VGND sky130_fd_pr__nfet_01v8 ad=0.1092 pd=1.36 as=0 ps=0 w=0.42 l=0.15
X4561 sky130_fd_sc_hd__mux2_1_28/a_439_47# V3R166 sky130_fd_sc_hd__mux2_1_28/a_76_199# VGND sky130_fd_pr__nfet_01v8 ad=0 pd=0 as=0.1995 ps=1.79 w=0.42 l=0.15
X4562 sky130_fd_sc_hd__mux2_1_28/a_535_374# V3R165 sky130_fd_sc_hd__mux2_1_28/a_76_199# VDPWR sky130_fd_pr__pfet_01v8_hvt ad=0 pd=0 as=0 ps=0 w=0.42 l=0.15
X4563 sky130_fd_sc_hd__mux2_1_28/a_76_199# V3R165 sky130_fd_sc_hd__mux2_1_28/a_218_47# VGND sky130_fd_pr__nfet_01v8 ad=0 pd=0 as=0.1386 ps=1.5 w=0.42 l=0.15
X4564 sky130_fd_sc_hd__mux2_1_28/a_218_47# V3R062 VGND VGND sky130_fd_pr__nfet_01v8 ad=0 pd=0 as=0 ps=0 w=0.42 l=0.15
X4565 VDPWR sky130_fd_sc_hd__mux2_1_28/a_76_199# V3R109 VDPWR sky130_fd_pr__pfet_01v8_hvt ad=0 pd=0 as=0.26 ps=2.52 w=1 l=0.15
X4566 VGND sky130_fd_sc_hd__mux2_1_28/a_76_199# V3R109 VGND sky130_fd_pr__nfet_01v8 ad=0 pd=0 as=0.169 ps=1.82 w=0.65 l=0.15
X4567 VDPWR V3R005 sky130_fd_sc_hd__and2b_1_8/a_207_413# VDPWR sky130_fd_pr__pfet_01v8_hvt ad=0 pd=0 as=0.1218 ps=1.42 w=0.42 l=0.15
X4568 V3R070 sky130_fd_sc_hd__and2b_1_8/a_207_413# VDPWR VDPWR sky130_fd_pr__pfet_01v8_hvt ad=0.26 pd=2.52 as=0 ps=0 w=1 l=0.15
X4569 sky130_fd_sc_hd__and2b_1_8/a_297_47# sky130_fd_sc_hd__and2b_1_8/a_27_413# sky130_fd_sc_hd__and2b_1_8/a_207_413# VGND sky130_fd_pr__nfet_01v8 ad=0.1008 pd=1.32 as=0.1092 ps=1.36 w=0.42 l=0.15
X4570 V3R070 sky130_fd_sc_hd__and2b_1_8/a_207_413# VGND VGND sky130_fd_pr__nfet_01v8 ad=0.169 pd=1.82 as=0 ps=0 w=0.65 l=0.15
X4571 sky130_fd_sc_hd__and2b_1_8/a_207_413# sky130_fd_sc_hd__and2b_1_8/a_27_413# VDPWR VDPWR sky130_fd_pr__pfet_01v8_hvt ad=0 pd=0 as=0 ps=0 w=0.42 l=0.15
X4572 VDPWR V3R238 sky130_fd_sc_hd__and2b_1_8/a_27_413# VDPWR sky130_fd_pr__pfet_01v8_hvt ad=0 pd=0 as=0.1092 ps=1.36 w=0.42 l=0.15
X4573 VGND V3R005 sky130_fd_sc_hd__and2b_1_8/a_297_47# VGND sky130_fd_pr__nfet_01v8 ad=0 pd=0 as=0 ps=0 w=0.42 l=0.15
X4574 sky130_fd_sc_hd__and2b_1_8/a_27_413# V3R238 VGND VGND sky130_fd_pr__nfet_01v8 ad=0.1092 pd=1.36 as=0 ps=0 w=0.42 l=0.15
X4575 VDPWR sky130_fd_sc_hd__mux2_1_29/a_505_21# sky130_fd_sc_hd__mux2_1_29/a_535_374# VDPWR sky130_fd_pr__pfet_01v8_hvt ad=0 pd=0 as=0.0882 ps=1.26 w=0.42 l=0.15
X4576 sky130_fd_sc_hd__mux2_1_29/a_505_21# V3R045 VDPWR VDPWR sky130_fd_pr__pfet_01v8_hvt ad=0.1176 pd=1.4 as=0 ps=0 w=0.42 l=0.15
X4577 sky130_fd_sc_hd__mux2_1_29/a_218_374# V3R045 VDPWR VDPWR sky130_fd_pr__pfet_01v8_hvt ad=0.1533 pd=1.57 as=0 ps=0 w=0.42 l=0.15
X4578 VGND sky130_fd_sc_hd__mux2_1_29/a_505_21# sky130_fd_sc_hd__mux2_1_29/a_439_47# VGND sky130_fd_pr__nfet_01v8 ad=0 pd=0 as=0.1386 ps=1.5 w=0.42 l=0.15
X4579 sky130_fd_sc_hd__mux2_1_29/a_76_199# V3R026 sky130_fd_sc_hd__mux2_1_29/a_218_374# VDPWR sky130_fd_pr__pfet_01v8_hvt ad=0.3864 pd=2.68 as=0 ps=0 w=0.42 l=0.15
X4580 sky130_fd_sc_hd__mux2_1_29/a_505_21# V3R045 VGND VGND sky130_fd_pr__nfet_01v8 ad=0.1092 pd=1.36 as=0 ps=0 w=0.42 l=0.15
X4581 sky130_fd_sc_hd__mux2_1_29/a_439_47# V3R026 sky130_fd_sc_hd__mux2_1_29/a_76_199# VGND sky130_fd_pr__nfet_01v8 ad=0 pd=0 as=0.1995 ps=1.79 w=0.42 l=0.15
X4582 sky130_fd_sc_hd__mux2_1_29/a_535_374# V3R165 sky130_fd_sc_hd__mux2_1_29/a_76_199# VDPWR sky130_fd_pr__pfet_01v8_hvt ad=0 pd=0 as=0 ps=0 w=0.42 l=0.15
X4583 sky130_fd_sc_hd__mux2_1_29/a_76_199# V3R165 sky130_fd_sc_hd__mux2_1_29/a_218_47# VGND sky130_fd_pr__nfet_01v8 ad=0 pd=0 as=0.1386 ps=1.5 w=0.42 l=0.15
X4584 sky130_fd_sc_hd__mux2_1_29/a_218_47# V3R045 VGND VGND sky130_fd_pr__nfet_01v8 ad=0 pd=0 as=0 ps=0 w=0.42 l=0.15
X4585 VDPWR sky130_fd_sc_hd__mux2_1_29/a_76_199# V3R141 VDPWR sky130_fd_pr__pfet_01v8_hvt ad=0 pd=0 as=0.26 ps=2.52 w=1 l=0.15
X4586 VGND sky130_fd_sc_hd__mux2_1_29/a_76_199# V3R141 VGND sky130_fd_pr__nfet_01v8 ad=0 pd=0 as=0.169 ps=1.82 w=0.65 l=0.15
X4587 VDPWR sky130_fd_sc_hd__mux2_1_18/a_505_21# sky130_fd_sc_hd__mux2_1_18/a_535_374# VDPWR sky130_fd_pr__pfet_01v8_hvt ad=0 pd=0 as=0.0882 ps=1.26 w=0.42 l=0.15
X4588 sky130_fd_sc_hd__mux2_1_18/a_505_21# V3R288 VDPWR VDPWR sky130_fd_pr__pfet_01v8_hvt ad=0.1176 pd=1.4 as=0 ps=0 w=0.42 l=0.15
X4589 sky130_fd_sc_hd__mux2_1_18/a_218_374# V3R288 VDPWR VDPWR sky130_fd_pr__pfet_01v8_hvt ad=0.1533 pd=1.57 as=0 ps=0 w=0.42 l=0.15
X4590 VGND sky130_fd_sc_hd__mux2_1_18/a_505_21# sky130_fd_sc_hd__mux2_1_18/a_439_47# VGND sky130_fd_pr__nfet_01v8 ad=0 pd=0 as=0.1386 ps=1.5 w=0.42 l=0.15
X4591 sky130_fd_sc_hd__mux2_1_18/a_76_199# V3R000 sky130_fd_sc_hd__mux2_1_18/a_218_374# VDPWR sky130_fd_pr__pfet_01v8_hvt ad=0.3864 pd=2.68 as=0 ps=0 w=0.42 l=0.15
X4592 sky130_fd_sc_hd__mux2_1_18/a_505_21# V3R288 VGND VGND sky130_fd_pr__nfet_01v8 ad=0.1092 pd=1.36 as=0 ps=0 w=0.42 l=0.15
X4593 sky130_fd_sc_hd__mux2_1_18/a_439_47# V3R000 sky130_fd_sc_hd__mux2_1_18/a_76_199# VGND sky130_fd_pr__nfet_01v8 ad=0 pd=0 as=0.1995 ps=1.79 w=0.42 l=0.15
X4594 sky130_fd_sc_hd__mux2_1_18/a_535_374# V3R050 sky130_fd_sc_hd__mux2_1_18/a_76_199# VDPWR sky130_fd_pr__pfet_01v8_hvt ad=0 pd=0 as=0 ps=0 w=0.42 l=0.15
X4595 sky130_fd_sc_hd__mux2_1_18/a_76_199# V3R050 sky130_fd_sc_hd__mux2_1_18/a_218_47# VGND sky130_fd_pr__nfet_01v8 ad=0 pd=0 as=0.1386 ps=1.5 w=0.42 l=0.15
X4596 sky130_fd_sc_hd__mux2_1_18/a_218_47# V3R288 VGND VGND sky130_fd_pr__nfet_01v8 ad=0 pd=0 as=0 ps=0 w=0.42 l=0.15
X4597 VDPWR sky130_fd_sc_hd__mux2_1_18/a_76_199# V3R183 VDPWR sky130_fd_pr__pfet_01v8_hvt ad=0 pd=0 as=0.26 ps=2.52 w=1 l=0.15
X4598 VGND sky130_fd_sc_hd__mux2_1_18/a_76_199# V3R183 VGND sky130_fd_pr__nfet_01v8 ad=0 pd=0 as=0.169 ps=1.82 w=0.65 l=0.15
X4599 VDPWR V3R284 sky130_fd_sc_hd__and2b_1_9/a_207_413# VDPWR sky130_fd_pr__pfet_01v8_hvt ad=0 pd=0 as=0.1218 ps=1.42 w=0.42 l=0.15
X4600 V3R285 sky130_fd_sc_hd__and2b_1_9/a_207_413# VDPWR VDPWR sky130_fd_pr__pfet_01v8_hvt ad=0.26 pd=2.52 as=0 ps=0 w=1 l=0.15
X4601 sky130_fd_sc_hd__and2b_1_9/a_297_47# sky130_fd_sc_hd__and2b_1_9/a_27_413# sky130_fd_sc_hd__and2b_1_9/a_207_413# VGND sky130_fd_pr__nfet_01v8 ad=0.1008 pd=1.32 as=0.1092 ps=1.36 w=0.42 l=0.15
X4602 V3R285 sky130_fd_sc_hd__and2b_1_9/a_207_413# VGND VGND sky130_fd_pr__nfet_01v8 ad=0.169 pd=1.82 as=0 ps=0 w=0.65 l=0.15
X4603 sky130_fd_sc_hd__and2b_1_9/a_207_413# sky130_fd_sc_hd__and2b_1_9/a_27_413# VDPWR VDPWR sky130_fd_pr__pfet_01v8_hvt ad=0 pd=0 as=0 ps=0 w=0.42 l=0.15
X4604 VDPWR V3R064 sky130_fd_sc_hd__and2b_1_9/a_27_413# VDPWR sky130_fd_pr__pfet_01v8_hvt ad=0 pd=0 as=0.1092 ps=1.36 w=0.42 l=0.15
X4605 VGND V3R284 sky130_fd_sc_hd__and2b_1_9/a_297_47# VGND sky130_fd_pr__nfet_01v8 ad=0 pd=0 as=0 ps=0 w=0.42 l=0.15
X4606 sky130_fd_sc_hd__and2b_1_9/a_27_413# V3R064 VGND VGND sky130_fd_pr__nfet_01v8 ad=0.1092 pd=1.36 as=0 ps=0 w=0.42 l=0.15
X4607 VDPWR sky130_fd_sc_hd__mux2_1_19/a_505_21# sky130_fd_sc_hd__mux2_1_19/a_535_374# VDPWR sky130_fd_pr__pfet_01v8_hvt ad=0 pd=0 as=0.0882 ps=1.26 w=0.42 l=0.15
X4608 sky130_fd_sc_hd__mux2_1_19/a_505_21# V3R009 VDPWR VDPWR sky130_fd_pr__pfet_01v8_hvt ad=0.1176 pd=1.4 as=0 ps=0 w=0.42 l=0.15
X4609 sky130_fd_sc_hd__mux2_1_19/a_218_374# V3R009 VDPWR VDPWR sky130_fd_pr__pfet_01v8_hvt ad=0.1533 pd=1.57 as=0 ps=0 w=0.42 l=0.15
X4610 VGND sky130_fd_sc_hd__mux2_1_19/a_505_21# sky130_fd_sc_hd__mux2_1_19/a_439_47# VGND sky130_fd_pr__nfet_01v8 ad=0 pd=0 as=0.1386 ps=1.5 w=0.42 l=0.15
X4611 sky130_fd_sc_hd__mux2_1_19/a_76_199# V3R258 sky130_fd_sc_hd__mux2_1_19/a_218_374# VDPWR sky130_fd_pr__pfet_01v8_hvt ad=0.3864 pd=2.68 as=0 ps=0 w=0.42 l=0.15
X4612 sky130_fd_sc_hd__mux2_1_19/a_505_21# V3R009 VGND VGND sky130_fd_pr__nfet_01v8 ad=0.1092 pd=1.36 as=0 ps=0 w=0.42 l=0.15
X4613 sky130_fd_sc_hd__mux2_1_19/a_439_47# V3R258 sky130_fd_sc_hd__mux2_1_19/a_76_199# VGND sky130_fd_pr__nfet_01v8 ad=0 pd=0 as=0.1995 ps=1.79 w=0.42 l=0.15
X4614 sky130_fd_sc_hd__mux2_1_19/a_535_374# V3R030 sky130_fd_sc_hd__mux2_1_19/a_76_199# VDPWR sky130_fd_pr__pfet_01v8_hvt ad=0 pd=0 as=0 ps=0 w=0.42 l=0.15
X4615 sky130_fd_sc_hd__mux2_1_19/a_76_199# V3R030 sky130_fd_sc_hd__mux2_1_19/a_218_47# VGND sky130_fd_pr__nfet_01v8 ad=0 pd=0 as=0.1386 ps=1.5 w=0.42 l=0.15
X4616 sky130_fd_sc_hd__mux2_1_19/a_218_47# V3R009 VGND VGND sky130_fd_pr__nfet_01v8 ad=0 pd=0 as=0 ps=0 w=0.42 l=0.15
X4617 VDPWR sky130_fd_sc_hd__mux2_1_19/a_76_199# V3R225 VDPWR sky130_fd_pr__pfet_01v8_hvt ad=0 pd=0 as=0.26 ps=2.52 w=1 l=0.15
X4618 VGND sky130_fd_sc_hd__mux2_1_19/a_76_199# V3R225 VGND sky130_fd_pr__nfet_01v8 ad=0 pd=0 as=0.169 ps=1.82 w=0.65 l=0.15
X4619 VDPWR V3R001 V3R257 VDPWR sky130_fd_pr__pfet_01v8_hvt ad=0.26 pd=2.52 as=0.135 ps=1.27 w=1 l=0.15
X4620 V3R257 V3R001 sky130_fd_sc_hd__nand2_1_0/a_113_47# VGND sky130_fd_pr__nfet_01v8 ad=0.169 pd=1.82 as=0.08775 ps=0.92 w=0.65 l=0.15
X4621 sky130_fd_sc_hd__nand2_1_0/a_113_47# V3R000 VGND VGND sky130_fd_pr__nfet_01v8 ad=0.08775 pd=0.92 as=0.169 ps=1.82 w=0.65 l=0.15
X4622 V3R257 V3R000 VDPWR VDPWR sky130_fd_pr__pfet_01v8_hvt ad=0.135 pd=1.27 as=0.26 ps=2.52 w=1 l=0.15
X4623 sky130_fd_sc_hd__dfrtp_1_80/a_805_47# sky130_fd_sc_hd__dfrtp_1_80/a_761_289# sky130_fd_sc_hd__dfrtp_1_80/a_639_47# VGND sky130_fd_pr__nfet_01v8 ad=0.0882 pd=1.26 as=0.2802 ps=2.2 w=0.42 l=0.15
X4624 sky130_fd_sc_hd__dfrtp_1_80/a_1217_47# sky130_fd_sc_hd__dfrtp_1_80/a_27_47# sky130_fd_sc_hd__dfrtp_1_80/a_1108_47# VGND sky130_fd_pr__special_nfet_01v8 ad=0.1338 pd=1.5 as=0.1422 ps=1.51 w=0.36 l=0.15
X4625 sky130_fd_sc_hd__dfrtp_1_80/a_1283_21# sky130_fd_sc_hd__dfrtp_1_80/a_1108_47# sky130_fd_sc_hd__dfrtp_1_80/a_1462_47# VGND sky130_fd_pr__nfet_01v8 ad=0.1092 pd=1.36 as=0.1281 ps=1.45 w=0.42 l=0.15
X4626 sky130_fd_sc_hd__dfrtp_1_80/a_651_413# sky130_fd_sc_hd__dfrtp_1_80/a_27_47# sky130_fd_sc_hd__dfrtp_1_80/a_543_47# VDPWR sky130_fd_pr__pfet_01v8_hvt ad=0.3402 pd=3.3 as=0.1449 ps=1.53 w=0.42 l=0.15
X4627 sky130_fd_sc_hd__dfrtp_1_80/a_1108_47# sky130_fd_sc_hd__dfrtp_1_80/a_193_47# sky130_fd_sc_hd__dfrtp_1_80/a_761_289# VGND sky130_fd_pr__special_nfet_01v8 ad=0 pd=0 as=0.1998 ps=1.97 w=0.36 l=0.15
X4628 VGND V3R298 sky130_fd_sc_hd__dfrtp_1_80/a_805_47# VGND sky130_fd_pr__nfet_01v8 ad=0 pd=0 as=0 ps=0 w=0.42 l=0.15
X4629 V3R177 sky130_fd_sc_hd__dfrtp_1_80/a_1283_21# VDPWR VDPWR sky130_fd_pr__pfet_01v8_hvt ad=0.26 pd=2.52 as=0 ps=0 w=1 l=0.15
X4630 VDPWR V3R055 sky130_fd_sc_hd__dfrtp_1_80/a_27_47# VDPWR sky130_fd_pr__pfet_01v8_hvt ad=0 pd=0 as=0.1664 ps=1.8 w=0.64 l=0.15
X4631 sky130_fd_sc_hd__dfrtp_1_80/a_448_47# V3R091 VDPWR VDPWR sky130_fd_pr__pfet_01v8_hvt ad=0.1302 pd=1.46 as=0 ps=0 w=0.42 l=0.15
X4632 sky130_fd_sc_hd__dfrtp_1_80/a_761_289# sky130_fd_sc_hd__dfrtp_1_80/a_543_47# VGND VGND sky130_fd_pr__nfet_01v8 ad=0 pd=0 as=0 ps=0 w=0.64 l=0.15
X4633 sky130_fd_sc_hd__dfrtp_1_80/a_193_47# sky130_fd_sc_hd__dfrtp_1_80/a_27_47# VGND VGND sky130_fd_pr__nfet_01v8 ad=0.1092 pd=1.36 as=0 ps=0 w=0.42 l=0.15
X4634 sky130_fd_sc_hd__dfrtp_1_80/a_1108_47# sky130_fd_sc_hd__dfrtp_1_80/a_27_47# sky130_fd_sc_hd__dfrtp_1_80/a_761_289# VDPWR sky130_fd_pr__pfet_01v8_hvt ad=0.1176 pd=1.4 as=0.2583 ps=2.37 w=0.42 l=0.15
X4635 sky130_fd_sc_hd__dfrtp_1_80/a_1462_47# V3R298 VGND VGND sky130_fd_pr__nfet_01v8 ad=0 pd=0 as=0 ps=0 w=0.42 l=0.15
X4636 sky130_fd_sc_hd__dfrtp_1_80/a_543_47# sky130_fd_sc_hd__dfrtp_1_80/a_27_47# sky130_fd_sc_hd__dfrtp_1_80/a_448_47# VGND sky130_fd_pr__special_nfet_01v8 ad=0.1188 pd=1.38 as=0.132 ps=1.49 w=0.36 l=0.15
X4637 sky130_fd_sc_hd__dfrtp_1_80/a_543_47# sky130_fd_sc_hd__dfrtp_1_80/a_193_47# sky130_fd_sc_hd__dfrtp_1_80/a_448_47# VDPWR sky130_fd_pr__pfet_01v8_hvt ad=0 pd=0 as=0 ps=0 w=0.42 l=0.15
X4638 sky130_fd_sc_hd__dfrtp_1_80/a_448_47# V3R091 VGND VGND sky130_fd_pr__nfet_01v8 ad=0 pd=0 as=0 ps=0 w=0.42 l=0.15
X4639 VDPWR sky130_fd_sc_hd__dfrtp_1_80/a_1283_21# sky130_fd_sc_hd__dfrtp_1_80/a_1270_413# VDPWR sky130_fd_pr__pfet_01v8_hvt ad=0 pd=0 as=0.1134 ps=1.38 w=0.42 l=0.15
X4640 VDPWR sky130_fd_sc_hd__dfrtp_1_80/a_1108_47# sky130_fd_sc_hd__dfrtp_1_80/a_1283_21# VDPWR sky130_fd_pr__pfet_01v8_hvt ad=0 pd=0 as=0.1134 ps=1.38 w=0.42 l=0.15
X4641 sky130_fd_sc_hd__dfrtp_1_80/a_1270_413# sky130_fd_sc_hd__dfrtp_1_80/a_193_47# sky130_fd_sc_hd__dfrtp_1_80/a_1108_47# VDPWR sky130_fd_pr__pfet_01v8_hvt ad=0 pd=0 as=0 ps=0 w=0.42 l=0.15
X4642 sky130_fd_sc_hd__dfrtp_1_80/a_193_47# sky130_fd_sc_hd__dfrtp_1_80/a_27_47# VDPWR VDPWR sky130_fd_pr__pfet_01v8_hvt ad=0.1664 pd=1.8 as=0 ps=0 w=0.64 l=0.15
X4643 sky130_fd_sc_hd__dfrtp_1_80/a_1283_21# V3R298 VDPWR VDPWR sky130_fd_pr__pfet_01v8_hvt ad=0 pd=0 as=0 ps=0 w=0.42 l=0.15
X4644 VDPWR sky130_fd_sc_hd__dfrtp_1_80/a_761_289# sky130_fd_sc_hd__dfrtp_1_80/a_651_413# VDPWR sky130_fd_pr__pfet_01v8_hvt ad=0 pd=0 as=0 ps=0 w=0.42 l=0.15
X4645 V3R177 sky130_fd_sc_hd__dfrtp_1_80/a_1283_21# VGND VGND sky130_fd_pr__nfet_01v8 ad=0.169 pd=1.82 as=0 ps=0 w=0.65 l=0.15
X4646 sky130_fd_sc_hd__dfrtp_1_80/a_639_47# sky130_fd_sc_hd__dfrtp_1_80/a_193_47# sky130_fd_sc_hd__dfrtp_1_80/a_543_47# VGND sky130_fd_pr__special_nfet_01v8 ad=0 pd=0 as=0 ps=0 w=0.36 l=0.15
X4647 VGND sky130_fd_sc_hd__dfrtp_1_80/a_1283_21# sky130_fd_sc_hd__dfrtp_1_80/a_1217_47# VGND sky130_fd_pr__nfet_01v8 ad=0 pd=0 as=0 ps=0 w=0.42 l=0.15
X4648 sky130_fd_sc_hd__dfrtp_1_80/a_651_413# V3R298 VDPWR VDPWR sky130_fd_pr__pfet_01v8_hvt ad=0 pd=0 as=0 ps=0 w=0.42 l=0.15
X4649 VGND V3R055 sky130_fd_sc_hd__dfrtp_1_80/a_27_47# VGND sky130_fd_pr__nfet_01v8 ad=0 pd=0 as=0.1092 ps=1.36 w=0.42 l=0.15
X4650 sky130_fd_sc_hd__dfrtp_1_80/a_761_289# sky130_fd_sc_hd__dfrtp_1_80/a_543_47# VDPWR VDPWR sky130_fd_pr__pfet_01v8_hvt ad=0 pd=0 as=0 ps=0 w=0.84 l=0.15
X4651 VGND V3R282 sky130_fd_sc_hd__or2_1_10/a_68_297# VGND sky130_fd_pr__nfet_01v8 ad=0 pd=0 as=0.1134 ps=1.38 w=0.42 l=0.15
X4652 sky130_fd_sc_hd__or2_1_10/a_68_297# V3R279 VGND VGND sky130_fd_pr__nfet_01v8 ad=0 pd=0 as=0 ps=0 w=0.42 l=0.15
X4653 V3R283 sky130_fd_sc_hd__or2_1_10/a_68_297# VGND VGND sky130_fd_pr__nfet_01v8 ad=0.169 pd=1.82 as=0 ps=0 w=0.65 l=0.15
X4654 VDPWR V3R282 sky130_fd_sc_hd__or2_1_10/a_150_297# VDPWR sky130_fd_pr__pfet_01v8_hvt ad=0 pd=0 as=0.0882 ps=1.26 w=0.42 l=0.15
X4655 V3R283 sky130_fd_sc_hd__or2_1_10/a_68_297# VDPWR VDPWR sky130_fd_pr__pfet_01v8_hvt ad=0.34 pd=2.68 as=0 ps=0 w=1 l=0.15
X4656 sky130_fd_sc_hd__or2_1_10/a_150_297# V3R279 sky130_fd_sc_hd__or2_1_10/a_68_297# VDPWR sky130_fd_pr__pfet_01v8_hvt ad=0 pd=0 as=0.1092 ps=1.36 w=0.42 l=0.15
X4657 VDPWR V3R203 V3R289 VDPWR sky130_fd_pr__pfet_01v8_hvt ad=0 pd=0 as=0.27 ps=2.54 w=1 l=0.15
X4658 V3R289 V3R203 sky130_fd_sc_hd__nand2_1_1/a_113_47# VGND sky130_fd_pr__nfet_01v8 ad=0.169 pd=1.82 as=0.1755 ps=1.84 w=0.65 l=0.15
X4659 sky130_fd_sc_hd__nand2_1_1/a_113_47# V3R053 VGND VGND sky130_fd_pr__nfet_01v8 ad=0 pd=0 as=0 ps=0 w=0.65 l=0.15
X4660 V3R289 V3R053 VDPWR VDPWR sky130_fd_pr__pfet_01v8_hvt ad=0 pd=0 as=0 ps=0 w=1 l=0.15
X4661 sky130_fd_sc_hd__dfrtp_1_81/a_805_47# sky130_fd_sc_hd__dfrtp_1_81/a_761_289# sky130_fd_sc_hd__dfrtp_1_81/a_639_47# VGND sky130_fd_pr__nfet_01v8 ad=0.0882 pd=1.26 as=0.2802 ps=2.2 w=0.42 l=0.15
X4662 sky130_fd_sc_hd__dfrtp_1_81/a_1217_47# sky130_fd_sc_hd__dfrtp_1_81/a_27_47# sky130_fd_sc_hd__dfrtp_1_81/a_1108_47# VGND sky130_fd_pr__special_nfet_01v8 ad=0.1338 pd=1.5 as=0.1422 ps=1.51 w=0.36 l=0.15
X4663 sky130_fd_sc_hd__dfrtp_1_81/a_1283_21# sky130_fd_sc_hd__dfrtp_1_81/a_1108_47# sky130_fd_sc_hd__dfrtp_1_81/a_1462_47# VGND sky130_fd_pr__nfet_01v8 ad=0.1092 pd=1.36 as=0.1281 ps=1.45 w=0.42 l=0.15
X4664 sky130_fd_sc_hd__dfrtp_1_81/a_651_413# sky130_fd_sc_hd__dfrtp_1_81/a_27_47# sky130_fd_sc_hd__dfrtp_1_81/a_543_47# VDPWR sky130_fd_pr__pfet_01v8_hvt ad=0.3402 pd=3.3 as=0.1449 ps=1.53 w=0.42 l=0.15
X4665 sky130_fd_sc_hd__dfrtp_1_81/a_1108_47# sky130_fd_sc_hd__dfrtp_1_81/a_193_47# sky130_fd_sc_hd__dfrtp_1_81/a_761_289# VGND sky130_fd_pr__special_nfet_01v8 ad=0 pd=0 as=0.1998 ps=1.97 w=0.36 l=0.15
X4666 VGND V3R300 sky130_fd_sc_hd__dfrtp_1_81/a_805_47# VGND sky130_fd_pr__nfet_01v8 ad=0 pd=0 as=0 ps=0 w=0.42 l=0.15
X4667 V3R038 sky130_fd_sc_hd__dfrtp_1_81/a_1283_21# VDPWR VDPWR sky130_fd_pr__pfet_01v8_hvt ad=0.26 pd=2.52 as=0 ps=0 w=1 l=0.15
X4668 VDPWR V3R081 sky130_fd_sc_hd__dfrtp_1_81/a_27_47# VDPWR sky130_fd_pr__pfet_01v8_hvt ad=0 pd=0 as=0.1664 ps=1.8 w=0.64 l=0.15
X4669 sky130_fd_sc_hd__dfrtp_1_81/a_448_47# V3R123 VDPWR VDPWR sky130_fd_pr__pfet_01v8_hvt ad=0.1302 pd=1.46 as=0 ps=0 w=0.42 l=0.15
X4670 sky130_fd_sc_hd__dfrtp_1_81/a_761_289# sky130_fd_sc_hd__dfrtp_1_81/a_543_47# VGND VGND sky130_fd_pr__nfet_01v8 ad=0 pd=0 as=0 ps=0 w=0.64 l=0.15
X4671 sky130_fd_sc_hd__dfrtp_1_81/a_193_47# sky130_fd_sc_hd__dfrtp_1_81/a_27_47# VGND VGND sky130_fd_pr__nfet_01v8 ad=0.1092 pd=1.36 as=0 ps=0 w=0.42 l=0.15
X4672 sky130_fd_sc_hd__dfrtp_1_81/a_1108_47# sky130_fd_sc_hd__dfrtp_1_81/a_27_47# sky130_fd_sc_hd__dfrtp_1_81/a_761_289# VDPWR sky130_fd_pr__pfet_01v8_hvt ad=0.1176 pd=1.4 as=0.2583 ps=2.37 w=0.42 l=0.15
X4673 sky130_fd_sc_hd__dfrtp_1_81/a_1462_47# V3R300 VGND VGND sky130_fd_pr__nfet_01v8 ad=0 pd=0 as=0 ps=0 w=0.42 l=0.15
X4674 sky130_fd_sc_hd__dfrtp_1_81/a_543_47# sky130_fd_sc_hd__dfrtp_1_81/a_27_47# sky130_fd_sc_hd__dfrtp_1_81/a_448_47# VGND sky130_fd_pr__special_nfet_01v8 ad=0.1188 pd=1.38 as=0.132 ps=1.49 w=0.36 l=0.15
X4675 sky130_fd_sc_hd__dfrtp_1_81/a_543_47# sky130_fd_sc_hd__dfrtp_1_81/a_193_47# sky130_fd_sc_hd__dfrtp_1_81/a_448_47# VDPWR sky130_fd_pr__pfet_01v8_hvt ad=0 pd=0 as=0 ps=0 w=0.42 l=0.15
X4676 sky130_fd_sc_hd__dfrtp_1_81/a_448_47# V3R123 VGND VGND sky130_fd_pr__nfet_01v8 ad=0 pd=0 as=0 ps=0 w=0.42 l=0.15
X4677 VDPWR sky130_fd_sc_hd__dfrtp_1_81/a_1283_21# sky130_fd_sc_hd__dfrtp_1_81/a_1270_413# VDPWR sky130_fd_pr__pfet_01v8_hvt ad=0 pd=0 as=0.1134 ps=1.38 w=0.42 l=0.15
X4678 VDPWR sky130_fd_sc_hd__dfrtp_1_81/a_1108_47# sky130_fd_sc_hd__dfrtp_1_81/a_1283_21# VDPWR sky130_fd_pr__pfet_01v8_hvt ad=0 pd=0 as=0.1134 ps=1.38 w=0.42 l=0.15
X4679 sky130_fd_sc_hd__dfrtp_1_81/a_1270_413# sky130_fd_sc_hd__dfrtp_1_81/a_193_47# sky130_fd_sc_hd__dfrtp_1_81/a_1108_47# VDPWR sky130_fd_pr__pfet_01v8_hvt ad=0 pd=0 as=0 ps=0 w=0.42 l=0.15
X4680 sky130_fd_sc_hd__dfrtp_1_81/a_193_47# sky130_fd_sc_hd__dfrtp_1_81/a_27_47# VDPWR VDPWR sky130_fd_pr__pfet_01v8_hvt ad=0.1664 pd=1.8 as=0 ps=0 w=0.64 l=0.15
X4681 sky130_fd_sc_hd__dfrtp_1_81/a_1283_21# V3R300 VDPWR VDPWR sky130_fd_pr__pfet_01v8_hvt ad=0 pd=0 as=0 ps=0 w=0.42 l=0.15
X4682 VDPWR sky130_fd_sc_hd__dfrtp_1_81/a_761_289# sky130_fd_sc_hd__dfrtp_1_81/a_651_413# VDPWR sky130_fd_pr__pfet_01v8_hvt ad=0 pd=0 as=0 ps=0 w=0.42 l=0.15
X4683 V3R038 sky130_fd_sc_hd__dfrtp_1_81/a_1283_21# VGND VGND sky130_fd_pr__nfet_01v8 ad=0.169 pd=1.82 as=0 ps=0 w=0.65 l=0.15
X4684 sky130_fd_sc_hd__dfrtp_1_81/a_639_47# sky130_fd_sc_hd__dfrtp_1_81/a_193_47# sky130_fd_sc_hd__dfrtp_1_81/a_543_47# VGND sky130_fd_pr__special_nfet_01v8 ad=0 pd=0 as=0 ps=0 w=0.36 l=0.15
X4685 VGND sky130_fd_sc_hd__dfrtp_1_81/a_1283_21# sky130_fd_sc_hd__dfrtp_1_81/a_1217_47# VGND sky130_fd_pr__nfet_01v8 ad=0 pd=0 as=0 ps=0 w=0.42 l=0.15
X4686 sky130_fd_sc_hd__dfrtp_1_81/a_651_413# V3R300 VDPWR VDPWR sky130_fd_pr__pfet_01v8_hvt ad=0 pd=0 as=0 ps=0 w=0.42 l=0.15
X4687 VGND V3R081 sky130_fd_sc_hd__dfrtp_1_81/a_27_47# VGND sky130_fd_pr__nfet_01v8 ad=0 pd=0 as=0.1092 ps=1.36 w=0.42 l=0.15
X4688 sky130_fd_sc_hd__dfrtp_1_81/a_761_289# sky130_fd_sc_hd__dfrtp_1_81/a_543_47# VDPWR VDPWR sky130_fd_pr__pfet_01v8_hvt ad=0 pd=0 as=0 ps=0 w=0.84 l=0.15
X4689 sky130_fd_sc_hd__dfrtp_1_70/a_805_47# sky130_fd_sc_hd__dfrtp_1_70/a_761_289# sky130_fd_sc_hd__dfrtp_1_70/a_639_47# VGND sky130_fd_pr__nfet_01v8 ad=0.0882 pd=1.26 as=0.2802 ps=2.2 w=0.42 l=0.15
X4690 sky130_fd_sc_hd__dfrtp_1_70/a_1217_47# sky130_fd_sc_hd__dfrtp_1_70/a_27_47# sky130_fd_sc_hd__dfrtp_1_70/a_1108_47# VGND sky130_fd_pr__special_nfet_01v8 ad=0.1338 pd=1.5 as=0.1422 ps=1.51 w=0.36 l=0.15
X4691 sky130_fd_sc_hd__dfrtp_1_70/a_1283_21# sky130_fd_sc_hd__dfrtp_1_70/a_1108_47# sky130_fd_sc_hd__dfrtp_1_70/a_1462_47# VGND sky130_fd_pr__nfet_01v8 ad=0.1092 pd=1.36 as=0.1281 ps=1.45 w=0.42 l=0.15
X4692 sky130_fd_sc_hd__dfrtp_1_70/a_651_413# sky130_fd_sc_hd__dfrtp_1_70/a_27_47# sky130_fd_sc_hd__dfrtp_1_70/a_543_47# VDPWR sky130_fd_pr__pfet_01v8_hvt ad=0.3402 pd=3.3 as=0.1449 ps=1.53 w=0.42 l=0.15
X4693 sky130_fd_sc_hd__dfrtp_1_70/a_1108_47# sky130_fd_sc_hd__dfrtp_1_70/a_193_47# sky130_fd_sc_hd__dfrtp_1_70/a_761_289# VGND sky130_fd_pr__special_nfet_01v8 ad=0 pd=0 as=0.1998 ps=1.97 w=0.36 l=0.15
X4694 VGND V3R298 sky130_fd_sc_hd__dfrtp_1_70/a_805_47# VGND sky130_fd_pr__nfet_01v8 ad=0 pd=0 as=0 ps=0 w=0.42 l=0.15
X4695 V3R181 sky130_fd_sc_hd__dfrtp_1_70/a_1283_21# VDPWR VDPWR sky130_fd_pr__pfet_01v8_hvt ad=0.26 pd=2.52 as=0 ps=0 w=1 l=0.15
X4696 VDPWR V3R055 sky130_fd_sc_hd__dfrtp_1_70/a_27_47# VDPWR sky130_fd_pr__pfet_01v8_hvt ad=0 pd=0 as=0.1664 ps=1.8 w=0.64 l=0.15
X4697 sky130_fd_sc_hd__dfrtp_1_70/a_448_47# V3R095 VDPWR VDPWR sky130_fd_pr__pfet_01v8_hvt ad=0.1302 pd=1.46 as=0 ps=0 w=0.42 l=0.15
X4698 sky130_fd_sc_hd__dfrtp_1_70/a_761_289# sky130_fd_sc_hd__dfrtp_1_70/a_543_47# VGND VGND sky130_fd_pr__nfet_01v8 ad=0 pd=0 as=0 ps=0 w=0.64 l=0.15
X4699 sky130_fd_sc_hd__dfrtp_1_70/a_193_47# sky130_fd_sc_hd__dfrtp_1_70/a_27_47# VGND VGND sky130_fd_pr__nfet_01v8 ad=0.1092 pd=1.36 as=0 ps=0 w=0.42 l=0.15
X4700 sky130_fd_sc_hd__dfrtp_1_70/a_1108_47# sky130_fd_sc_hd__dfrtp_1_70/a_27_47# sky130_fd_sc_hd__dfrtp_1_70/a_761_289# VDPWR sky130_fd_pr__pfet_01v8_hvt ad=0.1176 pd=1.4 as=0.2583 ps=2.37 w=0.42 l=0.15
X4701 sky130_fd_sc_hd__dfrtp_1_70/a_1462_47# V3R298 VGND VGND sky130_fd_pr__nfet_01v8 ad=0 pd=0 as=0 ps=0 w=0.42 l=0.15
X4702 sky130_fd_sc_hd__dfrtp_1_70/a_543_47# sky130_fd_sc_hd__dfrtp_1_70/a_27_47# sky130_fd_sc_hd__dfrtp_1_70/a_448_47# VGND sky130_fd_pr__special_nfet_01v8 ad=0.1188 pd=1.38 as=0.132 ps=1.49 w=0.36 l=0.15
X4703 sky130_fd_sc_hd__dfrtp_1_70/a_543_47# sky130_fd_sc_hd__dfrtp_1_70/a_193_47# sky130_fd_sc_hd__dfrtp_1_70/a_448_47# VDPWR sky130_fd_pr__pfet_01v8_hvt ad=0 pd=0 as=0 ps=0 w=0.42 l=0.15
X4704 sky130_fd_sc_hd__dfrtp_1_70/a_448_47# V3R095 VGND VGND sky130_fd_pr__nfet_01v8 ad=0 pd=0 as=0 ps=0 w=0.42 l=0.15
X4705 VDPWR sky130_fd_sc_hd__dfrtp_1_70/a_1283_21# sky130_fd_sc_hd__dfrtp_1_70/a_1270_413# VDPWR sky130_fd_pr__pfet_01v8_hvt ad=0 pd=0 as=0.1134 ps=1.38 w=0.42 l=0.15
X4706 VDPWR sky130_fd_sc_hd__dfrtp_1_70/a_1108_47# sky130_fd_sc_hd__dfrtp_1_70/a_1283_21# VDPWR sky130_fd_pr__pfet_01v8_hvt ad=0 pd=0 as=0.1134 ps=1.38 w=0.42 l=0.15
X4707 sky130_fd_sc_hd__dfrtp_1_70/a_1270_413# sky130_fd_sc_hd__dfrtp_1_70/a_193_47# sky130_fd_sc_hd__dfrtp_1_70/a_1108_47# VDPWR sky130_fd_pr__pfet_01v8_hvt ad=0 pd=0 as=0 ps=0 w=0.42 l=0.15
X4708 sky130_fd_sc_hd__dfrtp_1_70/a_193_47# sky130_fd_sc_hd__dfrtp_1_70/a_27_47# VDPWR VDPWR sky130_fd_pr__pfet_01v8_hvt ad=0.1664 pd=1.8 as=0 ps=0 w=0.64 l=0.15
X4709 sky130_fd_sc_hd__dfrtp_1_70/a_1283_21# V3R298 VDPWR VDPWR sky130_fd_pr__pfet_01v8_hvt ad=0 pd=0 as=0 ps=0 w=0.42 l=0.15
X4710 VDPWR sky130_fd_sc_hd__dfrtp_1_70/a_761_289# sky130_fd_sc_hd__dfrtp_1_70/a_651_413# VDPWR sky130_fd_pr__pfet_01v8_hvt ad=0 pd=0 as=0 ps=0 w=0.42 l=0.15
X4711 V3R181 sky130_fd_sc_hd__dfrtp_1_70/a_1283_21# VGND VGND sky130_fd_pr__nfet_01v8 ad=0.169 pd=1.82 as=0 ps=0 w=0.65 l=0.15
X4712 sky130_fd_sc_hd__dfrtp_1_70/a_639_47# sky130_fd_sc_hd__dfrtp_1_70/a_193_47# sky130_fd_sc_hd__dfrtp_1_70/a_543_47# VGND sky130_fd_pr__special_nfet_01v8 ad=0 pd=0 as=0 ps=0 w=0.36 l=0.15
X4713 VGND sky130_fd_sc_hd__dfrtp_1_70/a_1283_21# sky130_fd_sc_hd__dfrtp_1_70/a_1217_47# VGND sky130_fd_pr__nfet_01v8 ad=0 pd=0 as=0 ps=0 w=0.42 l=0.15
X4714 sky130_fd_sc_hd__dfrtp_1_70/a_651_413# V3R298 VDPWR VDPWR sky130_fd_pr__pfet_01v8_hvt ad=0 pd=0 as=0 ps=0 w=0.42 l=0.15
X4715 VGND V3R055 sky130_fd_sc_hd__dfrtp_1_70/a_27_47# VGND sky130_fd_pr__nfet_01v8 ad=0 pd=0 as=0.1092 ps=1.36 w=0.42 l=0.15
X4716 sky130_fd_sc_hd__dfrtp_1_70/a_761_289# sky130_fd_sc_hd__dfrtp_1_70/a_543_47# VDPWR VDPWR sky130_fd_pr__pfet_01v8_hvt ad=0 pd=0 as=0 ps=0 w=0.84 l=0.15
X4717 V3R277 sky130_fd_sc_hd__xor2_1_10/a_35_297# sky130_fd_sc_hd__xor2_1_10/a_285_297# VDPWR sky130_fd_pr__pfet_01v8_hvt ad=0.3 pd=2.6 as=0.53 ps=5.06 w=1 l=0.15
X4718 V3R277 V3R076 sky130_fd_sc_hd__xor2_1_10/a_285_47# VGND sky130_fd_pr__nfet_01v8 ad=0.5005 pd=2.84 as=0.1755 ps=1.84 w=0.65 l=0.15
X4719 sky130_fd_sc_hd__xor2_1_10/a_35_297# V3R076 VGND VGND sky130_fd_pr__nfet_01v8 ad=0.1755 pd=1.84 as=0 ps=0 w=0.65 l=0.15
X4720 sky130_fd_sc_hd__xor2_1_10/a_117_297# V3R076 sky130_fd_sc_hd__xor2_1_10/a_35_297# VDPWR sky130_fd_pr__pfet_01v8_hvt ad=0.27 pd=2.54 as=0.26 ps=2.52 w=1 l=0.15
X4721 VDPWR V3R076 sky130_fd_sc_hd__xor2_1_10/a_285_297# VDPWR sky130_fd_pr__pfet_01v8_hvt ad=0 pd=0 as=0 ps=0 w=1 l=0.15
X4722 VGND V3R003 sky130_fd_sc_hd__xor2_1_10/a_35_297# VGND sky130_fd_pr__nfet_01v8 ad=0 pd=0 as=0 ps=0 w=0.65 l=0.15
X4723 VGND sky130_fd_sc_hd__xor2_1_10/a_35_297# V3R277 VGND sky130_fd_pr__nfet_01v8 ad=0 pd=0 as=0 ps=0 w=0.65 l=0.15
X4724 sky130_fd_sc_hd__xor2_1_10/a_285_297# V3R003 VDPWR VDPWR sky130_fd_pr__pfet_01v8_hvt ad=0 pd=0 as=0 ps=0 w=1 l=0.15
X4725 VDPWR V3R003 sky130_fd_sc_hd__xor2_1_10/a_117_297# VDPWR sky130_fd_pr__pfet_01v8_hvt ad=0 pd=0 as=0 ps=0 w=1 l=0.15
X4726 sky130_fd_sc_hd__xor2_1_10/a_285_47# V3R003 VGND VGND sky130_fd_pr__nfet_01v8 ad=0 pd=0 as=0 ps=0 w=0.65 l=0.15
X4727 VGND V3R248 sky130_fd_sc_hd__or2_1_11/a_68_297# VGND sky130_fd_pr__nfet_01v8 ad=0 pd=0 as=0.1134 ps=1.38 w=0.42 l=0.15
X4728 sky130_fd_sc_hd__or2_1_11/a_68_297# V3R244 VGND VGND sky130_fd_pr__nfet_01v8 ad=0 pd=0 as=0 ps=0 w=0.42 l=0.15
X4729 V3R259 sky130_fd_sc_hd__or2_1_11/a_68_297# VGND VGND sky130_fd_pr__nfet_01v8 ad=0.169 pd=1.82 as=0 ps=0 w=0.65 l=0.15
X4730 VDPWR V3R248 sky130_fd_sc_hd__or2_1_11/a_150_297# VDPWR sky130_fd_pr__pfet_01v8_hvt ad=0 pd=0 as=0.0882 ps=1.26 w=0.42 l=0.15
X4731 V3R259 sky130_fd_sc_hd__or2_1_11/a_68_297# VDPWR VDPWR sky130_fd_pr__pfet_01v8_hvt ad=0.34 pd=2.68 as=0 ps=0 w=1 l=0.15
X4732 sky130_fd_sc_hd__or2_1_11/a_150_297# V3R244 sky130_fd_sc_hd__or2_1_11/a_68_297# VDPWR sky130_fd_pr__pfet_01v8_hvt ad=0 pd=0 as=0.1092 ps=1.36 w=0.42 l=0.15
X4733 VDPWR V3R261 V3R262 VDPWR sky130_fd_pr__pfet_01v8_hvt ad=0 pd=0 as=0.27 ps=2.54 w=1 l=0.15
X4734 V3R262 V3R261 sky130_fd_sc_hd__nand2_1_2/a_113_47# VGND sky130_fd_pr__nfet_01v8 ad=0.169 pd=1.82 as=0.1755 ps=1.84 w=0.65 l=0.15
X4735 sky130_fd_sc_hd__nand2_1_2/a_113_47# V3R203 VGND VGND sky130_fd_pr__nfet_01v8 ad=0 pd=0 as=0 ps=0 w=0.65 l=0.15
X4736 V3R262 V3R203 VDPWR VDPWR sky130_fd_pr__pfet_01v8_hvt ad=0 pd=0 as=0 ps=0 w=1 l=0.15
X4737 sky130_fd_sc_hd__dfrtp_1_82/a_805_47# sky130_fd_sc_hd__dfrtp_1_82/a_761_289# sky130_fd_sc_hd__dfrtp_1_82/a_639_47# VGND sky130_fd_pr__nfet_01v8 ad=0.0882 pd=1.26 as=0.2802 ps=2.2 w=0.42 l=0.15
X4738 sky130_fd_sc_hd__dfrtp_1_82/a_1217_47# sky130_fd_sc_hd__dfrtp_1_82/a_27_47# sky130_fd_sc_hd__dfrtp_1_82/a_1108_47# VGND sky130_fd_pr__special_nfet_01v8 ad=0.1338 pd=1.5 as=0.1422 ps=1.51 w=0.36 l=0.15
X4739 sky130_fd_sc_hd__dfrtp_1_82/a_1283_21# sky130_fd_sc_hd__dfrtp_1_82/a_1108_47# sky130_fd_sc_hd__dfrtp_1_82/a_1462_47# VGND sky130_fd_pr__nfet_01v8 ad=0.1092 pd=1.36 as=0.1281 ps=1.45 w=0.42 l=0.15
X4740 sky130_fd_sc_hd__dfrtp_1_82/a_651_413# sky130_fd_sc_hd__dfrtp_1_82/a_27_47# sky130_fd_sc_hd__dfrtp_1_82/a_543_47# VDPWR sky130_fd_pr__pfet_01v8_hvt ad=0.3402 pd=3.3 as=0.1449 ps=1.53 w=0.42 l=0.15
X4741 sky130_fd_sc_hd__dfrtp_1_82/a_1108_47# sky130_fd_sc_hd__dfrtp_1_82/a_193_47# sky130_fd_sc_hd__dfrtp_1_82/a_761_289# VGND sky130_fd_pr__special_nfet_01v8 ad=0 pd=0 as=0.1998 ps=1.97 w=0.36 l=0.15
X4742 VGND V3R302 sky130_fd_sc_hd__dfrtp_1_82/a_805_47# VGND sky130_fd_pr__nfet_01v8 ad=0 pd=0 as=0 ps=0 w=0.42 l=0.15
X4743 V3R006 sky130_fd_sc_hd__dfrtp_1_82/a_1283_21# VDPWR VDPWR sky130_fd_pr__pfet_01v8_hvt ad=0.26 pd=2.52 as=0 ps=0 w=1 l=0.15
X4744 VDPWR V3R083 sky130_fd_sc_hd__dfrtp_1_82/a_27_47# VDPWR sky130_fd_pr__pfet_01v8_hvt ad=0 pd=0 as=0.1664 ps=1.8 w=0.64 l=0.15
X4745 sky130_fd_sc_hd__dfrtp_1_82/a_448_47# V3R190 VDPWR VDPWR sky130_fd_pr__pfet_01v8_hvt ad=0.1302 pd=1.46 as=0 ps=0 w=0.42 l=0.15
X4746 sky130_fd_sc_hd__dfrtp_1_82/a_761_289# sky130_fd_sc_hd__dfrtp_1_82/a_543_47# VGND VGND sky130_fd_pr__nfet_01v8 ad=0 pd=0 as=0 ps=0 w=0.64 l=0.15
X4747 sky130_fd_sc_hd__dfrtp_1_82/a_193_47# sky130_fd_sc_hd__dfrtp_1_82/a_27_47# VGND VGND sky130_fd_pr__nfet_01v8 ad=0.1092 pd=1.36 as=0 ps=0 w=0.42 l=0.15
X4748 sky130_fd_sc_hd__dfrtp_1_82/a_1108_47# sky130_fd_sc_hd__dfrtp_1_82/a_27_47# sky130_fd_sc_hd__dfrtp_1_82/a_761_289# VDPWR sky130_fd_pr__pfet_01v8_hvt ad=0.1176 pd=1.4 as=0.2583 ps=2.37 w=0.42 l=0.15
X4749 sky130_fd_sc_hd__dfrtp_1_82/a_1462_47# V3R302 VGND VGND sky130_fd_pr__nfet_01v8 ad=0 pd=0 as=0 ps=0 w=0.42 l=0.15
X4750 sky130_fd_sc_hd__dfrtp_1_82/a_543_47# sky130_fd_sc_hd__dfrtp_1_82/a_27_47# sky130_fd_sc_hd__dfrtp_1_82/a_448_47# VGND sky130_fd_pr__special_nfet_01v8 ad=0.1188 pd=1.38 as=0.132 ps=1.49 w=0.36 l=0.15
X4751 sky130_fd_sc_hd__dfrtp_1_82/a_543_47# sky130_fd_sc_hd__dfrtp_1_82/a_193_47# sky130_fd_sc_hd__dfrtp_1_82/a_448_47# VDPWR sky130_fd_pr__pfet_01v8_hvt ad=0 pd=0 as=0 ps=0 w=0.42 l=0.15
X4752 sky130_fd_sc_hd__dfrtp_1_82/a_448_47# V3R190 VGND VGND sky130_fd_pr__nfet_01v8 ad=0 pd=0 as=0 ps=0 w=0.42 l=0.15
X4753 VDPWR sky130_fd_sc_hd__dfrtp_1_82/a_1283_21# sky130_fd_sc_hd__dfrtp_1_82/a_1270_413# VDPWR sky130_fd_pr__pfet_01v8_hvt ad=0 pd=0 as=0.1134 ps=1.38 w=0.42 l=0.15
X4754 VDPWR sky130_fd_sc_hd__dfrtp_1_82/a_1108_47# sky130_fd_sc_hd__dfrtp_1_82/a_1283_21# VDPWR sky130_fd_pr__pfet_01v8_hvt ad=0 pd=0 as=0.1134 ps=1.38 w=0.42 l=0.15
X4755 sky130_fd_sc_hd__dfrtp_1_82/a_1270_413# sky130_fd_sc_hd__dfrtp_1_82/a_193_47# sky130_fd_sc_hd__dfrtp_1_82/a_1108_47# VDPWR sky130_fd_pr__pfet_01v8_hvt ad=0 pd=0 as=0 ps=0 w=0.42 l=0.15
X4756 sky130_fd_sc_hd__dfrtp_1_82/a_193_47# sky130_fd_sc_hd__dfrtp_1_82/a_27_47# VDPWR VDPWR sky130_fd_pr__pfet_01v8_hvt ad=0.1664 pd=1.8 as=0 ps=0 w=0.64 l=0.15
X4757 sky130_fd_sc_hd__dfrtp_1_82/a_1283_21# V3R302 VDPWR VDPWR sky130_fd_pr__pfet_01v8_hvt ad=0 pd=0 as=0 ps=0 w=0.42 l=0.15
X4758 VDPWR sky130_fd_sc_hd__dfrtp_1_82/a_761_289# sky130_fd_sc_hd__dfrtp_1_82/a_651_413# VDPWR sky130_fd_pr__pfet_01v8_hvt ad=0 pd=0 as=0 ps=0 w=0.42 l=0.15
X4759 V3R006 sky130_fd_sc_hd__dfrtp_1_82/a_1283_21# VGND VGND sky130_fd_pr__nfet_01v8 ad=0.169 pd=1.82 as=0 ps=0 w=0.65 l=0.15
X4760 sky130_fd_sc_hd__dfrtp_1_82/a_639_47# sky130_fd_sc_hd__dfrtp_1_82/a_193_47# sky130_fd_sc_hd__dfrtp_1_82/a_543_47# VGND sky130_fd_pr__special_nfet_01v8 ad=0 pd=0 as=0 ps=0 w=0.36 l=0.15
X4761 VGND sky130_fd_sc_hd__dfrtp_1_82/a_1283_21# sky130_fd_sc_hd__dfrtp_1_82/a_1217_47# VGND sky130_fd_pr__nfet_01v8 ad=0 pd=0 as=0 ps=0 w=0.42 l=0.15
X4762 sky130_fd_sc_hd__dfrtp_1_82/a_651_413# V3R302 VDPWR VDPWR sky130_fd_pr__pfet_01v8_hvt ad=0 pd=0 as=0 ps=0 w=0.42 l=0.15
X4763 VGND V3R083 sky130_fd_sc_hd__dfrtp_1_82/a_27_47# VGND sky130_fd_pr__nfet_01v8 ad=0 pd=0 as=0.1092 ps=1.36 w=0.42 l=0.15
X4764 sky130_fd_sc_hd__dfrtp_1_82/a_761_289# sky130_fd_sc_hd__dfrtp_1_82/a_543_47# VDPWR VDPWR sky130_fd_pr__pfet_01v8_hvt ad=0 pd=0 as=0 ps=0 w=0.84 l=0.15
X4765 sky130_fd_sc_hd__dfrtp_1_71/a_805_47# sky130_fd_sc_hd__dfrtp_1_71/a_761_289# sky130_fd_sc_hd__dfrtp_1_71/a_639_47# VGND sky130_fd_pr__nfet_01v8 ad=0.0882 pd=1.26 as=0.2802 ps=2.2 w=0.42 l=0.15
X4766 sky130_fd_sc_hd__dfrtp_1_71/a_1217_47# sky130_fd_sc_hd__dfrtp_1_71/a_27_47# sky130_fd_sc_hd__dfrtp_1_71/a_1108_47# VGND sky130_fd_pr__special_nfet_01v8 ad=0.1338 pd=1.5 as=0.1422 ps=1.51 w=0.36 l=0.15
X4767 sky130_fd_sc_hd__dfrtp_1_71/a_1283_21# sky130_fd_sc_hd__dfrtp_1_71/a_1108_47# sky130_fd_sc_hd__dfrtp_1_71/a_1462_47# VGND sky130_fd_pr__nfet_01v8 ad=0.1092 pd=1.36 as=0.1281 ps=1.45 w=0.42 l=0.15
X4768 sky130_fd_sc_hd__dfrtp_1_71/a_651_413# sky130_fd_sc_hd__dfrtp_1_71/a_27_47# sky130_fd_sc_hd__dfrtp_1_71/a_543_47# VDPWR sky130_fd_pr__pfet_01v8_hvt ad=0.3402 pd=3.3 as=0.1449 ps=1.53 w=0.42 l=0.15
X4769 sky130_fd_sc_hd__dfrtp_1_71/a_1108_47# sky130_fd_sc_hd__dfrtp_1_71/a_193_47# sky130_fd_sc_hd__dfrtp_1_71/a_761_289# VGND sky130_fd_pr__special_nfet_01v8 ad=0 pd=0 as=0.1998 ps=1.97 w=0.36 l=0.15
X4770 VGND V3R300 sky130_fd_sc_hd__dfrtp_1_71/a_805_47# VGND sky130_fd_pr__nfet_01v8 ad=0 pd=0 as=0 ps=0 w=0.42 l=0.15
X4771 V3R042 sky130_fd_sc_hd__dfrtp_1_71/a_1283_21# VDPWR VDPWR sky130_fd_pr__pfet_01v8_hvt ad=0.26 pd=2.52 as=0 ps=0 w=1 l=0.15
X4772 VDPWR V3R081 sky130_fd_sc_hd__dfrtp_1_71/a_27_47# VDPWR sky130_fd_pr__pfet_01v8_hvt ad=0 pd=0 as=0.1664 ps=1.8 w=0.64 l=0.15
X4773 sky130_fd_sc_hd__dfrtp_1_71/a_448_47# V3R127 VDPWR VDPWR sky130_fd_pr__pfet_01v8_hvt ad=0.1302 pd=1.46 as=0 ps=0 w=0.42 l=0.15
X4774 sky130_fd_sc_hd__dfrtp_1_71/a_761_289# sky130_fd_sc_hd__dfrtp_1_71/a_543_47# VGND VGND sky130_fd_pr__nfet_01v8 ad=0 pd=0 as=0 ps=0 w=0.64 l=0.15
X4775 sky130_fd_sc_hd__dfrtp_1_71/a_193_47# sky130_fd_sc_hd__dfrtp_1_71/a_27_47# VGND VGND sky130_fd_pr__nfet_01v8 ad=0.1092 pd=1.36 as=0 ps=0 w=0.42 l=0.15
X4776 sky130_fd_sc_hd__dfrtp_1_71/a_1108_47# sky130_fd_sc_hd__dfrtp_1_71/a_27_47# sky130_fd_sc_hd__dfrtp_1_71/a_761_289# VDPWR sky130_fd_pr__pfet_01v8_hvt ad=0.1176 pd=1.4 as=0.2583 ps=2.37 w=0.42 l=0.15
X4777 sky130_fd_sc_hd__dfrtp_1_71/a_1462_47# V3R300 VGND VGND sky130_fd_pr__nfet_01v8 ad=0 pd=0 as=0 ps=0 w=0.42 l=0.15
X4778 sky130_fd_sc_hd__dfrtp_1_71/a_543_47# sky130_fd_sc_hd__dfrtp_1_71/a_27_47# sky130_fd_sc_hd__dfrtp_1_71/a_448_47# VGND sky130_fd_pr__special_nfet_01v8 ad=0.1188 pd=1.38 as=0.132 ps=1.49 w=0.36 l=0.15
X4779 sky130_fd_sc_hd__dfrtp_1_71/a_543_47# sky130_fd_sc_hd__dfrtp_1_71/a_193_47# sky130_fd_sc_hd__dfrtp_1_71/a_448_47# VDPWR sky130_fd_pr__pfet_01v8_hvt ad=0 pd=0 as=0 ps=0 w=0.42 l=0.15
X4780 sky130_fd_sc_hd__dfrtp_1_71/a_448_47# V3R127 VGND VGND sky130_fd_pr__nfet_01v8 ad=0 pd=0 as=0 ps=0 w=0.42 l=0.15
X4781 VDPWR sky130_fd_sc_hd__dfrtp_1_71/a_1283_21# sky130_fd_sc_hd__dfrtp_1_71/a_1270_413# VDPWR sky130_fd_pr__pfet_01v8_hvt ad=0 pd=0 as=0.1134 ps=1.38 w=0.42 l=0.15
X4782 VDPWR sky130_fd_sc_hd__dfrtp_1_71/a_1108_47# sky130_fd_sc_hd__dfrtp_1_71/a_1283_21# VDPWR sky130_fd_pr__pfet_01v8_hvt ad=0 pd=0 as=0.1134 ps=1.38 w=0.42 l=0.15
X4783 sky130_fd_sc_hd__dfrtp_1_71/a_1270_413# sky130_fd_sc_hd__dfrtp_1_71/a_193_47# sky130_fd_sc_hd__dfrtp_1_71/a_1108_47# VDPWR sky130_fd_pr__pfet_01v8_hvt ad=0 pd=0 as=0 ps=0 w=0.42 l=0.15
X4784 sky130_fd_sc_hd__dfrtp_1_71/a_193_47# sky130_fd_sc_hd__dfrtp_1_71/a_27_47# VDPWR VDPWR sky130_fd_pr__pfet_01v8_hvt ad=0.1664 pd=1.8 as=0 ps=0 w=0.64 l=0.15
X4785 sky130_fd_sc_hd__dfrtp_1_71/a_1283_21# V3R300 VDPWR VDPWR sky130_fd_pr__pfet_01v8_hvt ad=0 pd=0 as=0 ps=0 w=0.42 l=0.15
X4786 VDPWR sky130_fd_sc_hd__dfrtp_1_71/a_761_289# sky130_fd_sc_hd__dfrtp_1_71/a_651_413# VDPWR sky130_fd_pr__pfet_01v8_hvt ad=0 pd=0 as=0 ps=0 w=0.42 l=0.15
X4787 V3R042 sky130_fd_sc_hd__dfrtp_1_71/a_1283_21# VGND VGND sky130_fd_pr__nfet_01v8 ad=0.169 pd=1.82 as=0 ps=0 w=0.65 l=0.15
X4788 sky130_fd_sc_hd__dfrtp_1_71/a_639_47# sky130_fd_sc_hd__dfrtp_1_71/a_193_47# sky130_fd_sc_hd__dfrtp_1_71/a_543_47# VGND sky130_fd_pr__special_nfet_01v8 ad=0 pd=0 as=0 ps=0 w=0.36 l=0.15
X4789 VGND sky130_fd_sc_hd__dfrtp_1_71/a_1283_21# sky130_fd_sc_hd__dfrtp_1_71/a_1217_47# VGND sky130_fd_pr__nfet_01v8 ad=0 pd=0 as=0 ps=0 w=0.42 l=0.15
X4790 sky130_fd_sc_hd__dfrtp_1_71/a_651_413# V3R300 VDPWR VDPWR sky130_fd_pr__pfet_01v8_hvt ad=0 pd=0 as=0 ps=0 w=0.42 l=0.15
X4791 VGND V3R081 sky130_fd_sc_hd__dfrtp_1_71/a_27_47# VGND sky130_fd_pr__nfet_01v8 ad=0 pd=0 as=0.1092 ps=1.36 w=0.42 l=0.15
X4792 sky130_fd_sc_hd__dfrtp_1_71/a_761_289# sky130_fd_sc_hd__dfrtp_1_71/a_543_47# VDPWR VDPWR sky130_fd_pr__pfet_01v8_hvt ad=0 pd=0 as=0 ps=0 w=0.84 l=0.15
X4793 sky130_fd_sc_hd__dfrtp_1_60/a_805_47# sky130_fd_sc_hd__dfrtp_1_60/a_761_289# sky130_fd_sc_hd__dfrtp_1_60/a_639_47# VGND sky130_fd_pr__nfet_01v8 ad=0.0882 pd=1.26 as=0.2802 ps=2.2 w=0.42 l=0.15
X4794 sky130_fd_sc_hd__dfrtp_1_60/a_1217_47# sky130_fd_sc_hd__dfrtp_1_60/a_27_47# sky130_fd_sc_hd__dfrtp_1_60/a_1108_47# VGND sky130_fd_pr__special_nfet_01v8 ad=0.1338 pd=1.5 as=0.1422 ps=1.51 w=0.36 l=0.15
X4795 sky130_fd_sc_hd__dfrtp_1_60/a_1283_21# sky130_fd_sc_hd__dfrtp_1_60/a_1108_47# sky130_fd_sc_hd__dfrtp_1_60/a_1462_47# VGND sky130_fd_pr__nfet_01v8 ad=0.1092 pd=1.36 as=0.1281 ps=1.45 w=0.42 l=0.15
X4796 sky130_fd_sc_hd__dfrtp_1_60/a_651_413# sky130_fd_sc_hd__dfrtp_1_60/a_27_47# sky130_fd_sc_hd__dfrtp_1_60/a_543_47# VDPWR sky130_fd_pr__pfet_01v8_hvt ad=0.3402 pd=3.3 as=0.1449 ps=1.53 w=0.42 l=0.15
X4797 sky130_fd_sc_hd__dfrtp_1_60/a_1108_47# sky130_fd_sc_hd__dfrtp_1_60/a_193_47# sky130_fd_sc_hd__dfrtp_1_60/a_761_289# VGND sky130_fd_pr__special_nfet_01v8 ad=0 pd=0 as=0.1998 ps=1.97 w=0.36 l=0.15
X4798 VGND V3R298 sky130_fd_sc_hd__dfrtp_1_60/a_805_47# VGND sky130_fd_pr__nfet_01v8 ad=0 pd=0 as=0 ps=0 w=0.42 l=0.15
X4799 V3R153 sky130_fd_sc_hd__dfrtp_1_60/a_1283_21# VDPWR VDPWR sky130_fd_pr__pfet_01v8_hvt ad=0.26 pd=2.52 as=0 ps=0 w=1 l=0.15
X4800 VDPWR V3R055 sky130_fd_sc_hd__dfrtp_1_60/a_27_47# VDPWR sky130_fd_pr__pfet_01v8_hvt ad=0 pd=0 as=0.1664 ps=1.8 w=0.64 l=0.15
X4801 sky130_fd_sc_hd__dfrtp_1_60/a_448_47# V3R098 VDPWR VDPWR sky130_fd_pr__pfet_01v8_hvt ad=0.1302 pd=1.46 as=0 ps=0 w=0.42 l=0.15
X4802 sky130_fd_sc_hd__dfrtp_1_60/a_761_289# sky130_fd_sc_hd__dfrtp_1_60/a_543_47# VGND VGND sky130_fd_pr__nfet_01v8 ad=0 pd=0 as=0 ps=0 w=0.64 l=0.15
X4803 sky130_fd_sc_hd__dfrtp_1_60/a_193_47# sky130_fd_sc_hd__dfrtp_1_60/a_27_47# VGND VGND sky130_fd_pr__nfet_01v8 ad=0.1092 pd=1.36 as=0 ps=0 w=0.42 l=0.15
X4804 sky130_fd_sc_hd__dfrtp_1_60/a_1108_47# sky130_fd_sc_hd__dfrtp_1_60/a_27_47# sky130_fd_sc_hd__dfrtp_1_60/a_761_289# VDPWR sky130_fd_pr__pfet_01v8_hvt ad=0.1176 pd=1.4 as=0.2583 ps=2.37 w=0.42 l=0.15
X4805 sky130_fd_sc_hd__dfrtp_1_60/a_1462_47# V3R298 VGND VGND sky130_fd_pr__nfet_01v8 ad=0 pd=0 as=0 ps=0 w=0.42 l=0.15
X4806 sky130_fd_sc_hd__dfrtp_1_60/a_543_47# sky130_fd_sc_hd__dfrtp_1_60/a_27_47# sky130_fd_sc_hd__dfrtp_1_60/a_448_47# VGND sky130_fd_pr__special_nfet_01v8 ad=0.1188 pd=1.38 as=0.132 ps=1.49 w=0.36 l=0.15
X4807 sky130_fd_sc_hd__dfrtp_1_60/a_543_47# sky130_fd_sc_hd__dfrtp_1_60/a_193_47# sky130_fd_sc_hd__dfrtp_1_60/a_448_47# VDPWR sky130_fd_pr__pfet_01v8_hvt ad=0 pd=0 as=0 ps=0 w=0.42 l=0.15
X4808 sky130_fd_sc_hd__dfrtp_1_60/a_448_47# V3R098 VGND VGND sky130_fd_pr__nfet_01v8 ad=0 pd=0 as=0 ps=0 w=0.42 l=0.15
X4809 VDPWR sky130_fd_sc_hd__dfrtp_1_60/a_1283_21# sky130_fd_sc_hd__dfrtp_1_60/a_1270_413# VDPWR sky130_fd_pr__pfet_01v8_hvt ad=0 pd=0 as=0.1134 ps=1.38 w=0.42 l=0.15
X4810 VDPWR sky130_fd_sc_hd__dfrtp_1_60/a_1108_47# sky130_fd_sc_hd__dfrtp_1_60/a_1283_21# VDPWR sky130_fd_pr__pfet_01v8_hvt ad=0 pd=0 as=0.1134 ps=1.38 w=0.42 l=0.15
X4811 sky130_fd_sc_hd__dfrtp_1_60/a_1270_413# sky130_fd_sc_hd__dfrtp_1_60/a_193_47# sky130_fd_sc_hd__dfrtp_1_60/a_1108_47# VDPWR sky130_fd_pr__pfet_01v8_hvt ad=0 pd=0 as=0 ps=0 w=0.42 l=0.15
X4812 sky130_fd_sc_hd__dfrtp_1_60/a_193_47# sky130_fd_sc_hd__dfrtp_1_60/a_27_47# VDPWR VDPWR sky130_fd_pr__pfet_01v8_hvt ad=0.1664 pd=1.8 as=0 ps=0 w=0.64 l=0.15
X4813 sky130_fd_sc_hd__dfrtp_1_60/a_1283_21# V3R298 VDPWR VDPWR sky130_fd_pr__pfet_01v8_hvt ad=0 pd=0 as=0 ps=0 w=0.42 l=0.15
X4814 VDPWR sky130_fd_sc_hd__dfrtp_1_60/a_761_289# sky130_fd_sc_hd__dfrtp_1_60/a_651_413# VDPWR sky130_fd_pr__pfet_01v8_hvt ad=0 pd=0 as=0 ps=0 w=0.42 l=0.15
X4815 V3R153 sky130_fd_sc_hd__dfrtp_1_60/a_1283_21# VGND VGND sky130_fd_pr__nfet_01v8 ad=0.169 pd=1.82 as=0 ps=0 w=0.65 l=0.15
X4816 sky130_fd_sc_hd__dfrtp_1_60/a_639_47# sky130_fd_sc_hd__dfrtp_1_60/a_193_47# sky130_fd_sc_hd__dfrtp_1_60/a_543_47# VGND sky130_fd_pr__special_nfet_01v8 ad=0 pd=0 as=0 ps=0 w=0.36 l=0.15
X4817 VGND sky130_fd_sc_hd__dfrtp_1_60/a_1283_21# sky130_fd_sc_hd__dfrtp_1_60/a_1217_47# VGND sky130_fd_pr__nfet_01v8 ad=0 pd=0 as=0 ps=0 w=0.42 l=0.15
X4818 sky130_fd_sc_hd__dfrtp_1_60/a_651_413# V3R298 VDPWR VDPWR sky130_fd_pr__pfet_01v8_hvt ad=0 pd=0 as=0 ps=0 w=0.42 l=0.15
X4819 VGND V3R055 sky130_fd_sc_hd__dfrtp_1_60/a_27_47# VGND sky130_fd_pr__nfet_01v8 ad=0 pd=0 as=0.1092 ps=1.36 w=0.42 l=0.15
X4820 sky130_fd_sc_hd__dfrtp_1_60/a_761_289# sky130_fd_sc_hd__dfrtp_1_60/a_543_47# VDPWR VDPWR sky130_fd_pr__pfet_01v8_hvt ad=0 pd=0 as=0 ps=0 w=0.84 l=0.15
X4821 V3R182 sky130_fd_sc_hd__xor2_1_11/a_35_297# sky130_fd_sc_hd__xor2_1_11/a_285_297# VDPWR sky130_fd_pr__pfet_01v8_hvt ad=0.3 pd=2.6 as=0.53 ps=5.06 w=1 l=0.15
X4822 V3R182 V3R000 sky130_fd_sc_hd__xor2_1_11/a_285_47# VGND sky130_fd_pr__nfet_01v8 ad=0.5005 pd=2.84 as=0.1755 ps=1.84 w=0.65 l=0.15
X4823 sky130_fd_sc_hd__xor2_1_11/a_35_297# V3R000 VGND VGND sky130_fd_pr__nfet_01v8 ad=0.1755 pd=1.84 as=0 ps=0 w=0.65 l=0.15
X4824 sky130_fd_sc_hd__xor2_1_11/a_117_297# V3R000 sky130_fd_sc_hd__xor2_1_11/a_35_297# VDPWR sky130_fd_pr__pfet_01v8_hvt ad=0.27 pd=2.54 as=0.26 ps=2.52 w=1 l=0.15
X4825 VDPWR V3R000 sky130_fd_sc_hd__xor2_1_11/a_285_297# VDPWR sky130_fd_pr__pfet_01v8_hvt ad=0 pd=0 as=0 ps=0 w=1 l=0.15
X4826 VGND V3R001 sky130_fd_sc_hd__xor2_1_11/a_35_297# VGND sky130_fd_pr__nfet_01v8 ad=0 pd=0 as=0 ps=0 w=0.65 l=0.15
X4827 VGND sky130_fd_sc_hd__xor2_1_11/a_35_297# V3R182 VGND sky130_fd_pr__nfet_01v8 ad=0 pd=0 as=0 ps=0 w=0.65 l=0.15
X4828 sky130_fd_sc_hd__xor2_1_11/a_285_297# V3R001 VDPWR VDPWR sky130_fd_pr__pfet_01v8_hvt ad=0 pd=0 as=0 ps=0 w=1 l=0.15
X4829 VDPWR V3R001 sky130_fd_sc_hd__xor2_1_11/a_117_297# VDPWR sky130_fd_pr__pfet_01v8_hvt ad=0 pd=0 as=0 ps=0 w=1 l=0.15
X4830 sky130_fd_sc_hd__xor2_1_11/a_285_47# V3R001 VGND VGND sky130_fd_pr__nfet_01v8 ad=0 pd=0 as=0 ps=0 w=0.65 l=0.15
X4831 sky130_fd_sc_hd__dfrtp_1_72/a_805_47# sky130_fd_sc_hd__dfrtp_1_72/a_761_289# sky130_fd_sc_hd__dfrtp_1_72/a_639_47# VGND sky130_fd_pr__nfet_01v8 ad=0.0882 pd=1.26 as=0.2802 ps=2.2 w=0.42 l=0.15
X4832 sky130_fd_sc_hd__dfrtp_1_72/a_1217_47# sky130_fd_sc_hd__dfrtp_1_72/a_27_47# sky130_fd_sc_hd__dfrtp_1_72/a_1108_47# VGND sky130_fd_pr__special_nfet_01v8 ad=0.1338 pd=1.5 as=0.1422 ps=1.51 w=0.36 l=0.15
X4833 sky130_fd_sc_hd__dfrtp_1_72/a_1283_21# sky130_fd_sc_hd__dfrtp_1_72/a_1108_47# sky130_fd_sc_hd__dfrtp_1_72/a_1462_47# VGND sky130_fd_pr__nfet_01v8 ad=0.1092 pd=1.36 as=0.1281 ps=1.45 w=0.42 l=0.15
X4834 sky130_fd_sc_hd__dfrtp_1_72/a_651_413# sky130_fd_sc_hd__dfrtp_1_72/a_27_47# sky130_fd_sc_hd__dfrtp_1_72/a_543_47# VDPWR sky130_fd_pr__pfet_01v8_hvt ad=0.3402 pd=3.3 as=0.1449 ps=1.53 w=0.42 l=0.15
X4835 sky130_fd_sc_hd__dfrtp_1_72/a_1108_47# sky130_fd_sc_hd__dfrtp_1_72/a_193_47# sky130_fd_sc_hd__dfrtp_1_72/a_761_289# VGND sky130_fd_pr__special_nfet_01v8 ad=0 pd=0 as=0.1998 ps=1.97 w=0.36 l=0.15
X4836 VGND V3R302 sky130_fd_sc_hd__dfrtp_1_72/a_805_47# VGND sky130_fd_pr__nfet_01v8 ad=0 pd=0 as=0 ps=0 w=0.42 l=0.15
X4837 V3R004 sky130_fd_sc_hd__dfrtp_1_72/a_1283_21# VDPWR VDPWR sky130_fd_pr__pfet_01v8_hvt ad=0.26 pd=2.52 as=0 ps=0 w=1 l=0.15
X4838 VDPWR V3R083 sky130_fd_sc_hd__dfrtp_1_72/a_27_47# VDPWR sky130_fd_pr__pfet_01v8_hvt ad=0 pd=0 as=0.1664 ps=1.8 w=0.64 l=0.15
X4839 sky130_fd_sc_hd__dfrtp_1_72/a_448_47# V3R188 VDPWR VDPWR sky130_fd_pr__pfet_01v8_hvt ad=0.1302 pd=1.46 as=0 ps=0 w=0.42 l=0.15
X4840 sky130_fd_sc_hd__dfrtp_1_72/a_761_289# sky130_fd_sc_hd__dfrtp_1_72/a_543_47# VGND VGND sky130_fd_pr__nfet_01v8 ad=0 pd=0 as=0 ps=0 w=0.64 l=0.15
X4841 sky130_fd_sc_hd__dfrtp_1_72/a_193_47# sky130_fd_sc_hd__dfrtp_1_72/a_27_47# VGND VGND sky130_fd_pr__nfet_01v8 ad=0.1092 pd=1.36 as=0 ps=0 w=0.42 l=0.15
X4842 sky130_fd_sc_hd__dfrtp_1_72/a_1108_47# sky130_fd_sc_hd__dfrtp_1_72/a_27_47# sky130_fd_sc_hd__dfrtp_1_72/a_761_289# VDPWR sky130_fd_pr__pfet_01v8_hvt ad=0.1176 pd=1.4 as=0.2583 ps=2.37 w=0.42 l=0.15
X4843 sky130_fd_sc_hd__dfrtp_1_72/a_1462_47# V3R302 VGND VGND sky130_fd_pr__nfet_01v8 ad=0 pd=0 as=0 ps=0 w=0.42 l=0.15
X4844 sky130_fd_sc_hd__dfrtp_1_72/a_543_47# sky130_fd_sc_hd__dfrtp_1_72/a_27_47# sky130_fd_sc_hd__dfrtp_1_72/a_448_47# VGND sky130_fd_pr__special_nfet_01v8 ad=0.1188 pd=1.38 as=0.132 ps=1.49 w=0.36 l=0.15
X4845 sky130_fd_sc_hd__dfrtp_1_72/a_543_47# sky130_fd_sc_hd__dfrtp_1_72/a_193_47# sky130_fd_sc_hd__dfrtp_1_72/a_448_47# VDPWR sky130_fd_pr__pfet_01v8_hvt ad=0 pd=0 as=0 ps=0 w=0.42 l=0.15
X4846 sky130_fd_sc_hd__dfrtp_1_72/a_448_47# V3R188 VGND VGND sky130_fd_pr__nfet_01v8 ad=0 pd=0 as=0 ps=0 w=0.42 l=0.15
X4847 VDPWR sky130_fd_sc_hd__dfrtp_1_72/a_1283_21# sky130_fd_sc_hd__dfrtp_1_72/a_1270_413# VDPWR sky130_fd_pr__pfet_01v8_hvt ad=0 pd=0 as=0.1134 ps=1.38 w=0.42 l=0.15
X4848 VDPWR sky130_fd_sc_hd__dfrtp_1_72/a_1108_47# sky130_fd_sc_hd__dfrtp_1_72/a_1283_21# VDPWR sky130_fd_pr__pfet_01v8_hvt ad=0 pd=0 as=0.1134 ps=1.38 w=0.42 l=0.15
X4849 sky130_fd_sc_hd__dfrtp_1_72/a_1270_413# sky130_fd_sc_hd__dfrtp_1_72/a_193_47# sky130_fd_sc_hd__dfrtp_1_72/a_1108_47# VDPWR sky130_fd_pr__pfet_01v8_hvt ad=0 pd=0 as=0 ps=0 w=0.42 l=0.15
X4850 sky130_fd_sc_hd__dfrtp_1_72/a_193_47# sky130_fd_sc_hd__dfrtp_1_72/a_27_47# VDPWR VDPWR sky130_fd_pr__pfet_01v8_hvt ad=0.1664 pd=1.8 as=0 ps=0 w=0.64 l=0.15
X4851 sky130_fd_sc_hd__dfrtp_1_72/a_1283_21# V3R302 VDPWR VDPWR sky130_fd_pr__pfet_01v8_hvt ad=0 pd=0 as=0 ps=0 w=0.42 l=0.15
X4852 VDPWR sky130_fd_sc_hd__dfrtp_1_72/a_761_289# sky130_fd_sc_hd__dfrtp_1_72/a_651_413# VDPWR sky130_fd_pr__pfet_01v8_hvt ad=0 pd=0 as=0 ps=0 w=0.42 l=0.15
X4853 V3R004 sky130_fd_sc_hd__dfrtp_1_72/a_1283_21# VGND VGND sky130_fd_pr__nfet_01v8 ad=0.169 pd=1.82 as=0 ps=0 w=0.65 l=0.15
X4854 sky130_fd_sc_hd__dfrtp_1_72/a_639_47# sky130_fd_sc_hd__dfrtp_1_72/a_193_47# sky130_fd_sc_hd__dfrtp_1_72/a_543_47# VGND sky130_fd_pr__special_nfet_01v8 ad=0 pd=0 as=0 ps=0 w=0.36 l=0.15
X4855 VGND sky130_fd_sc_hd__dfrtp_1_72/a_1283_21# sky130_fd_sc_hd__dfrtp_1_72/a_1217_47# VGND sky130_fd_pr__nfet_01v8 ad=0 pd=0 as=0 ps=0 w=0.42 l=0.15
X4856 sky130_fd_sc_hd__dfrtp_1_72/a_651_413# V3R302 VDPWR VDPWR sky130_fd_pr__pfet_01v8_hvt ad=0 pd=0 as=0 ps=0 w=0.42 l=0.15
X4857 VGND V3R083 sky130_fd_sc_hd__dfrtp_1_72/a_27_47# VGND sky130_fd_pr__nfet_01v8 ad=0 pd=0 as=0.1092 ps=1.36 w=0.42 l=0.15
X4858 sky130_fd_sc_hd__dfrtp_1_72/a_761_289# sky130_fd_sc_hd__dfrtp_1_72/a_543_47# VDPWR VDPWR sky130_fd_pr__pfet_01v8_hvt ad=0 pd=0 as=0 ps=0 w=0.84 l=0.15
X4859 sky130_fd_sc_hd__dfrtp_1_83/a_805_47# sky130_fd_sc_hd__dfrtp_1_83/a_761_289# sky130_fd_sc_hd__dfrtp_1_83/a_639_47# VGND sky130_fd_pr__nfet_01v8 ad=0.0882 pd=1.26 as=0.2802 ps=2.2 w=0.42 l=0.15
X4860 sky130_fd_sc_hd__dfrtp_1_83/a_1217_47# sky130_fd_sc_hd__dfrtp_1_83/a_27_47# sky130_fd_sc_hd__dfrtp_1_83/a_1108_47# VGND sky130_fd_pr__special_nfet_01v8 ad=0.1338 pd=1.5 as=0.1422 ps=1.51 w=0.36 l=0.15
X4861 sky130_fd_sc_hd__dfrtp_1_83/a_1283_21# sky130_fd_sc_hd__dfrtp_1_83/a_1108_47# sky130_fd_sc_hd__dfrtp_1_83/a_1462_47# VGND sky130_fd_pr__nfet_01v8 ad=0.1092 pd=1.36 as=0.1281 ps=1.45 w=0.42 l=0.15
X4862 sky130_fd_sc_hd__dfrtp_1_83/a_651_413# sky130_fd_sc_hd__dfrtp_1_83/a_27_47# sky130_fd_sc_hd__dfrtp_1_83/a_543_47# VDPWR sky130_fd_pr__pfet_01v8_hvt ad=0.3402 pd=3.3 as=0.1449 ps=1.53 w=0.42 l=0.15
X4863 sky130_fd_sc_hd__dfrtp_1_83/a_1108_47# sky130_fd_sc_hd__dfrtp_1_83/a_193_47# sky130_fd_sc_hd__dfrtp_1_83/a_761_289# VGND sky130_fd_pr__special_nfet_01v8 ad=0 pd=0 as=0.1998 ps=1.97 w=0.36 l=0.15
X4864 VGND V3R298 sky130_fd_sc_hd__dfrtp_1_83/a_805_47# VGND sky130_fd_pr__nfet_01v8 ad=0 pd=0 as=0 ps=0 w=0.42 l=0.15
X4865 V3R172 sky130_fd_sc_hd__dfrtp_1_83/a_1283_21# VDPWR VDPWR sky130_fd_pr__pfet_01v8_hvt ad=0.26 pd=2.52 as=0 ps=0 w=1 l=0.15
X4866 VDPWR V3R055 sky130_fd_sc_hd__dfrtp_1_83/a_27_47# VDPWR sky130_fd_pr__pfet_01v8_hvt ad=0 pd=0 as=0.1664 ps=1.8 w=0.64 l=0.15
X4867 sky130_fd_sc_hd__dfrtp_1_83/a_448_47# V3R088 VDPWR VDPWR sky130_fd_pr__pfet_01v8_hvt ad=0.1302 pd=1.46 as=0 ps=0 w=0.42 l=0.15
X4868 sky130_fd_sc_hd__dfrtp_1_83/a_761_289# sky130_fd_sc_hd__dfrtp_1_83/a_543_47# VGND VGND sky130_fd_pr__nfet_01v8 ad=0 pd=0 as=0 ps=0 w=0.64 l=0.15
X4869 sky130_fd_sc_hd__dfrtp_1_83/a_193_47# sky130_fd_sc_hd__dfrtp_1_83/a_27_47# VGND VGND sky130_fd_pr__nfet_01v8 ad=0.1092 pd=1.36 as=0 ps=0 w=0.42 l=0.15
X4870 sky130_fd_sc_hd__dfrtp_1_83/a_1108_47# sky130_fd_sc_hd__dfrtp_1_83/a_27_47# sky130_fd_sc_hd__dfrtp_1_83/a_761_289# VDPWR sky130_fd_pr__pfet_01v8_hvt ad=0.1176 pd=1.4 as=0.2583 ps=2.37 w=0.42 l=0.15
X4871 sky130_fd_sc_hd__dfrtp_1_83/a_1462_47# V3R298 VGND VGND sky130_fd_pr__nfet_01v8 ad=0 pd=0 as=0 ps=0 w=0.42 l=0.15
X4872 sky130_fd_sc_hd__dfrtp_1_83/a_543_47# sky130_fd_sc_hd__dfrtp_1_83/a_27_47# sky130_fd_sc_hd__dfrtp_1_83/a_448_47# VGND sky130_fd_pr__special_nfet_01v8 ad=0.1188 pd=1.38 as=0.132 ps=1.49 w=0.36 l=0.15
X4873 sky130_fd_sc_hd__dfrtp_1_83/a_543_47# sky130_fd_sc_hd__dfrtp_1_83/a_193_47# sky130_fd_sc_hd__dfrtp_1_83/a_448_47# VDPWR sky130_fd_pr__pfet_01v8_hvt ad=0 pd=0 as=0 ps=0 w=0.42 l=0.15
X4874 sky130_fd_sc_hd__dfrtp_1_83/a_448_47# V3R088 VGND VGND sky130_fd_pr__nfet_01v8 ad=0 pd=0 as=0 ps=0 w=0.42 l=0.15
X4875 VDPWR sky130_fd_sc_hd__dfrtp_1_83/a_1283_21# sky130_fd_sc_hd__dfrtp_1_83/a_1270_413# VDPWR sky130_fd_pr__pfet_01v8_hvt ad=0 pd=0 as=0.1134 ps=1.38 w=0.42 l=0.15
X4876 VDPWR sky130_fd_sc_hd__dfrtp_1_83/a_1108_47# sky130_fd_sc_hd__dfrtp_1_83/a_1283_21# VDPWR sky130_fd_pr__pfet_01v8_hvt ad=0 pd=0 as=0.1134 ps=1.38 w=0.42 l=0.15
X4877 sky130_fd_sc_hd__dfrtp_1_83/a_1270_413# sky130_fd_sc_hd__dfrtp_1_83/a_193_47# sky130_fd_sc_hd__dfrtp_1_83/a_1108_47# VDPWR sky130_fd_pr__pfet_01v8_hvt ad=0 pd=0 as=0 ps=0 w=0.42 l=0.15
X4878 sky130_fd_sc_hd__dfrtp_1_83/a_193_47# sky130_fd_sc_hd__dfrtp_1_83/a_27_47# VDPWR VDPWR sky130_fd_pr__pfet_01v8_hvt ad=0.1664 pd=1.8 as=0 ps=0 w=0.64 l=0.15
X4879 sky130_fd_sc_hd__dfrtp_1_83/a_1283_21# V3R298 VDPWR VDPWR sky130_fd_pr__pfet_01v8_hvt ad=0 pd=0 as=0 ps=0 w=0.42 l=0.15
X4880 VDPWR sky130_fd_sc_hd__dfrtp_1_83/a_761_289# sky130_fd_sc_hd__dfrtp_1_83/a_651_413# VDPWR sky130_fd_pr__pfet_01v8_hvt ad=0 pd=0 as=0 ps=0 w=0.42 l=0.15
X4881 V3R172 sky130_fd_sc_hd__dfrtp_1_83/a_1283_21# VGND VGND sky130_fd_pr__nfet_01v8 ad=0.169 pd=1.82 as=0 ps=0 w=0.65 l=0.15
X4882 sky130_fd_sc_hd__dfrtp_1_83/a_639_47# sky130_fd_sc_hd__dfrtp_1_83/a_193_47# sky130_fd_sc_hd__dfrtp_1_83/a_543_47# VGND sky130_fd_pr__special_nfet_01v8 ad=0 pd=0 as=0 ps=0 w=0.36 l=0.15
X4883 VGND sky130_fd_sc_hd__dfrtp_1_83/a_1283_21# sky130_fd_sc_hd__dfrtp_1_83/a_1217_47# VGND sky130_fd_pr__nfet_01v8 ad=0 pd=0 as=0 ps=0 w=0.42 l=0.15
X4884 sky130_fd_sc_hd__dfrtp_1_83/a_651_413# V3R298 VDPWR VDPWR sky130_fd_pr__pfet_01v8_hvt ad=0 pd=0 as=0 ps=0 w=0.42 l=0.15
X4885 VGND V3R055 sky130_fd_sc_hd__dfrtp_1_83/a_27_47# VGND sky130_fd_pr__nfet_01v8 ad=0 pd=0 as=0.1092 ps=1.36 w=0.42 l=0.15
X4886 sky130_fd_sc_hd__dfrtp_1_83/a_761_289# sky130_fd_sc_hd__dfrtp_1_83/a_543_47# VDPWR VDPWR sky130_fd_pr__pfet_01v8_hvt ad=0 pd=0 as=0 ps=0 w=0.84 l=0.15
X4887 sky130_fd_sc_hd__dfrtp_1_61/a_805_47# sky130_fd_sc_hd__dfrtp_1_61/a_761_289# sky130_fd_sc_hd__dfrtp_1_61/a_639_47# VGND sky130_fd_pr__nfet_01v8 ad=0.0882 pd=1.26 as=0.2802 ps=2.2 w=0.42 l=0.15
X4888 sky130_fd_sc_hd__dfrtp_1_61/a_1217_47# sky130_fd_sc_hd__dfrtp_1_61/a_27_47# sky130_fd_sc_hd__dfrtp_1_61/a_1108_47# VGND sky130_fd_pr__special_nfet_01v8 ad=0.1338 pd=1.5 as=0.1422 ps=1.51 w=0.36 l=0.15
X4889 sky130_fd_sc_hd__dfrtp_1_61/a_1283_21# sky130_fd_sc_hd__dfrtp_1_61/a_1108_47# sky130_fd_sc_hd__dfrtp_1_61/a_1462_47# VGND sky130_fd_pr__nfet_01v8 ad=0.1092 pd=1.36 as=0.1281 ps=1.45 w=0.42 l=0.15
X4890 sky130_fd_sc_hd__dfrtp_1_61/a_651_413# sky130_fd_sc_hd__dfrtp_1_61/a_27_47# sky130_fd_sc_hd__dfrtp_1_61/a_543_47# VDPWR sky130_fd_pr__pfet_01v8_hvt ad=0.3402 pd=3.3 as=0.1449 ps=1.53 w=0.42 l=0.15
X4891 sky130_fd_sc_hd__dfrtp_1_61/a_1108_47# sky130_fd_sc_hd__dfrtp_1_61/a_193_47# sky130_fd_sc_hd__dfrtp_1_61/a_761_289# VGND sky130_fd_pr__special_nfet_01v8 ad=0 pd=0 as=0.1998 ps=1.97 w=0.36 l=0.15
X4892 VGND V3R300 sky130_fd_sc_hd__dfrtp_1_61/a_805_47# VGND sky130_fd_pr__nfet_01v8 ad=0 pd=0 as=0 ps=0 w=0.42 l=0.15
X4893 V3R014 sky130_fd_sc_hd__dfrtp_1_61/a_1283_21# VDPWR VDPWR sky130_fd_pr__pfet_01v8_hvt ad=0.26 pd=2.52 as=0 ps=0 w=1 l=0.15
X4894 VDPWR V3R081 sky130_fd_sc_hd__dfrtp_1_61/a_27_47# VDPWR sky130_fd_pr__pfet_01v8_hvt ad=0 pd=0 as=0.1664 ps=1.8 w=0.64 l=0.15
X4895 sky130_fd_sc_hd__dfrtp_1_61/a_448_47# V3R130 VDPWR VDPWR sky130_fd_pr__pfet_01v8_hvt ad=0.1302 pd=1.46 as=0 ps=0 w=0.42 l=0.15
X4896 sky130_fd_sc_hd__dfrtp_1_61/a_761_289# sky130_fd_sc_hd__dfrtp_1_61/a_543_47# VGND VGND sky130_fd_pr__nfet_01v8 ad=0 pd=0 as=0 ps=0 w=0.64 l=0.15
X4897 sky130_fd_sc_hd__dfrtp_1_61/a_193_47# sky130_fd_sc_hd__dfrtp_1_61/a_27_47# VGND VGND sky130_fd_pr__nfet_01v8 ad=0.1092 pd=1.36 as=0 ps=0 w=0.42 l=0.15
X4898 sky130_fd_sc_hd__dfrtp_1_61/a_1108_47# sky130_fd_sc_hd__dfrtp_1_61/a_27_47# sky130_fd_sc_hd__dfrtp_1_61/a_761_289# VDPWR sky130_fd_pr__pfet_01v8_hvt ad=0.1176 pd=1.4 as=0.2583 ps=2.37 w=0.42 l=0.15
X4899 sky130_fd_sc_hd__dfrtp_1_61/a_1462_47# V3R300 VGND VGND sky130_fd_pr__nfet_01v8 ad=0 pd=0 as=0 ps=0 w=0.42 l=0.15
X4900 sky130_fd_sc_hd__dfrtp_1_61/a_543_47# sky130_fd_sc_hd__dfrtp_1_61/a_27_47# sky130_fd_sc_hd__dfrtp_1_61/a_448_47# VGND sky130_fd_pr__special_nfet_01v8 ad=0.1188 pd=1.38 as=0.132 ps=1.49 w=0.36 l=0.15
X4901 sky130_fd_sc_hd__dfrtp_1_61/a_543_47# sky130_fd_sc_hd__dfrtp_1_61/a_193_47# sky130_fd_sc_hd__dfrtp_1_61/a_448_47# VDPWR sky130_fd_pr__pfet_01v8_hvt ad=0 pd=0 as=0 ps=0 w=0.42 l=0.15
X4902 sky130_fd_sc_hd__dfrtp_1_61/a_448_47# V3R130 VGND VGND sky130_fd_pr__nfet_01v8 ad=0 pd=0 as=0 ps=0 w=0.42 l=0.15
X4903 VDPWR sky130_fd_sc_hd__dfrtp_1_61/a_1283_21# sky130_fd_sc_hd__dfrtp_1_61/a_1270_413# VDPWR sky130_fd_pr__pfet_01v8_hvt ad=0 pd=0 as=0.1134 ps=1.38 w=0.42 l=0.15
X4904 VDPWR sky130_fd_sc_hd__dfrtp_1_61/a_1108_47# sky130_fd_sc_hd__dfrtp_1_61/a_1283_21# VDPWR sky130_fd_pr__pfet_01v8_hvt ad=0 pd=0 as=0.1134 ps=1.38 w=0.42 l=0.15
X4905 sky130_fd_sc_hd__dfrtp_1_61/a_1270_413# sky130_fd_sc_hd__dfrtp_1_61/a_193_47# sky130_fd_sc_hd__dfrtp_1_61/a_1108_47# VDPWR sky130_fd_pr__pfet_01v8_hvt ad=0 pd=0 as=0 ps=0 w=0.42 l=0.15
X4906 sky130_fd_sc_hd__dfrtp_1_61/a_193_47# sky130_fd_sc_hd__dfrtp_1_61/a_27_47# VDPWR VDPWR sky130_fd_pr__pfet_01v8_hvt ad=0.1664 pd=1.8 as=0 ps=0 w=0.64 l=0.15
X4907 sky130_fd_sc_hd__dfrtp_1_61/a_1283_21# V3R300 VDPWR VDPWR sky130_fd_pr__pfet_01v8_hvt ad=0 pd=0 as=0 ps=0 w=0.42 l=0.15
X4908 VDPWR sky130_fd_sc_hd__dfrtp_1_61/a_761_289# sky130_fd_sc_hd__dfrtp_1_61/a_651_413# VDPWR sky130_fd_pr__pfet_01v8_hvt ad=0 pd=0 as=0 ps=0 w=0.42 l=0.15
X4909 V3R014 sky130_fd_sc_hd__dfrtp_1_61/a_1283_21# VGND VGND sky130_fd_pr__nfet_01v8 ad=0.169 pd=1.82 as=0 ps=0 w=0.65 l=0.15
X4910 sky130_fd_sc_hd__dfrtp_1_61/a_639_47# sky130_fd_sc_hd__dfrtp_1_61/a_193_47# sky130_fd_sc_hd__dfrtp_1_61/a_543_47# VGND sky130_fd_pr__special_nfet_01v8 ad=0 pd=0 as=0 ps=0 w=0.36 l=0.15
X4911 VGND sky130_fd_sc_hd__dfrtp_1_61/a_1283_21# sky130_fd_sc_hd__dfrtp_1_61/a_1217_47# VGND sky130_fd_pr__nfet_01v8 ad=0 pd=0 as=0 ps=0 w=0.42 l=0.15
X4912 sky130_fd_sc_hd__dfrtp_1_61/a_651_413# V3R300 VDPWR VDPWR sky130_fd_pr__pfet_01v8_hvt ad=0 pd=0 as=0 ps=0 w=0.42 l=0.15
X4913 VGND V3R081 sky130_fd_sc_hd__dfrtp_1_61/a_27_47# VGND sky130_fd_pr__nfet_01v8 ad=0 pd=0 as=0.1092 ps=1.36 w=0.42 l=0.15
X4914 sky130_fd_sc_hd__dfrtp_1_61/a_761_289# sky130_fd_sc_hd__dfrtp_1_61/a_543_47# VDPWR VDPWR sky130_fd_pr__pfet_01v8_hvt ad=0 pd=0 as=0 ps=0 w=0.84 l=0.15
X4915 sky130_fd_sc_hd__dfrtp_1_50/a_805_47# sky130_fd_sc_hd__dfrtp_1_50/a_761_289# sky130_fd_sc_hd__dfrtp_1_50/a_639_47# VGND sky130_fd_pr__nfet_01v8 ad=0.0882 pd=1.26 as=0.2802 ps=2.2 w=0.42 l=0.15
X4916 sky130_fd_sc_hd__dfrtp_1_50/a_1217_47# sky130_fd_sc_hd__dfrtp_1_50/a_27_47# sky130_fd_sc_hd__dfrtp_1_50/a_1108_47# VGND sky130_fd_pr__special_nfet_01v8 ad=0.1338 pd=1.5 as=0.1422 ps=1.51 w=0.36 l=0.15
X4917 sky130_fd_sc_hd__dfrtp_1_50/a_1283_21# sky130_fd_sc_hd__dfrtp_1_50/a_1108_47# sky130_fd_sc_hd__dfrtp_1_50/a_1462_47# VGND sky130_fd_pr__nfet_01v8 ad=0.1092 pd=1.36 as=0.1281 ps=1.45 w=0.42 l=0.15
X4918 sky130_fd_sc_hd__dfrtp_1_50/a_651_413# sky130_fd_sc_hd__dfrtp_1_50/a_27_47# sky130_fd_sc_hd__dfrtp_1_50/a_543_47# VDPWR sky130_fd_pr__pfet_01v8_hvt ad=0.3402 pd=3.3 as=0.1449 ps=1.53 w=0.42 l=0.15
X4919 sky130_fd_sc_hd__dfrtp_1_50/a_1108_47# sky130_fd_sc_hd__dfrtp_1_50/a_193_47# sky130_fd_sc_hd__dfrtp_1_50/a_761_289# VGND sky130_fd_pr__special_nfet_01v8 ad=0 pd=0 as=0.1998 ps=1.97 w=0.36 l=0.15
X4920 VGND V3R301 sky130_fd_sc_hd__dfrtp_1_50/a_805_47# VGND sky130_fd_pr__nfet_01v8 ad=0 pd=0 as=0 ps=0 w=0.42 l=0.15
X4921 V3R018 sky130_fd_sc_hd__dfrtp_1_50/a_1283_21# VDPWR VDPWR sky130_fd_pr__pfet_01v8_hvt ad=0.26 pd=2.52 as=0 ps=0 w=1 l=0.15
X4922 VDPWR V3R082 sky130_fd_sc_hd__dfrtp_1_50/a_27_47# VDPWR sky130_fd_pr__pfet_01v8_hvt ad=0 pd=0 as=0.1664 ps=1.8 w=0.64 l=0.15
X4923 sky130_fd_sc_hd__dfrtp_1_50/a_448_47# V3R134 VDPWR VDPWR sky130_fd_pr__pfet_01v8_hvt ad=0.1302 pd=1.46 as=0 ps=0 w=0.42 l=0.15
X4924 sky130_fd_sc_hd__dfrtp_1_50/a_761_289# sky130_fd_sc_hd__dfrtp_1_50/a_543_47# VGND VGND sky130_fd_pr__nfet_01v8 ad=0 pd=0 as=0 ps=0 w=0.64 l=0.15
X4925 sky130_fd_sc_hd__dfrtp_1_50/a_193_47# sky130_fd_sc_hd__dfrtp_1_50/a_27_47# VGND VGND sky130_fd_pr__nfet_01v8 ad=0.1092 pd=1.36 as=0 ps=0 w=0.42 l=0.15
X4926 sky130_fd_sc_hd__dfrtp_1_50/a_1108_47# sky130_fd_sc_hd__dfrtp_1_50/a_27_47# sky130_fd_sc_hd__dfrtp_1_50/a_761_289# VDPWR sky130_fd_pr__pfet_01v8_hvt ad=0.1176 pd=1.4 as=0.2583 ps=2.37 w=0.42 l=0.15
X4927 sky130_fd_sc_hd__dfrtp_1_50/a_1462_47# V3R301 VGND VGND sky130_fd_pr__nfet_01v8 ad=0 pd=0 as=0 ps=0 w=0.42 l=0.15
X4928 sky130_fd_sc_hd__dfrtp_1_50/a_543_47# sky130_fd_sc_hd__dfrtp_1_50/a_27_47# sky130_fd_sc_hd__dfrtp_1_50/a_448_47# VGND sky130_fd_pr__special_nfet_01v8 ad=0.1188 pd=1.38 as=0.132 ps=1.49 w=0.36 l=0.15
X4929 sky130_fd_sc_hd__dfrtp_1_50/a_543_47# sky130_fd_sc_hd__dfrtp_1_50/a_193_47# sky130_fd_sc_hd__dfrtp_1_50/a_448_47# VDPWR sky130_fd_pr__pfet_01v8_hvt ad=0 pd=0 as=0 ps=0 w=0.42 l=0.15
X4930 sky130_fd_sc_hd__dfrtp_1_50/a_448_47# V3R134 VGND VGND sky130_fd_pr__nfet_01v8 ad=0 pd=0 as=0 ps=0 w=0.42 l=0.15
X4931 VDPWR sky130_fd_sc_hd__dfrtp_1_50/a_1283_21# sky130_fd_sc_hd__dfrtp_1_50/a_1270_413# VDPWR sky130_fd_pr__pfet_01v8_hvt ad=0 pd=0 as=0.1134 ps=1.38 w=0.42 l=0.15
X4932 VDPWR sky130_fd_sc_hd__dfrtp_1_50/a_1108_47# sky130_fd_sc_hd__dfrtp_1_50/a_1283_21# VDPWR sky130_fd_pr__pfet_01v8_hvt ad=0 pd=0 as=0.1134 ps=1.38 w=0.42 l=0.15
X4933 sky130_fd_sc_hd__dfrtp_1_50/a_1270_413# sky130_fd_sc_hd__dfrtp_1_50/a_193_47# sky130_fd_sc_hd__dfrtp_1_50/a_1108_47# VDPWR sky130_fd_pr__pfet_01v8_hvt ad=0 pd=0 as=0 ps=0 w=0.42 l=0.15
X4934 sky130_fd_sc_hd__dfrtp_1_50/a_193_47# sky130_fd_sc_hd__dfrtp_1_50/a_27_47# VDPWR VDPWR sky130_fd_pr__pfet_01v8_hvt ad=0.1664 pd=1.8 as=0 ps=0 w=0.64 l=0.15
X4935 sky130_fd_sc_hd__dfrtp_1_50/a_1283_21# V3R301 VDPWR VDPWR sky130_fd_pr__pfet_01v8_hvt ad=0 pd=0 as=0 ps=0 w=0.42 l=0.15
X4936 VDPWR sky130_fd_sc_hd__dfrtp_1_50/a_761_289# sky130_fd_sc_hd__dfrtp_1_50/a_651_413# VDPWR sky130_fd_pr__pfet_01v8_hvt ad=0 pd=0 as=0 ps=0 w=0.42 l=0.15
X4937 V3R018 sky130_fd_sc_hd__dfrtp_1_50/a_1283_21# VGND VGND sky130_fd_pr__nfet_01v8 ad=0.169 pd=1.82 as=0 ps=0 w=0.65 l=0.15
X4938 sky130_fd_sc_hd__dfrtp_1_50/a_639_47# sky130_fd_sc_hd__dfrtp_1_50/a_193_47# sky130_fd_sc_hd__dfrtp_1_50/a_543_47# VGND sky130_fd_pr__special_nfet_01v8 ad=0 pd=0 as=0 ps=0 w=0.36 l=0.15
X4939 VGND sky130_fd_sc_hd__dfrtp_1_50/a_1283_21# sky130_fd_sc_hd__dfrtp_1_50/a_1217_47# VGND sky130_fd_pr__nfet_01v8 ad=0 pd=0 as=0 ps=0 w=0.42 l=0.15
X4940 sky130_fd_sc_hd__dfrtp_1_50/a_651_413# V3R301 VDPWR VDPWR sky130_fd_pr__pfet_01v8_hvt ad=0 pd=0 as=0 ps=0 w=0.42 l=0.15
X4941 VGND V3R082 sky130_fd_sc_hd__dfrtp_1_50/a_27_47# VGND sky130_fd_pr__nfet_01v8 ad=0 pd=0 as=0.1092 ps=1.36 w=0.42 l=0.15
X4942 sky130_fd_sc_hd__dfrtp_1_50/a_761_289# sky130_fd_sc_hd__dfrtp_1_50/a_543_47# VDPWR VDPWR sky130_fd_pr__pfet_01v8_hvt ad=0 pd=0 as=0 ps=0 w=0.84 l=0.15
X4943 sky130_fd_sc_hd__dfrtp_1_62/a_805_47# sky130_fd_sc_hd__dfrtp_1_62/a_761_289# sky130_fd_sc_hd__dfrtp_1_62/a_639_47# VGND sky130_fd_pr__nfet_01v8 ad=0.0882 pd=1.26 as=0.2802 ps=2.2 w=0.42 l=0.15
X4944 sky130_fd_sc_hd__dfrtp_1_62/a_1217_47# sky130_fd_sc_hd__dfrtp_1_62/a_27_47# sky130_fd_sc_hd__dfrtp_1_62/a_1108_47# VGND sky130_fd_pr__special_nfet_01v8 ad=0.1338 pd=1.5 as=0.1422 ps=1.51 w=0.36 l=0.15
X4945 sky130_fd_sc_hd__dfrtp_1_62/a_1283_21# sky130_fd_sc_hd__dfrtp_1_62/a_1108_47# sky130_fd_sc_hd__dfrtp_1_62/a_1462_47# VGND sky130_fd_pr__nfet_01v8 ad=0.1092 pd=1.36 as=0.1281 ps=1.45 w=0.42 l=0.15
X4946 sky130_fd_sc_hd__dfrtp_1_62/a_651_413# sky130_fd_sc_hd__dfrtp_1_62/a_27_47# sky130_fd_sc_hd__dfrtp_1_62/a_543_47# VDPWR sky130_fd_pr__pfet_01v8_hvt ad=0.3402 pd=3.3 as=0.1449 ps=1.53 w=0.42 l=0.15
X4947 sky130_fd_sc_hd__dfrtp_1_62/a_1108_47# sky130_fd_sc_hd__dfrtp_1_62/a_193_47# sky130_fd_sc_hd__dfrtp_1_62/a_761_289# VGND sky130_fd_pr__special_nfet_01v8 ad=0 pd=0 as=0.1998 ps=1.97 w=0.36 l=0.15
X4948 VGND V3R298 sky130_fd_sc_hd__dfrtp_1_62/a_805_47# VGND sky130_fd_pr__nfet_01v8 ad=0 pd=0 as=0 ps=0 w=0.42 l=0.15
X4949 V3R154 sky130_fd_sc_hd__dfrtp_1_62/a_1283_21# VDPWR VDPWR sky130_fd_pr__pfet_01v8_hvt ad=0.26 pd=2.52 as=0 ps=0 w=1 l=0.15
X4950 VDPWR V3R055 sky130_fd_sc_hd__dfrtp_1_62/a_27_47# VDPWR sky130_fd_pr__pfet_01v8_hvt ad=0 pd=0 as=0.1664 ps=1.8 w=0.64 l=0.15
X4951 sky130_fd_sc_hd__dfrtp_1_62/a_448_47# V3R099 VDPWR VDPWR sky130_fd_pr__pfet_01v8_hvt ad=0.1302 pd=1.46 as=0 ps=0 w=0.42 l=0.15
X4952 sky130_fd_sc_hd__dfrtp_1_62/a_761_289# sky130_fd_sc_hd__dfrtp_1_62/a_543_47# VGND VGND sky130_fd_pr__nfet_01v8 ad=0 pd=0 as=0 ps=0 w=0.64 l=0.15
X4953 sky130_fd_sc_hd__dfrtp_1_62/a_193_47# sky130_fd_sc_hd__dfrtp_1_62/a_27_47# VGND VGND sky130_fd_pr__nfet_01v8 ad=0.1092 pd=1.36 as=0 ps=0 w=0.42 l=0.15
X4954 sky130_fd_sc_hd__dfrtp_1_62/a_1108_47# sky130_fd_sc_hd__dfrtp_1_62/a_27_47# sky130_fd_sc_hd__dfrtp_1_62/a_761_289# VDPWR sky130_fd_pr__pfet_01v8_hvt ad=0.1176 pd=1.4 as=0.2583 ps=2.37 w=0.42 l=0.15
X4955 sky130_fd_sc_hd__dfrtp_1_62/a_1462_47# V3R298 VGND VGND sky130_fd_pr__nfet_01v8 ad=0 pd=0 as=0 ps=0 w=0.42 l=0.15
X4956 sky130_fd_sc_hd__dfrtp_1_62/a_543_47# sky130_fd_sc_hd__dfrtp_1_62/a_27_47# sky130_fd_sc_hd__dfrtp_1_62/a_448_47# VGND sky130_fd_pr__special_nfet_01v8 ad=0.1188 pd=1.38 as=0.132 ps=1.49 w=0.36 l=0.15
X4957 sky130_fd_sc_hd__dfrtp_1_62/a_543_47# sky130_fd_sc_hd__dfrtp_1_62/a_193_47# sky130_fd_sc_hd__dfrtp_1_62/a_448_47# VDPWR sky130_fd_pr__pfet_01v8_hvt ad=0 pd=0 as=0 ps=0 w=0.42 l=0.15
X4958 sky130_fd_sc_hd__dfrtp_1_62/a_448_47# V3R099 VGND VGND sky130_fd_pr__nfet_01v8 ad=0 pd=0 as=0 ps=0 w=0.42 l=0.15
X4959 VDPWR sky130_fd_sc_hd__dfrtp_1_62/a_1283_21# sky130_fd_sc_hd__dfrtp_1_62/a_1270_413# VDPWR sky130_fd_pr__pfet_01v8_hvt ad=0 pd=0 as=0.1134 ps=1.38 w=0.42 l=0.15
X4960 VDPWR sky130_fd_sc_hd__dfrtp_1_62/a_1108_47# sky130_fd_sc_hd__dfrtp_1_62/a_1283_21# VDPWR sky130_fd_pr__pfet_01v8_hvt ad=0 pd=0 as=0.1134 ps=1.38 w=0.42 l=0.15
X4961 sky130_fd_sc_hd__dfrtp_1_62/a_1270_413# sky130_fd_sc_hd__dfrtp_1_62/a_193_47# sky130_fd_sc_hd__dfrtp_1_62/a_1108_47# VDPWR sky130_fd_pr__pfet_01v8_hvt ad=0 pd=0 as=0 ps=0 w=0.42 l=0.15
X4962 sky130_fd_sc_hd__dfrtp_1_62/a_193_47# sky130_fd_sc_hd__dfrtp_1_62/a_27_47# VDPWR VDPWR sky130_fd_pr__pfet_01v8_hvt ad=0.1664 pd=1.8 as=0 ps=0 w=0.64 l=0.15
X4963 sky130_fd_sc_hd__dfrtp_1_62/a_1283_21# V3R298 VDPWR VDPWR sky130_fd_pr__pfet_01v8_hvt ad=0 pd=0 as=0 ps=0 w=0.42 l=0.15
X4964 VDPWR sky130_fd_sc_hd__dfrtp_1_62/a_761_289# sky130_fd_sc_hd__dfrtp_1_62/a_651_413# VDPWR sky130_fd_pr__pfet_01v8_hvt ad=0 pd=0 as=0 ps=0 w=0.42 l=0.15
X4965 V3R154 sky130_fd_sc_hd__dfrtp_1_62/a_1283_21# VGND VGND sky130_fd_pr__nfet_01v8 ad=0.169 pd=1.82 as=0 ps=0 w=0.65 l=0.15
X4966 sky130_fd_sc_hd__dfrtp_1_62/a_639_47# sky130_fd_sc_hd__dfrtp_1_62/a_193_47# sky130_fd_sc_hd__dfrtp_1_62/a_543_47# VGND sky130_fd_pr__special_nfet_01v8 ad=0 pd=0 as=0 ps=0 w=0.36 l=0.15
X4967 VGND sky130_fd_sc_hd__dfrtp_1_62/a_1283_21# sky130_fd_sc_hd__dfrtp_1_62/a_1217_47# VGND sky130_fd_pr__nfet_01v8 ad=0 pd=0 as=0 ps=0 w=0.42 l=0.15
X4968 sky130_fd_sc_hd__dfrtp_1_62/a_651_413# V3R298 VDPWR VDPWR sky130_fd_pr__pfet_01v8_hvt ad=0 pd=0 as=0 ps=0 w=0.42 l=0.15
X4969 VGND V3R055 sky130_fd_sc_hd__dfrtp_1_62/a_27_47# VGND sky130_fd_pr__nfet_01v8 ad=0 pd=0 as=0.1092 ps=1.36 w=0.42 l=0.15
X4970 sky130_fd_sc_hd__dfrtp_1_62/a_761_289# sky130_fd_sc_hd__dfrtp_1_62/a_543_47# VDPWR VDPWR sky130_fd_pr__pfet_01v8_hvt ad=0 pd=0 as=0 ps=0 w=0.84 l=0.15
X4971 sky130_fd_sc_hd__dfrtp_1_51/a_805_47# sky130_fd_sc_hd__dfrtp_1_51/a_761_289# sky130_fd_sc_hd__dfrtp_1_51/a_639_47# VGND sky130_fd_pr__nfet_01v8 ad=0.0882 pd=1.26 as=0.2802 ps=2.2 w=0.42 l=0.15
X4972 sky130_fd_sc_hd__dfrtp_1_51/a_1217_47# sky130_fd_sc_hd__dfrtp_1_51/a_27_47# sky130_fd_sc_hd__dfrtp_1_51/a_1108_47# VGND sky130_fd_pr__special_nfet_01v8 ad=0.1338 pd=1.5 as=0.1422 ps=1.51 w=0.36 l=0.15
X4973 sky130_fd_sc_hd__dfrtp_1_51/a_1283_21# sky130_fd_sc_hd__dfrtp_1_51/a_1108_47# sky130_fd_sc_hd__dfrtp_1_51/a_1462_47# VGND sky130_fd_pr__nfet_01v8 ad=0.1092 pd=1.36 as=0.1281 ps=1.45 w=0.42 l=0.15
X4974 sky130_fd_sc_hd__dfrtp_1_51/a_651_413# sky130_fd_sc_hd__dfrtp_1_51/a_27_47# sky130_fd_sc_hd__dfrtp_1_51/a_543_47# VDPWR sky130_fd_pr__pfet_01v8_hvt ad=0.3402 pd=3.3 as=0.1449 ps=1.53 w=0.42 l=0.15
X4975 sky130_fd_sc_hd__dfrtp_1_51/a_1108_47# sky130_fd_sc_hd__dfrtp_1_51/a_193_47# sky130_fd_sc_hd__dfrtp_1_51/a_761_289# VGND sky130_fd_pr__special_nfet_01v8 ad=0 pd=0 as=0.1998 ps=1.97 w=0.36 l=0.15
X4976 VGND V3R299 sky130_fd_sc_hd__dfrtp_1_51/a_805_47# VGND sky130_fd_pr__nfet_01v8 ad=0 pd=0 as=0 ps=0 w=0.42 l=0.15
X4977 V3R158 sky130_fd_sc_hd__dfrtp_1_51/a_1283_21# VDPWR VDPWR sky130_fd_pr__pfet_01v8_hvt ad=0.26 pd=2.52 as=0 ps=0 w=1 l=0.15
X4978 VDPWR V3R056 sky130_fd_sc_hd__dfrtp_1_51/a_27_47# VDPWR sky130_fd_pr__pfet_01v8_hvt ad=0 pd=0 as=0.1664 ps=1.8 w=0.64 l=0.15
X4979 sky130_fd_sc_hd__dfrtp_1_51/a_448_47# V3R103 VDPWR VDPWR sky130_fd_pr__pfet_01v8_hvt ad=0.1302 pd=1.46 as=0 ps=0 w=0.42 l=0.15
X4980 sky130_fd_sc_hd__dfrtp_1_51/a_761_289# sky130_fd_sc_hd__dfrtp_1_51/a_543_47# VGND VGND sky130_fd_pr__nfet_01v8 ad=0 pd=0 as=0 ps=0 w=0.64 l=0.15
X4981 sky130_fd_sc_hd__dfrtp_1_51/a_193_47# sky130_fd_sc_hd__dfrtp_1_51/a_27_47# VGND VGND sky130_fd_pr__nfet_01v8 ad=0.1092 pd=1.36 as=0 ps=0 w=0.42 l=0.15
X4982 sky130_fd_sc_hd__dfrtp_1_51/a_1108_47# sky130_fd_sc_hd__dfrtp_1_51/a_27_47# sky130_fd_sc_hd__dfrtp_1_51/a_761_289# VDPWR sky130_fd_pr__pfet_01v8_hvt ad=0.1176 pd=1.4 as=0.2583 ps=2.37 w=0.42 l=0.15
X4983 sky130_fd_sc_hd__dfrtp_1_51/a_1462_47# V3R299 VGND VGND sky130_fd_pr__nfet_01v8 ad=0 pd=0 as=0 ps=0 w=0.42 l=0.15
X4984 sky130_fd_sc_hd__dfrtp_1_51/a_543_47# sky130_fd_sc_hd__dfrtp_1_51/a_27_47# sky130_fd_sc_hd__dfrtp_1_51/a_448_47# VGND sky130_fd_pr__special_nfet_01v8 ad=0.1188 pd=1.38 as=0.132 ps=1.49 w=0.36 l=0.15
X4985 sky130_fd_sc_hd__dfrtp_1_51/a_543_47# sky130_fd_sc_hd__dfrtp_1_51/a_193_47# sky130_fd_sc_hd__dfrtp_1_51/a_448_47# VDPWR sky130_fd_pr__pfet_01v8_hvt ad=0 pd=0 as=0 ps=0 w=0.42 l=0.15
X4986 sky130_fd_sc_hd__dfrtp_1_51/a_448_47# V3R103 VGND VGND sky130_fd_pr__nfet_01v8 ad=0 pd=0 as=0 ps=0 w=0.42 l=0.15
X4987 VDPWR sky130_fd_sc_hd__dfrtp_1_51/a_1283_21# sky130_fd_sc_hd__dfrtp_1_51/a_1270_413# VDPWR sky130_fd_pr__pfet_01v8_hvt ad=0 pd=0 as=0.1134 ps=1.38 w=0.42 l=0.15
X4988 VDPWR sky130_fd_sc_hd__dfrtp_1_51/a_1108_47# sky130_fd_sc_hd__dfrtp_1_51/a_1283_21# VDPWR sky130_fd_pr__pfet_01v8_hvt ad=0 pd=0 as=0.1134 ps=1.38 w=0.42 l=0.15
X4989 sky130_fd_sc_hd__dfrtp_1_51/a_1270_413# sky130_fd_sc_hd__dfrtp_1_51/a_193_47# sky130_fd_sc_hd__dfrtp_1_51/a_1108_47# VDPWR sky130_fd_pr__pfet_01v8_hvt ad=0 pd=0 as=0 ps=0 w=0.42 l=0.15
X4990 sky130_fd_sc_hd__dfrtp_1_51/a_193_47# sky130_fd_sc_hd__dfrtp_1_51/a_27_47# VDPWR VDPWR sky130_fd_pr__pfet_01v8_hvt ad=0.1664 pd=1.8 as=0 ps=0 w=0.64 l=0.15
X4991 sky130_fd_sc_hd__dfrtp_1_51/a_1283_21# V3R299 VDPWR VDPWR sky130_fd_pr__pfet_01v8_hvt ad=0 pd=0 as=0 ps=0 w=0.42 l=0.15
X4992 VDPWR sky130_fd_sc_hd__dfrtp_1_51/a_761_289# sky130_fd_sc_hd__dfrtp_1_51/a_651_413# VDPWR sky130_fd_pr__pfet_01v8_hvt ad=0 pd=0 as=0 ps=0 w=0.42 l=0.15
X4993 V3R158 sky130_fd_sc_hd__dfrtp_1_51/a_1283_21# VGND VGND sky130_fd_pr__nfet_01v8 ad=0.169 pd=1.82 as=0 ps=0 w=0.65 l=0.15
X4994 sky130_fd_sc_hd__dfrtp_1_51/a_639_47# sky130_fd_sc_hd__dfrtp_1_51/a_193_47# sky130_fd_sc_hd__dfrtp_1_51/a_543_47# VGND sky130_fd_pr__special_nfet_01v8 ad=0 pd=0 as=0 ps=0 w=0.36 l=0.15
X4995 VGND sky130_fd_sc_hd__dfrtp_1_51/a_1283_21# sky130_fd_sc_hd__dfrtp_1_51/a_1217_47# VGND sky130_fd_pr__nfet_01v8 ad=0 pd=0 as=0 ps=0 w=0.42 l=0.15
X4996 sky130_fd_sc_hd__dfrtp_1_51/a_651_413# V3R299 VDPWR VDPWR sky130_fd_pr__pfet_01v8_hvt ad=0 pd=0 as=0 ps=0 w=0.42 l=0.15
X4997 VGND V3R056 sky130_fd_sc_hd__dfrtp_1_51/a_27_47# VGND sky130_fd_pr__nfet_01v8 ad=0 pd=0 as=0.1092 ps=1.36 w=0.42 l=0.15
X4998 sky130_fd_sc_hd__dfrtp_1_51/a_761_289# sky130_fd_sc_hd__dfrtp_1_51/a_543_47# VDPWR VDPWR sky130_fd_pr__pfet_01v8_hvt ad=0 pd=0 as=0 ps=0 w=0.84 l=0.15
X4999 sky130_fd_sc_hd__dfrtp_1_40/a_805_47# sky130_fd_sc_hd__dfrtp_1_40/a_761_289# sky130_fd_sc_hd__dfrtp_1_40/a_639_47# VGND sky130_fd_pr__nfet_01v8 ad=0.0882 pd=1.26 as=0.2802 ps=2.2 w=0.42 l=0.15
X5000 sky130_fd_sc_hd__dfrtp_1_40/a_1217_47# sky130_fd_sc_hd__dfrtp_1_40/a_27_47# sky130_fd_sc_hd__dfrtp_1_40/a_1108_47# VGND sky130_fd_pr__special_nfet_01v8 ad=0.1338 pd=1.5 as=0.1422 ps=1.51 w=0.36 l=0.15
X5001 sky130_fd_sc_hd__dfrtp_1_40/a_1283_21# sky130_fd_sc_hd__dfrtp_1_40/a_1108_47# sky130_fd_sc_hd__dfrtp_1_40/a_1462_47# VGND sky130_fd_pr__nfet_01v8 ad=0.1092 pd=1.36 as=0.1281 ps=1.45 w=0.42 l=0.15
X5002 sky130_fd_sc_hd__dfrtp_1_40/a_651_413# sky130_fd_sc_hd__dfrtp_1_40/a_27_47# sky130_fd_sc_hd__dfrtp_1_40/a_543_47# VDPWR sky130_fd_pr__pfet_01v8_hvt ad=0.3402 pd=3.3 as=0.1449 ps=1.53 w=0.42 l=0.15
X5003 sky130_fd_sc_hd__dfrtp_1_40/a_1108_47# sky130_fd_sc_hd__dfrtp_1_40/a_193_47# sky130_fd_sc_hd__dfrtp_1_40/a_761_289# VGND sky130_fd_pr__special_nfet_01v8 ad=0 pd=0 as=0.1998 ps=1.97 w=0.36 l=0.15
X5004 VGND V3R301 sky130_fd_sc_hd__dfrtp_1_40/a_805_47# VGND sky130_fd_pr__nfet_01v8 ad=0 pd=0 as=0 ps=0 w=0.42 l=0.15
X5005 V3R024 sky130_fd_sc_hd__dfrtp_1_40/a_1283_21# VDPWR VDPWR sky130_fd_pr__pfet_01v8_hvt ad=0.26 pd=2.52 as=0 ps=0 w=1 l=0.15
X5006 VDPWR V3R082 sky130_fd_sc_hd__dfrtp_1_40/a_27_47# VDPWR sky130_fd_pr__pfet_01v8_hvt ad=0 pd=0 as=0.1664 ps=1.8 w=0.64 l=0.15
X5007 sky130_fd_sc_hd__dfrtp_1_40/a_448_47# V3R139 VDPWR VDPWR sky130_fd_pr__pfet_01v8_hvt ad=0.1302 pd=1.46 as=0 ps=0 w=0.42 l=0.15
X5008 sky130_fd_sc_hd__dfrtp_1_40/a_761_289# sky130_fd_sc_hd__dfrtp_1_40/a_543_47# VGND VGND sky130_fd_pr__nfet_01v8 ad=0 pd=0 as=0 ps=0 w=0.64 l=0.15
X5009 sky130_fd_sc_hd__dfrtp_1_40/a_193_47# sky130_fd_sc_hd__dfrtp_1_40/a_27_47# VGND VGND sky130_fd_pr__nfet_01v8 ad=0.1092 pd=1.36 as=0 ps=0 w=0.42 l=0.15
X5010 sky130_fd_sc_hd__dfrtp_1_40/a_1108_47# sky130_fd_sc_hd__dfrtp_1_40/a_27_47# sky130_fd_sc_hd__dfrtp_1_40/a_761_289# VDPWR sky130_fd_pr__pfet_01v8_hvt ad=0.1176 pd=1.4 as=0.2583 ps=2.37 w=0.42 l=0.15
X5011 sky130_fd_sc_hd__dfrtp_1_40/a_1462_47# V3R301 VGND VGND sky130_fd_pr__nfet_01v8 ad=0 pd=0 as=0 ps=0 w=0.42 l=0.15
X5012 sky130_fd_sc_hd__dfrtp_1_40/a_543_47# sky130_fd_sc_hd__dfrtp_1_40/a_27_47# sky130_fd_sc_hd__dfrtp_1_40/a_448_47# VGND sky130_fd_pr__special_nfet_01v8 ad=0.1188 pd=1.38 as=0.132 ps=1.49 w=0.36 l=0.15
X5013 sky130_fd_sc_hd__dfrtp_1_40/a_543_47# sky130_fd_sc_hd__dfrtp_1_40/a_193_47# sky130_fd_sc_hd__dfrtp_1_40/a_448_47# VDPWR sky130_fd_pr__pfet_01v8_hvt ad=0 pd=0 as=0 ps=0 w=0.42 l=0.15
X5014 sky130_fd_sc_hd__dfrtp_1_40/a_448_47# V3R139 VGND VGND sky130_fd_pr__nfet_01v8 ad=0 pd=0 as=0 ps=0 w=0.42 l=0.15
X5015 VDPWR sky130_fd_sc_hd__dfrtp_1_40/a_1283_21# sky130_fd_sc_hd__dfrtp_1_40/a_1270_413# VDPWR sky130_fd_pr__pfet_01v8_hvt ad=0 pd=0 as=0.1134 ps=1.38 w=0.42 l=0.15
X5016 VDPWR sky130_fd_sc_hd__dfrtp_1_40/a_1108_47# sky130_fd_sc_hd__dfrtp_1_40/a_1283_21# VDPWR sky130_fd_pr__pfet_01v8_hvt ad=0 pd=0 as=0.1134 ps=1.38 w=0.42 l=0.15
X5017 sky130_fd_sc_hd__dfrtp_1_40/a_1270_413# sky130_fd_sc_hd__dfrtp_1_40/a_193_47# sky130_fd_sc_hd__dfrtp_1_40/a_1108_47# VDPWR sky130_fd_pr__pfet_01v8_hvt ad=0 pd=0 as=0 ps=0 w=0.42 l=0.15
X5018 sky130_fd_sc_hd__dfrtp_1_40/a_193_47# sky130_fd_sc_hd__dfrtp_1_40/a_27_47# VDPWR VDPWR sky130_fd_pr__pfet_01v8_hvt ad=0.1664 pd=1.8 as=0 ps=0 w=0.64 l=0.15
X5019 sky130_fd_sc_hd__dfrtp_1_40/a_1283_21# V3R301 VDPWR VDPWR sky130_fd_pr__pfet_01v8_hvt ad=0 pd=0 as=0 ps=0 w=0.42 l=0.15
X5020 VDPWR sky130_fd_sc_hd__dfrtp_1_40/a_761_289# sky130_fd_sc_hd__dfrtp_1_40/a_651_413# VDPWR sky130_fd_pr__pfet_01v8_hvt ad=0 pd=0 as=0 ps=0 w=0.42 l=0.15
X5021 V3R024 sky130_fd_sc_hd__dfrtp_1_40/a_1283_21# VGND VGND sky130_fd_pr__nfet_01v8 ad=0.169 pd=1.82 as=0 ps=0 w=0.65 l=0.15
X5022 sky130_fd_sc_hd__dfrtp_1_40/a_639_47# sky130_fd_sc_hd__dfrtp_1_40/a_193_47# sky130_fd_sc_hd__dfrtp_1_40/a_543_47# VGND sky130_fd_pr__special_nfet_01v8 ad=0 pd=0 as=0 ps=0 w=0.36 l=0.15
X5023 VGND sky130_fd_sc_hd__dfrtp_1_40/a_1283_21# sky130_fd_sc_hd__dfrtp_1_40/a_1217_47# VGND sky130_fd_pr__nfet_01v8 ad=0 pd=0 as=0 ps=0 w=0.42 l=0.15
X5024 sky130_fd_sc_hd__dfrtp_1_40/a_651_413# V3R301 VDPWR VDPWR sky130_fd_pr__pfet_01v8_hvt ad=0 pd=0 as=0 ps=0 w=0.42 l=0.15
X5025 VGND V3R082 sky130_fd_sc_hd__dfrtp_1_40/a_27_47# VGND sky130_fd_pr__nfet_01v8 ad=0 pd=0 as=0.1092 ps=1.36 w=0.42 l=0.15
X5026 sky130_fd_sc_hd__dfrtp_1_40/a_761_289# sky130_fd_sc_hd__dfrtp_1_40/a_543_47# VDPWR VDPWR sky130_fd_pr__pfet_01v8_hvt ad=0 pd=0 as=0 ps=0 w=0.84 l=0.15
X5027 sky130_fd_sc_hd__dfrtp_1_73/a_805_47# sky130_fd_sc_hd__dfrtp_1_73/a_761_289# sky130_fd_sc_hd__dfrtp_1_73/a_639_47# VGND sky130_fd_pr__nfet_01v8 ad=0.0882 pd=1.26 as=0.2802 ps=2.2 w=0.42 l=0.15
X5028 sky130_fd_sc_hd__dfrtp_1_73/a_1217_47# sky130_fd_sc_hd__dfrtp_1_73/a_27_47# sky130_fd_sc_hd__dfrtp_1_73/a_1108_47# VGND sky130_fd_pr__special_nfet_01v8 ad=0.1338 pd=1.5 as=0.1422 ps=1.51 w=0.36 l=0.15
X5029 sky130_fd_sc_hd__dfrtp_1_73/a_1283_21# sky130_fd_sc_hd__dfrtp_1_73/a_1108_47# sky130_fd_sc_hd__dfrtp_1_73/a_1462_47# VGND sky130_fd_pr__nfet_01v8 ad=0.1092 pd=1.36 as=0.1281 ps=1.45 w=0.42 l=0.15
X5030 sky130_fd_sc_hd__dfrtp_1_73/a_651_413# sky130_fd_sc_hd__dfrtp_1_73/a_27_47# sky130_fd_sc_hd__dfrtp_1_73/a_543_47# VDPWR sky130_fd_pr__pfet_01v8_hvt ad=0.3402 pd=3.3 as=0.1449 ps=1.53 w=0.42 l=0.15
X5031 sky130_fd_sc_hd__dfrtp_1_73/a_1108_47# sky130_fd_sc_hd__dfrtp_1_73/a_193_47# sky130_fd_sc_hd__dfrtp_1_73/a_761_289# VGND sky130_fd_pr__special_nfet_01v8 ad=0 pd=0 as=0.1998 ps=1.97 w=0.36 l=0.15
X5032 VGND V3R298 sky130_fd_sc_hd__dfrtp_1_73/a_805_47# VGND sky130_fd_pr__nfet_01v8 ad=0 pd=0 as=0 ps=0 w=0.42 l=0.15
X5033 V3R179 sky130_fd_sc_hd__dfrtp_1_73/a_1283_21# VDPWR VDPWR sky130_fd_pr__pfet_01v8_hvt ad=0.26 pd=2.52 as=0 ps=0 w=1 l=0.15
X5034 VDPWR V3R055 sky130_fd_sc_hd__dfrtp_1_73/a_27_47# VDPWR sky130_fd_pr__pfet_01v8_hvt ad=0 pd=0 as=0.1664 ps=1.8 w=0.64 l=0.15
X5035 sky130_fd_sc_hd__dfrtp_1_73/a_448_47# V3R093 VDPWR VDPWR sky130_fd_pr__pfet_01v8_hvt ad=0.1302 pd=1.46 as=0 ps=0 w=0.42 l=0.15
X5036 sky130_fd_sc_hd__dfrtp_1_73/a_761_289# sky130_fd_sc_hd__dfrtp_1_73/a_543_47# VGND VGND sky130_fd_pr__nfet_01v8 ad=0 pd=0 as=0 ps=0 w=0.64 l=0.15
X5037 sky130_fd_sc_hd__dfrtp_1_73/a_193_47# sky130_fd_sc_hd__dfrtp_1_73/a_27_47# VGND VGND sky130_fd_pr__nfet_01v8 ad=0.1092 pd=1.36 as=0 ps=0 w=0.42 l=0.15
X5038 sky130_fd_sc_hd__dfrtp_1_73/a_1108_47# sky130_fd_sc_hd__dfrtp_1_73/a_27_47# sky130_fd_sc_hd__dfrtp_1_73/a_761_289# VDPWR sky130_fd_pr__pfet_01v8_hvt ad=0.1176 pd=1.4 as=0.2583 ps=2.37 w=0.42 l=0.15
X5039 sky130_fd_sc_hd__dfrtp_1_73/a_1462_47# V3R298 VGND VGND sky130_fd_pr__nfet_01v8 ad=0 pd=0 as=0 ps=0 w=0.42 l=0.15
X5040 sky130_fd_sc_hd__dfrtp_1_73/a_543_47# sky130_fd_sc_hd__dfrtp_1_73/a_27_47# sky130_fd_sc_hd__dfrtp_1_73/a_448_47# VGND sky130_fd_pr__special_nfet_01v8 ad=0.1188 pd=1.38 as=0.132 ps=1.49 w=0.36 l=0.15
X5041 sky130_fd_sc_hd__dfrtp_1_73/a_543_47# sky130_fd_sc_hd__dfrtp_1_73/a_193_47# sky130_fd_sc_hd__dfrtp_1_73/a_448_47# VDPWR sky130_fd_pr__pfet_01v8_hvt ad=0 pd=0 as=0 ps=0 w=0.42 l=0.15
X5042 sky130_fd_sc_hd__dfrtp_1_73/a_448_47# V3R093 VGND VGND sky130_fd_pr__nfet_01v8 ad=0 pd=0 as=0 ps=0 w=0.42 l=0.15
X5043 VDPWR sky130_fd_sc_hd__dfrtp_1_73/a_1283_21# sky130_fd_sc_hd__dfrtp_1_73/a_1270_413# VDPWR sky130_fd_pr__pfet_01v8_hvt ad=0 pd=0 as=0.1134 ps=1.38 w=0.42 l=0.15
X5044 VDPWR sky130_fd_sc_hd__dfrtp_1_73/a_1108_47# sky130_fd_sc_hd__dfrtp_1_73/a_1283_21# VDPWR sky130_fd_pr__pfet_01v8_hvt ad=0 pd=0 as=0.1134 ps=1.38 w=0.42 l=0.15
X5045 sky130_fd_sc_hd__dfrtp_1_73/a_1270_413# sky130_fd_sc_hd__dfrtp_1_73/a_193_47# sky130_fd_sc_hd__dfrtp_1_73/a_1108_47# VDPWR sky130_fd_pr__pfet_01v8_hvt ad=0 pd=0 as=0 ps=0 w=0.42 l=0.15
X5046 sky130_fd_sc_hd__dfrtp_1_73/a_193_47# sky130_fd_sc_hd__dfrtp_1_73/a_27_47# VDPWR VDPWR sky130_fd_pr__pfet_01v8_hvt ad=0.1664 pd=1.8 as=0 ps=0 w=0.64 l=0.15
X5047 sky130_fd_sc_hd__dfrtp_1_73/a_1283_21# V3R298 VDPWR VDPWR sky130_fd_pr__pfet_01v8_hvt ad=0 pd=0 as=0 ps=0 w=0.42 l=0.15
X5048 VDPWR sky130_fd_sc_hd__dfrtp_1_73/a_761_289# sky130_fd_sc_hd__dfrtp_1_73/a_651_413# VDPWR sky130_fd_pr__pfet_01v8_hvt ad=0 pd=0 as=0 ps=0 w=0.42 l=0.15
X5049 V3R179 sky130_fd_sc_hd__dfrtp_1_73/a_1283_21# VGND VGND sky130_fd_pr__nfet_01v8 ad=0.169 pd=1.82 as=0 ps=0 w=0.65 l=0.15
X5050 sky130_fd_sc_hd__dfrtp_1_73/a_639_47# sky130_fd_sc_hd__dfrtp_1_73/a_193_47# sky130_fd_sc_hd__dfrtp_1_73/a_543_47# VGND sky130_fd_pr__special_nfet_01v8 ad=0 pd=0 as=0 ps=0 w=0.36 l=0.15
X5051 VGND sky130_fd_sc_hd__dfrtp_1_73/a_1283_21# sky130_fd_sc_hd__dfrtp_1_73/a_1217_47# VGND sky130_fd_pr__nfet_01v8 ad=0 pd=0 as=0 ps=0 w=0.42 l=0.15
X5052 sky130_fd_sc_hd__dfrtp_1_73/a_651_413# V3R298 VDPWR VDPWR sky130_fd_pr__pfet_01v8_hvt ad=0 pd=0 as=0 ps=0 w=0.42 l=0.15
X5053 VGND V3R055 sky130_fd_sc_hd__dfrtp_1_73/a_27_47# VGND sky130_fd_pr__nfet_01v8 ad=0 pd=0 as=0.1092 ps=1.36 w=0.42 l=0.15
X5054 sky130_fd_sc_hd__dfrtp_1_73/a_761_289# sky130_fd_sc_hd__dfrtp_1_73/a_543_47# VDPWR VDPWR sky130_fd_pr__pfet_01v8_hvt ad=0 pd=0 as=0 ps=0 w=0.84 l=0.15
X5055 sky130_fd_sc_hd__dfrtp_1_84/a_805_47# sky130_fd_sc_hd__dfrtp_1_84/a_761_289# sky130_fd_sc_hd__dfrtp_1_84/a_639_47# VGND sky130_fd_pr__nfet_01v8 ad=0.0882 pd=1.26 as=0.2802 ps=2.2 w=0.42 l=0.15
X5056 sky130_fd_sc_hd__dfrtp_1_84/a_1217_47# sky130_fd_sc_hd__dfrtp_1_84/a_27_47# sky130_fd_sc_hd__dfrtp_1_84/a_1108_47# VGND sky130_fd_pr__special_nfet_01v8 ad=0.1338 pd=1.5 as=0.1422 ps=1.51 w=0.36 l=0.15
X5057 sky130_fd_sc_hd__dfrtp_1_84/a_1283_21# sky130_fd_sc_hd__dfrtp_1_84/a_1108_47# sky130_fd_sc_hd__dfrtp_1_84/a_1462_47# VGND sky130_fd_pr__nfet_01v8 ad=0.1092 pd=1.36 as=0.1281 ps=1.45 w=0.42 l=0.15
X5058 sky130_fd_sc_hd__dfrtp_1_84/a_651_413# sky130_fd_sc_hd__dfrtp_1_84/a_27_47# sky130_fd_sc_hd__dfrtp_1_84/a_543_47# VDPWR sky130_fd_pr__pfet_01v8_hvt ad=0.3402 pd=3.3 as=0.1449 ps=1.53 w=0.42 l=0.15
X5059 sky130_fd_sc_hd__dfrtp_1_84/a_1108_47# sky130_fd_sc_hd__dfrtp_1_84/a_193_47# sky130_fd_sc_hd__dfrtp_1_84/a_761_289# VGND sky130_fd_pr__special_nfet_01v8 ad=0 pd=0 as=0.1998 ps=1.97 w=0.36 l=0.15
X5060 VGND V3R300 sky130_fd_sc_hd__dfrtp_1_84/a_805_47# VGND sky130_fd_pr__nfet_01v8 ad=0 pd=0 as=0 ps=0 w=0.42 l=0.15
X5061 V3R033 sky130_fd_sc_hd__dfrtp_1_84/a_1283_21# VDPWR VDPWR sky130_fd_pr__pfet_01v8_hvt ad=0.26 pd=2.52 as=0 ps=0 w=1 l=0.15
X5062 VDPWR V3R081 sky130_fd_sc_hd__dfrtp_1_84/a_27_47# VDPWR sky130_fd_pr__pfet_01v8_hvt ad=0 pd=0 as=0.1664 ps=1.8 w=0.64 l=0.15
X5063 sky130_fd_sc_hd__dfrtp_1_84/a_448_47# V3R120 VDPWR VDPWR sky130_fd_pr__pfet_01v8_hvt ad=0.1302 pd=1.46 as=0 ps=0 w=0.42 l=0.15
X5064 sky130_fd_sc_hd__dfrtp_1_84/a_761_289# sky130_fd_sc_hd__dfrtp_1_84/a_543_47# VGND VGND sky130_fd_pr__nfet_01v8 ad=0 pd=0 as=0 ps=0 w=0.64 l=0.15
X5065 sky130_fd_sc_hd__dfrtp_1_84/a_193_47# sky130_fd_sc_hd__dfrtp_1_84/a_27_47# VGND VGND sky130_fd_pr__nfet_01v8 ad=0.1092 pd=1.36 as=0 ps=0 w=0.42 l=0.15
X5066 sky130_fd_sc_hd__dfrtp_1_84/a_1108_47# sky130_fd_sc_hd__dfrtp_1_84/a_27_47# sky130_fd_sc_hd__dfrtp_1_84/a_761_289# VDPWR sky130_fd_pr__pfet_01v8_hvt ad=0.1176 pd=1.4 as=0.2583 ps=2.37 w=0.42 l=0.15
X5067 sky130_fd_sc_hd__dfrtp_1_84/a_1462_47# V3R300 VGND VGND sky130_fd_pr__nfet_01v8 ad=0 pd=0 as=0 ps=0 w=0.42 l=0.15
X5068 sky130_fd_sc_hd__dfrtp_1_84/a_543_47# sky130_fd_sc_hd__dfrtp_1_84/a_27_47# sky130_fd_sc_hd__dfrtp_1_84/a_448_47# VGND sky130_fd_pr__special_nfet_01v8 ad=0.1188 pd=1.38 as=0.132 ps=1.49 w=0.36 l=0.15
X5069 sky130_fd_sc_hd__dfrtp_1_84/a_543_47# sky130_fd_sc_hd__dfrtp_1_84/a_193_47# sky130_fd_sc_hd__dfrtp_1_84/a_448_47# VDPWR sky130_fd_pr__pfet_01v8_hvt ad=0 pd=0 as=0 ps=0 w=0.42 l=0.15
X5070 sky130_fd_sc_hd__dfrtp_1_84/a_448_47# V3R120 VGND VGND sky130_fd_pr__nfet_01v8 ad=0 pd=0 as=0 ps=0 w=0.42 l=0.15
X5071 VDPWR sky130_fd_sc_hd__dfrtp_1_84/a_1283_21# sky130_fd_sc_hd__dfrtp_1_84/a_1270_413# VDPWR sky130_fd_pr__pfet_01v8_hvt ad=0 pd=0 as=0.1134 ps=1.38 w=0.42 l=0.15
X5072 VDPWR sky130_fd_sc_hd__dfrtp_1_84/a_1108_47# sky130_fd_sc_hd__dfrtp_1_84/a_1283_21# VDPWR sky130_fd_pr__pfet_01v8_hvt ad=0 pd=0 as=0.1134 ps=1.38 w=0.42 l=0.15
X5073 sky130_fd_sc_hd__dfrtp_1_84/a_1270_413# sky130_fd_sc_hd__dfrtp_1_84/a_193_47# sky130_fd_sc_hd__dfrtp_1_84/a_1108_47# VDPWR sky130_fd_pr__pfet_01v8_hvt ad=0 pd=0 as=0 ps=0 w=0.42 l=0.15
X5074 sky130_fd_sc_hd__dfrtp_1_84/a_193_47# sky130_fd_sc_hd__dfrtp_1_84/a_27_47# VDPWR VDPWR sky130_fd_pr__pfet_01v8_hvt ad=0.1664 pd=1.8 as=0 ps=0 w=0.64 l=0.15
X5075 sky130_fd_sc_hd__dfrtp_1_84/a_1283_21# V3R300 VDPWR VDPWR sky130_fd_pr__pfet_01v8_hvt ad=0 pd=0 as=0 ps=0 w=0.42 l=0.15
X5076 VDPWR sky130_fd_sc_hd__dfrtp_1_84/a_761_289# sky130_fd_sc_hd__dfrtp_1_84/a_651_413# VDPWR sky130_fd_pr__pfet_01v8_hvt ad=0 pd=0 as=0 ps=0 w=0.42 l=0.15
X5077 V3R033 sky130_fd_sc_hd__dfrtp_1_84/a_1283_21# VGND VGND sky130_fd_pr__nfet_01v8 ad=0.169 pd=1.82 as=0 ps=0 w=0.65 l=0.15
X5078 sky130_fd_sc_hd__dfrtp_1_84/a_639_47# sky130_fd_sc_hd__dfrtp_1_84/a_193_47# sky130_fd_sc_hd__dfrtp_1_84/a_543_47# VGND sky130_fd_pr__special_nfet_01v8 ad=0 pd=0 as=0 ps=0 w=0.36 l=0.15
X5079 VGND sky130_fd_sc_hd__dfrtp_1_84/a_1283_21# sky130_fd_sc_hd__dfrtp_1_84/a_1217_47# VGND sky130_fd_pr__nfet_01v8 ad=0 pd=0 as=0 ps=0 w=0.42 l=0.15
X5080 sky130_fd_sc_hd__dfrtp_1_84/a_651_413# V3R300 VDPWR VDPWR sky130_fd_pr__pfet_01v8_hvt ad=0 pd=0 as=0 ps=0 w=0.42 l=0.15
X5081 VGND V3R081 sky130_fd_sc_hd__dfrtp_1_84/a_27_47# VGND sky130_fd_pr__nfet_01v8 ad=0 pd=0 as=0.1092 ps=1.36 w=0.42 l=0.15
X5082 sky130_fd_sc_hd__dfrtp_1_84/a_761_289# sky130_fd_sc_hd__dfrtp_1_84/a_543_47# VDPWR VDPWR sky130_fd_pr__pfet_01v8_hvt ad=0 pd=0 as=0 ps=0 w=0.84 l=0.15
X5083 VDPWR sky130_fd_sc_hd__mux2_1_100/a_505_21# sky130_fd_sc_hd__mux2_1_100/a_535_374# VDPWR sky130_fd_pr__pfet_01v8_hvt ad=0 pd=0 as=0.0882 ps=1.26 w=0.42 l=0.15
X5084 sky130_fd_sc_hd__mux2_1_100/a_505_21# V3R061 VDPWR VDPWR sky130_fd_pr__pfet_01v8_hvt ad=0.1176 pd=1.4 as=0 ps=0 w=0.42 l=0.15
X5085 sky130_fd_sc_hd__mux2_1_100/a_218_374# V3R061 VDPWR VDPWR sky130_fd_pr__pfet_01v8_hvt ad=0.1533 pd=1.57 as=0 ps=0 w=0.42 l=0.15
X5086 VGND sky130_fd_sc_hd__mux2_1_100/a_505_21# sky130_fd_sc_hd__mux2_1_100/a_439_47# VGND sky130_fd_pr__nfet_01v8 ad=0 pd=0 as=0.1386 ps=1.5 w=0.42 l=0.15
X5087 sky130_fd_sc_hd__mux2_1_100/a_76_199# V3R161 sky130_fd_sc_hd__mux2_1_100/a_218_374# VDPWR sky130_fd_pr__pfet_01v8_hvt ad=0.3864 pd=2.68 as=0 ps=0 w=0.42 l=0.15
X5088 sky130_fd_sc_hd__mux2_1_100/a_505_21# V3R061 VGND VGND sky130_fd_pr__nfet_01v8 ad=0.1092 pd=1.36 as=0 ps=0 w=0.42 l=0.15
X5089 sky130_fd_sc_hd__mux2_1_100/a_439_47# V3R161 sky130_fd_sc_hd__mux2_1_100/a_76_199# VGND sky130_fd_pr__nfet_01v8 ad=0 pd=0 as=0.1995 ps=1.79 w=0.42 l=0.15
X5090 sky130_fd_sc_hd__mux2_1_100/a_535_374# V3R150 sky130_fd_sc_hd__mux2_1_100/a_76_199# VDPWR sky130_fd_pr__pfet_01v8_hvt ad=0 pd=0 as=0 ps=0 w=0.42 l=0.15
X5091 sky130_fd_sc_hd__mux2_1_100/a_76_199# V3R150 sky130_fd_sc_hd__mux2_1_100/a_218_47# VGND sky130_fd_pr__nfet_01v8 ad=0 pd=0 as=0.1386 ps=1.5 w=0.42 l=0.15
X5092 sky130_fd_sc_hd__mux2_1_100/a_218_47# V3R061 VGND VGND sky130_fd_pr__nfet_01v8 ad=0 pd=0 as=0 ps=0 w=0.42 l=0.15
X5093 VDPWR sky130_fd_sc_hd__mux2_1_100/a_76_199# V3R086 VDPWR sky130_fd_pr__pfet_01v8_hvt ad=0 pd=0 as=0.26 ps=2.52 w=1 l=0.15
X5094 VGND sky130_fd_sc_hd__mux2_1_100/a_76_199# V3R086 VGND sky130_fd_pr__nfet_01v8 ad=0 pd=0 as=0.169 ps=1.82 w=0.65 l=0.15
X5095 V3R290 V3R292 VGND VGND sky130_fd_pr__nfet_01v8 ad=0.169 pd=1.82 as=0.169 ps=1.82 w=0.65 l=0.15
X5096 V3R290 V3R292 VDPWR VDPWR sky130_fd_pr__pfet_01v8_hvt ad=0.26 pd=2.52 as=0.26 ps=2.52 w=1 l=0.15
X5097 sky130_fd_sc_hd__dfrtp_1_74/a_805_47# sky130_fd_sc_hd__dfrtp_1_74/a_761_289# sky130_fd_sc_hd__dfrtp_1_74/a_639_47# VGND sky130_fd_pr__nfet_01v8 ad=0.0882 pd=1.26 as=0.2802 ps=2.2 w=0.42 l=0.15
X5098 sky130_fd_sc_hd__dfrtp_1_74/a_1217_47# sky130_fd_sc_hd__dfrtp_1_74/a_27_47# sky130_fd_sc_hd__dfrtp_1_74/a_1108_47# VGND sky130_fd_pr__special_nfet_01v8 ad=0.1338 pd=1.5 as=0.1422 ps=1.51 w=0.36 l=0.15
X5099 sky130_fd_sc_hd__dfrtp_1_74/a_1283_21# sky130_fd_sc_hd__dfrtp_1_74/a_1108_47# sky130_fd_sc_hd__dfrtp_1_74/a_1462_47# VGND sky130_fd_pr__nfet_01v8 ad=0.1092 pd=1.36 as=0.1281 ps=1.45 w=0.42 l=0.15
X5100 sky130_fd_sc_hd__dfrtp_1_74/a_651_413# sky130_fd_sc_hd__dfrtp_1_74/a_27_47# sky130_fd_sc_hd__dfrtp_1_74/a_543_47# VDPWR sky130_fd_pr__pfet_01v8_hvt ad=0.3402 pd=3.3 as=0.1449 ps=1.53 w=0.42 l=0.15
X5101 sky130_fd_sc_hd__dfrtp_1_74/a_1108_47# sky130_fd_sc_hd__dfrtp_1_74/a_193_47# sky130_fd_sc_hd__dfrtp_1_74/a_761_289# VGND sky130_fd_pr__special_nfet_01v8 ad=0 pd=0 as=0.1998 ps=1.97 w=0.36 l=0.15
X5102 VGND V3R300 sky130_fd_sc_hd__dfrtp_1_74/a_805_47# VGND sky130_fd_pr__nfet_01v8 ad=0 pd=0 as=0 ps=0 w=0.42 l=0.15
X5103 V3R040 sky130_fd_sc_hd__dfrtp_1_74/a_1283_21# VDPWR VDPWR sky130_fd_pr__pfet_01v8_hvt ad=0.26 pd=2.52 as=0 ps=0 w=1 l=0.15
X5104 VDPWR V3R081 sky130_fd_sc_hd__dfrtp_1_74/a_27_47# VDPWR sky130_fd_pr__pfet_01v8_hvt ad=0 pd=0 as=0.1664 ps=1.8 w=0.64 l=0.15
X5105 sky130_fd_sc_hd__dfrtp_1_74/a_448_47# V3R125 VDPWR VDPWR sky130_fd_pr__pfet_01v8_hvt ad=0.1302 pd=1.46 as=0 ps=0 w=0.42 l=0.15
X5106 sky130_fd_sc_hd__dfrtp_1_74/a_761_289# sky130_fd_sc_hd__dfrtp_1_74/a_543_47# VGND VGND sky130_fd_pr__nfet_01v8 ad=0 pd=0 as=0 ps=0 w=0.64 l=0.15
X5107 sky130_fd_sc_hd__dfrtp_1_74/a_193_47# sky130_fd_sc_hd__dfrtp_1_74/a_27_47# VGND VGND sky130_fd_pr__nfet_01v8 ad=0.1092 pd=1.36 as=0 ps=0 w=0.42 l=0.15
X5108 sky130_fd_sc_hd__dfrtp_1_74/a_1108_47# sky130_fd_sc_hd__dfrtp_1_74/a_27_47# sky130_fd_sc_hd__dfrtp_1_74/a_761_289# VDPWR sky130_fd_pr__pfet_01v8_hvt ad=0.1176 pd=1.4 as=0.2583 ps=2.37 w=0.42 l=0.15
X5109 sky130_fd_sc_hd__dfrtp_1_74/a_1462_47# V3R300 VGND VGND sky130_fd_pr__nfet_01v8 ad=0 pd=0 as=0 ps=0 w=0.42 l=0.15
X5110 sky130_fd_sc_hd__dfrtp_1_74/a_543_47# sky130_fd_sc_hd__dfrtp_1_74/a_27_47# sky130_fd_sc_hd__dfrtp_1_74/a_448_47# VGND sky130_fd_pr__special_nfet_01v8 ad=0.1188 pd=1.38 as=0.132 ps=1.49 w=0.36 l=0.15
X5111 sky130_fd_sc_hd__dfrtp_1_74/a_543_47# sky130_fd_sc_hd__dfrtp_1_74/a_193_47# sky130_fd_sc_hd__dfrtp_1_74/a_448_47# VDPWR sky130_fd_pr__pfet_01v8_hvt ad=0 pd=0 as=0 ps=0 w=0.42 l=0.15
X5112 sky130_fd_sc_hd__dfrtp_1_74/a_448_47# V3R125 VGND VGND sky130_fd_pr__nfet_01v8 ad=0 pd=0 as=0 ps=0 w=0.42 l=0.15
X5113 VDPWR sky130_fd_sc_hd__dfrtp_1_74/a_1283_21# sky130_fd_sc_hd__dfrtp_1_74/a_1270_413# VDPWR sky130_fd_pr__pfet_01v8_hvt ad=0 pd=0 as=0.1134 ps=1.38 w=0.42 l=0.15
X5114 VDPWR sky130_fd_sc_hd__dfrtp_1_74/a_1108_47# sky130_fd_sc_hd__dfrtp_1_74/a_1283_21# VDPWR sky130_fd_pr__pfet_01v8_hvt ad=0 pd=0 as=0.1134 ps=1.38 w=0.42 l=0.15
X5115 sky130_fd_sc_hd__dfrtp_1_74/a_1270_413# sky130_fd_sc_hd__dfrtp_1_74/a_193_47# sky130_fd_sc_hd__dfrtp_1_74/a_1108_47# VDPWR sky130_fd_pr__pfet_01v8_hvt ad=0 pd=0 as=0 ps=0 w=0.42 l=0.15
X5116 sky130_fd_sc_hd__dfrtp_1_74/a_193_47# sky130_fd_sc_hd__dfrtp_1_74/a_27_47# VDPWR VDPWR sky130_fd_pr__pfet_01v8_hvt ad=0.1664 pd=1.8 as=0 ps=0 w=0.64 l=0.15
X5117 sky130_fd_sc_hd__dfrtp_1_74/a_1283_21# V3R300 VDPWR VDPWR sky130_fd_pr__pfet_01v8_hvt ad=0 pd=0 as=0 ps=0 w=0.42 l=0.15
X5118 VDPWR sky130_fd_sc_hd__dfrtp_1_74/a_761_289# sky130_fd_sc_hd__dfrtp_1_74/a_651_413# VDPWR sky130_fd_pr__pfet_01v8_hvt ad=0 pd=0 as=0 ps=0 w=0.42 l=0.15
X5119 V3R040 sky130_fd_sc_hd__dfrtp_1_74/a_1283_21# VGND VGND sky130_fd_pr__nfet_01v8 ad=0.169 pd=1.82 as=0 ps=0 w=0.65 l=0.15
X5120 sky130_fd_sc_hd__dfrtp_1_74/a_639_47# sky130_fd_sc_hd__dfrtp_1_74/a_193_47# sky130_fd_sc_hd__dfrtp_1_74/a_543_47# VGND sky130_fd_pr__special_nfet_01v8 ad=0 pd=0 as=0 ps=0 w=0.36 l=0.15
X5121 VGND sky130_fd_sc_hd__dfrtp_1_74/a_1283_21# sky130_fd_sc_hd__dfrtp_1_74/a_1217_47# VGND sky130_fd_pr__nfet_01v8 ad=0 pd=0 as=0 ps=0 w=0.42 l=0.15
X5122 sky130_fd_sc_hd__dfrtp_1_74/a_651_413# V3R300 VDPWR VDPWR sky130_fd_pr__pfet_01v8_hvt ad=0 pd=0 as=0 ps=0 w=0.42 l=0.15
X5123 VGND V3R081 sky130_fd_sc_hd__dfrtp_1_74/a_27_47# VGND sky130_fd_pr__nfet_01v8 ad=0 pd=0 as=0.1092 ps=1.36 w=0.42 l=0.15
X5124 sky130_fd_sc_hd__dfrtp_1_74/a_761_289# sky130_fd_sc_hd__dfrtp_1_74/a_543_47# VDPWR VDPWR sky130_fd_pr__pfet_01v8_hvt ad=0 pd=0 as=0 ps=0 w=0.84 l=0.15
X5125 sky130_fd_sc_hd__dfrtp_1_63/a_805_47# sky130_fd_sc_hd__dfrtp_1_63/a_761_289# sky130_fd_sc_hd__dfrtp_1_63/a_639_47# VGND sky130_fd_pr__nfet_01v8 ad=0.0882 pd=1.26 as=0.2802 ps=2.2 w=0.42 l=0.15
X5126 sky130_fd_sc_hd__dfrtp_1_63/a_1217_47# sky130_fd_sc_hd__dfrtp_1_63/a_27_47# sky130_fd_sc_hd__dfrtp_1_63/a_1108_47# VGND sky130_fd_pr__special_nfet_01v8 ad=0.1338 pd=1.5 as=0.1422 ps=1.51 w=0.36 l=0.15
X5127 sky130_fd_sc_hd__dfrtp_1_63/a_1283_21# sky130_fd_sc_hd__dfrtp_1_63/a_1108_47# sky130_fd_sc_hd__dfrtp_1_63/a_1462_47# VGND sky130_fd_pr__nfet_01v8 ad=0.1092 pd=1.36 as=0.1281 ps=1.45 w=0.42 l=0.15
X5128 sky130_fd_sc_hd__dfrtp_1_63/a_651_413# sky130_fd_sc_hd__dfrtp_1_63/a_27_47# sky130_fd_sc_hd__dfrtp_1_63/a_543_47# VDPWR sky130_fd_pr__pfet_01v8_hvt ad=0.3402 pd=3.3 as=0.1449 ps=1.53 w=0.42 l=0.15
X5129 sky130_fd_sc_hd__dfrtp_1_63/a_1108_47# sky130_fd_sc_hd__dfrtp_1_63/a_193_47# sky130_fd_sc_hd__dfrtp_1_63/a_761_289# VGND sky130_fd_pr__special_nfet_01v8 ad=0 pd=0 as=0.1998 ps=1.97 w=0.36 l=0.15
X5130 VGND V3R300 sky130_fd_sc_hd__dfrtp_1_63/a_805_47# VGND sky130_fd_pr__nfet_01v8 ad=0 pd=0 as=0 ps=0 w=0.42 l=0.15
X5131 V3R015 sky130_fd_sc_hd__dfrtp_1_63/a_1283_21# VDPWR VDPWR sky130_fd_pr__pfet_01v8_hvt ad=0.26 pd=2.52 as=0 ps=0 w=1 l=0.15
X5132 VDPWR V3R081 sky130_fd_sc_hd__dfrtp_1_63/a_27_47# VDPWR sky130_fd_pr__pfet_01v8_hvt ad=0 pd=0 as=0.1664 ps=1.8 w=0.64 l=0.15
X5133 sky130_fd_sc_hd__dfrtp_1_63/a_448_47# V3R131 VDPWR VDPWR sky130_fd_pr__pfet_01v8_hvt ad=0.1302 pd=1.46 as=0 ps=0 w=0.42 l=0.15
X5134 sky130_fd_sc_hd__dfrtp_1_63/a_761_289# sky130_fd_sc_hd__dfrtp_1_63/a_543_47# VGND VGND sky130_fd_pr__nfet_01v8 ad=0 pd=0 as=0 ps=0 w=0.64 l=0.15
X5135 sky130_fd_sc_hd__dfrtp_1_63/a_193_47# sky130_fd_sc_hd__dfrtp_1_63/a_27_47# VGND VGND sky130_fd_pr__nfet_01v8 ad=0.1092 pd=1.36 as=0 ps=0 w=0.42 l=0.15
X5136 sky130_fd_sc_hd__dfrtp_1_63/a_1108_47# sky130_fd_sc_hd__dfrtp_1_63/a_27_47# sky130_fd_sc_hd__dfrtp_1_63/a_761_289# VDPWR sky130_fd_pr__pfet_01v8_hvt ad=0.1176 pd=1.4 as=0.2583 ps=2.37 w=0.42 l=0.15
X5137 sky130_fd_sc_hd__dfrtp_1_63/a_1462_47# V3R300 VGND VGND sky130_fd_pr__nfet_01v8 ad=0 pd=0 as=0 ps=0 w=0.42 l=0.15
X5138 sky130_fd_sc_hd__dfrtp_1_63/a_543_47# sky130_fd_sc_hd__dfrtp_1_63/a_27_47# sky130_fd_sc_hd__dfrtp_1_63/a_448_47# VGND sky130_fd_pr__special_nfet_01v8 ad=0.1188 pd=1.38 as=0.132 ps=1.49 w=0.36 l=0.15
X5139 sky130_fd_sc_hd__dfrtp_1_63/a_543_47# sky130_fd_sc_hd__dfrtp_1_63/a_193_47# sky130_fd_sc_hd__dfrtp_1_63/a_448_47# VDPWR sky130_fd_pr__pfet_01v8_hvt ad=0 pd=0 as=0 ps=0 w=0.42 l=0.15
X5140 sky130_fd_sc_hd__dfrtp_1_63/a_448_47# V3R131 VGND VGND sky130_fd_pr__nfet_01v8 ad=0 pd=0 as=0 ps=0 w=0.42 l=0.15
X5141 VDPWR sky130_fd_sc_hd__dfrtp_1_63/a_1283_21# sky130_fd_sc_hd__dfrtp_1_63/a_1270_413# VDPWR sky130_fd_pr__pfet_01v8_hvt ad=0 pd=0 as=0.1134 ps=1.38 w=0.42 l=0.15
X5142 VDPWR sky130_fd_sc_hd__dfrtp_1_63/a_1108_47# sky130_fd_sc_hd__dfrtp_1_63/a_1283_21# VDPWR sky130_fd_pr__pfet_01v8_hvt ad=0 pd=0 as=0.1134 ps=1.38 w=0.42 l=0.15
X5143 sky130_fd_sc_hd__dfrtp_1_63/a_1270_413# sky130_fd_sc_hd__dfrtp_1_63/a_193_47# sky130_fd_sc_hd__dfrtp_1_63/a_1108_47# VDPWR sky130_fd_pr__pfet_01v8_hvt ad=0 pd=0 as=0 ps=0 w=0.42 l=0.15
X5144 sky130_fd_sc_hd__dfrtp_1_63/a_193_47# sky130_fd_sc_hd__dfrtp_1_63/a_27_47# VDPWR VDPWR sky130_fd_pr__pfet_01v8_hvt ad=0.1664 pd=1.8 as=0 ps=0 w=0.64 l=0.15
X5145 sky130_fd_sc_hd__dfrtp_1_63/a_1283_21# V3R300 VDPWR VDPWR sky130_fd_pr__pfet_01v8_hvt ad=0 pd=0 as=0 ps=0 w=0.42 l=0.15
X5146 VDPWR sky130_fd_sc_hd__dfrtp_1_63/a_761_289# sky130_fd_sc_hd__dfrtp_1_63/a_651_413# VDPWR sky130_fd_pr__pfet_01v8_hvt ad=0 pd=0 as=0 ps=0 w=0.42 l=0.15
X5147 V3R015 sky130_fd_sc_hd__dfrtp_1_63/a_1283_21# VGND VGND sky130_fd_pr__nfet_01v8 ad=0.169 pd=1.82 as=0 ps=0 w=0.65 l=0.15
X5148 sky130_fd_sc_hd__dfrtp_1_63/a_639_47# sky130_fd_sc_hd__dfrtp_1_63/a_193_47# sky130_fd_sc_hd__dfrtp_1_63/a_543_47# VGND sky130_fd_pr__special_nfet_01v8 ad=0 pd=0 as=0 ps=0 w=0.36 l=0.15
X5149 VGND sky130_fd_sc_hd__dfrtp_1_63/a_1283_21# sky130_fd_sc_hd__dfrtp_1_63/a_1217_47# VGND sky130_fd_pr__nfet_01v8 ad=0 pd=0 as=0 ps=0 w=0.42 l=0.15
X5150 sky130_fd_sc_hd__dfrtp_1_63/a_651_413# V3R300 VDPWR VDPWR sky130_fd_pr__pfet_01v8_hvt ad=0 pd=0 as=0 ps=0 w=0.42 l=0.15
X5151 VGND V3R081 sky130_fd_sc_hd__dfrtp_1_63/a_27_47# VGND sky130_fd_pr__nfet_01v8 ad=0 pd=0 as=0.1092 ps=1.36 w=0.42 l=0.15
X5152 sky130_fd_sc_hd__dfrtp_1_63/a_761_289# sky130_fd_sc_hd__dfrtp_1_63/a_543_47# VDPWR VDPWR sky130_fd_pr__pfet_01v8_hvt ad=0 pd=0 as=0 ps=0 w=0.84 l=0.15
X5153 sky130_fd_sc_hd__dfrtp_1_52/a_805_47# sky130_fd_sc_hd__dfrtp_1_52/a_761_289# sky130_fd_sc_hd__dfrtp_1_52/a_639_47# VGND sky130_fd_pr__nfet_01v8 ad=0.0882 pd=1.26 as=0.2802 ps=2.2 w=0.42 l=0.15
X5154 sky130_fd_sc_hd__dfrtp_1_52/a_1217_47# sky130_fd_sc_hd__dfrtp_1_52/a_27_47# sky130_fd_sc_hd__dfrtp_1_52/a_1108_47# VGND sky130_fd_pr__special_nfet_01v8 ad=0.1338 pd=1.5 as=0.1422 ps=1.51 w=0.36 l=0.15
X5155 sky130_fd_sc_hd__dfrtp_1_52/a_1283_21# sky130_fd_sc_hd__dfrtp_1_52/a_1108_47# sky130_fd_sc_hd__dfrtp_1_52/a_1462_47# VGND sky130_fd_pr__nfet_01v8 ad=0.1092 pd=1.36 as=0.1281 ps=1.45 w=0.42 l=0.15
X5156 sky130_fd_sc_hd__dfrtp_1_52/a_651_413# sky130_fd_sc_hd__dfrtp_1_52/a_27_47# sky130_fd_sc_hd__dfrtp_1_52/a_543_47# VDPWR sky130_fd_pr__pfet_01v8_hvt ad=0.3402 pd=3.3 as=0.1449 ps=1.53 w=0.42 l=0.15
X5157 sky130_fd_sc_hd__dfrtp_1_52/a_1108_47# sky130_fd_sc_hd__dfrtp_1_52/a_193_47# sky130_fd_sc_hd__dfrtp_1_52/a_761_289# VGND sky130_fd_pr__special_nfet_01v8 ad=0 pd=0 as=0.1998 ps=1.97 w=0.36 l=0.15
X5158 VGND V3R301 sky130_fd_sc_hd__dfrtp_1_52/a_805_47# VGND sky130_fd_pr__nfet_01v8 ad=0 pd=0 as=0 ps=0 w=0.42 l=0.15
X5159 V3R019 sky130_fd_sc_hd__dfrtp_1_52/a_1283_21# VDPWR VDPWR sky130_fd_pr__pfet_01v8_hvt ad=0.26 pd=2.52 as=0 ps=0 w=1 l=0.15
X5160 VDPWR V3R082 sky130_fd_sc_hd__dfrtp_1_52/a_27_47# VDPWR sky130_fd_pr__pfet_01v8_hvt ad=0 pd=0 as=0.1664 ps=1.8 w=0.64 l=0.15
X5161 sky130_fd_sc_hd__dfrtp_1_52/a_448_47# V3R135 VDPWR VDPWR sky130_fd_pr__pfet_01v8_hvt ad=0.1302 pd=1.46 as=0 ps=0 w=0.42 l=0.15
X5162 sky130_fd_sc_hd__dfrtp_1_52/a_761_289# sky130_fd_sc_hd__dfrtp_1_52/a_543_47# VGND VGND sky130_fd_pr__nfet_01v8 ad=0 pd=0 as=0 ps=0 w=0.64 l=0.15
X5163 sky130_fd_sc_hd__dfrtp_1_52/a_193_47# sky130_fd_sc_hd__dfrtp_1_52/a_27_47# VGND VGND sky130_fd_pr__nfet_01v8 ad=0.1092 pd=1.36 as=0 ps=0 w=0.42 l=0.15
X5164 sky130_fd_sc_hd__dfrtp_1_52/a_1108_47# sky130_fd_sc_hd__dfrtp_1_52/a_27_47# sky130_fd_sc_hd__dfrtp_1_52/a_761_289# VDPWR sky130_fd_pr__pfet_01v8_hvt ad=0.1176 pd=1.4 as=0.2583 ps=2.37 w=0.42 l=0.15
X5165 sky130_fd_sc_hd__dfrtp_1_52/a_1462_47# V3R301 VGND VGND sky130_fd_pr__nfet_01v8 ad=0 pd=0 as=0 ps=0 w=0.42 l=0.15
X5166 sky130_fd_sc_hd__dfrtp_1_52/a_543_47# sky130_fd_sc_hd__dfrtp_1_52/a_27_47# sky130_fd_sc_hd__dfrtp_1_52/a_448_47# VGND sky130_fd_pr__special_nfet_01v8 ad=0.1188 pd=1.38 as=0.132 ps=1.49 w=0.36 l=0.15
X5167 sky130_fd_sc_hd__dfrtp_1_52/a_543_47# sky130_fd_sc_hd__dfrtp_1_52/a_193_47# sky130_fd_sc_hd__dfrtp_1_52/a_448_47# VDPWR sky130_fd_pr__pfet_01v8_hvt ad=0 pd=0 as=0 ps=0 w=0.42 l=0.15
X5168 sky130_fd_sc_hd__dfrtp_1_52/a_448_47# V3R135 VGND VGND sky130_fd_pr__nfet_01v8 ad=0 pd=0 as=0 ps=0 w=0.42 l=0.15
X5169 VDPWR sky130_fd_sc_hd__dfrtp_1_52/a_1283_21# sky130_fd_sc_hd__dfrtp_1_52/a_1270_413# VDPWR sky130_fd_pr__pfet_01v8_hvt ad=0 pd=0 as=0.1134 ps=1.38 w=0.42 l=0.15
X5170 VDPWR sky130_fd_sc_hd__dfrtp_1_52/a_1108_47# sky130_fd_sc_hd__dfrtp_1_52/a_1283_21# VDPWR sky130_fd_pr__pfet_01v8_hvt ad=0 pd=0 as=0.1134 ps=1.38 w=0.42 l=0.15
X5171 sky130_fd_sc_hd__dfrtp_1_52/a_1270_413# sky130_fd_sc_hd__dfrtp_1_52/a_193_47# sky130_fd_sc_hd__dfrtp_1_52/a_1108_47# VDPWR sky130_fd_pr__pfet_01v8_hvt ad=0 pd=0 as=0 ps=0 w=0.42 l=0.15
X5172 sky130_fd_sc_hd__dfrtp_1_52/a_193_47# sky130_fd_sc_hd__dfrtp_1_52/a_27_47# VDPWR VDPWR sky130_fd_pr__pfet_01v8_hvt ad=0.1664 pd=1.8 as=0 ps=0 w=0.64 l=0.15
X5173 sky130_fd_sc_hd__dfrtp_1_52/a_1283_21# V3R301 VDPWR VDPWR sky130_fd_pr__pfet_01v8_hvt ad=0 pd=0 as=0 ps=0 w=0.42 l=0.15
X5174 VDPWR sky130_fd_sc_hd__dfrtp_1_52/a_761_289# sky130_fd_sc_hd__dfrtp_1_52/a_651_413# VDPWR sky130_fd_pr__pfet_01v8_hvt ad=0 pd=0 as=0 ps=0 w=0.42 l=0.15
X5175 V3R019 sky130_fd_sc_hd__dfrtp_1_52/a_1283_21# VGND VGND sky130_fd_pr__nfet_01v8 ad=0.169 pd=1.82 as=0 ps=0 w=0.65 l=0.15
X5176 sky130_fd_sc_hd__dfrtp_1_52/a_639_47# sky130_fd_sc_hd__dfrtp_1_52/a_193_47# sky130_fd_sc_hd__dfrtp_1_52/a_543_47# VGND sky130_fd_pr__special_nfet_01v8 ad=0 pd=0 as=0 ps=0 w=0.36 l=0.15
X5177 VGND sky130_fd_sc_hd__dfrtp_1_52/a_1283_21# sky130_fd_sc_hd__dfrtp_1_52/a_1217_47# VGND sky130_fd_pr__nfet_01v8 ad=0 pd=0 as=0 ps=0 w=0.42 l=0.15
X5178 sky130_fd_sc_hd__dfrtp_1_52/a_651_413# V3R301 VDPWR VDPWR sky130_fd_pr__pfet_01v8_hvt ad=0 pd=0 as=0 ps=0 w=0.42 l=0.15
X5179 VGND V3R082 sky130_fd_sc_hd__dfrtp_1_52/a_27_47# VGND sky130_fd_pr__nfet_01v8 ad=0 pd=0 as=0.1092 ps=1.36 w=0.42 l=0.15
X5180 sky130_fd_sc_hd__dfrtp_1_52/a_761_289# sky130_fd_sc_hd__dfrtp_1_52/a_543_47# VDPWR VDPWR sky130_fd_pr__pfet_01v8_hvt ad=0 pd=0 as=0 ps=0 w=0.84 l=0.15
X5181 sky130_fd_sc_hd__dfrtp_1_41/a_805_47# sky130_fd_sc_hd__dfrtp_1_41/a_761_289# sky130_fd_sc_hd__dfrtp_1_41/a_639_47# VGND sky130_fd_pr__nfet_01v8 ad=0.0882 pd=1.26 as=0.2802 ps=2.2 w=0.42 l=0.15
X5182 sky130_fd_sc_hd__dfrtp_1_41/a_1217_47# sky130_fd_sc_hd__dfrtp_1_41/a_27_47# sky130_fd_sc_hd__dfrtp_1_41/a_1108_47# VGND sky130_fd_pr__special_nfet_01v8 ad=0.1338 pd=1.5 as=0.1422 ps=1.51 w=0.36 l=0.15
X5183 sky130_fd_sc_hd__dfrtp_1_41/a_1283_21# sky130_fd_sc_hd__dfrtp_1_41/a_1108_47# sky130_fd_sc_hd__dfrtp_1_41/a_1462_47# VGND sky130_fd_pr__nfet_01v8 ad=0.1092 pd=1.36 as=0.1281 ps=1.45 w=0.42 l=0.15
X5184 sky130_fd_sc_hd__dfrtp_1_41/a_651_413# sky130_fd_sc_hd__dfrtp_1_41/a_27_47# sky130_fd_sc_hd__dfrtp_1_41/a_543_47# VDPWR sky130_fd_pr__pfet_01v8_hvt ad=0.3402 pd=3.3 as=0.1449 ps=1.53 w=0.42 l=0.15
X5185 sky130_fd_sc_hd__dfrtp_1_41/a_1108_47# sky130_fd_sc_hd__dfrtp_1_41/a_193_47# sky130_fd_sc_hd__dfrtp_1_41/a_761_289# VGND sky130_fd_pr__special_nfet_01v8 ad=0 pd=0 as=0.1998 ps=1.97 w=0.36 l=0.15
X5186 VGND V3R302 sky130_fd_sc_hd__dfrtp_1_41/a_805_47# VGND sky130_fd_pr__nfet_01v8 ad=0 pd=0 as=0 ps=0 w=0.42 l=0.15
X5187 V3R067 sky130_fd_sc_hd__dfrtp_1_41/a_1283_21# VDPWR VDPWR sky130_fd_pr__pfet_01v8_hvt ad=0.26 pd=2.52 as=0 ps=0 w=1 l=0.15
X5188 VDPWR V3R083 sky130_fd_sc_hd__dfrtp_1_41/a_27_47# VDPWR sky130_fd_pr__pfet_01v8_hvt ad=0 pd=0 as=0.1664 ps=1.8 w=0.64 l=0.15
X5189 sky130_fd_sc_hd__dfrtp_1_41/a_448_47# V3R065 VDPWR VDPWR sky130_fd_pr__pfet_01v8_hvt ad=0.1302 pd=1.46 as=0 ps=0 w=0.42 l=0.15
X5190 sky130_fd_sc_hd__dfrtp_1_41/a_761_289# sky130_fd_sc_hd__dfrtp_1_41/a_543_47# VGND VGND sky130_fd_pr__nfet_01v8 ad=0 pd=0 as=0 ps=0 w=0.64 l=0.15
X5191 sky130_fd_sc_hd__dfrtp_1_41/a_193_47# sky130_fd_sc_hd__dfrtp_1_41/a_27_47# VGND VGND sky130_fd_pr__nfet_01v8 ad=0.1092 pd=1.36 as=0 ps=0 w=0.42 l=0.15
X5192 sky130_fd_sc_hd__dfrtp_1_41/a_1108_47# sky130_fd_sc_hd__dfrtp_1_41/a_27_47# sky130_fd_sc_hd__dfrtp_1_41/a_761_289# VDPWR sky130_fd_pr__pfet_01v8_hvt ad=0.1176 pd=1.4 as=0.2583 ps=2.37 w=0.42 l=0.15
X5193 sky130_fd_sc_hd__dfrtp_1_41/a_1462_47# V3R302 VGND VGND sky130_fd_pr__nfet_01v8 ad=0 pd=0 as=0 ps=0 w=0.42 l=0.15
X5194 sky130_fd_sc_hd__dfrtp_1_41/a_543_47# sky130_fd_sc_hd__dfrtp_1_41/a_27_47# sky130_fd_sc_hd__dfrtp_1_41/a_448_47# VGND sky130_fd_pr__special_nfet_01v8 ad=0.1188 pd=1.38 as=0.132 ps=1.49 w=0.36 l=0.15
X5195 sky130_fd_sc_hd__dfrtp_1_41/a_543_47# sky130_fd_sc_hd__dfrtp_1_41/a_193_47# sky130_fd_sc_hd__dfrtp_1_41/a_448_47# VDPWR sky130_fd_pr__pfet_01v8_hvt ad=0 pd=0 as=0 ps=0 w=0.42 l=0.15
X5196 sky130_fd_sc_hd__dfrtp_1_41/a_448_47# V3R065 VGND VGND sky130_fd_pr__nfet_01v8 ad=0 pd=0 as=0 ps=0 w=0.42 l=0.15
X5197 VDPWR sky130_fd_sc_hd__dfrtp_1_41/a_1283_21# sky130_fd_sc_hd__dfrtp_1_41/a_1270_413# VDPWR sky130_fd_pr__pfet_01v8_hvt ad=0 pd=0 as=0.1134 ps=1.38 w=0.42 l=0.15
X5198 VDPWR sky130_fd_sc_hd__dfrtp_1_41/a_1108_47# sky130_fd_sc_hd__dfrtp_1_41/a_1283_21# VDPWR sky130_fd_pr__pfet_01v8_hvt ad=0 pd=0 as=0.1134 ps=1.38 w=0.42 l=0.15
X5199 sky130_fd_sc_hd__dfrtp_1_41/a_1270_413# sky130_fd_sc_hd__dfrtp_1_41/a_193_47# sky130_fd_sc_hd__dfrtp_1_41/a_1108_47# VDPWR sky130_fd_pr__pfet_01v8_hvt ad=0 pd=0 as=0 ps=0 w=0.42 l=0.15
X5200 sky130_fd_sc_hd__dfrtp_1_41/a_193_47# sky130_fd_sc_hd__dfrtp_1_41/a_27_47# VDPWR VDPWR sky130_fd_pr__pfet_01v8_hvt ad=0.1664 pd=1.8 as=0 ps=0 w=0.64 l=0.15
X5201 sky130_fd_sc_hd__dfrtp_1_41/a_1283_21# V3R302 VDPWR VDPWR sky130_fd_pr__pfet_01v8_hvt ad=0 pd=0 as=0 ps=0 w=0.42 l=0.15
X5202 VDPWR sky130_fd_sc_hd__dfrtp_1_41/a_761_289# sky130_fd_sc_hd__dfrtp_1_41/a_651_413# VDPWR sky130_fd_pr__pfet_01v8_hvt ad=0 pd=0 as=0 ps=0 w=0.42 l=0.15
X5203 V3R067 sky130_fd_sc_hd__dfrtp_1_41/a_1283_21# VGND VGND sky130_fd_pr__nfet_01v8 ad=0.169 pd=1.82 as=0 ps=0 w=0.65 l=0.15
X5204 sky130_fd_sc_hd__dfrtp_1_41/a_639_47# sky130_fd_sc_hd__dfrtp_1_41/a_193_47# sky130_fd_sc_hd__dfrtp_1_41/a_543_47# VGND sky130_fd_pr__special_nfet_01v8 ad=0 pd=0 as=0 ps=0 w=0.36 l=0.15
X5205 VGND sky130_fd_sc_hd__dfrtp_1_41/a_1283_21# sky130_fd_sc_hd__dfrtp_1_41/a_1217_47# VGND sky130_fd_pr__nfet_01v8 ad=0 pd=0 as=0 ps=0 w=0.42 l=0.15
X5206 sky130_fd_sc_hd__dfrtp_1_41/a_651_413# V3R302 VDPWR VDPWR sky130_fd_pr__pfet_01v8_hvt ad=0 pd=0 as=0 ps=0 w=0.42 l=0.15
X5207 VGND V3R083 sky130_fd_sc_hd__dfrtp_1_41/a_27_47# VGND sky130_fd_pr__nfet_01v8 ad=0 pd=0 as=0.1092 ps=1.36 w=0.42 l=0.15
X5208 sky130_fd_sc_hd__dfrtp_1_41/a_761_289# sky130_fd_sc_hd__dfrtp_1_41/a_543_47# VDPWR VDPWR sky130_fd_pr__pfet_01v8_hvt ad=0 pd=0 as=0 ps=0 w=0.84 l=0.15
X5209 sky130_fd_sc_hd__dfrtp_1_85/a_805_47# sky130_fd_sc_hd__dfrtp_1_85/a_761_289# sky130_fd_sc_hd__dfrtp_1_85/a_639_47# VGND sky130_fd_pr__nfet_01v8 ad=0.0882 pd=1.26 as=0.2802 ps=2.2 w=0.42 l=0.15
X5210 sky130_fd_sc_hd__dfrtp_1_85/a_1217_47# sky130_fd_sc_hd__dfrtp_1_85/a_27_47# sky130_fd_sc_hd__dfrtp_1_85/a_1108_47# VGND sky130_fd_pr__special_nfet_01v8 ad=0.1338 pd=1.5 as=0.1422 ps=1.51 w=0.36 l=0.15
X5211 sky130_fd_sc_hd__dfrtp_1_85/a_1283_21# sky130_fd_sc_hd__dfrtp_1_85/a_1108_47# sky130_fd_sc_hd__dfrtp_1_85/a_1462_47# VGND sky130_fd_pr__nfet_01v8 ad=0.1092 pd=1.36 as=0.1281 ps=1.45 w=0.42 l=0.15
X5212 sky130_fd_sc_hd__dfrtp_1_85/a_651_413# sky130_fd_sc_hd__dfrtp_1_85/a_27_47# sky130_fd_sc_hd__dfrtp_1_85/a_543_47# VDPWR sky130_fd_pr__pfet_01v8_hvt ad=0.3402 pd=3.3 as=0.1449 ps=1.53 w=0.42 l=0.15
X5213 sky130_fd_sc_hd__dfrtp_1_85/a_1108_47# sky130_fd_sc_hd__dfrtp_1_85/a_193_47# sky130_fd_sc_hd__dfrtp_1_85/a_761_289# VGND sky130_fd_pr__special_nfet_01v8 ad=0 pd=0 as=0.1998 ps=1.97 w=0.36 l=0.15
X5214 VGND V3R298 sky130_fd_sc_hd__dfrtp_1_85/a_805_47# VGND sky130_fd_pr__nfet_01v8 ad=0 pd=0 as=0 ps=0 w=0.42 l=0.15
X5215 V3R150 sky130_fd_sc_hd__dfrtp_1_85/a_1283_21# VDPWR VDPWR sky130_fd_pr__pfet_01v8_hvt ad=0.26 pd=2.52 as=0 ps=0 w=1 l=0.15
X5216 VDPWR V3R055 sky130_fd_sc_hd__dfrtp_1_85/a_27_47# VDPWR sky130_fd_pr__pfet_01v8_hvt ad=0 pd=0 as=0.1664 ps=1.8 w=0.64 l=0.15
X5217 sky130_fd_sc_hd__dfrtp_1_85/a_448_47# V3R086 VDPWR VDPWR sky130_fd_pr__pfet_01v8_hvt ad=0.1302 pd=1.46 as=0 ps=0 w=0.42 l=0.15
X5218 sky130_fd_sc_hd__dfrtp_1_85/a_761_289# sky130_fd_sc_hd__dfrtp_1_85/a_543_47# VGND VGND sky130_fd_pr__nfet_01v8 ad=0 pd=0 as=0 ps=0 w=0.64 l=0.15
X5219 sky130_fd_sc_hd__dfrtp_1_85/a_193_47# sky130_fd_sc_hd__dfrtp_1_85/a_27_47# VGND VGND sky130_fd_pr__nfet_01v8 ad=0.1092 pd=1.36 as=0 ps=0 w=0.42 l=0.15
X5220 sky130_fd_sc_hd__dfrtp_1_85/a_1108_47# sky130_fd_sc_hd__dfrtp_1_85/a_27_47# sky130_fd_sc_hd__dfrtp_1_85/a_761_289# VDPWR sky130_fd_pr__pfet_01v8_hvt ad=0.1176 pd=1.4 as=0.2583 ps=2.37 w=0.42 l=0.15
X5221 sky130_fd_sc_hd__dfrtp_1_85/a_1462_47# V3R298 VGND VGND sky130_fd_pr__nfet_01v8 ad=0 pd=0 as=0 ps=0 w=0.42 l=0.15
X5222 sky130_fd_sc_hd__dfrtp_1_85/a_543_47# sky130_fd_sc_hd__dfrtp_1_85/a_27_47# sky130_fd_sc_hd__dfrtp_1_85/a_448_47# VGND sky130_fd_pr__special_nfet_01v8 ad=0.1188 pd=1.38 as=0.132 ps=1.49 w=0.36 l=0.15
X5223 sky130_fd_sc_hd__dfrtp_1_85/a_543_47# sky130_fd_sc_hd__dfrtp_1_85/a_193_47# sky130_fd_sc_hd__dfrtp_1_85/a_448_47# VDPWR sky130_fd_pr__pfet_01v8_hvt ad=0 pd=0 as=0 ps=0 w=0.42 l=0.15
X5224 sky130_fd_sc_hd__dfrtp_1_85/a_448_47# V3R086 VGND VGND sky130_fd_pr__nfet_01v8 ad=0 pd=0 as=0 ps=0 w=0.42 l=0.15
X5225 VDPWR sky130_fd_sc_hd__dfrtp_1_85/a_1283_21# sky130_fd_sc_hd__dfrtp_1_85/a_1270_413# VDPWR sky130_fd_pr__pfet_01v8_hvt ad=0 pd=0 as=0.1134 ps=1.38 w=0.42 l=0.15
X5226 VDPWR sky130_fd_sc_hd__dfrtp_1_85/a_1108_47# sky130_fd_sc_hd__dfrtp_1_85/a_1283_21# VDPWR sky130_fd_pr__pfet_01v8_hvt ad=0 pd=0 as=0.1134 ps=1.38 w=0.42 l=0.15
X5227 sky130_fd_sc_hd__dfrtp_1_85/a_1270_413# sky130_fd_sc_hd__dfrtp_1_85/a_193_47# sky130_fd_sc_hd__dfrtp_1_85/a_1108_47# VDPWR sky130_fd_pr__pfet_01v8_hvt ad=0 pd=0 as=0 ps=0 w=0.42 l=0.15
X5228 sky130_fd_sc_hd__dfrtp_1_85/a_193_47# sky130_fd_sc_hd__dfrtp_1_85/a_27_47# VDPWR VDPWR sky130_fd_pr__pfet_01v8_hvt ad=0.1664 pd=1.8 as=0 ps=0 w=0.64 l=0.15
X5229 sky130_fd_sc_hd__dfrtp_1_85/a_1283_21# V3R298 VDPWR VDPWR sky130_fd_pr__pfet_01v8_hvt ad=0 pd=0 as=0 ps=0 w=0.42 l=0.15
X5230 VDPWR sky130_fd_sc_hd__dfrtp_1_85/a_761_289# sky130_fd_sc_hd__dfrtp_1_85/a_651_413# VDPWR sky130_fd_pr__pfet_01v8_hvt ad=0 pd=0 as=0 ps=0 w=0.42 l=0.15
X5231 V3R150 sky130_fd_sc_hd__dfrtp_1_85/a_1283_21# VGND VGND sky130_fd_pr__nfet_01v8 ad=0.169 pd=1.82 as=0 ps=0 w=0.65 l=0.15
X5232 sky130_fd_sc_hd__dfrtp_1_85/a_639_47# sky130_fd_sc_hd__dfrtp_1_85/a_193_47# sky130_fd_sc_hd__dfrtp_1_85/a_543_47# VGND sky130_fd_pr__special_nfet_01v8 ad=0 pd=0 as=0 ps=0 w=0.36 l=0.15
X5233 VGND sky130_fd_sc_hd__dfrtp_1_85/a_1283_21# sky130_fd_sc_hd__dfrtp_1_85/a_1217_47# VGND sky130_fd_pr__nfet_01v8 ad=0 pd=0 as=0 ps=0 w=0.42 l=0.15
X5234 sky130_fd_sc_hd__dfrtp_1_85/a_651_413# V3R298 VDPWR VDPWR sky130_fd_pr__pfet_01v8_hvt ad=0 pd=0 as=0 ps=0 w=0.42 l=0.15
X5235 VGND V3R055 sky130_fd_sc_hd__dfrtp_1_85/a_27_47# VGND sky130_fd_pr__nfet_01v8 ad=0 pd=0 as=0.1092 ps=1.36 w=0.42 l=0.15
X5236 sky130_fd_sc_hd__dfrtp_1_85/a_761_289# sky130_fd_sc_hd__dfrtp_1_85/a_543_47# VDPWR VDPWR sky130_fd_pr__pfet_01v8_hvt ad=0 pd=0 as=0 ps=0 w=0.84 l=0.15
X5237 sky130_fd_sc_hd__dfrtp_1_30/a_805_47# sky130_fd_sc_hd__dfrtp_1_30/a_761_289# sky130_fd_sc_hd__dfrtp_1_30/a_639_47# VGND sky130_fd_pr__nfet_01v8 ad=0.0882 pd=1.26 as=0.2802 ps=2.2 w=0.42 l=0.15
X5238 sky130_fd_sc_hd__dfrtp_1_30/a_1217_47# sky130_fd_sc_hd__dfrtp_1_30/a_27_47# sky130_fd_sc_hd__dfrtp_1_30/a_1108_47# VGND sky130_fd_pr__special_nfet_01v8 ad=0.1338 pd=1.5 as=0.1422 ps=1.51 w=0.36 l=0.15
X5239 sky130_fd_sc_hd__dfrtp_1_30/a_1283_21# sky130_fd_sc_hd__dfrtp_1_30/a_1108_47# sky130_fd_sc_hd__dfrtp_1_30/a_1462_47# VGND sky130_fd_pr__nfet_01v8 ad=0.1092 pd=1.36 as=0.1281 ps=1.45 w=0.42 l=0.15
X5240 sky130_fd_sc_hd__dfrtp_1_30/a_651_413# sky130_fd_sc_hd__dfrtp_1_30/a_27_47# sky130_fd_sc_hd__dfrtp_1_30/a_543_47# VDPWR sky130_fd_pr__pfet_01v8_hvt ad=0.3402 pd=3.3 as=0.1449 ps=1.53 w=0.42 l=0.15
X5241 sky130_fd_sc_hd__dfrtp_1_30/a_1108_47# sky130_fd_sc_hd__dfrtp_1_30/a_193_47# sky130_fd_sc_hd__dfrtp_1_30/a_761_289# VGND sky130_fd_pr__special_nfet_01v8 ad=0 pd=0 as=0.1998 ps=1.97 w=0.36 l=0.15
X5242 VGND V3R299 sky130_fd_sc_hd__dfrtp_1_30/a_805_47# VGND sky130_fd_pr__nfet_01v8 ad=0 pd=0 as=0 ps=0 w=0.42 l=0.15
X5243 V3R165 sky130_fd_sc_hd__dfrtp_1_30/a_1283_21# VDPWR VDPWR sky130_fd_pr__pfet_01v8_hvt ad=0.26 pd=2.52 as=0 ps=0 w=1 l=0.15
X5244 VDPWR V3R056 sky130_fd_sc_hd__dfrtp_1_30/a_27_47# VDPWR sky130_fd_pr__pfet_01v8_hvt ad=0 pd=0 as=0.1664 ps=1.8 w=0.64 l=0.15
X5245 sky130_fd_sc_hd__dfrtp_1_30/a_448_47# V3R109 VDPWR VDPWR sky130_fd_pr__pfet_01v8_hvt ad=0.1302 pd=1.46 as=0 ps=0 w=0.42 l=0.15
X5246 sky130_fd_sc_hd__dfrtp_1_30/a_761_289# sky130_fd_sc_hd__dfrtp_1_30/a_543_47# VGND VGND sky130_fd_pr__nfet_01v8 ad=0 pd=0 as=0 ps=0 w=0.64 l=0.15
X5247 sky130_fd_sc_hd__dfrtp_1_30/a_193_47# sky130_fd_sc_hd__dfrtp_1_30/a_27_47# VGND VGND sky130_fd_pr__nfet_01v8 ad=0.1092 pd=1.36 as=0 ps=0 w=0.42 l=0.15
X5248 sky130_fd_sc_hd__dfrtp_1_30/a_1108_47# sky130_fd_sc_hd__dfrtp_1_30/a_27_47# sky130_fd_sc_hd__dfrtp_1_30/a_761_289# VDPWR sky130_fd_pr__pfet_01v8_hvt ad=0.1176 pd=1.4 as=0.2583 ps=2.37 w=0.42 l=0.15
X5249 sky130_fd_sc_hd__dfrtp_1_30/a_1462_47# V3R299 VGND VGND sky130_fd_pr__nfet_01v8 ad=0 pd=0 as=0 ps=0 w=0.42 l=0.15
X5250 sky130_fd_sc_hd__dfrtp_1_30/a_543_47# sky130_fd_sc_hd__dfrtp_1_30/a_27_47# sky130_fd_sc_hd__dfrtp_1_30/a_448_47# VGND sky130_fd_pr__special_nfet_01v8 ad=0.1188 pd=1.38 as=0.132 ps=1.49 w=0.36 l=0.15
X5251 sky130_fd_sc_hd__dfrtp_1_30/a_543_47# sky130_fd_sc_hd__dfrtp_1_30/a_193_47# sky130_fd_sc_hd__dfrtp_1_30/a_448_47# VDPWR sky130_fd_pr__pfet_01v8_hvt ad=0 pd=0 as=0 ps=0 w=0.42 l=0.15
X5252 sky130_fd_sc_hd__dfrtp_1_30/a_448_47# V3R109 VGND VGND sky130_fd_pr__nfet_01v8 ad=0 pd=0 as=0 ps=0 w=0.42 l=0.15
X5253 VDPWR sky130_fd_sc_hd__dfrtp_1_30/a_1283_21# sky130_fd_sc_hd__dfrtp_1_30/a_1270_413# VDPWR sky130_fd_pr__pfet_01v8_hvt ad=0 pd=0 as=0.1134 ps=1.38 w=0.42 l=0.15
X5254 VDPWR sky130_fd_sc_hd__dfrtp_1_30/a_1108_47# sky130_fd_sc_hd__dfrtp_1_30/a_1283_21# VDPWR sky130_fd_pr__pfet_01v8_hvt ad=0 pd=0 as=0.1134 ps=1.38 w=0.42 l=0.15
X5255 sky130_fd_sc_hd__dfrtp_1_30/a_1270_413# sky130_fd_sc_hd__dfrtp_1_30/a_193_47# sky130_fd_sc_hd__dfrtp_1_30/a_1108_47# VDPWR sky130_fd_pr__pfet_01v8_hvt ad=0 pd=0 as=0 ps=0 w=0.42 l=0.15
X5256 sky130_fd_sc_hd__dfrtp_1_30/a_193_47# sky130_fd_sc_hd__dfrtp_1_30/a_27_47# VDPWR VDPWR sky130_fd_pr__pfet_01v8_hvt ad=0.1664 pd=1.8 as=0 ps=0 w=0.64 l=0.15
X5257 sky130_fd_sc_hd__dfrtp_1_30/a_1283_21# V3R299 VDPWR VDPWR sky130_fd_pr__pfet_01v8_hvt ad=0 pd=0 as=0 ps=0 w=0.42 l=0.15
X5258 VDPWR sky130_fd_sc_hd__dfrtp_1_30/a_761_289# sky130_fd_sc_hd__dfrtp_1_30/a_651_413# VDPWR sky130_fd_pr__pfet_01v8_hvt ad=0 pd=0 as=0 ps=0 w=0.42 l=0.15
X5259 V3R165 sky130_fd_sc_hd__dfrtp_1_30/a_1283_21# VGND VGND sky130_fd_pr__nfet_01v8 ad=0.169 pd=1.82 as=0 ps=0 w=0.65 l=0.15
X5260 sky130_fd_sc_hd__dfrtp_1_30/a_639_47# sky130_fd_sc_hd__dfrtp_1_30/a_193_47# sky130_fd_sc_hd__dfrtp_1_30/a_543_47# VGND sky130_fd_pr__special_nfet_01v8 ad=0 pd=0 as=0 ps=0 w=0.36 l=0.15
X5261 VGND sky130_fd_sc_hd__dfrtp_1_30/a_1283_21# sky130_fd_sc_hd__dfrtp_1_30/a_1217_47# VGND sky130_fd_pr__nfet_01v8 ad=0 pd=0 as=0 ps=0 w=0.42 l=0.15
X5262 sky130_fd_sc_hd__dfrtp_1_30/a_651_413# V3R299 VDPWR VDPWR sky130_fd_pr__pfet_01v8_hvt ad=0 pd=0 as=0 ps=0 w=0.42 l=0.15
X5263 VGND V3R056 sky130_fd_sc_hd__dfrtp_1_30/a_27_47# VGND sky130_fd_pr__nfet_01v8 ad=0 pd=0 as=0.1092 ps=1.36 w=0.42 l=0.15
X5264 sky130_fd_sc_hd__dfrtp_1_30/a_761_289# sky130_fd_sc_hd__dfrtp_1_30/a_543_47# VDPWR VDPWR sky130_fd_pr__pfet_01v8_hvt ad=0 pd=0 as=0 ps=0 w=0.84 l=0.15
X5265 VDPWR sky130_fd_sc_hd__mux2_1_0/a_505_21# sky130_fd_sc_hd__mux2_1_0/a_535_374# VDPWR sky130_fd_pr__pfet_01v8_hvt ad=0 pd=0 as=0.0882 ps=1.26 w=0.42 l=0.15
X5266 sky130_fd_sc_hd__mux2_1_0/a_505_21# V3R062 VDPWR VDPWR sky130_fd_pr__pfet_01v8_hvt ad=0.1176 pd=1.4 as=0 ps=0 w=0.42 l=0.15
X5267 sky130_fd_sc_hd__mux2_1_0/a_218_374# V3R062 VDPWR VDPWR sky130_fd_pr__pfet_01v8_hvt ad=0.1533 pd=1.57 as=0 ps=0 w=0.42 l=0.15
X5268 VGND sky130_fd_sc_hd__mux2_1_0/a_505_21# sky130_fd_sc_hd__mux2_1_0/a_439_47# VGND sky130_fd_pr__nfet_01v8 ad=0 pd=0 as=0.1386 ps=1.5 w=0.42 l=0.15
X5269 sky130_fd_sc_hd__mux2_1_0/a_76_199# V3R059 sky130_fd_sc_hd__mux2_1_0/a_218_374# VDPWR sky130_fd_pr__pfet_01v8_hvt ad=0.3864 pd=2.68 as=0 ps=0 w=0.42 l=0.15
X5270 sky130_fd_sc_hd__mux2_1_0/a_505_21# V3R062 VGND VGND sky130_fd_pr__nfet_01v8 ad=0.1092 pd=1.36 as=0 ps=0 w=0.42 l=0.15
X5271 sky130_fd_sc_hd__mux2_1_0/a_439_47# V3R059 sky130_fd_sc_hd__mux2_1_0/a_76_199# VGND sky130_fd_pr__nfet_01v8 ad=0 pd=0 as=0.1995 ps=1.79 w=0.42 l=0.15
X5272 sky130_fd_sc_hd__mux2_1_0/a_535_374# V3R174 sky130_fd_sc_hd__mux2_1_0/a_76_199# VDPWR sky130_fd_pr__pfet_01v8_hvt ad=0 pd=0 as=0 ps=0 w=0.42 l=0.15
X5273 sky130_fd_sc_hd__mux2_1_0/a_76_199# V3R174 sky130_fd_sc_hd__mux2_1_0/a_218_47# VGND sky130_fd_pr__nfet_01v8 ad=0 pd=0 as=0.1386 ps=1.5 w=0.42 l=0.15
X5274 sky130_fd_sc_hd__mux2_1_0/a_218_47# V3R062 VGND VGND sky130_fd_pr__nfet_01v8 ad=0 pd=0 as=0 ps=0 w=0.42 l=0.15
X5275 VDPWR sky130_fd_sc_hd__mux2_1_0/a_76_199# V3R117 VDPWR sky130_fd_pr__pfet_01v8_hvt ad=0 pd=0 as=0.26 ps=2.52 w=1 l=0.15
X5276 VGND sky130_fd_sc_hd__mux2_1_0/a_76_199# V3R117 VGND sky130_fd_pr__nfet_01v8 ad=0 pd=0 as=0.169 ps=1.82 w=0.65 l=0.15
X5277 VDPWR sky130_fd_sc_hd__mux2_1_101/a_505_21# sky130_fd_sc_hd__mux2_1_101/a_535_374# VDPWR sky130_fd_pr__pfet_01v8_hvt ad=0 pd=0 as=0.0882 ps=1.26 w=0.42 l=0.15
X5278 sky130_fd_sc_hd__mux2_1_101/a_505_21# V3R044 VDPWR VDPWR sky130_fd_pr__pfet_01v8_hvt ad=0.1176 pd=1.4 as=0 ps=0 w=0.42 l=0.15
X5279 sky130_fd_sc_hd__mux2_1_101/a_218_374# V3R044 VDPWR VDPWR sky130_fd_pr__pfet_01v8_hvt ad=0.1533 pd=1.57 as=0 ps=0 w=0.42 l=0.15
X5280 VGND sky130_fd_sc_hd__mux2_1_101/a_505_21# sky130_fd_sc_hd__mux2_1_101/a_439_47# VGND sky130_fd_pr__nfet_01v8 ad=0 pd=0 as=0.1386 ps=1.5 w=0.42 l=0.15
X5281 sky130_fd_sc_hd__mux2_1_101/a_76_199# V3R011 sky130_fd_sc_hd__mux2_1_101/a_218_374# VDPWR sky130_fd_pr__pfet_01v8_hvt ad=0.3864 pd=2.68 as=0 ps=0 w=0.42 l=0.15
X5282 sky130_fd_sc_hd__mux2_1_101/a_505_21# V3R044 VGND VGND sky130_fd_pr__nfet_01v8 ad=0.1092 pd=1.36 as=0 ps=0 w=0.42 l=0.15
X5283 sky130_fd_sc_hd__mux2_1_101/a_439_47# V3R011 sky130_fd_sc_hd__mux2_1_101/a_76_199# VGND sky130_fd_pr__nfet_01v8 ad=0 pd=0 as=0.1995 ps=1.79 w=0.42 l=0.15
X5284 sky130_fd_sc_hd__mux2_1_101/a_535_374# V3R150 sky130_fd_sc_hd__mux2_1_101/a_76_199# VDPWR sky130_fd_pr__pfet_01v8_hvt ad=0 pd=0 as=0 ps=0 w=0.42 l=0.15
X5285 sky130_fd_sc_hd__mux2_1_101/a_76_199# V3R150 sky130_fd_sc_hd__mux2_1_101/a_218_47# VGND sky130_fd_pr__nfet_01v8 ad=0 pd=0 as=0.1386 ps=1.5 w=0.42 l=0.15
X5286 sky130_fd_sc_hd__mux2_1_101/a_218_47# V3R044 VGND VGND sky130_fd_pr__nfet_01v8 ad=0 pd=0 as=0 ps=0 w=0.42 l=0.15
X5287 VDPWR sky130_fd_sc_hd__mux2_1_101/a_76_199# V3R118 VDPWR sky130_fd_pr__pfet_01v8_hvt ad=0 pd=0 as=0.26 ps=2.52 w=1 l=0.15
X5288 VGND sky130_fd_sc_hd__mux2_1_101/a_76_199# V3R118 VGND sky130_fd_pr__nfet_01v8 ad=0 pd=0 as=0.169 ps=1.82 w=0.65 l=0.15
X5289 V3R293 V3R291 VGND VGND sky130_fd_pr__nfet_01v8 ad=0.169 pd=1.82 as=0 ps=0 w=0.65 l=0.15
X5290 V3R293 V3R291 VDPWR VDPWR sky130_fd_pr__pfet_01v8_hvt ad=0.26 pd=2.52 as=0 ps=0 w=1 l=0.15
X5291 sky130_fd_sc_hd__dfrtp_1_86/a_805_47# sky130_fd_sc_hd__dfrtp_1_86/a_761_289# sky130_fd_sc_hd__dfrtp_1_86/a_639_47# VGND sky130_fd_pr__nfet_01v8 ad=0.0882 pd=1.26 as=0.2802 ps=2.2 w=0.42 l=0.15
X5292 sky130_fd_sc_hd__dfrtp_1_86/a_1217_47# sky130_fd_sc_hd__dfrtp_1_86/a_27_47# sky130_fd_sc_hd__dfrtp_1_86/a_1108_47# VGND sky130_fd_pr__special_nfet_01v8 ad=0.1338 pd=1.5 as=0.1422 ps=1.51 w=0.36 l=0.15
X5293 sky130_fd_sc_hd__dfrtp_1_86/a_1283_21# sky130_fd_sc_hd__dfrtp_1_86/a_1108_47# sky130_fd_sc_hd__dfrtp_1_86/a_1462_47# VGND sky130_fd_pr__nfet_01v8 ad=0.1092 pd=1.36 as=0.1281 ps=1.45 w=0.42 l=0.15
X5294 sky130_fd_sc_hd__dfrtp_1_86/a_651_413# sky130_fd_sc_hd__dfrtp_1_86/a_27_47# sky130_fd_sc_hd__dfrtp_1_86/a_543_47# VDPWR sky130_fd_pr__pfet_01v8_hvt ad=0.3402 pd=3.3 as=0.1449 ps=1.53 w=0.42 l=0.15
X5295 sky130_fd_sc_hd__dfrtp_1_86/a_1108_47# sky130_fd_sc_hd__dfrtp_1_86/a_193_47# sky130_fd_sc_hd__dfrtp_1_86/a_761_289# VGND sky130_fd_pr__special_nfet_01v8 ad=0 pd=0 as=0.1998 ps=1.97 w=0.36 l=0.15
X5296 VGND V3R300 sky130_fd_sc_hd__dfrtp_1_86/a_805_47# VGND sky130_fd_pr__nfet_01v8 ad=0 pd=0 as=0 ps=0 w=0.42 l=0.15
X5297 V3R011 sky130_fd_sc_hd__dfrtp_1_86/a_1283_21# VDPWR VDPWR sky130_fd_pr__pfet_01v8_hvt ad=0.26 pd=2.52 as=0 ps=0 w=1 l=0.15
X5298 VDPWR V3R081 sky130_fd_sc_hd__dfrtp_1_86/a_27_47# VDPWR sky130_fd_pr__pfet_01v8_hvt ad=0 pd=0 as=0.1664 ps=1.8 w=0.64 l=0.15
X5299 sky130_fd_sc_hd__dfrtp_1_86/a_448_47# V3R118 VDPWR VDPWR sky130_fd_pr__pfet_01v8_hvt ad=0.1302 pd=1.46 as=0 ps=0 w=0.42 l=0.15
X5300 sky130_fd_sc_hd__dfrtp_1_86/a_761_289# sky130_fd_sc_hd__dfrtp_1_86/a_543_47# VGND VGND sky130_fd_pr__nfet_01v8 ad=0 pd=0 as=0 ps=0 w=0.64 l=0.15
X5301 sky130_fd_sc_hd__dfrtp_1_86/a_193_47# sky130_fd_sc_hd__dfrtp_1_86/a_27_47# VGND VGND sky130_fd_pr__nfet_01v8 ad=0.1092 pd=1.36 as=0 ps=0 w=0.42 l=0.15
X5302 sky130_fd_sc_hd__dfrtp_1_86/a_1108_47# sky130_fd_sc_hd__dfrtp_1_86/a_27_47# sky130_fd_sc_hd__dfrtp_1_86/a_761_289# VDPWR sky130_fd_pr__pfet_01v8_hvt ad=0.1176 pd=1.4 as=0.2583 ps=2.37 w=0.42 l=0.15
X5303 sky130_fd_sc_hd__dfrtp_1_86/a_1462_47# V3R300 VGND VGND sky130_fd_pr__nfet_01v8 ad=0 pd=0 as=0 ps=0 w=0.42 l=0.15
X5304 sky130_fd_sc_hd__dfrtp_1_86/a_543_47# sky130_fd_sc_hd__dfrtp_1_86/a_27_47# sky130_fd_sc_hd__dfrtp_1_86/a_448_47# VGND sky130_fd_pr__special_nfet_01v8 ad=0.1188 pd=1.38 as=0.132 ps=1.49 w=0.36 l=0.15
X5305 sky130_fd_sc_hd__dfrtp_1_86/a_543_47# sky130_fd_sc_hd__dfrtp_1_86/a_193_47# sky130_fd_sc_hd__dfrtp_1_86/a_448_47# VDPWR sky130_fd_pr__pfet_01v8_hvt ad=0 pd=0 as=0 ps=0 w=0.42 l=0.15
X5306 sky130_fd_sc_hd__dfrtp_1_86/a_448_47# V3R118 VGND VGND sky130_fd_pr__nfet_01v8 ad=0 pd=0 as=0 ps=0 w=0.42 l=0.15
X5307 VDPWR sky130_fd_sc_hd__dfrtp_1_86/a_1283_21# sky130_fd_sc_hd__dfrtp_1_86/a_1270_413# VDPWR sky130_fd_pr__pfet_01v8_hvt ad=0 pd=0 as=0.1134 ps=1.38 w=0.42 l=0.15
X5308 VDPWR sky130_fd_sc_hd__dfrtp_1_86/a_1108_47# sky130_fd_sc_hd__dfrtp_1_86/a_1283_21# VDPWR sky130_fd_pr__pfet_01v8_hvt ad=0 pd=0 as=0.1134 ps=1.38 w=0.42 l=0.15
X5309 sky130_fd_sc_hd__dfrtp_1_86/a_1270_413# sky130_fd_sc_hd__dfrtp_1_86/a_193_47# sky130_fd_sc_hd__dfrtp_1_86/a_1108_47# VDPWR sky130_fd_pr__pfet_01v8_hvt ad=0 pd=0 as=0 ps=0 w=0.42 l=0.15
X5310 sky130_fd_sc_hd__dfrtp_1_86/a_193_47# sky130_fd_sc_hd__dfrtp_1_86/a_27_47# VDPWR VDPWR sky130_fd_pr__pfet_01v8_hvt ad=0.1664 pd=1.8 as=0 ps=0 w=0.64 l=0.15
X5311 sky130_fd_sc_hd__dfrtp_1_86/a_1283_21# V3R300 VDPWR VDPWR sky130_fd_pr__pfet_01v8_hvt ad=0 pd=0 as=0 ps=0 w=0.42 l=0.15
X5312 VDPWR sky130_fd_sc_hd__dfrtp_1_86/a_761_289# sky130_fd_sc_hd__dfrtp_1_86/a_651_413# VDPWR sky130_fd_pr__pfet_01v8_hvt ad=0 pd=0 as=0 ps=0 w=0.42 l=0.15
X5313 V3R011 sky130_fd_sc_hd__dfrtp_1_86/a_1283_21# VGND VGND sky130_fd_pr__nfet_01v8 ad=0.169 pd=1.82 as=0 ps=0 w=0.65 l=0.15
X5314 sky130_fd_sc_hd__dfrtp_1_86/a_639_47# sky130_fd_sc_hd__dfrtp_1_86/a_193_47# sky130_fd_sc_hd__dfrtp_1_86/a_543_47# VGND sky130_fd_pr__special_nfet_01v8 ad=0 pd=0 as=0 ps=0 w=0.36 l=0.15
X5315 VGND sky130_fd_sc_hd__dfrtp_1_86/a_1283_21# sky130_fd_sc_hd__dfrtp_1_86/a_1217_47# VGND sky130_fd_pr__nfet_01v8 ad=0 pd=0 as=0 ps=0 w=0.42 l=0.15
X5316 sky130_fd_sc_hd__dfrtp_1_86/a_651_413# V3R300 VDPWR VDPWR sky130_fd_pr__pfet_01v8_hvt ad=0 pd=0 as=0 ps=0 w=0.42 l=0.15
X5317 VGND V3R081 sky130_fd_sc_hd__dfrtp_1_86/a_27_47# VGND sky130_fd_pr__nfet_01v8 ad=0 pd=0 as=0.1092 ps=1.36 w=0.42 l=0.15
X5318 sky130_fd_sc_hd__dfrtp_1_86/a_761_289# sky130_fd_sc_hd__dfrtp_1_86/a_543_47# VDPWR VDPWR sky130_fd_pr__pfet_01v8_hvt ad=0 pd=0 as=0 ps=0 w=0.84 l=0.15
X5319 sky130_fd_sc_hd__dfrtp_1_75/a_805_47# sky130_fd_sc_hd__dfrtp_1_75/a_761_289# sky130_fd_sc_hd__dfrtp_1_75/a_639_47# VGND sky130_fd_pr__nfet_01v8 ad=0.0882 pd=1.26 as=0.2802 ps=2.2 w=0.42 l=0.15
X5320 sky130_fd_sc_hd__dfrtp_1_75/a_1217_47# sky130_fd_sc_hd__dfrtp_1_75/a_27_47# sky130_fd_sc_hd__dfrtp_1_75/a_1108_47# VGND sky130_fd_pr__special_nfet_01v8 ad=0.1338 pd=1.5 as=0.1422 ps=1.51 w=0.36 l=0.15
X5321 sky130_fd_sc_hd__dfrtp_1_75/a_1283_21# sky130_fd_sc_hd__dfrtp_1_75/a_1108_47# sky130_fd_sc_hd__dfrtp_1_75/a_1462_47# VGND sky130_fd_pr__nfet_01v8 ad=0.1092 pd=1.36 as=0.1281 ps=1.45 w=0.42 l=0.15
X5322 sky130_fd_sc_hd__dfrtp_1_75/a_651_413# sky130_fd_sc_hd__dfrtp_1_75/a_27_47# sky130_fd_sc_hd__dfrtp_1_75/a_543_47# VDPWR sky130_fd_pr__pfet_01v8_hvt ad=0.3402 pd=3.3 as=0.1449 ps=1.53 w=0.42 l=0.15
X5323 sky130_fd_sc_hd__dfrtp_1_75/a_1108_47# sky130_fd_sc_hd__dfrtp_1_75/a_193_47# sky130_fd_sc_hd__dfrtp_1_75/a_761_289# VGND sky130_fd_pr__special_nfet_01v8 ad=0 pd=0 as=0.1998 ps=1.97 w=0.36 l=0.15
X5324 VGND V3R298 sky130_fd_sc_hd__dfrtp_1_75/a_805_47# VGND sky130_fd_pr__nfet_01v8 ad=0 pd=0 as=0 ps=0 w=0.42 l=0.15
X5325 V3R178 sky130_fd_sc_hd__dfrtp_1_75/a_1283_21# VDPWR VDPWR sky130_fd_pr__pfet_01v8_hvt ad=0.26 pd=2.52 as=0 ps=0 w=1 l=0.15
X5326 VDPWR V3R055 sky130_fd_sc_hd__dfrtp_1_75/a_27_47# VDPWR sky130_fd_pr__pfet_01v8_hvt ad=0 pd=0 as=0.1664 ps=1.8 w=0.64 l=0.15
X5327 sky130_fd_sc_hd__dfrtp_1_75/a_448_47# V3R092 VDPWR VDPWR sky130_fd_pr__pfet_01v8_hvt ad=0.1302 pd=1.46 as=0 ps=0 w=0.42 l=0.15
X5328 sky130_fd_sc_hd__dfrtp_1_75/a_761_289# sky130_fd_sc_hd__dfrtp_1_75/a_543_47# VGND VGND sky130_fd_pr__nfet_01v8 ad=0 pd=0 as=0 ps=0 w=0.64 l=0.15
X5329 sky130_fd_sc_hd__dfrtp_1_75/a_193_47# sky130_fd_sc_hd__dfrtp_1_75/a_27_47# VGND VGND sky130_fd_pr__nfet_01v8 ad=0.1092 pd=1.36 as=0 ps=0 w=0.42 l=0.15
X5330 sky130_fd_sc_hd__dfrtp_1_75/a_1108_47# sky130_fd_sc_hd__dfrtp_1_75/a_27_47# sky130_fd_sc_hd__dfrtp_1_75/a_761_289# VDPWR sky130_fd_pr__pfet_01v8_hvt ad=0.1176 pd=1.4 as=0.2583 ps=2.37 w=0.42 l=0.15
X5331 sky130_fd_sc_hd__dfrtp_1_75/a_1462_47# V3R298 VGND VGND sky130_fd_pr__nfet_01v8 ad=0 pd=0 as=0 ps=0 w=0.42 l=0.15
X5332 sky130_fd_sc_hd__dfrtp_1_75/a_543_47# sky130_fd_sc_hd__dfrtp_1_75/a_27_47# sky130_fd_sc_hd__dfrtp_1_75/a_448_47# VGND sky130_fd_pr__special_nfet_01v8 ad=0.1188 pd=1.38 as=0.132 ps=1.49 w=0.36 l=0.15
X5333 sky130_fd_sc_hd__dfrtp_1_75/a_543_47# sky130_fd_sc_hd__dfrtp_1_75/a_193_47# sky130_fd_sc_hd__dfrtp_1_75/a_448_47# VDPWR sky130_fd_pr__pfet_01v8_hvt ad=0 pd=0 as=0 ps=0 w=0.42 l=0.15
X5334 sky130_fd_sc_hd__dfrtp_1_75/a_448_47# V3R092 VGND VGND sky130_fd_pr__nfet_01v8 ad=0 pd=0 as=0 ps=0 w=0.42 l=0.15
X5335 VDPWR sky130_fd_sc_hd__dfrtp_1_75/a_1283_21# sky130_fd_sc_hd__dfrtp_1_75/a_1270_413# VDPWR sky130_fd_pr__pfet_01v8_hvt ad=0 pd=0 as=0.1134 ps=1.38 w=0.42 l=0.15
X5336 VDPWR sky130_fd_sc_hd__dfrtp_1_75/a_1108_47# sky130_fd_sc_hd__dfrtp_1_75/a_1283_21# VDPWR sky130_fd_pr__pfet_01v8_hvt ad=0 pd=0 as=0.1134 ps=1.38 w=0.42 l=0.15
X5337 sky130_fd_sc_hd__dfrtp_1_75/a_1270_413# sky130_fd_sc_hd__dfrtp_1_75/a_193_47# sky130_fd_sc_hd__dfrtp_1_75/a_1108_47# VDPWR sky130_fd_pr__pfet_01v8_hvt ad=0 pd=0 as=0 ps=0 w=0.42 l=0.15
X5338 sky130_fd_sc_hd__dfrtp_1_75/a_193_47# sky130_fd_sc_hd__dfrtp_1_75/a_27_47# VDPWR VDPWR sky130_fd_pr__pfet_01v8_hvt ad=0.1664 pd=1.8 as=0 ps=0 w=0.64 l=0.15
X5339 sky130_fd_sc_hd__dfrtp_1_75/a_1283_21# V3R298 VDPWR VDPWR sky130_fd_pr__pfet_01v8_hvt ad=0 pd=0 as=0 ps=0 w=0.42 l=0.15
X5340 VDPWR sky130_fd_sc_hd__dfrtp_1_75/a_761_289# sky130_fd_sc_hd__dfrtp_1_75/a_651_413# VDPWR sky130_fd_pr__pfet_01v8_hvt ad=0 pd=0 as=0 ps=0 w=0.42 l=0.15
X5341 V3R178 sky130_fd_sc_hd__dfrtp_1_75/a_1283_21# VGND VGND sky130_fd_pr__nfet_01v8 ad=0.169 pd=1.82 as=0 ps=0 w=0.65 l=0.15
X5342 sky130_fd_sc_hd__dfrtp_1_75/a_639_47# sky130_fd_sc_hd__dfrtp_1_75/a_193_47# sky130_fd_sc_hd__dfrtp_1_75/a_543_47# VGND sky130_fd_pr__special_nfet_01v8 ad=0 pd=0 as=0 ps=0 w=0.36 l=0.15
X5343 VGND sky130_fd_sc_hd__dfrtp_1_75/a_1283_21# sky130_fd_sc_hd__dfrtp_1_75/a_1217_47# VGND sky130_fd_pr__nfet_01v8 ad=0 pd=0 as=0 ps=0 w=0.42 l=0.15
X5344 sky130_fd_sc_hd__dfrtp_1_75/a_651_413# V3R298 VDPWR VDPWR sky130_fd_pr__pfet_01v8_hvt ad=0 pd=0 as=0 ps=0 w=0.42 l=0.15
X5345 VGND V3R055 sky130_fd_sc_hd__dfrtp_1_75/a_27_47# VGND sky130_fd_pr__nfet_01v8 ad=0 pd=0 as=0.1092 ps=1.36 w=0.42 l=0.15
X5346 sky130_fd_sc_hd__dfrtp_1_75/a_761_289# sky130_fd_sc_hd__dfrtp_1_75/a_543_47# VDPWR VDPWR sky130_fd_pr__pfet_01v8_hvt ad=0 pd=0 as=0 ps=0 w=0.84 l=0.15
X5347 sky130_fd_sc_hd__dfrtp_1_64/a_805_47# sky130_fd_sc_hd__dfrtp_1_64/a_761_289# sky130_fd_sc_hd__dfrtp_1_64/a_639_47# VGND sky130_fd_pr__nfet_01v8 ad=0.0882 pd=1.26 as=0.2802 ps=2.2 w=0.42 l=0.15
X5348 sky130_fd_sc_hd__dfrtp_1_64/a_1217_47# sky130_fd_sc_hd__dfrtp_1_64/a_27_47# sky130_fd_sc_hd__dfrtp_1_64/a_1108_47# VGND sky130_fd_pr__special_nfet_01v8 ad=0.1338 pd=1.5 as=0.1422 ps=1.51 w=0.36 l=0.15
X5349 sky130_fd_sc_hd__dfrtp_1_64/a_1283_21# sky130_fd_sc_hd__dfrtp_1_64/a_1108_47# sky130_fd_sc_hd__dfrtp_1_64/a_1462_47# VGND sky130_fd_pr__nfet_01v8 ad=0.1092 pd=1.36 as=0.1281 ps=1.45 w=0.42 l=0.15
X5350 sky130_fd_sc_hd__dfrtp_1_64/a_651_413# sky130_fd_sc_hd__dfrtp_1_64/a_27_47# sky130_fd_sc_hd__dfrtp_1_64/a_543_47# VDPWR sky130_fd_pr__pfet_01v8_hvt ad=0.3402 pd=3.3 as=0.1449 ps=1.53 w=0.42 l=0.15
X5351 sky130_fd_sc_hd__dfrtp_1_64/a_1108_47# sky130_fd_sc_hd__dfrtp_1_64/a_193_47# sky130_fd_sc_hd__dfrtp_1_64/a_761_289# VGND sky130_fd_pr__special_nfet_01v8 ad=0 pd=0 as=0.1998 ps=1.97 w=0.36 l=0.15
X5352 VGND V3R302 sky130_fd_sc_hd__dfrtp_1_64/a_805_47# VGND sky130_fd_pr__nfet_01v8 ad=0 pd=0 as=0 ps=0 w=0.42 l=0.15
X5353 V3R002 sky130_fd_sc_hd__dfrtp_1_64/a_1283_21# VDPWR VDPWR sky130_fd_pr__pfet_01v8_hvt ad=0.26 pd=2.52 as=0 ps=0 w=1 l=0.15
X5354 VDPWR V3R083 sky130_fd_sc_hd__dfrtp_1_64/a_27_47# VDPWR sky130_fd_pr__pfet_01v8_hvt ad=0 pd=0 as=0.1664 ps=1.8 w=0.64 l=0.15
X5355 sky130_fd_sc_hd__dfrtp_1_64/a_448_47# V3R185 VDPWR VDPWR sky130_fd_pr__pfet_01v8_hvt ad=0.1302 pd=1.46 as=0 ps=0 w=0.42 l=0.15
X5356 sky130_fd_sc_hd__dfrtp_1_64/a_761_289# sky130_fd_sc_hd__dfrtp_1_64/a_543_47# VGND VGND sky130_fd_pr__nfet_01v8 ad=0 pd=0 as=0 ps=0 w=0.64 l=0.15
X5357 sky130_fd_sc_hd__dfrtp_1_64/a_193_47# sky130_fd_sc_hd__dfrtp_1_64/a_27_47# VGND VGND sky130_fd_pr__nfet_01v8 ad=0.1092 pd=1.36 as=0 ps=0 w=0.42 l=0.15
X5358 sky130_fd_sc_hd__dfrtp_1_64/a_1108_47# sky130_fd_sc_hd__dfrtp_1_64/a_27_47# sky130_fd_sc_hd__dfrtp_1_64/a_761_289# VDPWR sky130_fd_pr__pfet_01v8_hvt ad=0.1176 pd=1.4 as=0.2583 ps=2.37 w=0.42 l=0.15
X5359 sky130_fd_sc_hd__dfrtp_1_64/a_1462_47# V3R302 VGND VGND sky130_fd_pr__nfet_01v8 ad=0 pd=0 as=0 ps=0 w=0.42 l=0.15
X5360 sky130_fd_sc_hd__dfrtp_1_64/a_543_47# sky130_fd_sc_hd__dfrtp_1_64/a_27_47# sky130_fd_sc_hd__dfrtp_1_64/a_448_47# VGND sky130_fd_pr__special_nfet_01v8 ad=0.1188 pd=1.38 as=0.132 ps=1.49 w=0.36 l=0.15
X5361 sky130_fd_sc_hd__dfrtp_1_64/a_543_47# sky130_fd_sc_hd__dfrtp_1_64/a_193_47# sky130_fd_sc_hd__dfrtp_1_64/a_448_47# VDPWR sky130_fd_pr__pfet_01v8_hvt ad=0 pd=0 as=0 ps=0 w=0.42 l=0.15
X5362 sky130_fd_sc_hd__dfrtp_1_64/a_448_47# V3R185 VGND VGND sky130_fd_pr__nfet_01v8 ad=0 pd=0 as=0 ps=0 w=0.42 l=0.15
X5363 VDPWR sky130_fd_sc_hd__dfrtp_1_64/a_1283_21# sky130_fd_sc_hd__dfrtp_1_64/a_1270_413# VDPWR sky130_fd_pr__pfet_01v8_hvt ad=0 pd=0 as=0.1134 ps=1.38 w=0.42 l=0.15
X5364 VDPWR sky130_fd_sc_hd__dfrtp_1_64/a_1108_47# sky130_fd_sc_hd__dfrtp_1_64/a_1283_21# VDPWR sky130_fd_pr__pfet_01v8_hvt ad=0 pd=0 as=0.1134 ps=1.38 w=0.42 l=0.15
X5365 sky130_fd_sc_hd__dfrtp_1_64/a_1270_413# sky130_fd_sc_hd__dfrtp_1_64/a_193_47# sky130_fd_sc_hd__dfrtp_1_64/a_1108_47# VDPWR sky130_fd_pr__pfet_01v8_hvt ad=0 pd=0 as=0 ps=0 w=0.42 l=0.15
X5366 sky130_fd_sc_hd__dfrtp_1_64/a_193_47# sky130_fd_sc_hd__dfrtp_1_64/a_27_47# VDPWR VDPWR sky130_fd_pr__pfet_01v8_hvt ad=0.1664 pd=1.8 as=0 ps=0 w=0.64 l=0.15
X5367 sky130_fd_sc_hd__dfrtp_1_64/a_1283_21# V3R302 VDPWR VDPWR sky130_fd_pr__pfet_01v8_hvt ad=0 pd=0 as=0 ps=0 w=0.42 l=0.15
X5368 VDPWR sky130_fd_sc_hd__dfrtp_1_64/a_761_289# sky130_fd_sc_hd__dfrtp_1_64/a_651_413# VDPWR sky130_fd_pr__pfet_01v8_hvt ad=0 pd=0 as=0 ps=0 w=0.42 l=0.15
X5369 V3R002 sky130_fd_sc_hd__dfrtp_1_64/a_1283_21# VGND VGND sky130_fd_pr__nfet_01v8 ad=0.169 pd=1.82 as=0 ps=0 w=0.65 l=0.15
X5370 sky130_fd_sc_hd__dfrtp_1_64/a_639_47# sky130_fd_sc_hd__dfrtp_1_64/a_193_47# sky130_fd_sc_hd__dfrtp_1_64/a_543_47# VGND sky130_fd_pr__special_nfet_01v8 ad=0 pd=0 as=0 ps=0 w=0.36 l=0.15
X5371 VGND sky130_fd_sc_hd__dfrtp_1_64/a_1283_21# sky130_fd_sc_hd__dfrtp_1_64/a_1217_47# VGND sky130_fd_pr__nfet_01v8 ad=0 pd=0 as=0 ps=0 w=0.42 l=0.15
X5372 sky130_fd_sc_hd__dfrtp_1_64/a_651_413# V3R302 VDPWR VDPWR sky130_fd_pr__pfet_01v8_hvt ad=0 pd=0 as=0 ps=0 w=0.42 l=0.15
X5373 VGND V3R083 sky130_fd_sc_hd__dfrtp_1_64/a_27_47# VGND sky130_fd_pr__nfet_01v8 ad=0 pd=0 as=0.1092 ps=1.36 w=0.42 l=0.15
X5374 sky130_fd_sc_hd__dfrtp_1_64/a_761_289# sky130_fd_sc_hd__dfrtp_1_64/a_543_47# VDPWR VDPWR sky130_fd_pr__pfet_01v8_hvt ad=0 pd=0 as=0 ps=0 w=0.84 l=0.15
X5375 sky130_fd_sc_hd__dfrtp_1_53/a_805_47# sky130_fd_sc_hd__dfrtp_1_53/a_761_289# sky130_fd_sc_hd__dfrtp_1_53/a_639_47# VGND sky130_fd_pr__nfet_01v8 ad=0.0882 pd=1.26 as=0.2802 ps=2.2 w=0.42 l=0.15
X5376 sky130_fd_sc_hd__dfrtp_1_53/a_1217_47# sky130_fd_sc_hd__dfrtp_1_53/a_27_47# sky130_fd_sc_hd__dfrtp_1_53/a_1108_47# VGND sky130_fd_pr__special_nfet_01v8 ad=0.1338 pd=1.5 as=0.1422 ps=1.51 w=0.36 l=0.15
X5377 sky130_fd_sc_hd__dfrtp_1_53/a_1283_21# sky130_fd_sc_hd__dfrtp_1_53/a_1108_47# sky130_fd_sc_hd__dfrtp_1_53/a_1462_47# VGND sky130_fd_pr__nfet_01v8 ad=0.1092 pd=1.36 as=0.1281 ps=1.45 w=0.42 l=0.15
X5378 sky130_fd_sc_hd__dfrtp_1_53/a_651_413# sky130_fd_sc_hd__dfrtp_1_53/a_27_47# sky130_fd_sc_hd__dfrtp_1_53/a_543_47# VDPWR sky130_fd_pr__pfet_01v8_hvt ad=0.3402 pd=3.3 as=0.1449 ps=1.53 w=0.42 l=0.15
X5379 sky130_fd_sc_hd__dfrtp_1_53/a_1108_47# sky130_fd_sc_hd__dfrtp_1_53/a_193_47# sky130_fd_sc_hd__dfrtp_1_53/a_761_289# VGND sky130_fd_pr__special_nfet_01v8 ad=0 pd=0 as=0.1998 ps=1.97 w=0.36 l=0.15
X5380 VGND V3R302 sky130_fd_sc_hd__dfrtp_1_53/a_805_47# VGND sky130_fd_pr__nfet_01v8 ad=0 pd=0 as=0 ps=0 w=0.42 l=0.15
X5381 V3R005 sky130_fd_sc_hd__dfrtp_1_53/a_1283_21# VDPWR VDPWR sky130_fd_pr__pfet_01v8_hvt ad=0.26 pd=2.52 as=0 ps=0 w=1 l=0.15
X5382 VDPWR V3R083 sky130_fd_sc_hd__dfrtp_1_53/a_27_47# VDPWR sky130_fd_pr__pfet_01v8_hvt ad=0 pd=0 as=0.1664 ps=1.8 w=0.64 l=0.15
X5383 sky130_fd_sc_hd__dfrtp_1_53/a_448_47# V3R189 VDPWR VDPWR sky130_fd_pr__pfet_01v8_hvt ad=0.1302 pd=1.46 as=0 ps=0 w=0.42 l=0.15
X5384 sky130_fd_sc_hd__dfrtp_1_53/a_761_289# sky130_fd_sc_hd__dfrtp_1_53/a_543_47# VGND VGND sky130_fd_pr__nfet_01v8 ad=0 pd=0 as=0 ps=0 w=0.64 l=0.15
X5385 sky130_fd_sc_hd__dfrtp_1_53/a_193_47# sky130_fd_sc_hd__dfrtp_1_53/a_27_47# VGND VGND sky130_fd_pr__nfet_01v8 ad=0.1092 pd=1.36 as=0 ps=0 w=0.42 l=0.15
X5386 sky130_fd_sc_hd__dfrtp_1_53/a_1108_47# sky130_fd_sc_hd__dfrtp_1_53/a_27_47# sky130_fd_sc_hd__dfrtp_1_53/a_761_289# VDPWR sky130_fd_pr__pfet_01v8_hvt ad=0.1176 pd=1.4 as=0.2583 ps=2.37 w=0.42 l=0.15
X5387 sky130_fd_sc_hd__dfrtp_1_53/a_1462_47# V3R302 VGND VGND sky130_fd_pr__nfet_01v8 ad=0 pd=0 as=0 ps=0 w=0.42 l=0.15
X5388 sky130_fd_sc_hd__dfrtp_1_53/a_543_47# sky130_fd_sc_hd__dfrtp_1_53/a_27_47# sky130_fd_sc_hd__dfrtp_1_53/a_448_47# VGND sky130_fd_pr__special_nfet_01v8 ad=0.1188 pd=1.38 as=0.132 ps=1.49 w=0.36 l=0.15
X5389 sky130_fd_sc_hd__dfrtp_1_53/a_543_47# sky130_fd_sc_hd__dfrtp_1_53/a_193_47# sky130_fd_sc_hd__dfrtp_1_53/a_448_47# VDPWR sky130_fd_pr__pfet_01v8_hvt ad=0 pd=0 as=0 ps=0 w=0.42 l=0.15
X5390 sky130_fd_sc_hd__dfrtp_1_53/a_448_47# V3R189 VGND VGND sky130_fd_pr__nfet_01v8 ad=0 pd=0 as=0 ps=0 w=0.42 l=0.15
X5391 VDPWR sky130_fd_sc_hd__dfrtp_1_53/a_1283_21# sky130_fd_sc_hd__dfrtp_1_53/a_1270_413# VDPWR sky130_fd_pr__pfet_01v8_hvt ad=0 pd=0 as=0.1134 ps=1.38 w=0.42 l=0.15
X5392 VDPWR sky130_fd_sc_hd__dfrtp_1_53/a_1108_47# sky130_fd_sc_hd__dfrtp_1_53/a_1283_21# VDPWR sky130_fd_pr__pfet_01v8_hvt ad=0 pd=0 as=0.1134 ps=1.38 w=0.42 l=0.15
X5393 sky130_fd_sc_hd__dfrtp_1_53/a_1270_413# sky130_fd_sc_hd__dfrtp_1_53/a_193_47# sky130_fd_sc_hd__dfrtp_1_53/a_1108_47# VDPWR sky130_fd_pr__pfet_01v8_hvt ad=0 pd=0 as=0 ps=0 w=0.42 l=0.15
X5394 sky130_fd_sc_hd__dfrtp_1_53/a_193_47# sky130_fd_sc_hd__dfrtp_1_53/a_27_47# VDPWR VDPWR sky130_fd_pr__pfet_01v8_hvt ad=0.1664 pd=1.8 as=0 ps=0 w=0.64 l=0.15
X5395 sky130_fd_sc_hd__dfrtp_1_53/a_1283_21# V3R302 VDPWR VDPWR sky130_fd_pr__pfet_01v8_hvt ad=0 pd=0 as=0 ps=0 w=0.42 l=0.15
X5396 VDPWR sky130_fd_sc_hd__dfrtp_1_53/a_761_289# sky130_fd_sc_hd__dfrtp_1_53/a_651_413# VDPWR sky130_fd_pr__pfet_01v8_hvt ad=0 pd=0 as=0 ps=0 w=0.42 l=0.15
X5397 V3R005 sky130_fd_sc_hd__dfrtp_1_53/a_1283_21# VGND VGND sky130_fd_pr__nfet_01v8 ad=0.169 pd=1.82 as=0 ps=0 w=0.65 l=0.15
X5398 sky130_fd_sc_hd__dfrtp_1_53/a_639_47# sky130_fd_sc_hd__dfrtp_1_53/a_193_47# sky130_fd_sc_hd__dfrtp_1_53/a_543_47# VGND sky130_fd_pr__special_nfet_01v8 ad=0 pd=0 as=0 ps=0 w=0.36 l=0.15
X5399 VGND sky130_fd_sc_hd__dfrtp_1_53/a_1283_21# sky130_fd_sc_hd__dfrtp_1_53/a_1217_47# VGND sky130_fd_pr__nfet_01v8 ad=0 pd=0 as=0 ps=0 w=0.42 l=0.15
X5400 sky130_fd_sc_hd__dfrtp_1_53/a_651_413# V3R302 VDPWR VDPWR sky130_fd_pr__pfet_01v8_hvt ad=0 pd=0 as=0 ps=0 w=0.42 l=0.15
X5401 VGND V3R083 sky130_fd_sc_hd__dfrtp_1_53/a_27_47# VGND sky130_fd_pr__nfet_01v8 ad=0 pd=0 as=0.1092 ps=1.36 w=0.42 l=0.15
X5402 sky130_fd_sc_hd__dfrtp_1_53/a_761_289# sky130_fd_sc_hd__dfrtp_1_53/a_543_47# VDPWR VDPWR sky130_fd_pr__pfet_01v8_hvt ad=0 pd=0 as=0 ps=0 w=0.84 l=0.15
X5403 sky130_fd_sc_hd__dfrtp_1_42/a_805_47# sky130_fd_sc_hd__dfrtp_1_42/a_761_289# sky130_fd_sc_hd__dfrtp_1_42/a_639_47# VGND sky130_fd_pr__nfet_01v8 ad=0.0882 pd=1.26 as=0.2802 ps=2.2 w=0.42 l=0.15
X5404 sky130_fd_sc_hd__dfrtp_1_42/a_1217_47# sky130_fd_sc_hd__dfrtp_1_42/a_27_47# sky130_fd_sc_hd__dfrtp_1_42/a_1108_47# VGND sky130_fd_pr__special_nfet_01v8 ad=0.1338 pd=1.5 as=0.1422 ps=1.51 w=0.36 l=0.15
X5405 sky130_fd_sc_hd__dfrtp_1_42/a_1283_21# sky130_fd_sc_hd__dfrtp_1_42/a_1108_47# sky130_fd_sc_hd__dfrtp_1_42/a_1462_47# VGND sky130_fd_pr__nfet_01v8 ad=0.1092 pd=1.36 as=0.1281 ps=1.45 w=0.42 l=0.15
X5406 sky130_fd_sc_hd__dfrtp_1_42/a_651_413# sky130_fd_sc_hd__dfrtp_1_42/a_27_47# sky130_fd_sc_hd__dfrtp_1_42/a_543_47# VDPWR sky130_fd_pr__pfet_01v8_hvt ad=0.3402 pd=3.3 as=0.1449 ps=1.53 w=0.42 l=0.15
X5407 sky130_fd_sc_hd__dfrtp_1_42/a_1108_47# sky130_fd_sc_hd__dfrtp_1_42/a_193_47# sky130_fd_sc_hd__dfrtp_1_42/a_761_289# VGND sky130_fd_pr__special_nfet_01v8 ad=0 pd=0 as=0.1998 ps=1.97 w=0.36 l=0.15
X5408 VGND V3R302 sky130_fd_sc_hd__dfrtp_1_42/a_805_47# VGND sky130_fd_pr__nfet_01v8 ad=0 pd=0 as=0 ps=0 w=0.42 l=0.15
X5409 V3R001 sky130_fd_sc_hd__dfrtp_1_42/a_1283_21# VDPWR VDPWR sky130_fd_pr__pfet_01v8_hvt ad=0.26 pd=2.52 as=0 ps=0 w=1 l=0.15
X5410 VDPWR V3R083 sky130_fd_sc_hd__dfrtp_1_42/a_27_47# VDPWR sky130_fd_pr__pfet_01v8_hvt ad=0 pd=0 as=0.1664 ps=1.8 w=0.64 l=0.15
X5411 sky130_fd_sc_hd__dfrtp_1_42/a_448_47# V3R184 VDPWR VDPWR sky130_fd_pr__pfet_01v8_hvt ad=0.1302 pd=1.46 as=0 ps=0 w=0.42 l=0.15
X5412 sky130_fd_sc_hd__dfrtp_1_42/a_761_289# sky130_fd_sc_hd__dfrtp_1_42/a_543_47# VGND VGND sky130_fd_pr__nfet_01v8 ad=0 pd=0 as=0 ps=0 w=0.64 l=0.15
X5413 sky130_fd_sc_hd__dfrtp_1_42/a_193_47# sky130_fd_sc_hd__dfrtp_1_42/a_27_47# VGND VGND sky130_fd_pr__nfet_01v8 ad=0.1092 pd=1.36 as=0 ps=0 w=0.42 l=0.15
X5414 sky130_fd_sc_hd__dfrtp_1_42/a_1108_47# sky130_fd_sc_hd__dfrtp_1_42/a_27_47# sky130_fd_sc_hd__dfrtp_1_42/a_761_289# VDPWR sky130_fd_pr__pfet_01v8_hvt ad=0.1176 pd=1.4 as=0.2583 ps=2.37 w=0.42 l=0.15
X5415 sky130_fd_sc_hd__dfrtp_1_42/a_1462_47# V3R302 VGND VGND sky130_fd_pr__nfet_01v8 ad=0 pd=0 as=0 ps=0 w=0.42 l=0.15
X5416 sky130_fd_sc_hd__dfrtp_1_42/a_543_47# sky130_fd_sc_hd__dfrtp_1_42/a_27_47# sky130_fd_sc_hd__dfrtp_1_42/a_448_47# VGND sky130_fd_pr__special_nfet_01v8 ad=0.1188 pd=1.38 as=0.132 ps=1.49 w=0.36 l=0.15
X5417 sky130_fd_sc_hd__dfrtp_1_42/a_543_47# sky130_fd_sc_hd__dfrtp_1_42/a_193_47# sky130_fd_sc_hd__dfrtp_1_42/a_448_47# VDPWR sky130_fd_pr__pfet_01v8_hvt ad=0 pd=0 as=0 ps=0 w=0.42 l=0.15
X5418 sky130_fd_sc_hd__dfrtp_1_42/a_448_47# V3R184 VGND VGND sky130_fd_pr__nfet_01v8 ad=0 pd=0 as=0 ps=0 w=0.42 l=0.15
X5419 VDPWR sky130_fd_sc_hd__dfrtp_1_42/a_1283_21# sky130_fd_sc_hd__dfrtp_1_42/a_1270_413# VDPWR sky130_fd_pr__pfet_01v8_hvt ad=0 pd=0 as=0.1134 ps=1.38 w=0.42 l=0.15
X5420 VDPWR sky130_fd_sc_hd__dfrtp_1_42/a_1108_47# sky130_fd_sc_hd__dfrtp_1_42/a_1283_21# VDPWR sky130_fd_pr__pfet_01v8_hvt ad=0 pd=0 as=0.1134 ps=1.38 w=0.42 l=0.15
X5421 sky130_fd_sc_hd__dfrtp_1_42/a_1270_413# sky130_fd_sc_hd__dfrtp_1_42/a_193_47# sky130_fd_sc_hd__dfrtp_1_42/a_1108_47# VDPWR sky130_fd_pr__pfet_01v8_hvt ad=0 pd=0 as=0 ps=0 w=0.42 l=0.15
X5422 sky130_fd_sc_hd__dfrtp_1_42/a_193_47# sky130_fd_sc_hd__dfrtp_1_42/a_27_47# VDPWR VDPWR sky130_fd_pr__pfet_01v8_hvt ad=0.1664 pd=1.8 as=0 ps=0 w=0.64 l=0.15
X5423 sky130_fd_sc_hd__dfrtp_1_42/a_1283_21# V3R302 VDPWR VDPWR sky130_fd_pr__pfet_01v8_hvt ad=0 pd=0 as=0 ps=0 w=0.42 l=0.15
X5424 VDPWR sky130_fd_sc_hd__dfrtp_1_42/a_761_289# sky130_fd_sc_hd__dfrtp_1_42/a_651_413# VDPWR sky130_fd_pr__pfet_01v8_hvt ad=0 pd=0 as=0 ps=0 w=0.42 l=0.15
X5425 V3R001 sky130_fd_sc_hd__dfrtp_1_42/a_1283_21# VGND VGND sky130_fd_pr__nfet_01v8 ad=0.169 pd=1.82 as=0 ps=0 w=0.65 l=0.15
X5426 sky130_fd_sc_hd__dfrtp_1_42/a_639_47# sky130_fd_sc_hd__dfrtp_1_42/a_193_47# sky130_fd_sc_hd__dfrtp_1_42/a_543_47# VGND sky130_fd_pr__special_nfet_01v8 ad=0 pd=0 as=0 ps=0 w=0.36 l=0.15
X5427 VGND sky130_fd_sc_hd__dfrtp_1_42/a_1283_21# sky130_fd_sc_hd__dfrtp_1_42/a_1217_47# VGND sky130_fd_pr__nfet_01v8 ad=0 pd=0 as=0 ps=0 w=0.42 l=0.15
X5428 sky130_fd_sc_hd__dfrtp_1_42/a_651_413# V3R302 VDPWR VDPWR sky130_fd_pr__pfet_01v8_hvt ad=0 pd=0 as=0 ps=0 w=0.42 l=0.15
X5429 VGND V3R083 sky130_fd_sc_hd__dfrtp_1_42/a_27_47# VGND sky130_fd_pr__nfet_01v8 ad=0 pd=0 as=0.1092 ps=1.36 w=0.42 l=0.15
X5430 sky130_fd_sc_hd__dfrtp_1_42/a_761_289# sky130_fd_sc_hd__dfrtp_1_42/a_543_47# VDPWR VDPWR sky130_fd_pr__pfet_01v8_hvt ad=0 pd=0 as=0 ps=0 w=0.84 l=0.15
X5431 sky130_fd_sc_hd__dfrtp_1_31/a_805_47# sky130_fd_sc_hd__dfrtp_1_31/a_761_289# sky130_fd_sc_hd__dfrtp_1_31/a_639_47# VGND sky130_fd_pr__nfet_01v8 ad=0.0882 pd=1.26 as=0.2802 ps=2.2 w=0.42 l=0.15
X5432 sky130_fd_sc_hd__dfrtp_1_31/a_1217_47# sky130_fd_sc_hd__dfrtp_1_31/a_27_47# sky130_fd_sc_hd__dfrtp_1_31/a_1108_47# VGND sky130_fd_pr__special_nfet_01v8 ad=0.1338 pd=1.5 as=0.1422 ps=1.51 w=0.36 l=0.15
X5433 sky130_fd_sc_hd__dfrtp_1_31/a_1283_21# sky130_fd_sc_hd__dfrtp_1_31/a_1108_47# sky130_fd_sc_hd__dfrtp_1_31/a_1462_47# VGND sky130_fd_pr__nfet_01v8 ad=0.1092 pd=1.36 as=0.1281 ps=1.45 w=0.42 l=0.15
X5434 sky130_fd_sc_hd__dfrtp_1_31/a_651_413# sky130_fd_sc_hd__dfrtp_1_31/a_27_47# sky130_fd_sc_hd__dfrtp_1_31/a_543_47# VDPWR sky130_fd_pr__pfet_01v8_hvt ad=0.3402 pd=3.3 as=0.1449 ps=1.53 w=0.42 l=0.15
X5435 sky130_fd_sc_hd__dfrtp_1_31/a_1108_47# sky130_fd_sc_hd__dfrtp_1_31/a_193_47# sky130_fd_sc_hd__dfrtp_1_31/a_761_289# VGND sky130_fd_pr__special_nfet_01v8 ad=0 pd=0 as=0.1998 ps=1.97 w=0.36 l=0.15
X5436 VGND V3R301 sky130_fd_sc_hd__dfrtp_1_31/a_805_47# VGND sky130_fd_pr__nfet_01v8 ad=0 pd=0 as=0 ps=0 w=0.42 l=0.15
X5437 V3R026 sky130_fd_sc_hd__dfrtp_1_31/a_1283_21# VDPWR VDPWR sky130_fd_pr__pfet_01v8_hvt ad=0.26 pd=2.52 as=0 ps=0 w=1 l=0.15
X5438 VDPWR V3R082 sky130_fd_sc_hd__dfrtp_1_31/a_27_47# VDPWR sky130_fd_pr__pfet_01v8_hvt ad=0 pd=0 as=0.1664 ps=1.8 w=0.64 l=0.15
X5439 sky130_fd_sc_hd__dfrtp_1_31/a_448_47# V3R141 VDPWR VDPWR sky130_fd_pr__pfet_01v8_hvt ad=0.1302 pd=1.46 as=0 ps=0 w=0.42 l=0.15
X5440 sky130_fd_sc_hd__dfrtp_1_31/a_761_289# sky130_fd_sc_hd__dfrtp_1_31/a_543_47# VGND VGND sky130_fd_pr__nfet_01v8 ad=0 pd=0 as=0 ps=0 w=0.64 l=0.15
X5441 sky130_fd_sc_hd__dfrtp_1_31/a_193_47# sky130_fd_sc_hd__dfrtp_1_31/a_27_47# VGND VGND sky130_fd_pr__nfet_01v8 ad=0.1092 pd=1.36 as=0 ps=0 w=0.42 l=0.15
X5442 sky130_fd_sc_hd__dfrtp_1_31/a_1108_47# sky130_fd_sc_hd__dfrtp_1_31/a_27_47# sky130_fd_sc_hd__dfrtp_1_31/a_761_289# VDPWR sky130_fd_pr__pfet_01v8_hvt ad=0.1176 pd=1.4 as=0.2583 ps=2.37 w=0.42 l=0.15
X5443 sky130_fd_sc_hd__dfrtp_1_31/a_1462_47# V3R301 VGND VGND sky130_fd_pr__nfet_01v8 ad=0 pd=0 as=0 ps=0 w=0.42 l=0.15
X5444 sky130_fd_sc_hd__dfrtp_1_31/a_543_47# sky130_fd_sc_hd__dfrtp_1_31/a_27_47# sky130_fd_sc_hd__dfrtp_1_31/a_448_47# VGND sky130_fd_pr__special_nfet_01v8 ad=0.1188 pd=1.38 as=0.132 ps=1.49 w=0.36 l=0.15
X5445 sky130_fd_sc_hd__dfrtp_1_31/a_543_47# sky130_fd_sc_hd__dfrtp_1_31/a_193_47# sky130_fd_sc_hd__dfrtp_1_31/a_448_47# VDPWR sky130_fd_pr__pfet_01v8_hvt ad=0 pd=0 as=0 ps=0 w=0.42 l=0.15
X5446 sky130_fd_sc_hd__dfrtp_1_31/a_448_47# V3R141 VGND VGND sky130_fd_pr__nfet_01v8 ad=0 pd=0 as=0 ps=0 w=0.42 l=0.15
X5447 VDPWR sky130_fd_sc_hd__dfrtp_1_31/a_1283_21# sky130_fd_sc_hd__dfrtp_1_31/a_1270_413# VDPWR sky130_fd_pr__pfet_01v8_hvt ad=0 pd=0 as=0.1134 ps=1.38 w=0.42 l=0.15
X5448 VDPWR sky130_fd_sc_hd__dfrtp_1_31/a_1108_47# sky130_fd_sc_hd__dfrtp_1_31/a_1283_21# VDPWR sky130_fd_pr__pfet_01v8_hvt ad=0 pd=0 as=0.1134 ps=1.38 w=0.42 l=0.15
X5449 sky130_fd_sc_hd__dfrtp_1_31/a_1270_413# sky130_fd_sc_hd__dfrtp_1_31/a_193_47# sky130_fd_sc_hd__dfrtp_1_31/a_1108_47# VDPWR sky130_fd_pr__pfet_01v8_hvt ad=0 pd=0 as=0 ps=0 w=0.42 l=0.15
X5450 sky130_fd_sc_hd__dfrtp_1_31/a_193_47# sky130_fd_sc_hd__dfrtp_1_31/a_27_47# VDPWR VDPWR sky130_fd_pr__pfet_01v8_hvt ad=0.1664 pd=1.8 as=0 ps=0 w=0.64 l=0.15
X5451 sky130_fd_sc_hd__dfrtp_1_31/a_1283_21# V3R301 VDPWR VDPWR sky130_fd_pr__pfet_01v8_hvt ad=0 pd=0 as=0 ps=0 w=0.42 l=0.15
X5452 VDPWR sky130_fd_sc_hd__dfrtp_1_31/a_761_289# sky130_fd_sc_hd__dfrtp_1_31/a_651_413# VDPWR sky130_fd_pr__pfet_01v8_hvt ad=0 pd=0 as=0 ps=0 w=0.42 l=0.15
X5453 V3R026 sky130_fd_sc_hd__dfrtp_1_31/a_1283_21# VGND VGND sky130_fd_pr__nfet_01v8 ad=0.169 pd=1.82 as=0 ps=0 w=0.65 l=0.15
X5454 sky130_fd_sc_hd__dfrtp_1_31/a_639_47# sky130_fd_sc_hd__dfrtp_1_31/a_193_47# sky130_fd_sc_hd__dfrtp_1_31/a_543_47# VGND sky130_fd_pr__special_nfet_01v8 ad=0 pd=0 as=0 ps=0 w=0.36 l=0.15
X5455 VGND sky130_fd_sc_hd__dfrtp_1_31/a_1283_21# sky130_fd_sc_hd__dfrtp_1_31/a_1217_47# VGND sky130_fd_pr__nfet_01v8 ad=0 pd=0 as=0 ps=0 w=0.42 l=0.15
X5456 sky130_fd_sc_hd__dfrtp_1_31/a_651_413# V3R301 VDPWR VDPWR sky130_fd_pr__pfet_01v8_hvt ad=0 pd=0 as=0 ps=0 w=0.42 l=0.15
X5457 VGND V3R082 sky130_fd_sc_hd__dfrtp_1_31/a_27_47# VGND sky130_fd_pr__nfet_01v8 ad=0 pd=0 as=0.1092 ps=1.36 w=0.42 l=0.15
X5458 sky130_fd_sc_hd__dfrtp_1_31/a_761_289# sky130_fd_sc_hd__dfrtp_1_31/a_543_47# VDPWR VDPWR sky130_fd_pr__pfet_01v8_hvt ad=0 pd=0 as=0 ps=0 w=0.84 l=0.15
X5459 sky130_fd_sc_hd__dfrtp_1_20/a_805_47# sky130_fd_sc_hd__dfrtp_1_20/a_761_289# sky130_fd_sc_hd__dfrtp_1_20/a_639_47# VGND sky130_fd_pr__nfet_01v8 ad=0.0882 pd=1.26 as=0.2802 ps=2.2 w=0.42 l=0.15
X5460 sky130_fd_sc_hd__dfrtp_1_20/a_1217_47# sky130_fd_sc_hd__dfrtp_1_20/a_27_47# sky130_fd_sc_hd__dfrtp_1_20/a_1108_47# VGND sky130_fd_pr__special_nfet_01v8 ad=0.1338 pd=1.5 as=0.1422 ps=1.51 w=0.36 l=0.15
X5461 sky130_fd_sc_hd__dfrtp_1_20/a_1283_21# sky130_fd_sc_hd__dfrtp_1_20/a_1108_47# sky130_fd_sc_hd__dfrtp_1_20/a_1462_47# VGND sky130_fd_pr__nfet_01v8 ad=0.1092 pd=1.36 as=0.1281 ps=1.45 w=0.42 l=0.15
X5462 sky130_fd_sc_hd__dfrtp_1_20/a_651_413# sky130_fd_sc_hd__dfrtp_1_20/a_27_47# sky130_fd_sc_hd__dfrtp_1_20/a_543_47# VDPWR sky130_fd_pr__pfet_01v8_hvt ad=0.3402 pd=3.3 as=0.1449 ps=1.53 w=0.42 l=0.15
X5463 sky130_fd_sc_hd__dfrtp_1_20/a_1108_47# sky130_fd_sc_hd__dfrtp_1_20/a_193_47# sky130_fd_sc_hd__dfrtp_1_20/a_761_289# VGND sky130_fd_pr__special_nfet_01v8 ad=0 pd=0 as=0.1998 ps=1.97 w=0.36 l=0.15
X5464 VGND V3R303 sky130_fd_sc_hd__dfrtp_1_20/a_805_47# VGND sky130_fd_pr__nfet_01v8 ad=0 pd=0 as=0 ps=0 w=0.42 l=0.15
X5465 V3R076 sky130_fd_sc_hd__dfrtp_1_20/a_1283_21# VDPWR VDPWR sky130_fd_pr__pfet_01v8_hvt ad=0.26 pd=2.52 as=0 ps=0 w=1 l=0.15
X5466 VDPWR V3R084 sky130_fd_sc_hd__dfrtp_1_20/a_27_47# VDPWR sky130_fd_pr__pfet_01v8_hvt ad=0 pd=0 as=0.1664 ps=1.8 w=0.64 l=0.15
X5467 sky130_fd_sc_hd__dfrtp_1_20/a_448_47# V3R199 VDPWR VDPWR sky130_fd_pr__pfet_01v8_hvt ad=0.1302 pd=1.46 as=0 ps=0 w=0.42 l=0.15
X5468 sky130_fd_sc_hd__dfrtp_1_20/a_761_289# sky130_fd_sc_hd__dfrtp_1_20/a_543_47# VGND VGND sky130_fd_pr__nfet_01v8 ad=0 pd=0 as=0 ps=0 w=0.64 l=0.15
X5469 sky130_fd_sc_hd__dfrtp_1_20/a_193_47# sky130_fd_sc_hd__dfrtp_1_20/a_27_47# VGND VGND sky130_fd_pr__nfet_01v8 ad=0.1092 pd=1.36 as=0 ps=0 w=0.42 l=0.15
X5470 sky130_fd_sc_hd__dfrtp_1_20/a_1108_47# sky130_fd_sc_hd__dfrtp_1_20/a_27_47# sky130_fd_sc_hd__dfrtp_1_20/a_761_289# VDPWR sky130_fd_pr__pfet_01v8_hvt ad=0.1176 pd=1.4 as=0.2583 ps=2.37 w=0.42 l=0.15
X5471 sky130_fd_sc_hd__dfrtp_1_20/a_1462_47# V3R303 VGND VGND sky130_fd_pr__nfet_01v8 ad=0 pd=0 as=0 ps=0 w=0.42 l=0.15
X5472 sky130_fd_sc_hd__dfrtp_1_20/a_543_47# sky130_fd_sc_hd__dfrtp_1_20/a_27_47# sky130_fd_sc_hd__dfrtp_1_20/a_448_47# VGND sky130_fd_pr__special_nfet_01v8 ad=0.1188 pd=1.38 as=0.132 ps=1.49 w=0.36 l=0.15
X5473 sky130_fd_sc_hd__dfrtp_1_20/a_543_47# sky130_fd_sc_hd__dfrtp_1_20/a_193_47# sky130_fd_sc_hd__dfrtp_1_20/a_448_47# VDPWR sky130_fd_pr__pfet_01v8_hvt ad=0 pd=0 as=0 ps=0 w=0.42 l=0.15
X5474 sky130_fd_sc_hd__dfrtp_1_20/a_448_47# V3R199 VGND VGND sky130_fd_pr__nfet_01v8 ad=0 pd=0 as=0 ps=0 w=0.42 l=0.15
X5475 VDPWR sky130_fd_sc_hd__dfrtp_1_20/a_1283_21# sky130_fd_sc_hd__dfrtp_1_20/a_1270_413# VDPWR sky130_fd_pr__pfet_01v8_hvt ad=0 pd=0 as=0.1134 ps=1.38 w=0.42 l=0.15
X5476 VDPWR sky130_fd_sc_hd__dfrtp_1_20/a_1108_47# sky130_fd_sc_hd__dfrtp_1_20/a_1283_21# VDPWR sky130_fd_pr__pfet_01v8_hvt ad=0 pd=0 as=0.1134 ps=1.38 w=0.42 l=0.15
X5477 sky130_fd_sc_hd__dfrtp_1_20/a_1270_413# sky130_fd_sc_hd__dfrtp_1_20/a_193_47# sky130_fd_sc_hd__dfrtp_1_20/a_1108_47# VDPWR sky130_fd_pr__pfet_01v8_hvt ad=0 pd=0 as=0 ps=0 w=0.42 l=0.15
X5478 sky130_fd_sc_hd__dfrtp_1_20/a_193_47# sky130_fd_sc_hd__dfrtp_1_20/a_27_47# VDPWR VDPWR sky130_fd_pr__pfet_01v8_hvt ad=0.1664 pd=1.8 as=0 ps=0 w=0.64 l=0.15
X5479 sky130_fd_sc_hd__dfrtp_1_20/a_1283_21# V3R303 VDPWR VDPWR sky130_fd_pr__pfet_01v8_hvt ad=0 pd=0 as=0 ps=0 w=0.42 l=0.15
X5480 VDPWR sky130_fd_sc_hd__dfrtp_1_20/a_761_289# sky130_fd_sc_hd__dfrtp_1_20/a_651_413# VDPWR sky130_fd_pr__pfet_01v8_hvt ad=0 pd=0 as=0 ps=0 w=0.42 l=0.15
X5481 V3R076 sky130_fd_sc_hd__dfrtp_1_20/a_1283_21# VGND VGND sky130_fd_pr__nfet_01v8 ad=0.169 pd=1.82 as=0 ps=0 w=0.65 l=0.15
X5482 sky130_fd_sc_hd__dfrtp_1_20/a_639_47# sky130_fd_sc_hd__dfrtp_1_20/a_193_47# sky130_fd_sc_hd__dfrtp_1_20/a_543_47# VGND sky130_fd_pr__special_nfet_01v8 ad=0 pd=0 as=0 ps=0 w=0.36 l=0.15
X5483 VGND sky130_fd_sc_hd__dfrtp_1_20/a_1283_21# sky130_fd_sc_hd__dfrtp_1_20/a_1217_47# VGND sky130_fd_pr__nfet_01v8 ad=0 pd=0 as=0 ps=0 w=0.42 l=0.15
X5484 sky130_fd_sc_hd__dfrtp_1_20/a_651_413# V3R303 VDPWR VDPWR sky130_fd_pr__pfet_01v8_hvt ad=0 pd=0 as=0 ps=0 w=0.42 l=0.15
X5485 VGND V3R084 sky130_fd_sc_hd__dfrtp_1_20/a_27_47# VGND sky130_fd_pr__nfet_01v8 ad=0 pd=0 as=0.1092 ps=1.36 w=0.42 l=0.15
X5486 sky130_fd_sc_hd__dfrtp_1_20/a_761_289# sky130_fd_sc_hd__dfrtp_1_20/a_543_47# VDPWR VDPWR sky130_fd_pr__pfet_01v8_hvt ad=0 pd=0 as=0 ps=0 w=0.84 l=0.15
X5487 V3R270 sky130_fd_sc_hd__xor2_1_0/a_35_297# sky130_fd_sc_hd__xor2_1_0/a_285_297# VDPWR sky130_fd_pr__pfet_01v8_hvt ad=0.3 pd=2.6 as=0.53 ps=5.06 w=1 l=0.15
X5488 V3R270 V3R000 sky130_fd_sc_hd__xor2_1_0/a_285_47# VGND sky130_fd_pr__nfet_01v8 ad=0.5005 pd=2.84 as=0.1755 ps=1.84 w=0.65 l=0.15
X5489 sky130_fd_sc_hd__xor2_1_0/a_35_297# V3R000 VGND VGND sky130_fd_pr__nfet_01v8 ad=0.1755 pd=1.84 as=0 ps=0 w=0.65 l=0.15
X5490 sky130_fd_sc_hd__xor2_1_0/a_117_297# V3R000 sky130_fd_sc_hd__xor2_1_0/a_35_297# VDPWR sky130_fd_pr__pfet_01v8_hvt ad=0.27 pd=2.54 as=0.26 ps=2.52 w=1 l=0.15
X5491 VDPWR V3R000 sky130_fd_sc_hd__xor2_1_0/a_285_297# VDPWR sky130_fd_pr__pfet_01v8_hvt ad=0 pd=0 as=0 ps=0 w=1 l=0.15
X5492 VGND V3R050 sky130_fd_sc_hd__xor2_1_0/a_35_297# VGND sky130_fd_pr__nfet_01v8 ad=0 pd=0 as=0 ps=0 w=0.65 l=0.15
X5493 VGND sky130_fd_sc_hd__xor2_1_0/a_35_297# V3R270 VGND sky130_fd_pr__nfet_01v8 ad=0 pd=0 as=0 ps=0 w=0.65 l=0.15
X5494 sky130_fd_sc_hd__xor2_1_0/a_285_297# V3R050 VDPWR VDPWR sky130_fd_pr__pfet_01v8_hvt ad=0 pd=0 as=0 ps=0 w=1 l=0.15
X5495 VDPWR V3R050 sky130_fd_sc_hd__xor2_1_0/a_117_297# VDPWR sky130_fd_pr__pfet_01v8_hvt ad=0 pd=0 as=0 ps=0 w=1 l=0.15
X5496 sky130_fd_sc_hd__xor2_1_0/a_285_47# V3R050 VGND VGND sky130_fd_pr__nfet_01v8 ad=0 pd=0 as=0 ps=0 w=0.65 l=0.15
X5497 VDPWR sky130_fd_sc_hd__mux2_1_1/a_505_21# sky130_fd_sc_hd__mux2_1_1/a_535_374# VDPWR sky130_fd_pr__pfet_01v8_hvt ad=0 pd=0 as=0.0882 ps=1.26 w=0.42 l=0.15
X5498 sky130_fd_sc_hd__mux2_1_1/a_505_21# V3R045 VDPWR VDPWR sky130_fd_pr__pfet_01v8_hvt ad=0.1176 pd=1.4 as=0 ps=0 w=0.42 l=0.15
X5499 sky130_fd_sc_hd__mux2_1_1/a_218_374# V3R045 VDPWR VDPWR sky130_fd_pr__pfet_01v8_hvt ad=0.1533 pd=1.57 as=0 ps=0 w=0.42 l=0.15
X5500 VGND sky130_fd_sc_hd__mux2_1_1/a_505_21# sky130_fd_sc_hd__mux2_1_1/a_439_47# VGND sky130_fd_pr__nfet_01v8 ad=0 pd=0 as=0.1386 ps=1.5 w=0.42 l=0.15
X5501 sky130_fd_sc_hd__mux2_1_1/a_76_199# V3R035 sky130_fd_sc_hd__mux2_1_1/a_218_374# VDPWR sky130_fd_pr__pfet_01v8_hvt ad=0.3864 pd=2.68 as=0 ps=0 w=0.42 l=0.15
X5502 sky130_fd_sc_hd__mux2_1_1/a_505_21# V3R045 VGND VGND sky130_fd_pr__nfet_01v8 ad=0.1092 pd=1.36 as=0 ps=0 w=0.42 l=0.15
X5503 sky130_fd_sc_hd__mux2_1_1/a_439_47# V3R035 sky130_fd_sc_hd__mux2_1_1/a_76_199# VGND sky130_fd_pr__nfet_01v8 ad=0 pd=0 as=0.1995 ps=1.79 w=0.42 l=0.15
X5504 sky130_fd_sc_hd__mux2_1_1/a_535_374# V3R174 sky130_fd_sc_hd__mux2_1_1/a_76_199# VDPWR sky130_fd_pr__pfet_01v8_hvt ad=0 pd=0 as=0 ps=0 w=0.42 l=0.15
X5505 sky130_fd_sc_hd__mux2_1_1/a_76_199# V3R174 sky130_fd_sc_hd__mux2_1_1/a_218_47# VGND sky130_fd_pr__nfet_01v8 ad=0 pd=0 as=0.1386 ps=1.5 w=0.42 l=0.15
X5506 sky130_fd_sc_hd__mux2_1_1/a_218_47# V3R045 VGND VGND sky130_fd_pr__nfet_01v8 ad=0 pd=0 as=0 ps=0 w=0.42 l=0.15
X5507 VDPWR sky130_fd_sc_hd__mux2_1_1/a_76_199# V3R149 VDPWR sky130_fd_pr__pfet_01v8_hvt ad=0 pd=0 as=0.26 ps=2.52 w=1 l=0.15
X5508 VGND sky130_fd_sc_hd__mux2_1_1/a_76_199# V3R149 VGND sky130_fd_pr__nfet_01v8 ad=0 pd=0 as=0.169 ps=1.82 w=0.65 l=0.15
X5509 VDPWR sky130_fd_sc_hd__mux2_1_102/a_505_21# sky130_fd_sc_hd__mux2_1_102/a_535_374# VDPWR sky130_fd_pr__pfet_01v8_hvt ad=0 pd=0 as=0.0882 ps=1.26 w=0.42 l=0.15
X5510 sky130_fd_sc_hd__mux2_1_102/a_505_21# V3R061 VDPWR VDPWR sky130_fd_pr__pfet_01v8_hvt ad=0.1176 pd=1.4 as=0 ps=0 w=0.42 l=0.15
X5511 sky130_fd_sc_hd__mux2_1_102/a_218_374# V3R061 VDPWR VDPWR sky130_fd_pr__pfet_01v8_hvt ad=0.1533 pd=1.57 as=0 ps=0 w=0.42 l=0.15
X5512 VGND sky130_fd_sc_hd__mux2_1_102/a_505_21# sky130_fd_sc_hd__mux2_1_102/a_439_47# VGND sky130_fd_pr__nfet_01v8 ad=0 pd=0 as=0.1386 ps=1.5 w=0.42 l=0.15
X5513 sky130_fd_sc_hd__mux2_1_102/a_76_199# V3R172 sky130_fd_sc_hd__mux2_1_102/a_218_374# VDPWR sky130_fd_pr__pfet_01v8_hvt ad=0.3864 pd=2.68 as=0 ps=0 w=0.42 l=0.15
X5514 sky130_fd_sc_hd__mux2_1_102/a_505_21# V3R061 VGND VGND sky130_fd_pr__nfet_01v8 ad=0.1092 pd=1.36 as=0 ps=0 w=0.42 l=0.15
X5515 sky130_fd_sc_hd__mux2_1_102/a_439_47# V3R172 sky130_fd_sc_hd__mux2_1_102/a_76_199# VGND sky130_fd_pr__nfet_01v8 ad=0 pd=0 as=0.1995 ps=1.79 w=0.42 l=0.15
X5516 sky130_fd_sc_hd__mux2_1_102/a_535_374# V3R161 sky130_fd_sc_hd__mux2_1_102/a_76_199# VDPWR sky130_fd_pr__pfet_01v8_hvt ad=0 pd=0 as=0 ps=0 w=0.42 l=0.15
X5517 sky130_fd_sc_hd__mux2_1_102/a_76_199# V3R161 sky130_fd_sc_hd__mux2_1_102/a_218_47# VGND sky130_fd_pr__nfet_01v8 ad=0 pd=0 as=0.1386 ps=1.5 w=0.42 l=0.15
X5518 sky130_fd_sc_hd__mux2_1_102/a_218_47# V3R061 VGND VGND sky130_fd_pr__nfet_01v8 ad=0 pd=0 as=0 ps=0 w=0.42 l=0.15
X5519 VDPWR sky130_fd_sc_hd__mux2_1_102/a_76_199# V3R087 VDPWR sky130_fd_pr__pfet_01v8_hvt ad=0 pd=0 as=0.26 ps=2.52 w=1 l=0.15
X5520 VGND sky130_fd_sc_hd__mux2_1_102/a_76_199# V3R087 VGND sky130_fd_pr__nfet_01v8 ad=0 pd=0 as=0.169 ps=1.82 w=0.65 l=0.15
X5521 V3R254 V3R182 VGND VGND sky130_fd_pr__nfet_01v8 ad=0.169 pd=1.82 as=0 ps=0 w=0.65 l=0.15
X5522 V3R254 V3R182 VDPWR VDPWR sky130_fd_pr__pfet_01v8_hvt ad=0.26 pd=2.52 as=0 ps=0 w=1 l=0.15
X5523 sky130_fd_sc_hd__dfrtp_1_10/a_805_47# sky130_fd_sc_hd__dfrtp_1_10/a_761_289# sky130_fd_sc_hd__dfrtp_1_10/a_639_47# VGND sky130_fd_pr__nfet_01v8 ad=0.0882 pd=1.26 as=0.2802 ps=2.2 w=0.42 l=0.15
X5524 sky130_fd_sc_hd__dfrtp_1_10/a_1217_47# sky130_fd_sc_hd__dfrtp_1_10/a_27_47# sky130_fd_sc_hd__dfrtp_1_10/a_1108_47# VGND sky130_fd_pr__special_nfet_01v8 ad=0.1338 pd=1.5 as=0.1422 ps=1.51 w=0.36 l=0.15
X5525 sky130_fd_sc_hd__dfrtp_1_10/a_1283_21# sky130_fd_sc_hd__dfrtp_1_10/a_1108_47# sky130_fd_sc_hd__dfrtp_1_10/a_1462_47# VGND sky130_fd_pr__nfet_01v8 ad=0.1092 pd=1.36 as=0.1281 ps=1.45 w=0.42 l=0.15
X5526 sky130_fd_sc_hd__dfrtp_1_10/a_651_413# sky130_fd_sc_hd__dfrtp_1_10/a_27_47# sky130_fd_sc_hd__dfrtp_1_10/a_543_47# VDPWR sky130_fd_pr__pfet_01v8_hvt ad=0.3402 pd=3.3 as=0.1449 ps=1.53 w=0.42 l=0.15
X5527 sky130_fd_sc_hd__dfrtp_1_10/a_1108_47# sky130_fd_sc_hd__dfrtp_1_10/a_193_47# sky130_fd_sc_hd__dfrtp_1_10/a_761_289# VGND sky130_fd_pr__special_nfet_01v8 ad=0 pd=0 as=0.1998 ps=1.97 w=0.36 l=0.15
X5528 VGND V3R303 sky130_fd_sc_hd__dfrtp_1_10/a_805_47# VGND sky130_fd_pr__nfet_01v8 ad=0 pd=0 as=0 ps=0 w=0.42 l=0.15
X5529 V3R203 sky130_fd_sc_hd__dfrtp_1_10/a_1283_21# VDPWR VDPWR sky130_fd_pr__pfet_01v8_hvt ad=0.26 pd=2.52 as=0 ps=0 w=1 l=0.15
X5530 VDPWR V3R084 sky130_fd_sc_hd__dfrtp_1_10/a_27_47# VDPWR sky130_fd_pr__pfet_01v8_hvt ad=0 pd=0 as=0.1664 ps=1.8 w=0.64 l=0.15
X5531 sky130_fd_sc_hd__dfrtp_1_10/a_448_47# V3R194 VDPWR VDPWR sky130_fd_pr__pfet_01v8_hvt ad=0.1302 pd=1.46 as=0 ps=0 w=0.42 l=0.15
X5532 sky130_fd_sc_hd__dfrtp_1_10/a_761_289# sky130_fd_sc_hd__dfrtp_1_10/a_543_47# VGND VGND sky130_fd_pr__nfet_01v8 ad=0 pd=0 as=0 ps=0 w=0.64 l=0.15
X5533 sky130_fd_sc_hd__dfrtp_1_10/a_193_47# sky130_fd_sc_hd__dfrtp_1_10/a_27_47# VGND VGND sky130_fd_pr__nfet_01v8 ad=0.1092 pd=1.36 as=0 ps=0 w=0.42 l=0.15
X5534 sky130_fd_sc_hd__dfrtp_1_10/a_1108_47# sky130_fd_sc_hd__dfrtp_1_10/a_27_47# sky130_fd_sc_hd__dfrtp_1_10/a_761_289# VDPWR sky130_fd_pr__pfet_01v8_hvt ad=0.1176 pd=1.4 as=0.2583 ps=2.37 w=0.42 l=0.15
X5535 sky130_fd_sc_hd__dfrtp_1_10/a_1462_47# V3R303 VGND VGND sky130_fd_pr__nfet_01v8 ad=0 pd=0 as=0 ps=0 w=0.42 l=0.15
X5536 sky130_fd_sc_hd__dfrtp_1_10/a_543_47# sky130_fd_sc_hd__dfrtp_1_10/a_27_47# sky130_fd_sc_hd__dfrtp_1_10/a_448_47# VGND sky130_fd_pr__special_nfet_01v8 ad=0.1188 pd=1.38 as=0.132 ps=1.49 w=0.36 l=0.15
X5537 sky130_fd_sc_hd__dfrtp_1_10/a_543_47# sky130_fd_sc_hd__dfrtp_1_10/a_193_47# sky130_fd_sc_hd__dfrtp_1_10/a_448_47# VDPWR sky130_fd_pr__pfet_01v8_hvt ad=0 pd=0 as=0 ps=0 w=0.42 l=0.15
X5538 sky130_fd_sc_hd__dfrtp_1_10/a_448_47# V3R194 VGND VGND sky130_fd_pr__nfet_01v8 ad=0 pd=0 as=0 ps=0 w=0.42 l=0.15
X5539 VDPWR sky130_fd_sc_hd__dfrtp_1_10/a_1283_21# sky130_fd_sc_hd__dfrtp_1_10/a_1270_413# VDPWR sky130_fd_pr__pfet_01v8_hvt ad=0 pd=0 as=0.1134 ps=1.38 w=0.42 l=0.15
X5540 VDPWR sky130_fd_sc_hd__dfrtp_1_10/a_1108_47# sky130_fd_sc_hd__dfrtp_1_10/a_1283_21# VDPWR sky130_fd_pr__pfet_01v8_hvt ad=0 pd=0 as=0.1134 ps=1.38 w=0.42 l=0.15
X5541 sky130_fd_sc_hd__dfrtp_1_10/a_1270_413# sky130_fd_sc_hd__dfrtp_1_10/a_193_47# sky130_fd_sc_hd__dfrtp_1_10/a_1108_47# VDPWR sky130_fd_pr__pfet_01v8_hvt ad=0 pd=0 as=0 ps=0 w=0.42 l=0.15
X5542 sky130_fd_sc_hd__dfrtp_1_10/a_193_47# sky130_fd_sc_hd__dfrtp_1_10/a_27_47# VDPWR VDPWR sky130_fd_pr__pfet_01v8_hvt ad=0.1664 pd=1.8 as=0 ps=0 w=0.64 l=0.15
X5543 sky130_fd_sc_hd__dfrtp_1_10/a_1283_21# V3R303 VDPWR VDPWR sky130_fd_pr__pfet_01v8_hvt ad=0 pd=0 as=0 ps=0 w=0.42 l=0.15
X5544 VDPWR sky130_fd_sc_hd__dfrtp_1_10/a_761_289# sky130_fd_sc_hd__dfrtp_1_10/a_651_413# VDPWR sky130_fd_pr__pfet_01v8_hvt ad=0 pd=0 as=0 ps=0 w=0.42 l=0.15
X5545 V3R203 sky130_fd_sc_hd__dfrtp_1_10/a_1283_21# VGND VGND sky130_fd_pr__nfet_01v8 ad=0.169 pd=1.82 as=0 ps=0 w=0.65 l=0.15
X5546 sky130_fd_sc_hd__dfrtp_1_10/a_639_47# sky130_fd_sc_hd__dfrtp_1_10/a_193_47# sky130_fd_sc_hd__dfrtp_1_10/a_543_47# VGND sky130_fd_pr__special_nfet_01v8 ad=0 pd=0 as=0 ps=0 w=0.36 l=0.15
X5547 VGND sky130_fd_sc_hd__dfrtp_1_10/a_1283_21# sky130_fd_sc_hd__dfrtp_1_10/a_1217_47# VGND sky130_fd_pr__nfet_01v8 ad=0 pd=0 as=0 ps=0 w=0.42 l=0.15
X5548 sky130_fd_sc_hd__dfrtp_1_10/a_651_413# V3R303 VDPWR VDPWR sky130_fd_pr__pfet_01v8_hvt ad=0 pd=0 as=0 ps=0 w=0.42 l=0.15
X5549 VGND V3R084 sky130_fd_sc_hd__dfrtp_1_10/a_27_47# VGND sky130_fd_pr__nfet_01v8 ad=0 pd=0 as=0.1092 ps=1.36 w=0.42 l=0.15
X5550 sky130_fd_sc_hd__dfrtp_1_10/a_761_289# sky130_fd_sc_hd__dfrtp_1_10/a_543_47# VDPWR VDPWR sky130_fd_pr__pfet_01v8_hvt ad=0 pd=0 as=0 ps=0 w=0.84 l=0.15
X5551 sky130_fd_sc_hd__dfrtp_1_21/a_805_47# sky130_fd_sc_hd__dfrtp_1_21/a_761_289# sky130_fd_sc_hd__dfrtp_1_21/a_639_47# VGND sky130_fd_pr__nfet_01v8 ad=0.0882 pd=1.26 as=0.2802 ps=2.2 w=0.42 l=0.15
X5552 sky130_fd_sc_hd__dfrtp_1_21/a_1217_47# sky130_fd_sc_hd__dfrtp_1_21/a_27_47# sky130_fd_sc_hd__dfrtp_1_21/a_1108_47# VGND sky130_fd_pr__special_nfet_01v8 ad=0.1338 pd=1.5 as=0.1422 ps=1.51 w=0.36 l=0.15
X5553 sky130_fd_sc_hd__dfrtp_1_21/a_1283_21# sky130_fd_sc_hd__dfrtp_1_21/a_1108_47# sky130_fd_sc_hd__dfrtp_1_21/a_1462_47# VGND sky130_fd_pr__nfet_01v8 ad=0.1092 pd=1.36 as=0.1281 ps=1.45 w=0.42 l=0.15
X5554 sky130_fd_sc_hd__dfrtp_1_21/a_651_413# sky130_fd_sc_hd__dfrtp_1_21/a_27_47# sky130_fd_sc_hd__dfrtp_1_21/a_543_47# VDPWR sky130_fd_pr__pfet_01v8_hvt ad=0.3402 pd=3.3 as=0.1449 ps=1.53 w=0.42 l=0.15
X5555 sky130_fd_sc_hd__dfrtp_1_21/a_1108_47# sky130_fd_sc_hd__dfrtp_1_21/a_193_47# sky130_fd_sc_hd__dfrtp_1_21/a_761_289# VGND sky130_fd_pr__special_nfet_01v8 ad=0 pd=0 as=0.1998 ps=1.97 w=0.36 l=0.15
X5556 VGND V3R303 sky130_fd_sc_hd__dfrtp_1_21/a_805_47# VGND sky130_fd_pr__nfet_01v8 ad=0 pd=0 as=0 ps=0 w=0.42 l=0.15
X5557 V3R204 sky130_fd_sc_hd__dfrtp_1_21/a_1283_21# VDPWR VDPWR sky130_fd_pr__pfet_01v8_hvt ad=0.26 pd=2.52 as=0 ps=0 w=1 l=0.15
X5558 VDPWR V3R084 sky130_fd_sc_hd__dfrtp_1_21/a_27_47# VDPWR sky130_fd_pr__pfet_01v8_hvt ad=0 pd=0 as=0.1664 ps=1.8 w=0.64 l=0.15
X5559 sky130_fd_sc_hd__dfrtp_1_21/a_448_47# V3R198 VDPWR VDPWR sky130_fd_pr__pfet_01v8_hvt ad=0.1302 pd=1.46 as=0 ps=0 w=0.42 l=0.15
X5560 sky130_fd_sc_hd__dfrtp_1_21/a_761_289# sky130_fd_sc_hd__dfrtp_1_21/a_543_47# VGND VGND sky130_fd_pr__nfet_01v8 ad=0 pd=0 as=0 ps=0 w=0.64 l=0.15
X5561 sky130_fd_sc_hd__dfrtp_1_21/a_193_47# sky130_fd_sc_hd__dfrtp_1_21/a_27_47# VGND VGND sky130_fd_pr__nfet_01v8 ad=0.1092 pd=1.36 as=0 ps=0 w=0.42 l=0.15
X5562 sky130_fd_sc_hd__dfrtp_1_21/a_1108_47# sky130_fd_sc_hd__dfrtp_1_21/a_27_47# sky130_fd_sc_hd__dfrtp_1_21/a_761_289# VDPWR sky130_fd_pr__pfet_01v8_hvt ad=0.1176 pd=1.4 as=0.2583 ps=2.37 w=0.42 l=0.15
X5563 sky130_fd_sc_hd__dfrtp_1_21/a_1462_47# V3R303 VGND VGND sky130_fd_pr__nfet_01v8 ad=0 pd=0 as=0 ps=0 w=0.42 l=0.15
X5564 sky130_fd_sc_hd__dfrtp_1_21/a_543_47# sky130_fd_sc_hd__dfrtp_1_21/a_27_47# sky130_fd_sc_hd__dfrtp_1_21/a_448_47# VGND sky130_fd_pr__special_nfet_01v8 ad=0.1188 pd=1.38 as=0.132 ps=1.49 w=0.36 l=0.15
X5565 sky130_fd_sc_hd__dfrtp_1_21/a_543_47# sky130_fd_sc_hd__dfrtp_1_21/a_193_47# sky130_fd_sc_hd__dfrtp_1_21/a_448_47# VDPWR sky130_fd_pr__pfet_01v8_hvt ad=0 pd=0 as=0 ps=0 w=0.42 l=0.15
X5566 sky130_fd_sc_hd__dfrtp_1_21/a_448_47# V3R198 VGND VGND sky130_fd_pr__nfet_01v8 ad=0 pd=0 as=0 ps=0 w=0.42 l=0.15
X5567 VDPWR sky130_fd_sc_hd__dfrtp_1_21/a_1283_21# sky130_fd_sc_hd__dfrtp_1_21/a_1270_413# VDPWR sky130_fd_pr__pfet_01v8_hvt ad=0 pd=0 as=0.1134 ps=1.38 w=0.42 l=0.15
X5568 VDPWR sky130_fd_sc_hd__dfrtp_1_21/a_1108_47# sky130_fd_sc_hd__dfrtp_1_21/a_1283_21# VDPWR sky130_fd_pr__pfet_01v8_hvt ad=0 pd=0 as=0.1134 ps=1.38 w=0.42 l=0.15
X5569 sky130_fd_sc_hd__dfrtp_1_21/a_1270_413# sky130_fd_sc_hd__dfrtp_1_21/a_193_47# sky130_fd_sc_hd__dfrtp_1_21/a_1108_47# VDPWR sky130_fd_pr__pfet_01v8_hvt ad=0 pd=0 as=0 ps=0 w=0.42 l=0.15
X5570 sky130_fd_sc_hd__dfrtp_1_21/a_193_47# sky130_fd_sc_hd__dfrtp_1_21/a_27_47# VDPWR VDPWR sky130_fd_pr__pfet_01v8_hvt ad=0.1664 pd=1.8 as=0 ps=0 w=0.64 l=0.15
X5571 sky130_fd_sc_hd__dfrtp_1_21/a_1283_21# V3R303 VDPWR VDPWR sky130_fd_pr__pfet_01v8_hvt ad=0 pd=0 as=0 ps=0 w=0.42 l=0.15
X5572 VDPWR sky130_fd_sc_hd__dfrtp_1_21/a_761_289# sky130_fd_sc_hd__dfrtp_1_21/a_651_413# VDPWR sky130_fd_pr__pfet_01v8_hvt ad=0 pd=0 as=0 ps=0 w=0.42 l=0.15
X5573 V3R204 sky130_fd_sc_hd__dfrtp_1_21/a_1283_21# VGND VGND sky130_fd_pr__nfet_01v8 ad=0.169 pd=1.82 as=0 ps=0 w=0.65 l=0.15
X5574 sky130_fd_sc_hd__dfrtp_1_21/a_639_47# sky130_fd_sc_hd__dfrtp_1_21/a_193_47# sky130_fd_sc_hd__dfrtp_1_21/a_543_47# VGND sky130_fd_pr__special_nfet_01v8 ad=0 pd=0 as=0 ps=0 w=0.36 l=0.15
X5575 VGND sky130_fd_sc_hd__dfrtp_1_21/a_1283_21# sky130_fd_sc_hd__dfrtp_1_21/a_1217_47# VGND sky130_fd_pr__nfet_01v8 ad=0 pd=0 as=0 ps=0 w=0.42 l=0.15
X5576 sky130_fd_sc_hd__dfrtp_1_21/a_651_413# V3R303 VDPWR VDPWR sky130_fd_pr__pfet_01v8_hvt ad=0 pd=0 as=0 ps=0 w=0.42 l=0.15
X5577 VGND V3R084 sky130_fd_sc_hd__dfrtp_1_21/a_27_47# VGND sky130_fd_pr__nfet_01v8 ad=0 pd=0 as=0.1092 ps=1.36 w=0.42 l=0.15
X5578 sky130_fd_sc_hd__dfrtp_1_21/a_761_289# sky130_fd_sc_hd__dfrtp_1_21/a_543_47# VDPWR VDPWR sky130_fd_pr__pfet_01v8_hvt ad=0 pd=0 as=0 ps=0 w=0.84 l=0.15
X5579 sky130_fd_sc_hd__dfrtp_1_87/a_805_47# sky130_fd_sc_hd__dfrtp_1_87/a_761_289# sky130_fd_sc_hd__dfrtp_1_87/a_639_47# VGND sky130_fd_pr__nfet_01v8 ad=0.0882 pd=1.26 as=0.2802 ps=2.2 w=0.42 l=0.15
X5580 sky130_fd_sc_hd__dfrtp_1_87/a_1217_47# sky130_fd_sc_hd__dfrtp_1_87/a_27_47# sky130_fd_sc_hd__dfrtp_1_87/a_1108_47# VGND sky130_fd_pr__special_nfet_01v8 ad=0.1338 pd=1.5 as=0.1422 ps=1.51 w=0.36 l=0.15
X5581 sky130_fd_sc_hd__dfrtp_1_87/a_1283_21# sky130_fd_sc_hd__dfrtp_1_87/a_1108_47# sky130_fd_sc_hd__dfrtp_1_87/a_1462_47# VGND sky130_fd_pr__nfet_01v8 ad=0.1092 pd=1.36 as=0.1281 ps=1.45 w=0.42 l=0.15
X5582 sky130_fd_sc_hd__dfrtp_1_87/a_651_413# sky130_fd_sc_hd__dfrtp_1_87/a_27_47# sky130_fd_sc_hd__dfrtp_1_87/a_543_47# VDPWR sky130_fd_pr__pfet_01v8_hvt ad=0.3402 pd=3.3 as=0.1449 ps=1.53 w=0.42 l=0.15
X5583 sky130_fd_sc_hd__dfrtp_1_87/a_1108_47# sky130_fd_sc_hd__dfrtp_1_87/a_193_47# sky130_fd_sc_hd__dfrtp_1_87/a_761_289# VGND sky130_fd_pr__special_nfet_01v8 ad=0 pd=0 as=0.1998 ps=1.97 w=0.36 l=0.15
X5584 VGND V3R298 sky130_fd_sc_hd__dfrtp_1_87/a_805_47# VGND sky130_fd_pr__nfet_01v8 ad=0 pd=0 as=0 ps=0 w=0.42 l=0.15
X5585 V3R161 sky130_fd_sc_hd__dfrtp_1_87/a_1283_21# VDPWR VDPWR sky130_fd_pr__pfet_01v8_hvt ad=0.26 pd=2.52 as=0 ps=0 w=1 l=0.15
X5586 VDPWR V3R055 sky130_fd_sc_hd__dfrtp_1_87/a_27_47# VDPWR sky130_fd_pr__pfet_01v8_hvt ad=0 pd=0 as=0.1664 ps=1.8 w=0.64 l=0.15
X5587 sky130_fd_sc_hd__dfrtp_1_87/a_448_47# V3R087 VDPWR VDPWR sky130_fd_pr__pfet_01v8_hvt ad=0.1302 pd=1.46 as=0 ps=0 w=0.42 l=0.15
X5588 sky130_fd_sc_hd__dfrtp_1_87/a_761_289# sky130_fd_sc_hd__dfrtp_1_87/a_543_47# VGND VGND sky130_fd_pr__nfet_01v8 ad=0 pd=0 as=0 ps=0 w=0.64 l=0.15
X5589 sky130_fd_sc_hd__dfrtp_1_87/a_193_47# sky130_fd_sc_hd__dfrtp_1_87/a_27_47# VGND VGND sky130_fd_pr__nfet_01v8 ad=0.1092 pd=1.36 as=0 ps=0 w=0.42 l=0.15
X5590 sky130_fd_sc_hd__dfrtp_1_87/a_1108_47# sky130_fd_sc_hd__dfrtp_1_87/a_27_47# sky130_fd_sc_hd__dfrtp_1_87/a_761_289# VDPWR sky130_fd_pr__pfet_01v8_hvt ad=0.1176 pd=1.4 as=0.2583 ps=2.37 w=0.42 l=0.15
X5591 sky130_fd_sc_hd__dfrtp_1_87/a_1462_47# V3R298 VGND VGND sky130_fd_pr__nfet_01v8 ad=0 pd=0 as=0 ps=0 w=0.42 l=0.15
X5592 sky130_fd_sc_hd__dfrtp_1_87/a_543_47# sky130_fd_sc_hd__dfrtp_1_87/a_27_47# sky130_fd_sc_hd__dfrtp_1_87/a_448_47# VGND sky130_fd_pr__special_nfet_01v8 ad=0.1188 pd=1.38 as=0.132 ps=1.49 w=0.36 l=0.15
X5593 sky130_fd_sc_hd__dfrtp_1_87/a_543_47# sky130_fd_sc_hd__dfrtp_1_87/a_193_47# sky130_fd_sc_hd__dfrtp_1_87/a_448_47# VDPWR sky130_fd_pr__pfet_01v8_hvt ad=0 pd=0 as=0 ps=0 w=0.42 l=0.15
X5594 sky130_fd_sc_hd__dfrtp_1_87/a_448_47# V3R087 VGND VGND sky130_fd_pr__nfet_01v8 ad=0 pd=0 as=0 ps=0 w=0.42 l=0.15
X5595 VDPWR sky130_fd_sc_hd__dfrtp_1_87/a_1283_21# sky130_fd_sc_hd__dfrtp_1_87/a_1270_413# VDPWR sky130_fd_pr__pfet_01v8_hvt ad=0 pd=0 as=0.1134 ps=1.38 w=0.42 l=0.15
X5596 VDPWR sky130_fd_sc_hd__dfrtp_1_87/a_1108_47# sky130_fd_sc_hd__dfrtp_1_87/a_1283_21# VDPWR sky130_fd_pr__pfet_01v8_hvt ad=0 pd=0 as=0.1134 ps=1.38 w=0.42 l=0.15
X5597 sky130_fd_sc_hd__dfrtp_1_87/a_1270_413# sky130_fd_sc_hd__dfrtp_1_87/a_193_47# sky130_fd_sc_hd__dfrtp_1_87/a_1108_47# VDPWR sky130_fd_pr__pfet_01v8_hvt ad=0 pd=0 as=0 ps=0 w=0.42 l=0.15
X5598 sky130_fd_sc_hd__dfrtp_1_87/a_193_47# sky130_fd_sc_hd__dfrtp_1_87/a_27_47# VDPWR VDPWR sky130_fd_pr__pfet_01v8_hvt ad=0.1664 pd=1.8 as=0 ps=0 w=0.64 l=0.15
X5599 sky130_fd_sc_hd__dfrtp_1_87/a_1283_21# V3R298 VDPWR VDPWR sky130_fd_pr__pfet_01v8_hvt ad=0 pd=0 as=0 ps=0 w=0.42 l=0.15
X5600 VDPWR sky130_fd_sc_hd__dfrtp_1_87/a_761_289# sky130_fd_sc_hd__dfrtp_1_87/a_651_413# VDPWR sky130_fd_pr__pfet_01v8_hvt ad=0 pd=0 as=0 ps=0 w=0.42 l=0.15
X5601 V3R161 sky130_fd_sc_hd__dfrtp_1_87/a_1283_21# VGND VGND sky130_fd_pr__nfet_01v8 ad=0.169 pd=1.82 as=0 ps=0 w=0.65 l=0.15
X5602 sky130_fd_sc_hd__dfrtp_1_87/a_639_47# sky130_fd_sc_hd__dfrtp_1_87/a_193_47# sky130_fd_sc_hd__dfrtp_1_87/a_543_47# VGND sky130_fd_pr__special_nfet_01v8 ad=0 pd=0 as=0 ps=0 w=0.36 l=0.15
X5603 VGND sky130_fd_sc_hd__dfrtp_1_87/a_1283_21# sky130_fd_sc_hd__dfrtp_1_87/a_1217_47# VGND sky130_fd_pr__nfet_01v8 ad=0 pd=0 as=0 ps=0 w=0.42 l=0.15
X5604 sky130_fd_sc_hd__dfrtp_1_87/a_651_413# V3R298 VDPWR VDPWR sky130_fd_pr__pfet_01v8_hvt ad=0 pd=0 as=0 ps=0 w=0.42 l=0.15
X5605 VGND V3R055 sky130_fd_sc_hd__dfrtp_1_87/a_27_47# VGND sky130_fd_pr__nfet_01v8 ad=0 pd=0 as=0.1092 ps=1.36 w=0.42 l=0.15
X5606 sky130_fd_sc_hd__dfrtp_1_87/a_761_289# sky130_fd_sc_hd__dfrtp_1_87/a_543_47# VDPWR VDPWR sky130_fd_pr__pfet_01v8_hvt ad=0 pd=0 as=0 ps=0 w=0.84 l=0.15
X5607 sky130_fd_sc_hd__dfrtp_1_76/a_805_47# sky130_fd_sc_hd__dfrtp_1_76/a_761_289# sky130_fd_sc_hd__dfrtp_1_76/a_639_47# VGND sky130_fd_pr__nfet_01v8 ad=0.0882 pd=1.26 as=0.2802 ps=2.2 w=0.42 l=0.15
X5608 sky130_fd_sc_hd__dfrtp_1_76/a_1217_47# sky130_fd_sc_hd__dfrtp_1_76/a_27_47# sky130_fd_sc_hd__dfrtp_1_76/a_1108_47# VGND sky130_fd_pr__special_nfet_01v8 ad=0.1338 pd=1.5 as=0.1422 ps=1.51 w=0.36 l=0.15
X5609 sky130_fd_sc_hd__dfrtp_1_76/a_1283_21# sky130_fd_sc_hd__dfrtp_1_76/a_1108_47# sky130_fd_sc_hd__dfrtp_1_76/a_1462_47# VGND sky130_fd_pr__nfet_01v8 ad=0.1092 pd=1.36 as=0.1281 ps=1.45 w=0.42 l=0.15
X5610 sky130_fd_sc_hd__dfrtp_1_76/a_651_413# sky130_fd_sc_hd__dfrtp_1_76/a_27_47# sky130_fd_sc_hd__dfrtp_1_76/a_543_47# VDPWR sky130_fd_pr__pfet_01v8_hvt ad=0.3402 pd=3.3 as=0.1449 ps=1.53 w=0.42 l=0.15
X5611 sky130_fd_sc_hd__dfrtp_1_76/a_1108_47# sky130_fd_sc_hd__dfrtp_1_76/a_193_47# sky130_fd_sc_hd__dfrtp_1_76/a_761_289# VGND sky130_fd_pr__special_nfet_01v8 ad=0 pd=0 as=0.1998 ps=1.97 w=0.36 l=0.15
X5612 VGND V3R300 sky130_fd_sc_hd__dfrtp_1_76/a_805_47# VGND sky130_fd_pr__nfet_01v8 ad=0 pd=0 as=0 ps=0 w=0.42 l=0.15
X5613 V3R039 sky130_fd_sc_hd__dfrtp_1_76/a_1283_21# VDPWR VDPWR sky130_fd_pr__pfet_01v8_hvt ad=0.26 pd=2.52 as=0 ps=0 w=1 l=0.15
X5614 VDPWR V3R081 sky130_fd_sc_hd__dfrtp_1_76/a_27_47# VDPWR sky130_fd_pr__pfet_01v8_hvt ad=0 pd=0 as=0.1664 ps=1.8 w=0.64 l=0.15
X5615 sky130_fd_sc_hd__dfrtp_1_76/a_448_47# V3R124 VDPWR VDPWR sky130_fd_pr__pfet_01v8_hvt ad=0.1302 pd=1.46 as=0 ps=0 w=0.42 l=0.15
X5616 sky130_fd_sc_hd__dfrtp_1_76/a_761_289# sky130_fd_sc_hd__dfrtp_1_76/a_543_47# VGND VGND sky130_fd_pr__nfet_01v8 ad=0 pd=0 as=0 ps=0 w=0.64 l=0.15
X5617 sky130_fd_sc_hd__dfrtp_1_76/a_193_47# sky130_fd_sc_hd__dfrtp_1_76/a_27_47# VGND VGND sky130_fd_pr__nfet_01v8 ad=0.1092 pd=1.36 as=0 ps=0 w=0.42 l=0.15
X5618 sky130_fd_sc_hd__dfrtp_1_76/a_1108_47# sky130_fd_sc_hd__dfrtp_1_76/a_27_47# sky130_fd_sc_hd__dfrtp_1_76/a_761_289# VDPWR sky130_fd_pr__pfet_01v8_hvt ad=0.1176 pd=1.4 as=0.2583 ps=2.37 w=0.42 l=0.15
X5619 sky130_fd_sc_hd__dfrtp_1_76/a_1462_47# V3R300 VGND VGND sky130_fd_pr__nfet_01v8 ad=0 pd=0 as=0 ps=0 w=0.42 l=0.15
X5620 sky130_fd_sc_hd__dfrtp_1_76/a_543_47# sky130_fd_sc_hd__dfrtp_1_76/a_27_47# sky130_fd_sc_hd__dfrtp_1_76/a_448_47# VGND sky130_fd_pr__special_nfet_01v8 ad=0.1188 pd=1.38 as=0.132 ps=1.49 w=0.36 l=0.15
X5621 sky130_fd_sc_hd__dfrtp_1_76/a_543_47# sky130_fd_sc_hd__dfrtp_1_76/a_193_47# sky130_fd_sc_hd__dfrtp_1_76/a_448_47# VDPWR sky130_fd_pr__pfet_01v8_hvt ad=0 pd=0 as=0 ps=0 w=0.42 l=0.15
X5622 sky130_fd_sc_hd__dfrtp_1_76/a_448_47# V3R124 VGND VGND sky130_fd_pr__nfet_01v8 ad=0 pd=0 as=0 ps=0 w=0.42 l=0.15
X5623 VDPWR sky130_fd_sc_hd__dfrtp_1_76/a_1283_21# sky130_fd_sc_hd__dfrtp_1_76/a_1270_413# VDPWR sky130_fd_pr__pfet_01v8_hvt ad=0 pd=0 as=0.1134 ps=1.38 w=0.42 l=0.15
X5624 VDPWR sky130_fd_sc_hd__dfrtp_1_76/a_1108_47# sky130_fd_sc_hd__dfrtp_1_76/a_1283_21# VDPWR sky130_fd_pr__pfet_01v8_hvt ad=0 pd=0 as=0.1134 ps=1.38 w=0.42 l=0.15
X5625 sky130_fd_sc_hd__dfrtp_1_76/a_1270_413# sky130_fd_sc_hd__dfrtp_1_76/a_193_47# sky130_fd_sc_hd__dfrtp_1_76/a_1108_47# VDPWR sky130_fd_pr__pfet_01v8_hvt ad=0 pd=0 as=0 ps=0 w=0.42 l=0.15
X5626 sky130_fd_sc_hd__dfrtp_1_76/a_193_47# sky130_fd_sc_hd__dfrtp_1_76/a_27_47# VDPWR VDPWR sky130_fd_pr__pfet_01v8_hvt ad=0.1664 pd=1.8 as=0 ps=0 w=0.64 l=0.15
X5627 sky130_fd_sc_hd__dfrtp_1_76/a_1283_21# V3R300 VDPWR VDPWR sky130_fd_pr__pfet_01v8_hvt ad=0 pd=0 as=0 ps=0 w=0.42 l=0.15
X5628 VDPWR sky130_fd_sc_hd__dfrtp_1_76/a_761_289# sky130_fd_sc_hd__dfrtp_1_76/a_651_413# VDPWR sky130_fd_pr__pfet_01v8_hvt ad=0 pd=0 as=0 ps=0 w=0.42 l=0.15
X5629 V3R039 sky130_fd_sc_hd__dfrtp_1_76/a_1283_21# VGND VGND sky130_fd_pr__nfet_01v8 ad=0.169 pd=1.82 as=0 ps=0 w=0.65 l=0.15
X5630 sky130_fd_sc_hd__dfrtp_1_76/a_639_47# sky130_fd_sc_hd__dfrtp_1_76/a_193_47# sky130_fd_sc_hd__dfrtp_1_76/a_543_47# VGND sky130_fd_pr__special_nfet_01v8 ad=0 pd=0 as=0 ps=0 w=0.36 l=0.15
X5631 VGND sky130_fd_sc_hd__dfrtp_1_76/a_1283_21# sky130_fd_sc_hd__dfrtp_1_76/a_1217_47# VGND sky130_fd_pr__nfet_01v8 ad=0 pd=0 as=0 ps=0 w=0.42 l=0.15
X5632 sky130_fd_sc_hd__dfrtp_1_76/a_651_413# V3R300 VDPWR VDPWR sky130_fd_pr__pfet_01v8_hvt ad=0 pd=0 as=0 ps=0 w=0.42 l=0.15
X5633 VGND V3R081 sky130_fd_sc_hd__dfrtp_1_76/a_27_47# VGND sky130_fd_pr__nfet_01v8 ad=0 pd=0 as=0.1092 ps=1.36 w=0.42 l=0.15
X5634 sky130_fd_sc_hd__dfrtp_1_76/a_761_289# sky130_fd_sc_hd__dfrtp_1_76/a_543_47# VDPWR VDPWR sky130_fd_pr__pfet_01v8_hvt ad=0 pd=0 as=0 ps=0 w=0.84 l=0.15
X5635 sky130_fd_sc_hd__dfrtp_1_65/a_805_47# sky130_fd_sc_hd__dfrtp_1_65/a_761_289# sky130_fd_sc_hd__dfrtp_1_65/a_639_47# VGND sky130_fd_pr__nfet_01v8 ad=0.0882 pd=1.26 as=0.2802 ps=2.2 w=0.42 l=0.15
X5636 sky130_fd_sc_hd__dfrtp_1_65/a_1217_47# sky130_fd_sc_hd__dfrtp_1_65/a_27_47# sky130_fd_sc_hd__dfrtp_1_65/a_1108_47# VGND sky130_fd_pr__special_nfet_01v8 ad=0.1338 pd=1.5 as=0.1422 ps=1.51 w=0.36 l=0.15
X5637 sky130_fd_sc_hd__dfrtp_1_65/a_1283_21# sky130_fd_sc_hd__dfrtp_1_65/a_1108_47# sky130_fd_sc_hd__dfrtp_1_65/a_1462_47# VGND sky130_fd_pr__nfet_01v8 ad=0.1092 pd=1.36 as=0.1281 ps=1.45 w=0.42 l=0.15
X5638 sky130_fd_sc_hd__dfrtp_1_65/a_651_413# sky130_fd_sc_hd__dfrtp_1_65/a_27_47# sky130_fd_sc_hd__dfrtp_1_65/a_543_47# VDPWR sky130_fd_pr__pfet_01v8_hvt ad=0.3402 pd=3.3 as=0.1449 ps=1.53 w=0.42 l=0.15
X5639 sky130_fd_sc_hd__dfrtp_1_65/a_1108_47# sky130_fd_sc_hd__dfrtp_1_65/a_193_47# sky130_fd_sc_hd__dfrtp_1_65/a_761_289# VGND sky130_fd_pr__special_nfet_01v8 ad=0 pd=0 as=0.1998 ps=1.97 w=0.36 l=0.15
X5640 VGND V3R298 sky130_fd_sc_hd__dfrtp_1_65/a_805_47# VGND sky130_fd_pr__nfet_01v8 ad=0 pd=0 as=0 ps=0 w=0.42 l=0.15
X5641 V3R151 sky130_fd_sc_hd__dfrtp_1_65/a_1283_21# VDPWR VDPWR sky130_fd_pr__pfet_01v8_hvt ad=0.26 pd=2.52 as=0 ps=0 w=1 l=0.15
X5642 VDPWR V3R055 sky130_fd_sc_hd__dfrtp_1_65/a_27_47# VDPWR sky130_fd_pr__pfet_01v8_hvt ad=0 pd=0 as=0.1664 ps=1.8 w=0.64 l=0.15
X5643 sky130_fd_sc_hd__dfrtp_1_65/a_448_47# V3R096 VDPWR VDPWR sky130_fd_pr__pfet_01v8_hvt ad=0.1302 pd=1.46 as=0 ps=0 w=0.42 l=0.15
X5644 sky130_fd_sc_hd__dfrtp_1_65/a_761_289# sky130_fd_sc_hd__dfrtp_1_65/a_543_47# VGND VGND sky130_fd_pr__nfet_01v8 ad=0 pd=0 as=0 ps=0 w=0.64 l=0.15
X5645 sky130_fd_sc_hd__dfrtp_1_65/a_193_47# sky130_fd_sc_hd__dfrtp_1_65/a_27_47# VGND VGND sky130_fd_pr__nfet_01v8 ad=0.1092 pd=1.36 as=0 ps=0 w=0.42 l=0.15
X5646 sky130_fd_sc_hd__dfrtp_1_65/a_1108_47# sky130_fd_sc_hd__dfrtp_1_65/a_27_47# sky130_fd_sc_hd__dfrtp_1_65/a_761_289# VDPWR sky130_fd_pr__pfet_01v8_hvt ad=0.1176 pd=1.4 as=0.2583 ps=2.37 w=0.42 l=0.15
X5647 sky130_fd_sc_hd__dfrtp_1_65/a_1462_47# V3R298 VGND VGND sky130_fd_pr__nfet_01v8 ad=0 pd=0 as=0 ps=0 w=0.42 l=0.15
X5648 sky130_fd_sc_hd__dfrtp_1_65/a_543_47# sky130_fd_sc_hd__dfrtp_1_65/a_27_47# sky130_fd_sc_hd__dfrtp_1_65/a_448_47# VGND sky130_fd_pr__special_nfet_01v8 ad=0.1188 pd=1.38 as=0.132 ps=1.49 w=0.36 l=0.15
X5649 sky130_fd_sc_hd__dfrtp_1_65/a_543_47# sky130_fd_sc_hd__dfrtp_1_65/a_193_47# sky130_fd_sc_hd__dfrtp_1_65/a_448_47# VDPWR sky130_fd_pr__pfet_01v8_hvt ad=0 pd=0 as=0 ps=0 w=0.42 l=0.15
X5650 sky130_fd_sc_hd__dfrtp_1_65/a_448_47# V3R096 VGND VGND sky130_fd_pr__nfet_01v8 ad=0 pd=0 as=0 ps=0 w=0.42 l=0.15
X5651 VDPWR sky130_fd_sc_hd__dfrtp_1_65/a_1283_21# sky130_fd_sc_hd__dfrtp_1_65/a_1270_413# VDPWR sky130_fd_pr__pfet_01v8_hvt ad=0 pd=0 as=0.1134 ps=1.38 w=0.42 l=0.15
X5652 VDPWR sky130_fd_sc_hd__dfrtp_1_65/a_1108_47# sky130_fd_sc_hd__dfrtp_1_65/a_1283_21# VDPWR sky130_fd_pr__pfet_01v8_hvt ad=0 pd=0 as=0.1134 ps=1.38 w=0.42 l=0.15
X5653 sky130_fd_sc_hd__dfrtp_1_65/a_1270_413# sky130_fd_sc_hd__dfrtp_1_65/a_193_47# sky130_fd_sc_hd__dfrtp_1_65/a_1108_47# VDPWR sky130_fd_pr__pfet_01v8_hvt ad=0 pd=0 as=0 ps=0 w=0.42 l=0.15
X5654 sky130_fd_sc_hd__dfrtp_1_65/a_193_47# sky130_fd_sc_hd__dfrtp_1_65/a_27_47# VDPWR VDPWR sky130_fd_pr__pfet_01v8_hvt ad=0.1664 pd=1.8 as=0 ps=0 w=0.64 l=0.15
X5655 sky130_fd_sc_hd__dfrtp_1_65/a_1283_21# V3R298 VDPWR VDPWR sky130_fd_pr__pfet_01v8_hvt ad=0 pd=0 as=0 ps=0 w=0.42 l=0.15
X5656 VDPWR sky130_fd_sc_hd__dfrtp_1_65/a_761_289# sky130_fd_sc_hd__dfrtp_1_65/a_651_413# VDPWR sky130_fd_pr__pfet_01v8_hvt ad=0 pd=0 as=0 ps=0 w=0.42 l=0.15
X5657 V3R151 sky130_fd_sc_hd__dfrtp_1_65/a_1283_21# VGND VGND sky130_fd_pr__nfet_01v8 ad=0.169 pd=1.82 as=0 ps=0 w=0.65 l=0.15
X5658 sky130_fd_sc_hd__dfrtp_1_65/a_639_47# sky130_fd_sc_hd__dfrtp_1_65/a_193_47# sky130_fd_sc_hd__dfrtp_1_65/a_543_47# VGND sky130_fd_pr__special_nfet_01v8 ad=0 pd=0 as=0 ps=0 w=0.36 l=0.15
X5659 VGND sky130_fd_sc_hd__dfrtp_1_65/a_1283_21# sky130_fd_sc_hd__dfrtp_1_65/a_1217_47# VGND sky130_fd_pr__nfet_01v8 ad=0 pd=0 as=0 ps=0 w=0.42 l=0.15
X5660 sky130_fd_sc_hd__dfrtp_1_65/a_651_413# V3R298 VDPWR VDPWR sky130_fd_pr__pfet_01v8_hvt ad=0 pd=0 as=0 ps=0 w=0.42 l=0.15
X5661 VGND V3R055 sky130_fd_sc_hd__dfrtp_1_65/a_27_47# VGND sky130_fd_pr__nfet_01v8 ad=0 pd=0 as=0.1092 ps=1.36 w=0.42 l=0.15
X5662 sky130_fd_sc_hd__dfrtp_1_65/a_761_289# sky130_fd_sc_hd__dfrtp_1_65/a_543_47# VDPWR VDPWR sky130_fd_pr__pfet_01v8_hvt ad=0 pd=0 as=0 ps=0 w=0.84 l=0.15
X5663 sky130_fd_sc_hd__dfrtp_1_43/a_805_47# sky130_fd_sc_hd__dfrtp_1_43/a_761_289# sky130_fd_sc_hd__dfrtp_1_43/a_639_47# VGND sky130_fd_pr__nfet_01v8 ad=0.0882 pd=1.26 as=0.2802 ps=2.2 w=0.42 l=0.15
X5664 sky130_fd_sc_hd__dfrtp_1_43/a_1217_47# sky130_fd_sc_hd__dfrtp_1_43/a_27_47# sky130_fd_sc_hd__dfrtp_1_43/a_1108_47# VGND sky130_fd_pr__special_nfet_01v8 ad=0.1338 pd=1.5 as=0.1422 ps=1.51 w=0.36 l=0.15
X5665 sky130_fd_sc_hd__dfrtp_1_43/a_1283_21# sky130_fd_sc_hd__dfrtp_1_43/a_1108_47# sky130_fd_sc_hd__dfrtp_1_43/a_1462_47# VGND sky130_fd_pr__nfet_01v8 ad=0.1092 pd=1.36 as=0.1281 ps=1.45 w=0.42 l=0.15
X5666 sky130_fd_sc_hd__dfrtp_1_43/a_651_413# sky130_fd_sc_hd__dfrtp_1_43/a_27_47# sky130_fd_sc_hd__dfrtp_1_43/a_543_47# VDPWR sky130_fd_pr__pfet_01v8_hvt ad=0.3402 pd=3.3 as=0.1449 ps=1.53 w=0.42 l=0.15
X5667 sky130_fd_sc_hd__dfrtp_1_43/a_1108_47# sky130_fd_sc_hd__dfrtp_1_43/a_193_47# sky130_fd_sc_hd__dfrtp_1_43/a_761_289# VGND sky130_fd_pr__special_nfet_01v8 ad=0 pd=0 as=0.1998 ps=1.97 w=0.36 l=0.15
X5668 VGND V3R304 sky130_fd_sc_hd__dfrtp_1_43/a_805_47# VGND sky130_fd_pr__nfet_01v8 ad=0 pd=0 as=0 ps=0 w=0.42 l=0.15
X5669 V3R291 sky130_fd_sc_hd__dfrtp_1_43/a_1283_21# VDPWR VDPWR sky130_fd_pr__pfet_01v8_hvt ad=0.26 pd=2.52 as=0 ps=0 w=1 l=0.15
X5670 VDPWR V3R084 sky130_fd_sc_hd__dfrtp_1_43/a_27_47# VDPWR sky130_fd_pr__pfet_01v8_hvt ad=0 pd=0 as=0.1664 ps=1.8 w=0.64 l=0.15
X5671 sky130_fd_sc_hd__dfrtp_1_43/a_448_47# V3R295 VDPWR VDPWR sky130_fd_pr__pfet_01v8_hvt ad=0.1302 pd=1.46 as=0 ps=0 w=0.42 l=0.15
X5672 sky130_fd_sc_hd__dfrtp_1_43/a_761_289# sky130_fd_sc_hd__dfrtp_1_43/a_543_47# VGND VGND sky130_fd_pr__nfet_01v8 ad=0 pd=0 as=0 ps=0 w=0.64 l=0.15
X5673 sky130_fd_sc_hd__dfrtp_1_43/a_193_47# sky130_fd_sc_hd__dfrtp_1_43/a_27_47# VGND VGND sky130_fd_pr__nfet_01v8 ad=0.1092 pd=1.36 as=0 ps=0 w=0.42 l=0.15
X5674 sky130_fd_sc_hd__dfrtp_1_43/a_1108_47# sky130_fd_sc_hd__dfrtp_1_43/a_27_47# sky130_fd_sc_hd__dfrtp_1_43/a_761_289# VDPWR sky130_fd_pr__pfet_01v8_hvt ad=0.1176 pd=1.4 as=0.2583 ps=2.37 w=0.42 l=0.15
X5675 sky130_fd_sc_hd__dfrtp_1_43/a_1462_47# V3R304 VGND VGND sky130_fd_pr__nfet_01v8 ad=0 pd=0 as=0 ps=0 w=0.42 l=0.15
X5676 sky130_fd_sc_hd__dfrtp_1_43/a_543_47# sky130_fd_sc_hd__dfrtp_1_43/a_27_47# sky130_fd_sc_hd__dfrtp_1_43/a_448_47# VGND sky130_fd_pr__special_nfet_01v8 ad=0.1188 pd=1.38 as=0.132 ps=1.49 w=0.36 l=0.15
X5677 sky130_fd_sc_hd__dfrtp_1_43/a_543_47# sky130_fd_sc_hd__dfrtp_1_43/a_193_47# sky130_fd_sc_hd__dfrtp_1_43/a_448_47# VDPWR sky130_fd_pr__pfet_01v8_hvt ad=0 pd=0 as=0 ps=0 w=0.42 l=0.15
X5678 sky130_fd_sc_hd__dfrtp_1_43/a_448_47# V3R295 VGND VGND sky130_fd_pr__nfet_01v8 ad=0 pd=0 as=0 ps=0 w=0.42 l=0.15
X5679 VDPWR sky130_fd_sc_hd__dfrtp_1_43/a_1283_21# sky130_fd_sc_hd__dfrtp_1_43/a_1270_413# VDPWR sky130_fd_pr__pfet_01v8_hvt ad=0 pd=0 as=0.1134 ps=1.38 w=0.42 l=0.15
X5680 VDPWR sky130_fd_sc_hd__dfrtp_1_43/a_1108_47# sky130_fd_sc_hd__dfrtp_1_43/a_1283_21# VDPWR sky130_fd_pr__pfet_01v8_hvt ad=0 pd=0 as=0.1134 ps=1.38 w=0.42 l=0.15
X5681 sky130_fd_sc_hd__dfrtp_1_43/a_1270_413# sky130_fd_sc_hd__dfrtp_1_43/a_193_47# sky130_fd_sc_hd__dfrtp_1_43/a_1108_47# VDPWR sky130_fd_pr__pfet_01v8_hvt ad=0 pd=0 as=0 ps=0 w=0.42 l=0.15
X5682 sky130_fd_sc_hd__dfrtp_1_43/a_193_47# sky130_fd_sc_hd__dfrtp_1_43/a_27_47# VDPWR VDPWR sky130_fd_pr__pfet_01v8_hvt ad=0.1664 pd=1.8 as=0 ps=0 w=0.64 l=0.15
X5683 sky130_fd_sc_hd__dfrtp_1_43/a_1283_21# V3R304 VDPWR VDPWR sky130_fd_pr__pfet_01v8_hvt ad=0 pd=0 as=0 ps=0 w=0.42 l=0.15
X5684 VDPWR sky130_fd_sc_hd__dfrtp_1_43/a_761_289# sky130_fd_sc_hd__dfrtp_1_43/a_651_413# VDPWR sky130_fd_pr__pfet_01v8_hvt ad=0 pd=0 as=0 ps=0 w=0.42 l=0.15
X5685 V3R291 sky130_fd_sc_hd__dfrtp_1_43/a_1283_21# VGND VGND sky130_fd_pr__nfet_01v8 ad=0.169 pd=1.82 as=0 ps=0 w=0.65 l=0.15
X5686 sky130_fd_sc_hd__dfrtp_1_43/a_639_47# sky130_fd_sc_hd__dfrtp_1_43/a_193_47# sky130_fd_sc_hd__dfrtp_1_43/a_543_47# VGND sky130_fd_pr__special_nfet_01v8 ad=0 pd=0 as=0 ps=0 w=0.36 l=0.15
X5687 VGND sky130_fd_sc_hd__dfrtp_1_43/a_1283_21# sky130_fd_sc_hd__dfrtp_1_43/a_1217_47# VGND sky130_fd_pr__nfet_01v8 ad=0 pd=0 as=0 ps=0 w=0.42 l=0.15
X5688 sky130_fd_sc_hd__dfrtp_1_43/a_651_413# V3R304 VDPWR VDPWR sky130_fd_pr__pfet_01v8_hvt ad=0 pd=0 as=0 ps=0 w=0.42 l=0.15
X5689 VGND V3R084 sky130_fd_sc_hd__dfrtp_1_43/a_27_47# VGND sky130_fd_pr__nfet_01v8 ad=0 pd=0 as=0.1092 ps=1.36 w=0.42 l=0.15
X5690 sky130_fd_sc_hd__dfrtp_1_43/a_761_289# sky130_fd_sc_hd__dfrtp_1_43/a_543_47# VDPWR VDPWR sky130_fd_pr__pfet_01v8_hvt ad=0 pd=0 as=0 ps=0 w=0.84 l=0.15
X5691 sky130_fd_sc_hd__dfrtp_1_32/a_805_47# sky130_fd_sc_hd__dfrtp_1_32/a_761_289# sky130_fd_sc_hd__dfrtp_1_32/a_639_47# VGND sky130_fd_pr__nfet_01v8 ad=0.0882 pd=1.26 as=0.2802 ps=2.2 w=0.42 l=0.15
X5692 sky130_fd_sc_hd__dfrtp_1_32/a_1217_47# sky130_fd_sc_hd__dfrtp_1_32/a_27_47# sky130_fd_sc_hd__dfrtp_1_32/a_1108_47# VGND sky130_fd_pr__special_nfet_01v8 ad=0.1338 pd=1.5 as=0.1422 ps=1.51 w=0.36 l=0.15
X5693 sky130_fd_sc_hd__dfrtp_1_32/a_1283_21# sky130_fd_sc_hd__dfrtp_1_32/a_1108_47# sky130_fd_sc_hd__dfrtp_1_32/a_1462_47# VGND sky130_fd_pr__nfet_01v8 ad=0.1092 pd=1.36 as=0.1281 ps=1.45 w=0.42 l=0.15
X5694 sky130_fd_sc_hd__dfrtp_1_32/a_651_413# sky130_fd_sc_hd__dfrtp_1_32/a_27_47# sky130_fd_sc_hd__dfrtp_1_32/a_543_47# VDPWR sky130_fd_pr__pfet_01v8_hvt ad=0.3402 pd=3.3 as=0.1449 ps=1.53 w=0.42 l=0.15
X5695 sky130_fd_sc_hd__dfrtp_1_32/a_1108_47# sky130_fd_sc_hd__dfrtp_1_32/a_193_47# sky130_fd_sc_hd__dfrtp_1_32/a_761_289# VGND sky130_fd_pr__special_nfet_01v8 ad=0 pd=0 as=0.1998 ps=1.97 w=0.36 l=0.15
X5696 VGND V3R299 sky130_fd_sc_hd__dfrtp_1_32/a_805_47# VGND sky130_fd_pr__nfet_01v8 ad=0 pd=0 as=0 ps=0 w=0.42 l=0.15
X5697 V3R164 sky130_fd_sc_hd__dfrtp_1_32/a_1283_21# VDPWR VDPWR sky130_fd_pr__pfet_01v8_hvt ad=0.26 pd=2.52 as=0 ps=0 w=1 l=0.15
X5698 VDPWR V3R056 sky130_fd_sc_hd__dfrtp_1_32/a_27_47# VDPWR sky130_fd_pr__pfet_01v8_hvt ad=0 pd=0 as=0.1664 ps=1.8 w=0.64 l=0.15
X5699 sky130_fd_sc_hd__dfrtp_1_32/a_448_47# V3R108 VDPWR VDPWR sky130_fd_pr__pfet_01v8_hvt ad=0.1302 pd=1.46 as=0 ps=0 w=0.42 l=0.15
X5700 sky130_fd_sc_hd__dfrtp_1_32/a_761_289# sky130_fd_sc_hd__dfrtp_1_32/a_543_47# VGND VGND sky130_fd_pr__nfet_01v8 ad=0 pd=0 as=0 ps=0 w=0.64 l=0.15
X5701 sky130_fd_sc_hd__dfrtp_1_32/a_193_47# sky130_fd_sc_hd__dfrtp_1_32/a_27_47# VGND VGND sky130_fd_pr__nfet_01v8 ad=0.1092 pd=1.36 as=0 ps=0 w=0.42 l=0.15
X5702 sky130_fd_sc_hd__dfrtp_1_32/a_1108_47# sky130_fd_sc_hd__dfrtp_1_32/a_27_47# sky130_fd_sc_hd__dfrtp_1_32/a_761_289# VDPWR sky130_fd_pr__pfet_01v8_hvt ad=0.1176 pd=1.4 as=0.2583 ps=2.37 w=0.42 l=0.15
X5703 sky130_fd_sc_hd__dfrtp_1_32/a_1462_47# V3R299 VGND VGND sky130_fd_pr__nfet_01v8 ad=0 pd=0 as=0 ps=0 w=0.42 l=0.15
X5704 sky130_fd_sc_hd__dfrtp_1_32/a_543_47# sky130_fd_sc_hd__dfrtp_1_32/a_27_47# sky130_fd_sc_hd__dfrtp_1_32/a_448_47# VGND sky130_fd_pr__special_nfet_01v8 ad=0.1188 pd=1.38 as=0.132 ps=1.49 w=0.36 l=0.15
X5705 sky130_fd_sc_hd__dfrtp_1_32/a_543_47# sky130_fd_sc_hd__dfrtp_1_32/a_193_47# sky130_fd_sc_hd__dfrtp_1_32/a_448_47# VDPWR sky130_fd_pr__pfet_01v8_hvt ad=0 pd=0 as=0 ps=0 w=0.42 l=0.15
X5706 sky130_fd_sc_hd__dfrtp_1_32/a_448_47# V3R108 VGND VGND sky130_fd_pr__nfet_01v8 ad=0 pd=0 as=0 ps=0 w=0.42 l=0.15
X5707 VDPWR sky130_fd_sc_hd__dfrtp_1_32/a_1283_21# sky130_fd_sc_hd__dfrtp_1_32/a_1270_413# VDPWR sky130_fd_pr__pfet_01v8_hvt ad=0 pd=0 as=0.1134 ps=1.38 w=0.42 l=0.15
X5708 VDPWR sky130_fd_sc_hd__dfrtp_1_32/a_1108_47# sky130_fd_sc_hd__dfrtp_1_32/a_1283_21# VDPWR sky130_fd_pr__pfet_01v8_hvt ad=0 pd=0 as=0.1134 ps=1.38 w=0.42 l=0.15
X5709 sky130_fd_sc_hd__dfrtp_1_32/a_1270_413# sky130_fd_sc_hd__dfrtp_1_32/a_193_47# sky130_fd_sc_hd__dfrtp_1_32/a_1108_47# VDPWR sky130_fd_pr__pfet_01v8_hvt ad=0 pd=0 as=0 ps=0 w=0.42 l=0.15
X5710 sky130_fd_sc_hd__dfrtp_1_32/a_193_47# sky130_fd_sc_hd__dfrtp_1_32/a_27_47# VDPWR VDPWR sky130_fd_pr__pfet_01v8_hvt ad=0.1664 pd=1.8 as=0 ps=0 w=0.64 l=0.15
X5711 sky130_fd_sc_hd__dfrtp_1_32/a_1283_21# V3R299 VDPWR VDPWR sky130_fd_pr__pfet_01v8_hvt ad=0 pd=0 as=0 ps=0 w=0.42 l=0.15
X5712 VDPWR sky130_fd_sc_hd__dfrtp_1_32/a_761_289# sky130_fd_sc_hd__dfrtp_1_32/a_651_413# VDPWR sky130_fd_pr__pfet_01v8_hvt ad=0 pd=0 as=0 ps=0 w=0.42 l=0.15
X5713 V3R164 sky130_fd_sc_hd__dfrtp_1_32/a_1283_21# VGND VGND sky130_fd_pr__nfet_01v8 ad=0.169 pd=1.82 as=0 ps=0 w=0.65 l=0.15
X5714 sky130_fd_sc_hd__dfrtp_1_32/a_639_47# sky130_fd_sc_hd__dfrtp_1_32/a_193_47# sky130_fd_sc_hd__dfrtp_1_32/a_543_47# VGND sky130_fd_pr__special_nfet_01v8 ad=0 pd=0 as=0 ps=0 w=0.36 l=0.15
X5715 VGND sky130_fd_sc_hd__dfrtp_1_32/a_1283_21# sky130_fd_sc_hd__dfrtp_1_32/a_1217_47# VGND sky130_fd_pr__nfet_01v8 ad=0 pd=0 as=0 ps=0 w=0.42 l=0.15
X5716 sky130_fd_sc_hd__dfrtp_1_32/a_651_413# V3R299 VDPWR VDPWR sky130_fd_pr__pfet_01v8_hvt ad=0 pd=0 as=0 ps=0 w=0.42 l=0.15
X5717 VGND V3R056 sky130_fd_sc_hd__dfrtp_1_32/a_27_47# VGND sky130_fd_pr__nfet_01v8 ad=0 pd=0 as=0.1092 ps=1.36 w=0.42 l=0.15
X5718 sky130_fd_sc_hd__dfrtp_1_32/a_761_289# sky130_fd_sc_hd__dfrtp_1_32/a_543_47# VDPWR VDPWR sky130_fd_pr__pfet_01v8_hvt ad=0 pd=0 as=0 ps=0 w=0.84 l=0.15
X5719 sky130_fd_sc_hd__dfrtp_1_54/a_805_47# sky130_fd_sc_hd__dfrtp_1_54/a_761_289# sky130_fd_sc_hd__dfrtp_1_54/a_639_47# VGND sky130_fd_pr__nfet_01v8 ad=0.0882 pd=1.26 as=0.2802 ps=2.2 w=0.42 l=0.15
X5720 sky130_fd_sc_hd__dfrtp_1_54/a_1217_47# sky130_fd_sc_hd__dfrtp_1_54/a_27_47# sky130_fd_sc_hd__dfrtp_1_54/a_1108_47# VGND sky130_fd_pr__special_nfet_01v8 ad=0.1338 pd=1.5 as=0.1422 ps=1.51 w=0.36 l=0.15
X5721 sky130_fd_sc_hd__dfrtp_1_54/a_1283_21# sky130_fd_sc_hd__dfrtp_1_54/a_1108_47# sky130_fd_sc_hd__dfrtp_1_54/a_1462_47# VGND sky130_fd_pr__nfet_01v8 ad=0.1092 pd=1.36 as=0.1281 ps=1.45 w=0.42 l=0.15
X5722 sky130_fd_sc_hd__dfrtp_1_54/a_651_413# sky130_fd_sc_hd__dfrtp_1_54/a_27_47# sky130_fd_sc_hd__dfrtp_1_54/a_543_47# VDPWR sky130_fd_pr__pfet_01v8_hvt ad=0.3402 pd=3.3 as=0.1449 ps=1.53 w=0.42 l=0.15
X5723 sky130_fd_sc_hd__dfrtp_1_54/a_1108_47# sky130_fd_sc_hd__dfrtp_1_54/a_193_47# sky130_fd_sc_hd__dfrtp_1_54/a_761_289# VGND sky130_fd_pr__special_nfet_01v8 ad=0 pd=0 as=0.1998 ps=1.97 w=0.36 l=0.15
X5724 VGND V3R298 sky130_fd_sc_hd__dfrtp_1_54/a_805_47# VGND sky130_fd_pr__nfet_01v8 ad=0 pd=0 as=0 ps=0 w=0.42 l=0.15
X5725 V3R156 sky130_fd_sc_hd__dfrtp_1_54/a_1283_21# VDPWR VDPWR sky130_fd_pr__pfet_01v8_hvt ad=0.26 pd=2.52 as=0 ps=0 w=1 l=0.15
X5726 VDPWR V3R055 sky130_fd_sc_hd__dfrtp_1_54/a_27_47# VDPWR sky130_fd_pr__pfet_01v8_hvt ad=0 pd=0 as=0.1664 ps=1.8 w=0.64 l=0.15
X5727 sky130_fd_sc_hd__dfrtp_1_54/a_448_47# V3R101 VDPWR VDPWR sky130_fd_pr__pfet_01v8_hvt ad=0.1302 pd=1.46 as=0 ps=0 w=0.42 l=0.15
X5728 sky130_fd_sc_hd__dfrtp_1_54/a_761_289# sky130_fd_sc_hd__dfrtp_1_54/a_543_47# VGND VGND sky130_fd_pr__nfet_01v8 ad=0 pd=0 as=0 ps=0 w=0.64 l=0.15
X5729 sky130_fd_sc_hd__dfrtp_1_54/a_193_47# sky130_fd_sc_hd__dfrtp_1_54/a_27_47# VGND VGND sky130_fd_pr__nfet_01v8 ad=0.1092 pd=1.36 as=0 ps=0 w=0.42 l=0.15
X5730 sky130_fd_sc_hd__dfrtp_1_54/a_1108_47# sky130_fd_sc_hd__dfrtp_1_54/a_27_47# sky130_fd_sc_hd__dfrtp_1_54/a_761_289# VDPWR sky130_fd_pr__pfet_01v8_hvt ad=0.1176 pd=1.4 as=0.2583 ps=2.37 w=0.42 l=0.15
X5731 sky130_fd_sc_hd__dfrtp_1_54/a_1462_47# V3R298 VGND VGND sky130_fd_pr__nfet_01v8 ad=0 pd=0 as=0 ps=0 w=0.42 l=0.15
X5732 sky130_fd_sc_hd__dfrtp_1_54/a_543_47# sky130_fd_sc_hd__dfrtp_1_54/a_27_47# sky130_fd_sc_hd__dfrtp_1_54/a_448_47# VGND sky130_fd_pr__special_nfet_01v8 ad=0.1188 pd=1.38 as=0.132 ps=1.49 w=0.36 l=0.15
X5733 sky130_fd_sc_hd__dfrtp_1_54/a_543_47# sky130_fd_sc_hd__dfrtp_1_54/a_193_47# sky130_fd_sc_hd__dfrtp_1_54/a_448_47# VDPWR sky130_fd_pr__pfet_01v8_hvt ad=0 pd=0 as=0 ps=0 w=0.42 l=0.15
X5734 sky130_fd_sc_hd__dfrtp_1_54/a_448_47# V3R101 VGND VGND sky130_fd_pr__nfet_01v8 ad=0 pd=0 as=0 ps=0 w=0.42 l=0.15
X5735 VDPWR sky130_fd_sc_hd__dfrtp_1_54/a_1283_21# sky130_fd_sc_hd__dfrtp_1_54/a_1270_413# VDPWR sky130_fd_pr__pfet_01v8_hvt ad=0 pd=0 as=0.1134 ps=1.38 w=0.42 l=0.15
X5736 VDPWR sky130_fd_sc_hd__dfrtp_1_54/a_1108_47# sky130_fd_sc_hd__dfrtp_1_54/a_1283_21# VDPWR sky130_fd_pr__pfet_01v8_hvt ad=0 pd=0 as=0.1134 ps=1.38 w=0.42 l=0.15
X5737 sky130_fd_sc_hd__dfrtp_1_54/a_1270_413# sky130_fd_sc_hd__dfrtp_1_54/a_193_47# sky130_fd_sc_hd__dfrtp_1_54/a_1108_47# VDPWR sky130_fd_pr__pfet_01v8_hvt ad=0 pd=0 as=0 ps=0 w=0.42 l=0.15
X5738 sky130_fd_sc_hd__dfrtp_1_54/a_193_47# sky130_fd_sc_hd__dfrtp_1_54/a_27_47# VDPWR VDPWR sky130_fd_pr__pfet_01v8_hvt ad=0.1664 pd=1.8 as=0 ps=0 w=0.64 l=0.15
X5739 sky130_fd_sc_hd__dfrtp_1_54/a_1283_21# V3R298 VDPWR VDPWR sky130_fd_pr__pfet_01v8_hvt ad=0 pd=0 as=0 ps=0 w=0.42 l=0.15
X5740 VDPWR sky130_fd_sc_hd__dfrtp_1_54/a_761_289# sky130_fd_sc_hd__dfrtp_1_54/a_651_413# VDPWR sky130_fd_pr__pfet_01v8_hvt ad=0 pd=0 as=0 ps=0 w=0.42 l=0.15
X5741 V3R156 sky130_fd_sc_hd__dfrtp_1_54/a_1283_21# VGND VGND sky130_fd_pr__nfet_01v8 ad=0.169 pd=1.82 as=0 ps=0 w=0.65 l=0.15
X5742 sky130_fd_sc_hd__dfrtp_1_54/a_639_47# sky130_fd_sc_hd__dfrtp_1_54/a_193_47# sky130_fd_sc_hd__dfrtp_1_54/a_543_47# VGND sky130_fd_pr__special_nfet_01v8 ad=0 pd=0 as=0 ps=0 w=0.36 l=0.15
X5743 VGND sky130_fd_sc_hd__dfrtp_1_54/a_1283_21# sky130_fd_sc_hd__dfrtp_1_54/a_1217_47# VGND sky130_fd_pr__nfet_01v8 ad=0 pd=0 as=0 ps=0 w=0.42 l=0.15
X5744 sky130_fd_sc_hd__dfrtp_1_54/a_651_413# V3R298 VDPWR VDPWR sky130_fd_pr__pfet_01v8_hvt ad=0 pd=0 as=0 ps=0 w=0.42 l=0.15
X5745 VGND V3R055 sky130_fd_sc_hd__dfrtp_1_54/a_27_47# VGND sky130_fd_pr__nfet_01v8 ad=0 pd=0 as=0.1092 ps=1.36 w=0.42 l=0.15
X5746 sky130_fd_sc_hd__dfrtp_1_54/a_761_289# sky130_fd_sc_hd__dfrtp_1_54/a_543_47# VDPWR VDPWR sky130_fd_pr__pfet_01v8_hvt ad=0 pd=0 as=0 ps=0 w=0.84 l=0.15
X5747 V3R251 sky130_fd_sc_hd__xor2_1_1/a_35_297# sky130_fd_sc_hd__xor2_1_1/a_285_297# VDPWR sky130_fd_pr__pfet_01v8_hvt ad=0.3 pd=2.6 as=0.53 ps=5.06 w=1 l=0.15
X5748 V3R251 V3R000 sky130_fd_sc_hd__xor2_1_1/a_285_47# VGND sky130_fd_pr__nfet_01v8 ad=0.5005 pd=2.84 as=0.1755 ps=1.84 w=0.65 l=0.15
X5749 sky130_fd_sc_hd__xor2_1_1/a_35_297# V3R000 VGND VGND sky130_fd_pr__nfet_01v8 ad=0.1755 pd=1.84 as=0 ps=0 w=0.65 l=0.15
X5750 sky130_fd_sc_hd__xor2_1_1/a_117_297# V3R000 sky130_fd_sc_hd__xor2_1_1/a_35_297# VDPWR sky130_fd_pr__pfet_01v8_hvt ad=0.27 pd=2.54 as=0.26 ps=2.52 w=1 l=0.15
X5751 VDPWR V3R000 sky130_fd_sc_hd__xor2_1_1/a_285_297# VDPWR sky130_fd_pr__pfet_01v8_hvt ad=0 pd=0 as=0 ps=0 w=1 l=0.15
X5752 VGND V3R001 sky130_fd_sc_hd__xor2_1_1/a_35_297# VGND sky130_fd_pr__nfet_01v8 ad=0 pd=0 as=0 ps=0 w=0.65 l=0.15
X5753 VGND sky130_fd_sc_hd__xor2_1_1/a_35_297# V3R251 VGND sky130_fd_pr__nfet_01v8 ad=0 pd=0 as=0 ps=0 w=0.65 l=0.15
X5754 sky130_fd_sc_hd__xor2_1_1/a_285_297# V3R001 VDPWR VDPWR sky130_fd_pr__pfet_01v8_hvt ad=0 pd=0 as=0 ps=0 w=1 l=0.15
X5755 VDPWR V3R001 sky130_fd_sc_hd__xor2_1_1/a_117_297# VDPWR sky130_fd_pr__pfet_01v8_hvt ad=0 pd=0 as=0 ps=0 w=1 l=0.15
X5756 sky130_fd_sc_hd__xor2_1_1/a_285_47# V3R001 VGND VGND sky130_fd_pr__nfet_01v8 ad=0 pd=0 as=0 ps=0 w=0.65 l=0.15
X5757 VDPWR sky130_fd_sc_hd__mux2_1_2/a_505_21# sky130_fd_sc_hd__mux2_1_2/a_535_374# VDPWR sky130_fd_pr__pfet_01v8_hvt ad=0 pd=0 as=0.0882 ps=1.26 w=0.42 l=0.15
X5758 sky130_fd_sc_hd__mux2_1_2/a_505_21# V3R062 VDPWR VDPWR sky130_fd_pr__pfet_01v8_hvt ad=0.1176 pd=1.4 as=0 ps=0 w=0.42 l=0.15
X5759 sky130_fd_sc_hd__mux2_1_2/a_218_374# V3R062 VDPWR VDPWR sky130_fd_pr__pfet_01v8_hvt ad=0.1533 pd=1.57 as=0 ps=0 w=0.42 l=0.15
X5760 VGND sky130_fd_sc_hd__mux2_1_2/a_505_21# sky130_fd_sc_hd__mux2_1_2/a_439_47# VGND sky130_fd_pr__nfet_01v8 ad=0 pd=0 as=0.1386 ps=1.5 w=0.42 l=0.15
X5761 sky130_fd_sc_hd__mux2_1_2/a_76_199# V3R174 sky130_fd_sc_hd__mux2_1_2/a_218_374# VDPWR sky130_fd_pr__pfet_01v8_hvt ad=0.3864 pd=2.68 as=0 ps=0 w=0.42 l=0.15
X5762 sky130_fd_sc_hd__mux2_1_2/a_505_21# V3R062 VGND VGND sky130_fd_pr__nfet_01v8 ad=0.1092 pd=1.36 as=0 ps=0 w=0.42 l=0.15
X5763 sky130_fd_sc_hd__mux2_1_2/a_439_47# V3R174 sky130_fd_sc_hd__mux2_1_2/a_76_199# VGND sky130_fd_pr__nfet_01v8 ad=0 pd=0 as=0.1995 ps=1.79 w=0.42 l=0.15
X5764 sky130_fd_sc_hd__mux2_1_2/a_535_374# V3R173 sky130_fd_sc_hd__mux2_1_2/a_76_199# VDPWR sky130_fd_pr__pfet_01v8_hvt ad=0 pd=0 as=0 ps=0 w=0.42 l=0.15
X5765 sky130_fd_sc_hd__mux2_1_2/a_76_199# V3R173 sky130_fd_sc_hd__mux2_1_2/a_218_47# VGND sky130_fd_pr__nfet_01v8 ad=0 pd=0 as=0.1386 ps=1.5 w=0.42 l=0.15
X5766 sky130_fd_sc_hd__mux2_1_2/a_218_47# V3R062 VGND VGND sky130_fd_pr__nfet_01v8 ad=0 pd=0 as=0 ps=0 w=0.42 l=0.15
X5767 VDPWR sky130_fd_sc_hd__mux2_1_2/a_76_199# V3R116 VDPWR sky130_fd_pr__pfet_01v8_hvt ad=0 pd=0 as=0.26 ps=2.52 w=1 l=0.15
X5768 VGND sky130_fd_sc_hd__mux2_1_2/a_76_199# V3R116 VGND sky130_fd_pr__nfet_01v8 ad=0 pd=0 as=0.169 ps=1.82 w=0.65 l=0.15
X5769 VDPWR sky130_fd_sc_hd__mux2_1_103/a_505_21# sky130_fd_sc_hd__mux2_1_103/a_535_374# VDPWR sky130_fd_pr__pfet_01v8_hvt ad=0 pd=0 as=0.0882 ps=1.26 w=0.42 l=0.15
X5770 sky130_fd_sc_hd__mux2_1_103/a_505_21# V3R044 VDPWR VDPWR sky130_fd_pr__pfet_01v8_hvt ad=0.1176 pd=1.4 as=0 ps=0 w=0.42 l=0.15
X5771 sky130_fd_sc_hd__mux2_1_103/a_218_374# V3R044 VDPWR VDPWR sky130_fd_pr__pfet_01v8_hvt ad=0.1533 pd=1.57 as=0 ps=0 w=0.42 l=0.15
X5772 VGND sky130_fd_sc_hd__mux2_1_103/a_505_21# sky130_fd_sc_hd__mux2_1_103/a_439_47# VGND sky130_fd_pr__nfet_01v8 ad=0 pd=0 as=0.1386 ps=1.5 w=0.42 l=0.15
X5773 sky130_fd_sc_hd__mux2_1_103/a_76_199# V3R022 sky130_fd_sc_hd__mux2_1_103/a_218_374# VDPWR sky130_fd_pr__pfet_01v8_hvt ad=0.3864 pd=2.68 as=0 ps=0 w=0.42 l=0.15
X5774 sky130_fd_sc_hd__mux2_1_103/a_505_21# V3R044 VGND VGND sky130_fd_pr__nfet_01v8 ad=0.1092 pd=1.36 as=0 ps=0 w=0.42 l=0.15
X5775 sky130_fd_sc_hd__mux2_1_103/a_439_47# V3R022 sky130_fd_sc_hd__mux2_1_103/a_76_199# VGND sky130_fd_pr__nfet_01v8 ad=0 pd=0 as=0.1995 ps=1.79 w=0.42 l=0.15
X5776 sky130_fd_sc_hd__mux2_1_103/a_535_374# V3R161 sky130_fd_sc_hd__mux2_1_103/a_76_199# VDPWR sky130_fd_pr__pfet_01v8_hvt ad=0 pd=0 as=0 ps=0 w=0.42 l=0.15
X5777 sky130_fd_sc_hd__mux2_1_103/a_76_199# V3R161 sky130_fd_sc_hd__mux2_1_103/a_218_47# VGND sky130_fd_pr__nfet_01v8 ad=0 pd=0 as=0.1386 ps=1.5 w=0.42 l=0.15
X5778 sky130_fd_sc_hd__mux2_1_103/a_218_47# V3R044 VGND VGND sky130_fd_pr__nfet_01v8 ad=0 pd=0 as=0 ps=0 w=0.42 l=0.15
X5779 VDPWR sky130_fd_sc_hd__mux2_1_103/a_76_199# V3R119 VDPWR sky130_fd_pr__pfet_01v8_hvt ad=0 pd=0 as=0.26 ps=2.52 w=1 l=0.15
X5780 VGND sky130_fd_sc_hd__mux2_1_103/a_76_199# V3R119 VGND sky130_fd_pr__nfet_01v8 ad=0 pd=0 as=0.169 ps=1.82 w=0.65 l=0.15
X5781 VDPWR V3R287 sky130_fd_sc_hd__and2b_1_10/a_207_413# VDPWR sky130_fd_pr__pfet_01v8_hvt ad=0 pd=0 as=0.1218 ps=1.42 w=0.42 l=0.15
X5782 V3R288 sky130_fd_sc_hd__and2b_1_10/a_207_413# VDPWR VDPWR sky130_fd_pr__pfet_01v8_hvt ad=0.26 pd=2.52 as=0 ps=0 w=1 l=0.15
X5783 sky130_fd_sc_hd__and2b_1_10/a_297_47# sky130_fd_sc_hd__and2b_1_10/a_27_413# sky130_fd_sc_hd__and2b_1_10/a_207_413# VGND sky130_fd_pr__nfet_01v8 ad=0.1008 pd=1.32 as=0.1092 ps=1.36 w=0.42 l=0.15
X5784 V3R288 sky130_fd_sc_hd__and2b_1_10/a_207_413# VGND VGND sky130_fd_pr__nfet_01v8 ad=0.169 pd=1.82 as=0 ps=0 w=0.65 l=0.15
X5785 sky130_fd_sc_hd__and2b_1_10/a_207_413# sky130_fd_sc_hd__and2b_1_10/a_27_413# VDPWR VDPWR sky130_fd_pr__pfet_01v8_hvt ad=0 pd=0 as=0 ps=0 w=0.42 l=0.15
X5786 VDPWR V3R053 sky130_fd_sc_hd__and2b_1_10/a_27_413# VDPWR sky130_fd_pr__pfet_01v8_hvt ad=0 pd=0 as=0.1092 ps=1.36 w=0.42 l=0.15
X5787 VGND V3R287 sky130_fd_sc_hd__and2b_1_10/a_297_47# VGND sky130_fd_pr__nfet_01v8 ad=0 pd=0 as=0 ps=0 w=0.42 l=0.15
X5788 sky130_fd_sc_hd__and2b_1_10/a_27_413# V3R053 VGND VGND sky130_fd_pr__nfet_01v8 ad=0.1092 pd=1.36 as=0 ps=0 w=0.42 l=0.15
X5789 V3R267 V3R058 VGND VGND sky130_fd_pr__nfet_01v8 ad=0.169 pd=1.82 as=0 ps=0 w=0.65 l=0.15
X5790 V3R267 V3R058 VDPWR VDPWR sky130_fd_pr__pfet_01v8_hvt ad=0.26 pd=2.52 as=0 ps=0 w=1 l=0.15
X5791 sky130_fd_sc_hd__dfrtp_1_11/a_805_47# sky130_fd_sc_hd__dfrtp_1_11/a_761_289# sky130_fd_sc_hd__dfrtp_1_11/a_639_47# VGND sky130_fd_pr__nfet_01v8 ad=0.0882 pd=1.26 as=0.2802 ps=2.2 w=0.42 l=0.15
X5792 sky130_fd_sc_hd__dfrtp_1_11/a_1217_47# sky130_fd_sc_hd__dfrtp_1_11/a_27_47# sky130_fd_sc_hd__dfrtp_1_11/a_1108_47# VGND sky130_fd_pr__special_nfet_01v8 ad=0.1338 pd=1.5 as=0.1422 ps=1.51 w=0.36 l=0.15
X5793 sky130_fd_sc_hd__dfrtp_1_11/a_1283_21# sky130_fd_sc_hd__dfrtp_1_11/a_1108_47# sky130_fd_sc_hd__dfrtp_1_11/a_1462_47# VGND sky130_fd_pr__nfet_01v8 ad=0.1092 pd=1.36 as=0.1281 ps=1.45 w=0.42 l=0.15
X5794 sky130_fd_sc_hd__dfrtp_1_11/a_651_413# sky130_fd_sc_hd__dfrtp_1_11/a_27_47# sky130_fd_sc_hd__dfrtp_1_11/a_543_47# VDPWR sky130_fd_pr__pfet_01v8_hvt ad=0.3402 pd=3.3 as=0.1449 ps=1.53 w=0.42 l=0.15
X5795 sky130_fd_sc_hd__dfrtp_1_11/a_1108_47# sky130_fd_sc_hd__dfrtp_1_11/a_193_47# sky130_fd_sc_hd__dfrtp_1_11/a_761_289# VGND sky130_fd_pr__special_nfet_01v8 ad=0 pd=0 as=0.1998 ps=1.97 w=0.36 l=0.15
X5796 VGND V3R299 sky130_fd_sc_hd__dfrtp_1_11/a_805_47# VGND sky130_fd_pr__nfet_01v8 ad=0 pd=0 as=0 ps=0 w=0.42 l=0.15
X5797 V3R170 sky130_fd_sc_hd__dfrtp_1_11/a_1283_21# VDPWR VDPWR sky130_fd_pr__pfet_01v8_hvt ad=0.26 pd=2.52 as=0 ps=0 w=1 l=0.15
X5798 VDPWR V3R056 sky130_fd_sc_hd__dfrtp_1_11/a_27_47# VDPWR sky130_fd_pr__pfet_01v8_hvt ad=0 pd=0 as=0.1664 ps=1.8 w=0.64 l=0.15
X5799 sky130_fd_sc_hd__dfrtp_1_11/a_448_47# V3R114 VDPWR VDPWR sky130_fd_pr__pfet_01v8_hvt ad=0.1302 pd=1.46 as=0 ps=0 w=0.42 l=0.15
X5800 sky130_fd_sc_hd__dfrtp_1_11/a_761_289# sky130_fd_sc_hd__dfrtp_1_11/a_543_47# VGND VGND sky130_fd_pr__nfet_01v8 ad=0 pd=0 as=0 ps=0 w=0.64 l=0.15
X5801 sky130_fd_sc_hd__dfrtp_1_11/a_193_47# sky130_fd_sc_hd__dfrtp_1_11/a_27_47# VGND VGND sky130_fd_pr__nfet_01v8 ad=0.1092 pd=1.36 as=0 ps=0 w=0.42 l=0.15
X5802 sky130_fd_sc_hd__dfrtp_1_11/a_1108_47# sky130_fd_sc_hd__dfrtp_1_11/a_27_47# sky130_fd_sc_hd__dfrtp_1_11/a_761_289# VDPWR sky130_fd_pr__pfet_01v8_hvt ad=0.1176 pd=1.4 as=0.2583 ps=2.37 w=0.42 l=0.15
X5803 sky130_fd_sc_hd__dfrtp_1_11/a_1462_47# V3R299 VGND VGND sky130_fd_pr__nfet_01v8 ad=0 pd=0 as=0 ps=0 w=0.42 l=0.15
X5804 sky130_fd_sc_hd__dfrtp_1_11/a_543_47# sky130_fd_sc_hd__dfrtp_1_11/a_27_47# sky130_fd_sc_hd__dfrtp_1_11/a_448_47# VGND sky130_fd_pr__special_nfet_01v8 ad=0.1188 pd=1.38 as=0.132 ps=1.49 w=0.36 l=0.15
X5805 sky130_fd_sc_hd__dfrtp_1_11/a_543_47# sky130_fd_sc_hd__dfrtp_1_11/a_193_47# sky130_fd_sc_hd__dfrtp_1_11/a_448_47# VDPWR sky130_fd_pr__pfet_01v8_hvt ad=0 pd=0 as=0 ps=0 w=0.42 l=0.15
X5806 sky130_fd_sc_hd__dfrtp_1_11/a_448_47# V3R114 VGND VGND sky130_fd_pr__nfet_01v8 ad=0 pd=0 as=0 ps=0 w=0.42 l=0.15
X5807 VDPWR sky130_fd_sc_hd__dfrtp_1_11/a_1283_21# sky130_fd_sc_hd__dfrtp_1_11/a_1270_413# VDPWR sky130_fd_pr__pfet_01v8_hvt ad=0 pd=0 as=0.1134 ps=1.38 w=0.42 l=0.15
X5808 VDPWR sky130_fd_sc_hd__dfrtp_1_11/a_1108_47# sky130_fd_sc_hd__dfrtp_1_11/a_1283_21# VDPWR sky130_fd_pr__pfet_01v8_hvt ad=0 pd=0 as=0.1134 ps=1.38 w=0.42 l=0.15
X5809 sky130_fd_sc_hd__dfrtp_1_11/a_1270_413# sky130_fd_sc_hd__dfrtp_1_11/a_193_47# sky130_fd_sc_hd__dfrtp_1_11/a_1108_47# VDPWR sky130_fd_pr__pfet_01v8_hvt ad=0 pd=0 as=0 ps=0 w=0.42 l=0.15
X5810 sky130_fd_sc_hd__dfrtp_1_11/a_193_47# sky130_fd_sc_hd__dfrtp_1_11/a_27_47# VDPWR VDPWR sky130_fd_pr__pfet_01v8_hvt ad=0.1664 pd=1.8 as=0 ps=0 w=0.64 l=0.15
X5811 sky130_fd_sc_hd__dfrtp_1_11/a_1283_21# V3R299 VDPWR VDPWR sky130_fd_pr__pfet_01v8_hvt ad=0 pd=0 as=0 ps=0 w=0.42 l=0.15
X5812 VDPWR sky130_fd_sc_hd__dfrtp_1_11/a_761_289# sky130_fd_sc_hd__dfrtp_1_11/a_651_413# VDPWR sky130_fd_pr__pfet_01v8_hvt ad=0 pd=0 as=0 ps=0 w=0.42 l=0.15
X5813 V3R170 sky130_fd_sc_hd__dfrtp_1_11/a_1283_21# VGND VGND sky130_fd_pr__nfet_01v8 ad=0.169 pd=1.82 as=0 ps=0 w=0.65 l=0.15
X5814 sky130_fd_sc_hd__dfrtp_1_11/a_639_47# sky130_fd_sc_hd__dfrtp_1_11/a_193_47# sky130_fd_sc_hd__dfrtp_1_11/a_543_47# VGND sky130_fd_pr__special_nfet_01v8 ad=0 pd=0 as=0 ps=0 w=0.36 l=0.15
X5815 VGND sky130_fd_sc_hd__dfrtp_1_11/a_1283_21# sky130_fd_sc_hd__dfrtp_1_11/a_1217_47# VGND sky130_fd_pr__nfet_01v8 ad=0 pd=0 as=0 ps=0 w=0.42 l=0.15
X5816 sky130_fd_sc_hd__dfrtp_1_11/a_651_413# V3R299 VDPWR VDPWR sky130_fd_pr__pfet_01v8_hvt ad=0 pd=0 as=0 ps=0 w=0.42 l=0.15
X5817 VGND V3R056 sky130_fd_sc_hd__dfrtp_1_11/a_27_47# VGND sky130_fd_pr__nfet_01v8 ad=0 pd=0 as=0.1092 ps=1.36 w=0.42 l=0.15
X5818 sky130_fd_sc_hd__dfrtp_1_11/a_761_289# sky130_fd_sc_hd__dfrtp_1_11/a_543_47# VDPWR VDPWR sky130_fd_pr__pfet_01v8_hvt ad=0 pd=0 as=0 ps=0 w=0.84 l=0.15
X5819 sky130_fd_sc_hd__dfrtp_1_55/a_805_47# sky130_fd_sc_hd__dfrtp_1_55/a_761_289# sky130_fd_sc_hd__dfrtp_1_55/a_639_47# VGND sky130_fd_pr__nfet_01v8 ad=0.0882 pd=1.26 as=0.2802 ps=2.2 w=0.42 l=0.15
X5820 sky130_fd_sc_hd__dfrtp_1_55/a_1217_47# sky130_fd_sc_hd__dfrtp_1_55/a_27_47# sky130_fd_sc_hd__dfrtp_1_55/a_1108_47# VGND sky130_fd_pr__special_nfet_01v8 ad=0.1338 pd=1.5 as=0.1422 ps=1.51 w=0.36 l=0.15
X5821 sky130_fd_sc_hd__dfrtp_1_55/a_1283_21# sky130_fd_sc_hd__dfrtp_1_55/a_1108_47# sky130_fd_sc_hd__dfrtp_1_55/a_1462_47# VGND sky130_fd_pr__nfet_01v8 ad=0.1092 pd=1.36 as=0.1281 ps=1.45 w=0.42 l=0.15
X5822 sky130_fd_sc_hd__dfrtp_1_55/a_651_413# sky130_fd_sc_hd__dfrtp_1_55/a_27_47# sky130_fd_sc_hd__dfrtp_1_55/a_543_47# VDPWR sky130_fd_pr__pfet_01v8_hvt ad=0.3402 pd=3.3 as=0.1449 ps=1.53 w=0.42 l=0.15
X5823 sky130_fd_sc_hd__dfrtp_1_55/a_1108_47# sky130_fd_sc_hd__dfrtp_1_55/a_193_47# sky130_fd_sc_hd__dfrtp_1_55/a_761_289# VGND sky130_fd_pr__special_nfet_01v8 ad=0 pd=0 as=0.1998 ps=1.97 w=0.36 l=0.15
X5824 VGND V3R300 sky130_fd_sc_hd__dfrtp_1_55/a_805_47# VGND sky130_fd_pr__nfet_01v8 ad=0 pd=0 as=0 ps=0 w=0.42 l=0.15
X5825 V3R017 sky130_fd_sc_hd__dfrtp_1_55/a_1283_21# VDPWR VDPWR sky130_fd_pr__pfet_01v8_hvt ad=0.26 pd=2.52 as=0 ps=0 w=1 l=0.15
X5826 VDPWR V3R081 sky130_fd_sc_hd__dfrtp_1_55/a_27_47# VDPWR sky130_fd_pr__pfet_01v8_hvt ad=0 pd=0 as=0.1664 ps=1.8 w=0.64 l=0.15
X5827 sky130_fd_sc_hd__dfrtp_1_55/a_448_47# V3R133 VDPWR VDPWR sky130_fd_pr__pfet_01v8_hvt ad=0.1302 pd=1.46 as=0 ps=0 w=0.42 l=0.15
X5828 sky130_fd_sc_hd__dfrtp_1_55/a_761_289# sky130_fd_sc_hd__dfrtp_1_55/a_543_47# VGND VGND sky130_fd_pr__nfet_01v8 ad=0 pd=0 as=0 ps=0 w=0.64 l=0.15
X5829 sky130_fd_sc_hd__dfrtp_1_55/a_193_47# sky130_fd_sc_hd__dfrtp_1_55/a_27_47# VGND VGND sky130_fd_pr__nfet_01v8 ad=0.1092 pd=1.36 as=0 ps=0 w=0.42 l=0.15
X5830 sky130_fd_sc_hd__dfrtp_1_55/a_1108_47# sky130_fd_sc_hd__dfrtp_1_55/a_27_47# sky130_fd_sc_hd__dfrtp_1_55/a_761_289# VDPWR sky130_fd_pr__pfet_01v8_hvt ad=0.1176 pd=1.4 as=0.2583 ps=2.37 w=0.42 l=0.15
X5831 sky130_fd_sc_hd__dfrtp_1_55/a_1462_47# V3R300 VGND VGND sky130_fd_pr__nfet_01v8 ad=0 pd=0 as=0 ps=0 w=0.42 l=0.15
X5832 sky130_fd_sc_hd__dfrtp_1_55/a_543_47# sky130_fd_sc_hd__dfrtp_1_55/a_27_47# sky130_fd_sc_hd__dfrtp_1_55/a_448_47# VGND sky130_fd_pr__special_nfet_01v8 ad=0.1188 pd=1.38 as=0.132 ps=1.49 w=0.36 l=0.15
X5833 sky130_fd_sc_hd__dfrtp_1_55/a_543_47# sky130_fd_sc_hd__dfrtp_1_55/a_193_47# sky130_fd_sc_hd__dfrtp_1_55/a_448_47# VDPWR sky130_fd_pr__pfet_01v8_hvt ad=0 pd=0 as=0 ps=0 w=0.42 l=0.15
X5834 sky130_fd_sc_hd__dfrtp_1_55/a_448_47# V3R133 VGND VGND sky130_fd_pr__nfet_01v8 ad=0 pd=0 as=0 ps=0 w=0.42 l=0.15
X5835 VDPWR sky130_fd_sc_hd__dfrtp_1_55/a_1283_21# sky130_fd_sc_hd__dfrtp_1_55/a_1270_413# VDPWR sky130_fd_pr__pfet_01v8_hvt ad=0 pd=0 as=0.1134 ps=1.38 w=0.42 l=0.15
X5836 VDPWR sky130_fd_sc_hd__dfrtp_1_55/a_1108_47# sky130_fd_sc_hd__dfrtp_1_55/a_1283_21# VDPWR sky130_fd_pr__pfet_01v8_hvt ad=0 pd=0 as=0.1134 ps=1.38 w=0.42 l=0.15
X5837 sky130_fd_sc_hd__dfrtp_1_55/a_1270_413# sky130_fd_sc_hd__dfrtp_1_55/a_193_47# sky130_fd_sc_hd__dfrtp_1_55/a_1108_47# VDPWR sky130_fd_pr__pfet_01v8_hvt ad=0 pd=0 as=0 ps=0 w=0.42 l=0.15
X5838 sky130_fd_sc_hd__dfrtp_1_55/a_193_47# sky130_fd_sc_hd__dfrtp_1_55/a_27_47# VDPWR VDPWR sky130_fd_pr__pfet_01v8_hvt ad=0.1664 pd=1.8 as=0 ps=0 w=0.64 l=0.15
X5839 sky130_fd_sc_hd__dfrtp_1_55/a_1283_21# V3R300 VDPWR VDPWR sky130_fd_pr__pfet_01v8_hvt ad=0 pd=0 as=0 ps=0 w=0.42 l=0.15
X5840 VDPWR sky130_fd_sc_hd__dfrtp_1_55/a_761_289# sky130_fd_sc_hd__dfrtp_1_55/a_651_413# VDPWR sky130_fd_pr__pfet_01v8_hvt ad=0 pd=0 as=0 ps=0 w=0.42 l=0.15
X5841 V3R017 sky130_fd_sc_hd__dfrtp_1_55/a_1283_21# VGND VGND sky130_fd_pr__nfet_01v8 ad=0.169 pd=1.82 as=0 ps=0 w=0.65 l=0.15
X5842 sky130_fd_sc_hd__dfrtp_1_55/a_639_47# sky130_fd_sc_hd__dfrtp_1_55/a_193_47# sky130_fd_sc_hd__dfrtp_1_55/a_543_47# VGND sky130_fd_pr__special_nfet_01v8 ad=0 pd=0 as=0 ps=0 w=0.36 l=0.15
X5843 VGND sky130_fd_sc_hd__dfrtp_1_55/a_1283_21# sky130_fd_sc_hd__dfrtp_1_55/a_1217_47# VGND sky130_fd_pr__nfet_01v8 ad=0 pd=0 as=0 ps=0 w=0.42 l=0.15
X5844 sky130_fd_sc_hd__dfrtp_1_55/a_651_413# V3R300 VDPWR VDPWR sky130_fd_pr__pfet_01v8_hvt ad=0 pd=0 as=0 ps=0 w=0.42 l=0.15
X5845 VGND V3R081 sky130_fd_sc_hd__dfrtp_1_55/a_27_47# VGND sky130_fd_pr__nfet_01v8 ad=0 pd=0 as=0.1092 ps=1.36 w=0.42 l=0.15
X5846 sky130_fd_sc_hd__dfrtp_1_55/a_761_289# sky130_fd_sc_hd__dfrtp_1_55/a_543_47# VDPWR VDPWR sky130_fd_pr__pfet_01v8_hvt ad=0 pd=0 as=0 ps=0 w=0.84 l=0.15
X5847 sky130_fd_sc_hd__dfrtp_1_44/a_805_47# sky130_fd_sc_hd__dfrtp_1_44/a_761_289# sky130_fd_sc_hd__dfrtp_1_44/a_639_47# VGND sky130_fd_pr__nfet_01v8 ad=0.0882 pd=1.26 as=0.2802 ps=2.2 w=0.42 l=0.15
X5848 sky130_fd_sc_hd__dfrtp_1_44/a_1217_47# sky130_fd_sc_hd__dfrtp_1_44/a_27_47# sky130_fd_sc_hd__dfrtp_1_44/a_1108_47# VGND sky130_fd_pr__special_nfet_01v8 ad=0.1338 pd=1.5 as=0.1422 ps=1.51 w=0.36 l=0.15
X5849 sky130_fd_sc_hd__dfrtp_1_44/a_1283_21# sky130_fd_sc_hd__dfrtp_1_44/a_1108_47# sky130_fd_sc_hd__dfrtp_1_44/a_1462_47# VGND sky130_fd_pr__nfet_01v8 ad=0.1092 pd=1.36 as=0.1281 ps=1.45 w=0.42 l=0.15
X5850 sky130_fd_sc_hd__dfrtp_1_44/a_651_413# sky130_fd_sc_hd__dfrtp_1_44/a_27_47# sky130_fd_sc_hd__dfrtp_1_44/a_543_47# VDPWR sky130_fd_pr__pfet_01v8_hvt ad=0.3402 pd=3.3 as=0.1449 ps=1.53 w=0.42 l=0.15
X5851 sky130_fd_sc_hd__dfrtp_1_44/a_1108_47# sky130_fd_sc_hd__dfrtp_1_44/a_193_47# sky130_fd_sc_hd__dfrtp_1_44/a_761_289# VGND sky130_fd_pr__special_nfet_01v8 ad=0 pd=0 as=0.1998 ps=1.97 w=0.36 l=0.15
X5852 VGND V3R299 sky130_fd_sc_hd__dfrtp_1_44/a_805_47# VGND sky130_fd_pr__nfet_01v8 ad=0 pd=0 as=0 ps=0 w=0.42 l=0.15
X5853 V3R159 sky130_fd_sc_hd__dfrtp_1_44/a_1283_21# VDPWR VDPWR sky130_fd_pr__pfet_01v8_hvt ad=0.26 pd=2.52 as=0 ps=0 w=1 l=0.15
X5854 VDPWR V3R056 sky130_fd_sc_hd__dfrtp_1_44/a_27_47# VDPWR sky130_fd_pr__pfet_01v8_hvt ad=0 pd=0 as=0.1664 ps=1.8 w=0.64 l=0.15
X5855 sky130_fd_sc_hd__dfrtp_1_44/a_448_47# V3R104 VDPWR VDPWR sky130_fd_pr__pfet_01v8_hvt ad=0.1302 pd=1.46 as=0 ps=0 w=0.42 l=0.15
X5856 sky130_fd_sc_hd__dfrtp_1_44/a_761_289# sky130_fd_sc_hd__dfrtp_1_44/a_543_47# VGND VGND sky130_fd_pr__nfet_01v8 ad=0 pd=0 as=0 ps=0 w=0.64 l=0.15
X5857 sky130_fd_sc_hd__dfrtp_1_44/a_193_47# sky130_fd_sc_hd__dfrtp_1_44/a_27_47# VGND VGND sky130_fd_pr__nfet_01v8 ad=0.1092 pd=1.36 as=0 ps=0 w=0.42 l=0.15
X5858 sky130_fd_sc_hd__dfrtp_1_44/a_1108_47# sky130_fd_sc_hd__dfrtp_1_44/a_27_47# sky130_fd_sc_hd__dfrtp_1_44/a_761_289# VDPWR sky130_fd_pr__pfet_01v8_hvt ad=0.1176 pd=1.4 as=0.2583 ps=2.37 w=0.42 l=0.15
X5859 sky130_fd_sc_hd__dfrtp_1_44/a_1462_47# V3R299 VGND VGND sky130_fd_pr__nfet_01v8 ad=0 pd=0 as=0 ps=0 w=0.42 l=0.15
X5860 sky130_fd_sc_hd__dfrtp_1_44/a_543_47# sky130_fd_sc_hd__dfrtp_1_44/a_27_47# sky130_fd_sc_hd__dfrtp_1_44/a_448_47# VGND sky130_fd_pr__special_nfet_01v8 ad=0.1188 pd=1.38 as=0.132 ps=1.49 w=0.36 l=0.15
X5861 sky130_fd_sc_hd__dfrtp_1_44/a_543_47# sky130_fd_sc_hd__dfrtp_1_44/a_193_47# sky130_fd_sc_hd__dfrtp_1_44/a_448_47# VDPWR sky130_fd_pr__pfet_01v8_hvt ad=0 pd=0 as=0 ps=0 w=0.42 l=0.15
X5862 sky130_fd_sc_hd__dfrtp_1_44/a_448_47# V3R104 VGND VGND sky130_fd_pr__nfet_01v8 ad=0 pd=0 as=0 ps=0 w=0.42 l=0.15
X5863 VDPWR sky130_fd_sc_hd__dfrtp_1_44/a_1283_21# sky130_fd_sc_hd__dfrtp_1_44/a_1270_413# VDPWR sky130_fd_pr__pfet_01v8_hvt ad=0 pd=0 as=0.1134 ps=1.38 w=0.42 l=0.15
X5864 VDPWR sky130_fd_sc_hd__dfrtp_1_44/a_1108_47# sky130_fd_sc_hd__dfrtp_1_44/a_1283_21# VDPWR sky130_fd_pr__pfet_01v8_hvt ad=0 pd=0 as=0.1134 ps=1.38 w=0.42 l=0.15
X5865 sky130_fd_sc_hd__dfrtp_1_44/a_1270_413# sky130_fd_sc_hd__dfrtp_1_44/a_193_47# sky130_fd_sc_hd__dfrtp_1_44/a_1108_47# VDPWR sky130_fd_pr__pfet_01v8_hvt ad=0 pd=0 as=0 ps=0 w=0.42 l=0.15
X5866 sky130_fd_sc_hd__dfrtp_1_44/a_193_47# sky130_fd_sc_hd__dfrtp_1_44/a_27_47# VDPWR VDPWR sky130_fd_pr__pfet_01v8_hvt ad=0.1664 pd=1.8 as=0 ps=0 w=0.64 l=0.15
X5867 sky130_fd_sc_hd__dfrtp_1_44/a_1283_21# V3R299 VDPWR VDPWR sky130_fd_pr__pfet_01v8_hvt ad=0 pd=0 as=0 ps=0 w=0.42 l=0.15
X5868 VDPWR sky130_fd_sc_hd__dfrtp_1_44/a_761_289# sky130_fd_sc_hd__dfrtp_1_44/a_651_413# VDPWR sky130_fd_pr__pfet_01v8_hvt ad=0 pd=0 as=0 ps=0 w=0.42 l=0.15
X5869 V3R159 sky130_fd_sc_hd__dfrtp_1_44/a_1283_21# VGND VGND sky130_fd_pr__nfet_01v8 ad=0.169 pd=1.82 as=0 ps=0 w=0.65 l=0.15
X5870 sky130_fd_sc_hd__dfrtp_1_44/a_639_47# sky130_fd_sc_hd__dfrtp_1_44/a_193_47# sky130_fd_sc_hd__dfrtp_1_44/a_543_47# VGND sky130_fd_pr__special_nfet_01v8 ad=0 pd=0 as=0 ps=0 w=0.36 l=0.15
X5871 VGND sky130_fd_sc_hd__dfrtp_1_44/a_1283_21# sky130_fd_sc_hd__dfrtp_1_44/a_1217_47# VGND sky130_fd_pr__nfet_01v8 ad=0 pd=0 as=0 ps=0 w=0.42 l=0.15
X5872 sky130_fd_sc_hd__dfrtp_1_44/a_651_413# V3R299 VDPWR VDPWR sky130_fd_pr__pfet_01v8_hvt ad=0 pd=0 as=0 ps=0 w=0.42 l=0.15
X5873 VGND V3R056 sky130_fd_sc_hd__dfrtp_1_44/a_27_47# VGND sky130_fd_pr__nfet_01v8 ad=0 pd=0 as=0.1092 ps=1.36 w=0.42 l=0.15
X5874 sky130_fd_sc_hd__dfrtp_1_44/a_761_289# sky130_fd_sc_hd__dfrtp_1_44/a_543_47# VDPWR VDPWR sky130_fd_pr__pfet_01v8_hvt ad=0 pd=0 as=0 ps=0 w=0.84 l=0.15
X5875 sky130_fd_sc_hd__dfrtp_1_33/a_805_47# sky130_fd_sc_hd__dfrtp_1_33/a_761_289# sky130_fd_sc_hd__dfrtp_1_33/a_639_47# VGND sky130_fd_pr__nfet_01v8 ad=0.0882 pd=1.26 as=0.2802 ps=2.2 w=0.42 l=0.15
X5876 sky130_fd_sc_hd__dfrtp_1_33/a_1217_47# sky130_fd_sc_hd__dfrtp_1_33/a_27_47# sky130_fd_sc_hd__dfrtp_1_33/a_1108_47# VGND sky130_fd_pr__special_nfet_01v8 ad=0.1338 pd=1.5 as=0.1422 ps=1.51 w=0.36 l=0.15
X5877 sky130_fd_sc_hd__dfrtp_1_33/a_1283_21# sky130_fd_sc_hd__dfrtp_1_33/a_1108_47# sky130_fd_sc_hd__dfrtp_1_33/a_1462_47# VGND sky130_fd_pr__nfet_01v8 ad=0.1092 pd=1.36 as=0.1281 ps=1.45 w=0.42 l=0.15
X5878 sky130_fd_sc_hd__dfrtp_1_33/a_651_413# sky130_fd_sc_hd__dfrtp_1_33/a_27_47# sky130_fd_sc_hd__dfrtp_1_33/a_543_47# VDPWR sky130_fd_pr__pfet_01v8_hvt ad=0.3402 pd=3.3 as=0.1449 ps=1.53 w=0.42 l=0.15
X5879 sky130_fd_sc_hd__dfrtp_1_33/a_1108_47# sky130_fd_sc_hd__dfrtp_1_33/a_193_47# sky130_fd_sc_hd__dfrtp_1_33/a_761_289# VGND sky130_fd_pr__special_nfet_01v8 ad=0 pd=0 as=0.1998 ps=1.97 w=0.36 l=0.15
X5880 VGND V3R301 sky130_fd_sc_hd__dfrtp_1_33/a_805_47# VGND sky130_fd_pr__nfet_01v8 ad=0 pd=0 as=0 ps=0 w=0.42 l=0.15
X5881 V3R025 sky130_fd_sc_hd__dfrtp_1_33/a_1283_21# VDPWR VDPWR sky130_fd_pr__pfet_01v8_hvt ad=0.26 pd=2.52 as=0 ps=0 w=1 l=0.15
X5882 VDPWR V3R082 sky130_fd_sc_hd__dfrtp_1_33/a_27_47# VDPWR sky130_fd_pr__pfet_01v8_hvt ad=0 pd=0 as=0.1664 ps=1.8 w=0.64 l=0.15
X5883 sky130_fd_sc_hd__dfrtp_1_33/a_448_47# V3R140 VDPWR VDPWR sky130_fd_pr__pfet_01v8_hvt ad=0.1302 pd=1.46 as=0 ps=0 w=0.42 l=0.15
X5884 sky130_fd_sc_hd__dfrtp_1_33/a_761_289# sky130_fd_sc_hd__dfrtp_1_33/a_543_47# VGND VGND sky130_fd_pr__nfet_01v8 ad=0 pd=0 as=0 ps=0 w=0.64 l=0.15
X5885 sky130_fd_sc_hd__dfrtp_1_33/a_193_47# sky130_fd_sc_hd__dfrtp_1_33/a_27_47# VGND VGND sky130_fd_pr__nfet_01v8 ad=0.1092 pd=1.36 as=0 ps=0 w=0.42 l=0.15
X5886 sky130_fd_sc_hd__dfrtp_1_33/a_1108_47# sky130_fd_sc_hd__dfrtp_1_33/a_27_47# sky130_fd_sc_hd__dfrtp_1_33/a_761_289# VDPWR sky130_fd_pr__pfet_01v8_hvt ad=0.1176 pd=1.4 as=0.2583 ps=2.37 w=0.42 l=0.15
X5887 sky130_fd_sc_hd__dfrtp_1_33/a_1462_47# V3R301 VGND VGND sky130_fd_pr__nfet_01v8 ad=0 pd=0 as=0 ps=0 w=0.42 l=0.15
X5888 sky130_fd_sc_hd__dfrtp_1_33/a_543_47# sky130_fd_sc_hd__dfrtp_1_33/a_27_47# sky130_fd_sc_hd__dfrtp_1_33/a_448_47# VGND sky130_fd_pr__special_nfet_01v8 ad=0.1188 pd=1.38 as=0.132 ps=1.49 w=0.36 l=0.15
X5889 sky130_fd_sc_hd__dfrtp_1_33/a_543_47# sky130_fd_sc_hd__dfrtp_1_33/a_193_47# sky130_fd_sc_hd__dfrtp_1_33/a_448_47# VDPWR sky130_fd_pr__pfet_01v8_hvt ad=0 pd=0 as=0 ps=0 w=0.42 l=0.15
X5890 sky130_fd_sc_hd__dfrtp_1_33/a_448_47# V3R140 VGND VGND sky130_fd_pr__nfet_01v8 ad=0 pd=0 as=0 ps=0 w=0.42 l=0.15
X5891 VDPWR sky130_fd_sc_hd__dfrtp_1_33/a_1283_21# sky130_fd_sc_hd__dfrtp_1_33/a_1270_413# VDPWR sky130_fd_pr__pfet_01v8_hvt ad=0 pd=0 as=0.1134 ps=1.38 w=0.42 l=0.15
X5892 VDPWR sky130_fd_sc_hd__dfrtp_1_33/a_1108_47# sky130_fd_sc_hd__dfrtp_1_33/a_1283_21# VDPWR sky130_fd_pr__pfet_01v8_hvt ad=0 pd=0 as=0.1134 ps=1.38 w=0.42 l=0.15
X5893 sky130_fd_sc_hd__dfrtp_1_33/a_1270_413# sky130_fd_sc_hd__dfrtp_1_33/a_193_47# sky130_fd_sc_hd__dfrtp_1_33/a_1108_47# VDPWR sky130_fd_pr__pfet_01v8_hvt ad=0 pd=0 as=0 ps=0 w=0.42 l=0.15
X5894 sky130_fd_sc_hd__dfrtp_1_33/a_193_47# sky130_fd_sc_hd__dfrtp_1_33/a_27_47# VDPWR VDPWR sky130_fd_pr__pfet_01v8_hvt ad=0.1664 pd=1.8 as=0 ps=0 w=0.64 l=0.15
X5895 sky130_fd_sc_hd__dfrtp_1_33/a_1283_21# V3R301 VDPWR VDPWR sky130_fd_pr__pfet_01v8_hvt ad=0 pd=0 as=0 ps=0 w=0.42 l=0.15
X5896 VDPWR sky130_fd_sc_hd__dfrtp_1_33/a_761_289# sky130_fd_sc_hd__dfrtp_1_33/a_651_413# VDPWR sky130_fd_pr__pfet_01v8_hvt ad=0 pd=0 as=0 ps=0 w=0.42 l=0.15
X5897 V3R025 sky130_fd_sc_hd__dfrtp_1_33/a_1283_21# VGND VGND sky130_fd_pr__nfet_01v8 ad=0.169 pd=1.82 as=0 ps=0 w=0.65 l=0.15
X5898 sky130_fd_sc_hd__dfrtp_1_33/a_639_47# sky130_fd_sc_hd__dfrtp_1_33/a_193_47# sky130_fd_sc_hd__dfrtp_1_33/a_543_47# VGND sky130_fd_pr__special_nfet_01v8 ad=0 pd=0 as=0 ps=0 w=0.36 l=0.15
X5899 VGND sky130_fd_sc_hd__dfrtp_1_33/a_1283_21# sky130_fd_sc_hd__dfrtp_1_33/a_1217_47# VGND sky130_fd_pr__nfet_01v8 ad=0 pd=0 as=0 ps=0 w=0.42 l=0.15
X5900 sky130_fd_sc_hd__dfrtp_1_33/a_651_413# V3R301 VDPWR VDPWR sky130_fd_pr__pfet_01v8_hvt ad=0 pd=0 as=0 ps=0 w=0.42 l=0.15
X5901 VGND V3R082 sky130_fd_sc_hd__dfrtp_1_33/a_27_47# VGND sky130_fd_pr__nfet_01v8 ad=0 pd=0 as=0.1092 ps=1.36 w=0.42 l=0.15
X5902 sky130_fd_sc_hd__dfrtp_1_33/a_761_289# sky130_fd_sc_hd__dfrtp_1_33/a_543_47# VDPWR VDPWR sky130_fd_pr__pfet_01v8_hvt ad=0 pd=0 as=0 ps=0 w=0.84 l=0.15
X5903 sky130_fd_sc_hd__dfrtp_1_22/a_805_47# sky130_fd_sc_hd__dfrtp_1_22/a_761_289# sky130_fd_sc_hd__dfrtp_1_22/a_639_47# VGND sky130_fd_pr__nfet_01v8 ad=0.0882 pd=1.26 as=0.2802 ps=2.2 w=0.42 l=0.15
X5904 sky130_fd_sc_hd__dfrtp_1_22/a_1217_47# sky130_fd_sc_hd__dfrtp_1_22/a_27_47# sky130_fd_sc_hd__dfrtp_1_22/a_1108_47# VGND sky130_fd_pr__special_nfet_01v8 ad=0.1338 pd=1.5 as=0.1422 ps=1.51 w=0.36 l=0.15
X5905 sky130_fd_sc_hd__dfrtp_1_22/a_1283_21# sky130_fd_sc_hd__dfrtp_1_22/a_1108_47# sky130_fd_sc_hd__dfrtp_1_22/a_1462_47# VGND sky130_fd_pr__nfet_01v8 ad=0.1092 pd=1.36 as=0.1281 ps=1.45 w=0.42 l=0.15
X5906 sky130_fd_sc_hd__dfrtp_1_22/a_651_413# sky130_fd_sc_hd__dfrtp_1_22/a_27_47# sky130_fd_sc_hd__dfrtp_1_22/a_543_47# VDPWR sky130_fd_pr__pfet_01v8_hvt ad=0.3402 pd=3.3 as=0.1449 ps=1.53 w=0.42 l=0.15
X5907 sky130_fd_sc_hd__dfrtp_1_22/a_1108_47# sky130_fd_sc_hd__dfrtp_1_22/a_193_47# sky130_fd_sc_hd__dfrtp_1_22/a_761_289# VGND sky130_fd_pr__special_nfet_01v8 ad=0 pd=0 as=0.1998 ps=1.97 w=0.36 l=0.15
X5908 VGND V3R303 sky130_fd_sc_hd__dfrtp_1_22/a_805_47# VGND sky130_fd_pr__nfet_01v8 ad=0 pd=0 as=0 ps=0 w=0.42 l=0.15
X5909 V3R052 sky130_fd_sc_hd__dfrtp_1_22/a_1283_21# VDPWR VDPWR sky130_fd_pr__pfet_01v8_hvt ad=0.26 pd=2.52 as=0 ps=0 w=1 l=0.15
X5910 VDPWR V3R084 sky130_fd_sc_hd__dfrtp_1_22/a_27_47# VDPWR sky130_fd_pr__pfet_01v8_hvt ad=0 pd=0 as=0.1664 ps=1.8 w=0.64 l=0.15
X5911 sky130_fd_sc_hd__dfrtp_1_22/a_448_47# V3R197 VDPWR VDPWR sky130_fd_pr__pfet_01v8_hvt ad=0.1302 pd=1.46 as=0 ps=0 w=0.42 l=0.15
X5912 sky130_fd_sc_hd__dfrtp_1_22/a_761_289# sky130_fd_sc_hd__dfrtp_1_22/a_543_47# VGND VGND sky130_fd_pr__nfet_01v8 ad=0 pd=0 as=0 ps=0 w=0.64 l=0.15
X5913 sky130_fd_sc_hd__dfrtp_1_22/a_193_47# sky130_fd_sc_hd__dfrtp_1_22/a_27_47# VGND VGND sky130_fd_pr__nfet_01v8 ad=0.1092 pd=1.36 as=0 ps=0 w=0.42 l=0.15
X5914 sky130_fd_sc_hd__dfrtp_1_22/a_1108_47# sky130_fd_sc_hd__dfrtp_1_22/a_27_47# sky130_fd_sc_hd__dfrtp_1_22/a_761_289# VDPWR sky130_fd_pr__pfet_01v8_hvt ad=0.1176 pd=1.4 as=0.2583 ps=2.37 w=0.42 l=0.15
X5915 sky130_fd_sc_hd__dfrtp_1_22/a_1462_47# V3R303 VGND VGND sky130_fd_pr__nfet_01v8 ad=0 pd=0 as=0 ps=0 w=0.42 l=0.15
X5916 sky130_fd_sc_hd__dfrtp_1_22/a_543_47# sky130_fd_sc_hd__dfrtp_1_22/a_27_47# sky130_fd_sc_hd__dfrtp_1_22/a_448_47# VGND sky130_fd_pr__special_nfet_01v8 ad=0.1188 pd=1.38 as=0.132 ps=1.49 w=0.36 l=0.15
X5917 sky130_fd_sc_hd__dfrtp_1_22/a_543_47# sky130_fd_sc_hd__dfrtp_1_22/a_193_47# sky130_fd_sc_hd__dfrtp_1_22/a_448_47# VDPWR sky130_fd_pr__pfet_01v8_hvt ad=0 pd=0 as=0 ps=0 w=0.42 l=0.15
X5918 sky130_fd_sc_hd__dfrtp_1_22/a_448_47# V3R197 VGND VGND sky130_fd_pr__nfet_01v8 ad=0 pd=0 as=0 ps=0 w=0.42 l=0.15
X5919 VDPWR sky130_fd_sc_hd__dfrtp_1_22/a_1283_21# sky130_fd_sc_hd__dfrtp_1_22/a_1270_413# VDPWR sky130_fd_pr__pfet_01v8_hvt ad=0 pd=0 as=0.1134 ps=1.38 w=0.42 l=0.15
X5920 VDPWR sky130_fd_sc_hd__dfrtp_1_22/a_1108_47# sky130_fd_sc_hd__dfrtp_1_22/a_1283_21# VDPWR sky130_fd_pr__pfet_01v8_hvt ad=0 pd=0 as=0.1134 ps=1.38 w=0.42 l=0.15
X5921 sky130_fd_sc_hd__dfrtp_1_22/a_1270_413# sky130_fd_sc_hd__dfrtp_1_22/a_193_47# sky130_fd_sc_hd__dfrtp_1_22/a_1108_47# VDPWR sky130_fd_pr__pfet_01v8_hvt ad=0 pd=0 as=0 ps=0 w=0.42 l=0.15
X5922 sky130_fd_sc_hd__dfrtp_1_22/a_193_47# sky130_fd_sc_hd__dfrtp_1_22/a_27_47# VDPWR VDPWR sky130_fd_pr__pfet_01v8_hvt ad=0.1664 pd=1.8 as=0 ps=0 w=0.64 l=0.15
X5923 sky130_fd_sc_hd__dfrtp_1_22/a_1283_21# V3R303 VDPWR VDPWR sky130_fd_pr__pfet_01v8_hvt ad=0 pd=0 as=0 ps=0 w=0.42 l=0.15
X5924 VDPWR sky130_fd_sc_hd__dfrtp_1_22/a_761_289# sky130_fd_sc_hd__dfrtp_1_22/a_651_413# VDPWR sky130_fd_pr__pfet_01v8_hvt ad=0 pd=0 as=0 ps=0 w=0.42 l=0.15
X5925 V3R052 sky130_fd_sc_hd__dfrtp_1_22/a_1283_21# VGND VGND sky130_fd_pr__nfet_01v8 ad=0.169 pd=1.82 as=0 ps=0 w=0.65 l=0.15
X5926 sky130_fd_sc_hd__dfrtp_1_22/a_639_47# sky130_fd_sc_hd__dfrtp_1_22/a_193_47# sky130_fd_sc_hd__dfrtp_1_22/a_543_47# VGND sky130_fd_pr__special_nfet_01v8 ad=0 pd=0 as=0 ps=0 w=0.36 l=0.15
X5927 VGND sky130_fd_sc_hd__dfrtp_1_22/a_1283_21# sky130_fd_sc_hd__dfrtp_1_22/a_1217_47# VGND sky130_fd_pr__nfet_01v8 ad=0 pd=0 as=0 ps=0 w=0.42 l=0.15
X5928 sky130_fd_sc_hd__dfrtp_1_22/a_651_413# V3R303 VDPWR VDPWR sky130_fd_pr__pfet_01v8_hvt ad=0 pd=0 as=0 ps=0 w=0.42 l=0.15
X5929 VGND V3R084 sky130_fd_sc_hd__dfrtp_1_22/a_27_47# VGND sky130_fd_pr__nfet_01v8 ad=0 pd=0 as=0.1092 ps=1.36 w=0.42 l=0.15
X5930 sky130_fd_sc_hd__dfrtp_1_22/a_761_289# sky130_fd_sc_hd__dfrtp_1_22/a_543_47# VDPWR VDPWR sky130_fd_pr__pfet_01v8_hvt ad=0 pd=0 as=0 ps=0 w=0.84 l=0.15
X5931 sky130_fd_sc_hd__dfrtp_1_77/a_805_47# sky130_fd_sc_hd__dfrtp_1_77/a_761_289# sky130_fd_sc_hd__dfrtp_1_77/a_639_47# VGND sky130_fd_pr__nfet_01v8 ad=0.0882 pd=1.26 as=0.2802 ps=2.2 w=0.42 l=0.15
X5932 sky130_fd_sc_hd__dfrtp_1_77/a_1217_47# sky130_fd_sc_hd__dfrtp_1_77/a_27_47# sky130_fd_sc_hd__dfrtp_1_77/a_1108_47# VGND sky130_fd_pr__special_nfet_01v8 ad=0.1338 pd=1.5 as=0.1422 ps=1.51 w=0.36 l=0.15
X5933 sky130_fd_sc_hd__dfrtp_1_77/a_1283_21# sky130_fd_sc_hd__dfrtp_1_77/a_1108_47# sky130_fd_sc_hd__dfrtp_1_77/a_1462_47# VGND sky130_fd_pr__nfet_01v8 ad=0.1092 pd=1.36 as=0.1281 ps=1.45 w=0.42 l=0.15
X5934 sky130_fd_sc_hd__dfrtp_1_77/a_651_413# sky130_fd_sc_hd__dfrtp_1_77/a_27_47# sky130_fd_sc_hd__dfrtp_1_77/a_543_47# VDPWR sky130_fd_pr__pfet_01v8_hvt ad=0.3402 pd=3.3 as=0.1449 ps=1.53 w=0.42 l=0.15
X5935 sky130_fd_sc_hd__dfrtp_1_77/a_1108_47# sky130_fd_sc_hd__dfrtp_1_77/a_193_47# sky130_fd_sc_hd__dfrtp_1_77/a_761_289# VGND sky130_fd_pr__special_nfet_01v8 ad=0 pd=0 as=0.1998 ps=1.97 w=0.36 l=0.15
X5936 VGND V3R302 sky130_fd_sc_hd__dfrtp_1_77/a_805_47# VGND sky130_fd_pr__nfet_01v8 ad=0 pd=0 as=0 ps=0 w=0.42 l=0.15
X5937 V3R003 sky130_fd_sc_hd__dfrtp_1_77/a_1283_21# VDPWR VDPWR sky130_fd_pr__pfet_01v8_hvt ad=0.26 pd=2.52 as=0 ps=0 w=1 l=0.15
X5938 VDPWR V3R083 sky130_fd_sc_hd__dfrtp_1_77/a_27_47# VDPWR sky130_fd_pr__pfet_01v8_hvt ad=0 pd=0 as=0.1664 ps=1.8 w=0.64 l=0.15
X5939 sky130_fd_sc_hd__dfrtp_1_77/a_448_47# V3R187 VDPWR VDPWR sky130_fd_pr__pfet_01v8_hvt ad=0.1302 pd=1.46 as=0 ps=0 w=0.42 l=0.15
X5940 sky130_fd_sc_hd__dfrtp_1_77/a_761_289# sky130_fd_sc_hd__dfrtp_1_77/a_543_47# VGND VGND sky130_fd_pr__nfet_01v8 ad=0 pd=0 as=0 ps=0 w=0.64 l=0.15
X5941 sky130_fd_sc_hd__dfrtp_1_77/a_193_47# sky130_fd_sc_hd__dfrtp_1_77/a_27_47# VGND VGND sky130_fd_pr__nfet_01v8 ad=0.1092 pd=1.36 as=0 ps=0 w=0.42 l=0.15
X5942 sky130_fd_sc_hd__dfrtp_1_77/a_1108_47# sky130_fd_sc_hd__dfrtp_1_77/a_27_47# sky130_fd_sc_hd__dfrtp_1_77/a_761_289# VDPWR sky130_fd_pr__pfet_01v8_hvt ad=0.1176 pd=1.4 as=0.2583 ps=2.37 w=0.42 l=0.15
X5943 sky130_fd_sc_hd__dfrtp_1_77/a_1462_47# V3R302 VGND VGND sky130_fd_pr__nfet_01v8 ad=0 pd=0 as=0 ps=0 w=0.42 l=0.15
X5944 sky130_fd_sc_hd__dfrtp_1_77/a_543_47# sky130_fd_sc_hd__dfrtp_1_77/a_27_47# sky130_fd_sc_hd__dfrtp_1_77/a_448_47# VGND sky130_fd_pr__special_nfet_01v8 ad=0.1188 pd=1.38 as=0.132 ps=1.49 w=0.36 l=0.15
X5945 sky130_fd_sc_hd__dfrtp_1_77/a_543_47# sky130_fd_sc_hd__dfrtp_1_77/a_193_47# sky130_fd_sc_hd__dfrtp_1_77/a_448_47# VDPWR sky130_fd_pr__pfet_01v8_hvt ad=0 pd=0 as=0 ps=0 w=0.42 l=0.15
X5946 sky130_fd_sc_hd__dfrtp_1_77/a_448_47# V3R187 VGND VGND sky130_fd_pr__nfet_01v8 ad=0 pd=0 as=0 ps=0 w=0.42 l=0.15
X5947 VDPWR sky130_fd_sc_hd__dfrtp_1_77/a_1283_21# sky130_fd_sc_hd__dfrtp_1_77/a_1270_413# VDPWR sky130_fd_pr__pfet_01v8_hvt ad=0 pd=0 as=0.1134 ps=1.38 w=0.42 l=0.15
X5948 VDPWR sky130_fd_sc_hd__dfrtp_1_77/a_1108_47# sky130_fd_sc_hd__dfrtp_1_77/a_1283_21# VDPWR sky130_fd_pr__pfet_01v8_hvt ad=0 pd=0 as=0.1134 ps=1.38 w=0.42 l=0.15
X5949 sky130_fd_sc_hd__dfrtp_1_77/a_1270_413# sky130_fd_sc_hd__dfrtp_1_77/a_193_47# sky130_fd_sc_hd__dfrtp_1_77/a_1108_47# VDPWR sky130_fd_pr__pfet_01v8_hvt ad=0 pd=0 as=0 ps=0 w=0.42 l=0.15
X5950 sky130_fd_sc_hd__dfrtp_1_77/a_193_47# sky130_fd_sc_hd__dfrtp_1_77/a_27_47# VDPWR VDPWR sky130_fd_pr__pfet_01v8_hvt ad=0.1664 pd=1.8 as=0 ps=0 w=0.64 l=0.15
X5951 sky130_fd_sc_hd__dfrtp_1_77/a_1283_21# V3R302 VDPWR VDPWR sky130_fd_pr__pfet_01v8_hvt ad=0 pd=0 as=0 ps=0 w=0.42 l=0.15
X5952 VDPWR sky130_fd_sc_hd__dfrtp_1_77/a_761_289# sky130_fd_sc_hd__dfrtp_1_77/a_651_413# VDPWR sky130_fd_pr__pfet_01v8_hvt ad=0 pd=0 as=0 ps=0 w=0.42 l=0.15
X5953 V3R003 sky130_fd_sc_hd__dfrtp_1_77/a_1283_21# VGND VGND sky130_fd_pr__nfet_01v8 ad=0.169 pd=1.82 as=0 ps=0 w=0.65 l=0.15
X5954 sky130_fd_sc_hd__dfrtp_1_77/a_639_47# sky130_fd_sc_hd__dfrtp_1_77/a_193_47# sky130_fd_sc_hd__dfrtp_1_77/a_543_47# VGND sky130_fd_pr__special_nfet_01v8 ad=0 pd=0 as=0 ps=0 w=0.36 l=0.15
X5955 VGND sky130_fd_sc_hd__dfrtp_1_77/a_1283_21# sky130_fd_sc_hd__dfrtp_1_77/a_1217_47# VGND sky130_fd_pr__nfet_01v8 ad=0 pd=0 as=0 ps=0 w=0.42 l=0.15
X5956 sky130_fd_sc_hd__dfrtp_1_77/a_651_413# V3R302 VDPWR VDPWR sky130_fd_pr__pfet_01v8_hvt ad=0 pd=0 as=0 ps=0 w=0.42 l=0.15
X5957 VGND V3R083 sky130_fd_sc_hd__dfrtp_1_77/a_27_47# VGND sky130_fd_pr__nfet_01v8 ad=0 pd=0 as=0.1092 ps=1.36 w=0.42 l=0.15
X5958 sky130_fd_sc_hd__dfrtp_1_77/a_761_289# sky130_fd_sc_hd__dfrtp_1_77/a_543_47# VDPWR VDPWR sky130_fd_pr__pfet_01v8_hvt ad=0 pd=0 as=0 ps=0 w=0.84 l=0.15
X5959 sky130_fd_sc_hd__dfrtp_1_88/a_805_47# sky130_fd_sc_hd__dfrtp_1_88/a_761_289# sky130_fd_sc_hd__dfrtp_1_88/a_639_47# VGND sky130_fd_pr__nfet_01v8 ad=0.0882 pd=1.26 as=0.2802 ps=2.2 w=0.42 l=0.15
X5960 sky130_fd_sc_hd__dfrtp_1_88/a_1217_47# sky130_fd_sc_hd__dfrtp_1_88/a_27_47# sky130_fd_sc_hd__dfrtp_1_88/a_1108_47# VGND sky130_fd_pr__special_nfet_01v8 ad=0.1338 pd=1.5 as=0.1422 ps=1.51 w=0.36 l=0.15
X5961 sky130_fd_sc_hd__dfrtp_1_88/a_1283_21# sky130_fd_sc_hd__dfrtp_1_88/a_1108_47# sky130_fd_sc_hd__dfrtp_1_88/a_1462_47# VGND sky130_fd_pr__nfet_01v8 ad=0.1092 pd=1.36 as=0.1281 ps=1.45 w=0.42 l=0.15
X5962 sky130_fd_sc_hd__dfrtp_1_88/a_651_413# sky130_fd_sc_hd__dfrtp_1_88/a_27_47# sky130_fd_sc_hd__dfrtp_1_88/a_543_47# VDPWR sky130_fd_pr__pfet_01v8_hvt ad=0.3402 pd=3.3 as=0.1449 ps=1.53 w=0.42 l=0.15
X5963 sky130_fd_sc_hd__dfrtp_1_88/a_1108_47# sky130_fd_sc_hd__dfrtp_1_88/a_193_47# sky130_fd_sc_hd__dfrtp_1_88/a_761_289# VGND sky130_fd_pr__special_nfet_01v8 ad=0 pd=0 as=0.1998 ps=1.97 w=0.36 l=0.15
X5964 VGND V3R300 sky130_fd_sc_hd__dfrtp_1_88/a_805_47# VGND sky130_fd_pr__nfet_01v8 ad=0 pd=0 as=0 ps=0 w=0.42 l=0.15
X5965 V3R022 sky130_fd_sc_hd__dfrtp_1_88/a_1283_21# VDPWR VDPWR sky130_fd_pr__pfet_01v8_hvt ad=0.26 pd=2.52 as=0 ps=0 w=1 l=0.15
X5966 VDPWR V3R081 sky130_fd_sc_hd__dfrtp_1_88/a_27_47# VDPWR sky130_fd_pr__pfet_01v8_hvt ad=0 pd=0 as=0.1664 ps=1.8 w=0.64 l=0.15
X5967 sky130_fd_sc_hd__dfrtp_1_88/a_448_47# V3R119 VDPWR VDPWR sky130_fd_pr__pfet_01v8_hvt ad=0.1302 pd=1.46 as=0 ps=0 w=0.42 l=0.15
X5968 sky130_fd_sc_hd__dfrtp_1_88/a_761_289# sky130_fd_sc_hd__dfrtp_1_88/a_543_47# VGND VGND sky130_fd_pr__nfet_01v8 ad=0 pd=0 as=0 ps=0 w=0.64 l=0.15
X5969 sky130_fd_sc_hd__dfrtp_1_88/a_193_47# sky130_fd_sc_hd__dfrtp_1_88/a_27_47# VGND VGND sky130_fd_pr__nfet_01v8 ad=0.1092 pd=1.36 as=0 ps=0 w=0.42 l=0.15
X5970 sky130_fd_sc_hd__dfrtp_1_88/a_1108_47# sky130_fd_sc_hd__dfrtp_1_88/a_27_47# sky130_fd_sc_hd__dfrtp_1_88/a_761_289# VDPWR sky130_fd_pr__pfet_01v8_hvt ad=0.1176 pd=1.4 as=0.2583 ps=2.37 w=0.42 l=0.15
X5971 sky130_fd_sc_hd__dfrtp_1_88/a_1462_47# V3R300 VGND VGND sky130_fd_pr__nfet_01v8 ad=0 pd=0 as=0 ps=0 w=0.42 l=0.15
X5972 sky130_fd_sc_hd__dfrtp_1_88/a_543_47# sky130_fd_sc_hd__dfrtp_1_88/a_27_47# sky130_fd_sc_hd__dfrtp_1_88/a_448_47# VGND sky130_fd_pr__special_nfet_01v8 ad=0.1188 pd=1.38 as=0.132 ps=1.49 w=0.36 l=0.15
X5973 sky130_fd_sc_hd__dfrtp_1_88/a_543_47# sky130_fd_sc_hd__dfrtp_1_88/a_193_47# sky130_fd_sc_hd__dfrtp_1_88/a_448_47# VDPWR sky130_fd_pr__pfet_01v8_hvt ad=0 pd=0 as=0 ps=0 w=0.42 l=0.15
X5974 sky130_fd_sc_hd__dfrtp_1_88/a_448_47# V3R119 VGND VGND sky130_fd_pr__nfet_01v8 ad=0 pd=0 as=0 ps=0 w=0.42 l=0.15
X5975 VDPWR sky130_fd_sc_hd__dfrtp_1_88/a_1283_21# sky130_fd_sc_hd__dfrtp_1_88/a_1270_413# VDPWR sky130_fd_pr__pfet_01v8_hvt ad=0 pd=0 as=0.1134 ps=1.38 w=0.42 l=0.15
X5976 VDPWR sky130_fd_sc_hd__dfrtp_1_88/a_1108_47# sky130_fd_sc_hd__dfrtp_1_88/a_1283_21# VDPWR sky130_fd_pr__pfet_01v8_hvt ad=0 pd=0 as=0.1134 ps=1.38 w=0.42 l=0.15
X5977 sky130_fd_sc_hd__dfrtp_1_88/a_1270_413# sky130_fd_sc_hd__dfrtp_1_88/a_193_47# sky130_fd_sc_hd__dfrtp_1_88/a_1108_47# VDPWR sky130_fd_pr__pfet_01v8_hvt ad=0 pd=0 as=0 ps=0 w=0.42 l=0.15
X5978 sky130_fd_sc_hd__dfrtp_1_88/a_193_47# sky130_fd_sc_hd__dfrtp_1_88/a_27_47# VDPWR VDPWR sky130_fd_pr__pfet_01v8_hvt ad=0.1664 pd=1.8 as=0 ps=0 w=0.64 l=0.15
X5979 sky130_fd_sc_hd__dfrtp_1_88/a_1283_21# V3R300 VDPWR VDPWR sky130_fd_pr__pfet_01v8_hvt ad=0 pd=0 as=0 ps=0 w=0.42 l=0.15
X5980 VDPWR sky130_fd_sc_hd__dfrtp_1_88/a_761_289# sky130_fd_sc_hd__dfrtp_1_88/a_651_413# VDPWR sky130_fd_pr__pfet_01v8_hvt ad=0 pd=0 as=0 ps=0 w=0.42 l=0.15
X5981 V3R022 sky130_fd_sc_hd__dfrtp_1_88/a_1283_21# VGND VGND sky130_fd_pr__nfet_01v8 ad=0.169 pd=1.82 as=0 ps=0 w=0.65 l=0.15
X5982 sky130_fd_sc_hd__dfrtp_1_88/a_639_47# sky130_fd_sc_hd__dfrtp_1_88/a_193_47# sky130_fd_sc_hd__dfrtp_1_88/a_543_47# VGND sky130_fd_pr__special_nfet_01v8 ad=0 pd=0 as=0 ps=0 w=0.36 l=0.15
X5983 VGND sky130_fd_sc_hd__dfrtp_1_88/a_1283_21# sky130_fd_sc_hd__dfrtp_1_88/a_1217_47# VGND sky130_fd_pr__nfet_01v8 ad=0 pd=0 as=0 ps=0 w=0.42 l=0.15
X5984 sky130_fd_sc_hd__dfrtp_1_88/a_651_413# V3R300 VDPWR VDPWR sky130_fd_pr__pfet_01v8_hvt ad=0 pd=0 as=0 ps=0 w=0.42 l=0.15
X5985 VGND V3R081 sky130_fd_sc_hd__dfrtp_1_88/a_27_47# VGND sky130_fd_pr__nfet_01v8 ad=0 pd=0 as=0.1092 ps=1.36 w=0.42 l=0.15
X5986 sky130_fd_sc_hd__dfrtp_1_88/a_761_289# sky130_fd_sc_hd__dfrtp_1_88/a_543_47# VDPWR VDPWR sky130_fd_pr__pfet_01v8_hvt ad=0 pd=0 as=0 ps=0 w=0.84 l=0.15
X5987 sky130_fd_sc_hd__dfrtp_1_66/a_805_47# sky130_fd_sc_hd__dfrtp_1_66/a_761_289# sky130_fd_sc_hd__dfrtp_1_66/a_639_47# VGND sky130_fd_pr__nfet_01v8 ad=0.0882 pd=1.26 as=0.2802 ps=2.2 w=0.42 l=0.15
X5988 sky130_fd_sc_hd__dfrtp_1_66/a_1217_47# sky130_fd_sc_hd__dfrtp_1_66/a_27_47# sky130_fd_sc_hd__dfrtp_1_66/a_1108_47# VGND sky130_fd_pr__special_nfet_01v8 ad=0.1338 pd=1.5 as=0.1422 ps=1.51 w=0.36 l=0.15
X5989 sky130_fd_sc_hd__dfrtp_1_66/a_1283_21# sky130_fd_sc_hd__dfrtp_1_66/a_1108_47# sky130_fd_sc_hd__dfrtp_1_66/a_1462_47# VGND sky130_fd_pr__nfet_01v8 ad=0.1092 pd=1.36 as=0.1281 ps=1.45 w=0.42 l=0.15
X5990 sky130_fd_sc_hd__dfrtp_1_66/a_651_413# sky130_fd_sc_hd__dfrtp_1_66/a_27_47# sky130_fd_sc_hd__dfrtp_1_66/a_543_47# VDPWR sky130_fd_pr__pfet_01v8_hvt ad=0.3402 pd=3.3 as=0.1449 ps=1.53 w=0.42 l=0.15
X5991 sky130_fd_sc_hd__dfrtp_1_66/a_1108_47# sky130_fd_sc_hd__dfrtp_1_66/a_193_47# sky130_fd_sc_hd__dfrtp_1_66/a_761_289# VGND sky130_fd_pr__special_nfet_01v8 ad=0 pd=0 as=0.1998 ps=1.97 w=0.36 l=0.15
X5992 VGND V3R300 sky130_fd_sc_hd__dfrtp_1_66/a_805_47# VGND sky130_fd_pr__nfet_01v8 ad=0 pd=0 as=0 ps=0 w=0.42 l=0.15
X5993 V3R012 sky130_fd_sc_hd__dfrtp_1_66/a_1283_21# VDPWR VDPWR sky130_fd_pr__pfet_01v8_hvt ad=0.26 pd=2.52 as=0 ps=0 w=1 l=0.15
X5994 VDPWR V3R081 sky130_fd_sc_hd__dfrtp_1_66/a_27_47# VDPWR sky130_fd_pr__pfet_01v8_hvt ad=0 pd=0 as=0.1664 ps=1.8 w=0.64 l=0.15
X5995 sky130_fd_sc_hd__dfrtp_1_66/a_448_47# V3R128 VDPWR VDPWR sky130_fd_pr__pfet_01v8_hvt ad=0.1302 pd=1.46 as=0 ps=0 w=0.42 l=0.15
X5996 sky130_fd_sc_hd__dfrtp_1_66/a_761_289# sky130_fd_sc_hd__dfrtp_1_66/a_543_47# VGND VGND sky130_fd_pr__nfet_01v8 ad=0 pd=0 as=0 ps=0 w=0.64 l=0.15
X5997 sky130_fd_sc_hd__dfrtp_1_66/a_193_47# sky130_fd_sc_hd__dfrtp_1_66/a_27_47# VGND VGND sky130_fd_pr__nfet_01v8 ad=0.1092 pd=1.36 as=0 ps=0 w=0.42 l=0.15
X5998 sky130_fd_sc_hd__dfrtp_1_66/a_1108_47# sky130_fd_sc_hd__dfrtp_1_66/a_27_47# sky130_fd_sc_hd__dfrtp_1_66/a_761_289# VDPWR sky130_fd_pr__pfet_01v8_hvt ad=0.1176 pd=1.4 as=0.2583 ps=2.37 w=0.42 l=0.15
X5999 sky130_fd_sc_hd__dfrtp_1_66/a_1462_47# V3R300 VGND VGND sky130_fd_pr__nfet_01v8 ad=0 pd=0 as=0 ps=0 w=0.42 l=0.15
X6000 sky130_fd_sc_hd__dfrtp_1_66/a_543_47# sky130_fd_sc_hd__dfrtp_1_66/a_27_47# sky130_fd_sc_hd__dfrtp_1_66/a_448_47# VGND sky130_fd_pr__special_nfet_01v8 ad=0.1188 pd=1.38 as=0.132 ps=1.49 w=0.36 l=0.15
X6001 sky130_fd_sc_hd__dfrtp_1_66/a_543_47# sky130_fd_sc_hd__dfrtp_1_66/a_193_47# sky130_fd_sc_hd__dfrtp_1_66/a_448_47# VDPWR sky130_fd_pr__pfet_01v8_hvt ad=0 pd=0 as=0 ps=0 w=0.42 l=0.15
X6002 sky130_fd_sc_hd__dfrtp_1_66/a_448_47# V3R128 VGND VGND sky130_fd_pr__nfet_01v8 ad=0 pd=0 as=0 ps=0 w=0.42 l=0.15
X6003 VDPWR sky130_fd_sc_hd__dfrtp_1_66/a_1283_21# sky130_fd_sc_hd__dfrtp_1_66/a_1270_413# VDPWR sky130_fd_pr__pfet_01v8_hvt ad=0 pd=0 as=0.1134 ps=1.38 w=0.42 l=0.15
X6004 VDPWR sky130_fd_sc_hd__dfrtp_1_66/a_1108_47# sky130_fd_sc_hd__dfrtp_1_66/a_1283_21# VDPWR sky130_fd_pr__pfet_01v8_hvt ad=0 pd=0 as=0.1134 ps=1.38 w=0.42 l=0.15
X6005 sky130_fd_sc_hd__dfrtp_1_66/a_1270_413# sky130_fd_sc_hd__dfrtp_1_66/a_193_47# sky130_fd_sc_hd__dfrtp_1_66/a_1108_47# VDPWR sky130_fd_pr__pfet_01v8_hvt ad=0 pd=0 as=0 ps=0 w=0.42 l=0.15
X6006 sky130_fd_sc_hd__dfrtp_1_66/a_193_47# sky130_fd_sc_hd__dfrtp_1_66/a_27_47# VDPWR VDPWR sky130_fd_pr__pfet_01v8_hvt ad=0.1664 pd=1.8 as=0 ps=0 w=0.64 l=0.15
X6007 sky130_fd_sc_hd__dfrtp_1_66/a_1283_21# V3R300 VDPWR VDPWR sky130_fd_pr__pfet_01v8_hvt ad=0 pd=0 as=0 ps=0 w=0.42 l=0.15
X6008 VDPWR sky130_fd_sc_hd__dfrtp_1_66/a_761_289# sky130_fd_sc_hd__dfrtp_1_66/a_651_413# VDPWR sky130_fd_pr__pfet_01v8_hvt ad=0 pd=0 as=0 ps=0 w=0.42 l=0.15
X6009 V3R012 sky130_fd_sc_hd__dfrtp_1_66/a_1283_21# VGND VGND sky130_fd_pr__nfet_01v8 ad=0.169 pd=1.82 as=0 ps=0 w=0.65 l=0.15
X6010 sky130_fd_sc_hd__dfrtp_1_66/a_639_47# sky130_fd_sc_hd__dfrtp_1_66/a_193_47# sky130_fd_sc_hd__dfrtp_1_66/a_543_47# VGND sky130_fd_pr__special_nfet_01v8 ad=0 pd=0 as=0 ps=0 w=0.36 l=0.15
X6011 VGND sky130_fd_sc_hd__dfrtp_1_66/a_1283_21# sky130_fd_sc_hd__dfrtp_1_66/a_1217_47# VGND sky130_fd_pr__nfet_01v8 ad=0 pd=0 as=0 ps=0 w=0.42 l=0.15
X6012 sky130_fd_sc_hd__dfrtp_1_66/a_651_413# V3R300 VDPWR VDPWR sky130_fd_pr__pfet_01v8_hvt ad=0 pd=0 as=0 ps=0 w=0.42 l=0.15
X6013 VGND V3R081 sky130_fd_sc_hd__dfrtp_1_66/a_27_47# VGND sky130_fd_pr__nfet_01v8 ad=0 pd=0 as=0.1092 ps=1.36 w=0.42 l=0.15
X6014 sky130_fd_sc_hd__dfrtp_1_66/a_761_289# sky130_fd_sc_hd__dfrtp_1_66/a_543_47# VDPWR VDPWR sky130_fd_pr__pfet_01v8_hvt ad=0 pd=0 as=0 ps=0 w=0.84 l=0.15
X6015 V3R271 sky130_fd_sc_hd__xor2_1_2/a_35_297# sky130_fd_sc_hd__xor2_1_2/a_285_297# VDPWR sky130_fd_pr__pfet_01v8_hvt ad=0.3 pd=2.6 as=0.53 ps=5.06 w=1 l=0.15
X6016 V3R271 V3R001 sky130_fd_sc_hd__xor2_1_2/a_285_47# VGND sky130_fd_pr__nfet_01v8 ad=0.5005 pd=2.84 as=0.1755 ps=1.84 w=0.65 l=0.15
X6017 sky130_fd_sc_hd__xor2_1_2/a_35_297# V3R001 VGND VGND sky130_fd_pr__nfet_01v8 ad=0.1755 pd=1.84 as=0 ps=0 w=0.65 l=0.15
X6018 sky130_fd_sc_hd__xor2_1_2/a_117_297# V3R001 sky130_fd_sc_hd__xor2_1_2/a_35_297# VDPWR sky130_fd_pr__pfet_01v8_hvt ad=0.27 pd=2.54 as=0.26 ps=2.52 w=1 l=0.15
X6019 VDPWR V3R001 sky130_fd_sc_hd__xor2_1_2/a_285_297# VDPWR sky130_fd_pr__pfet_01v8_hvt ad=0 pd=0 as=0 ps=0 w=1 l=0.15
X6020 VGND V3R051 sky130_fd_sc_hd__xor2_1_2/a_35_297# VGND sky130_fd_pr__nfet_01v8 ad=0 pd=0 as=0 ps=0 w=0.65 l=0.15
X6021 VGND sky130_fd_sc_hd__xor2_1_2/a_35_297# V3R271 VGND sky130_fd_pr__nfet_01v8 ad=0 pd=0 as=0 ps=0 w=0.65 l=0.15
X6022 sky130_fd_sc_hd__xor2_1_2/a_285_297# V3R051 VDPWR VDPWR sky130_fd_pr__pfet_01v8_hvt ad=0 pd=0 as=0 ps=0 w=1 l=0.15
X6023 VDPWR V3R051 sky130_fd_sc_hd__xor2_1_2/a_117_297# VDPWR sky130_fd_pr__pfet_01v8_hvt ad=0 pd=0 as=0 ps=0 w=1 l=0.15
X6024 sky130_fd_sc_hd__xor2_1_2/a_285_47# V3R051 VGND VGND sky130_fd_pr__nfet_01v8 ad=0 pd=0 as=0 ps=0 w=0.65 l=0.15
X6025 VDPWR sky130_fd_sc_hd__mux2_1_3/a_505_21# sky130_fd_sc_hd__mux2_1_3/a_535_374# VDPWR sky130_fd_pr__pfet_01v8_hvt ad=0 pd=0 as=0.0882 ps=1.26 w=0.42 l=0.15
X6026 sky130_fd_sc_hd__mux2_1_3/a_505_21# V3R045 VDPWR VDPWR sky130_fd_pr__pfet_01v8_hvt ad=0.1176 pd=1.4 as=0 ps=0 w=0.42 l=0.15
X6027 sky130_fd_sc_hd__mux2_1_3/a_218_374# V3R045 VDPWR VDPWR sky130_fd_pr__pfet_01v8_hvt ad=0.1533 pd=1.57 as=0 ps=0 w=0.42 l=0.15
X6028 VGND sky130_fd_sc_hd__mux2_1_3/a_505_21# sky130_fd_sc_hd__mux2_1_3/a_439_47# VGND sky130_fd_pr__nfet_01v8 ad=0 pd=0 as=0.1386 ps=1.5 w=0.42 l=0.15
X6029 sky130_fd_sc_hd__mux2_1_3/a_76_199# V3R034 sky130_fd_sc_hd__mux2_1_3/a_218_374# VDPWR sky130_fd_pr__pfet_01v8_hvt ad=0.3864 pd=2.68 as=0 ps=0 w=0.42 l=0.15
X6030 sky130_fd_sc_hd__mux2_1_3/a_505_21# V3R045 VGND VGND sky130_fd_pr__nfet_01v8 ad=0.1092 pd=1.36 as=0 ps=0 w=0.42 l=0.15
X6031 sky130_fd_sc_hd__mux2_1_3/a_439_47# V3R034 sky130_fd_sc_hd__mux2_1_3/a_76_199# VGND sky130_fd_pr__nfet_01v8 ad=0 pd=0 as=0.1995 ps=1.79 w=0.42 l=0.15
X6032 sky130_fd_sc_hd__mux2_1_3/a_535_374# V3R173 sky130_fd_sc_hd__mux2_1_3/a_76_199# VDPWR sky130_fd_pr__pfet_01v8_hvt ad=0 pd=0 as=0 ps=0 w=0.42 l=0.15
X6033 sky130_fd_sc_hd__mux2_1_3/a_76_199# V3R173 sky130_fd_sc_hd__mux2_1_3/a_218_47# VGND sky130_fd_pr__nfet_01v8 ad=0 pd=0 as=0.1386 ps=1.5 w=0.42 l=0.15
X6034 sky130_fd_sc_hd__mux2_1_3/a_218_47# V3R045 VGND VGND sky130_fd_pr__nfet_01v8 ad=0 pd=0 as=0 ps=0 w=0.42 l=0.15
X6035 VDPWR sky130_fd_sc_hd__mux2_1_3/a_76_199# V3R148 VDPWR sky130_fd_pr__pfet_01v8_hvt ad=0 pd=0 as=0.26 ps=2.52 w=1 l=0.15
X6036 VGND sky130_fd_sc_hd__mux2_1_3/a_76_199# V3R148 VGND sky130_fd_pr__nfet_01v8 ad=0 pd=0 as=0.169 ps=1.82 w=0.65 l=0.15
