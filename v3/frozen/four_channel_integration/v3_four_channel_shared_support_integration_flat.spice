* NGSPICE file created from v3_four_channel_shared_support_integration.ext - technology: sky130A

X0 v3_tail_bias_support_block_0/vbias v3_tail_bias_support_block_0/vbias VSUBS VSUBS sky130_fd_pr__nfet_01v8 ad=1.16 pd=8.29 as=1.16 ps=8.29 w=8 l=1
X1 v3_tail_bias_support_block_0/vbias v3_tail_bias_support_block_0/vbias VSUBS VSUBS sky130_fd_pr__nfet_01v8 ad=2.32 pd=16.58 as=1.16 ps=8.29 w=8 l=1
X2 VSUBS v3_tail_bias_support_block_0/vbias v3_tail_bias_support_block_0/vbias VSUBS sky130_fd_pr__nfet_01v8 ad=1.16 pd=8.29 as=1.16 ps=8.29 w=8 l=1
X3 v3_tail_bias_support_block_0/vbias v3_tail_bias_support_block_0/vbias VSUBS VSUBS sky130_fd_pr__nfet_01v8 ad=1.16 pd=8.29 as=1.16 ps=8.29 w=8 l=1
X4 v3_tail_bias_support_block_0/vbias VSUBS sky130_fd_pr__cap_mim_m3_1 l=22 w=22
X5 VSUBS v3_tail_bias_support_block_0/vbias v3_tail_bias_support_block_0/vbias VSUBS sky130_fd_pr__nfet_01v8 ad=1.16 pd=8.29 as=2.32 ps=16.58 w=8 l=1
X6 v3_tail_bias_support_block_0/VDPWR v3_tail_bias_support_block_0/vbias VSUBS sky130_fd_pr__res_high_po_1p41 l=44.98
X7 VSUBS v3_tail_bias_support_block_0/vbias v3_tail_bias_support_block_0/vbias VSUBS sky130_fd_pr__nfet_01v8 ad=1.16 pd=8.29 as=1.16 ps=8.29 w=8 l=1
X8 VSUBS v3_tail_bias_support_block_0/vbias v3_tail_bias_support_block_0/vbias VSUBS sky130_fd_pr__nfet_01v8 ad=1.16 pd=8.29 as=1.16 ps=8.29 w=8 l=1
X9 v3_tail_bias_support_block_0/vbias v3_tail_bias_support_block_0/vbias VSUBS VSUBS sky130_fd_pr__nfet_01v8 ad=1.16 pd=8.29 as=1.16 ps=8.29 w=8 l=1
X10 v3_tail_bias_support_block_0/vbias VSUBS sky130_fd_pr__cap_mim_m3_1 l=22 w=22
X11 v3_vcm_support_block_0/a_4259_24172# v3_vcm_support_block_0/ref VSUBS sky130_fd_pr__res_xhigh_po_1p41 l=5.88
X12 v3_vcm_support_block_0/a_4259_27772# v3_vcm_support_block_0/a_4259_24172# VSUBS sky130_fd_pr__res_xhigh_po_1p41 l=5.88
X13 v3_vcm_support_block_0/ref VSUBS sky130_fd_pr__cap_mim_m3_1 l=22 w=22
X14 v3_vcm_support_block_0/ref VSUBS sky130_fd_pr__cap_mim_m3_1 l=22 w=22
X15 v3_vcm_support_block_0/ref VSUBS sky130_fd_pr__cap_mim_m3_1 l=22 w=22
X16 v3_vcm_support_block_0/a_8459_24172# VSUBS VSUBS sky130_fd_pr__res_xhigh_po_1p41 l=5.88
X17 v3_vcm_support_block_0/a_4259_27772# v3_vcm_support_block_0/a_8459_24172# VSUBS sky130_fd_pr__res_xhigh_po_1p41 l=5.88
X18 v3_vcm_support_block_0/a_6359_24172# v3_vcm_support_block_0/ref VSUBS sky130_fd_pr__res_xhigh_po_1p41 l=5.88
X19 v3_vcm_support_block_0/VDPWR v3_vcm_support_block_0/a_6359_24172# VSUBS sky130_fd_pr__res_xhigh_po_1p41 l=5.88
X20 v3_four_channel_bias_reference_distribution_0/v3_four_channel_phase_distribution_0/v3_four_channel_output_collection_0/v3_four_channel_placement_0/v3_channel_selector_late_promotion_0/v3_channel_input_bias_late_promotion_0/a_4678_23422# v3_four_channel_bias_reference_distribution_0/v3_four_channel_phase_distribution_0/v3_four_channel_output_collection_0/v3_four_channel_placement_0/v3_channel_selector_late_promotion_0/v3_selector_route_pilot_0/group3_lo_p v3_four_channel_bias_reference_distribution_0/v3_four_channel_phase_distribution_0/v3_four_channel_output_collection_0/combined_n_internal VSUBS sky130_fd_pr__nfet_01v8 ad=0.1885 pd=1.88 as=0.1885 ps=1.88 w=0.65 l=0.15
X21 v3_four_channel_bias_reference_distribution_0/v3_four_channel_phase_distribution_0/v3_four_channel_output_collection_0/combined_n_internal v3_four_channel_bias_reference_distribution_0/v3_four_channel_phase_distribution_0/v3_four_channel_output_collection_0/v3_four_channel_placement_0/v3_channel_selector_late_promotion_0/v3_selector_route_pilot_0/group3_lo_p v3_four_channel_bias_reference_distribution_0/v3_four_channel_phase_distribution_0/v3_four_channel_output_collection_0/v3_four_channel_placement_0/v3_channel_selector_late_promotion_0/v3_channel_input_bias_late_promotion_0/a_4254_6978# VSUBS sky130_fd_pr__nfet_01v8 ad=0.1885 pd=1.88 as=0.1885 ps=1.88 w=0.65 l=0.15
X22 v3_four_channel_bias_reference_distribution_0/v3_four_channel_phase_distribution_0/v3_four_channel_output_collection_0/v3_four_channel_placement_0/v3_channel_selector_late_promotion_0/v3_channel_input_bias_late_promotion_0/a_4678_23422# v3_vcm_support_block_0/ref v3_four_channel_bias_reference_distribution_0/v3_four_channel_phase_distribution_0/v3_four_channel_output_collection_0/v3_four_channel_placement_0/v3_channel_selector_late_promotion_0/v3_channel_input_bias_late_promotion_0/a_4382_21688# VSUBS sky130_fd_pr__nfet_01v8 ad=0.2436 pd=2.26 as=0.2436 ps=2.26 w=0.84 l=0.6
X23 v3_four_channel_bias_reference_distribution_0/v3_four_channel_phase_distribution_0/v3_four_channel_output_collection_0/combined_n_internal v3_four_channel_bias_reference_distribution_0/v3_four_channel_phase_distribution_0/v3_four_channel_output_collection_0/v3_four_channel_placement_0/v3_channel_selector_late_promotion_0/v3_selector_route_pilot_0/group3_lo_n v3_four_channel_bias_reference_distribution_0/v3_four_channel_phase_distribution_0/v3_four_channel_output_collection_0/v3_four_channel_placement_0/v3_channel_selector_late_promotion_0/v3_channel_input_bias_late_promotion_0/a_7038_22978# VSUBS sky130_fd_pr__nfet_01v8 ad=0.1885 pd=1.88 as=0.1885 ps=1.88 w=0.65 l=0.15
X24 v3_four_channel_bias_reference_distribution_0/v3_four_channel_phase_distribution_0/v3_four_channel_output_collection_0/combined_n_internal v3_four_channel_bias_reference_distribution_0/v3_four_channel_phase_distribution_0/v3_four_channel_output_collection_0/v3_four_channel_placement_0/v3_channel_selector_late_promotion_0/v3_selector_route_pilot_0/group3_lo_p v3_four_channel_bias_reference_distribution_0/v3_four_channel_phase_distribution_0/v3_four_channel_output_collection_0/v3_four_channel_placement_0/v3_channel_selector_late_promotion_0/v3_channel_input_bias_late_promotion_0/a_7038_6978# VSUBS sky130_fd_pr__nfet_01v8 ad=0.1885 pd=1.88 as=0.1885 ps=1.88 w=0.65 l=0.15
X25 v3_four_channel_bias_reference_distribution_0/v3_four_channel_phase_distribution_0/v3_four_channel_output_collection_0/v3_four_channel_placement_0/v3_channel_selector_late_promotion_0/v3_channel_input_bias_late_promotion_0/a_7462_11422# v3_four_channel_bias_reference_distribution_0/v3_four_channel_phase_distribution_0/v3_four_channel_output_collection_0/v3_four_channel_placement_0/v3_channel_selector_late_promotion_0/element_input v3_four_channel_bias_reference_distribution_0/v3_four_channel_phase_distribution_0/v3_four_channel_output_collection_0/v3_four_channel_placement_0/v3_channel_selector_late_promotion_0/v3_channel_input_bias_late_promotion_0/a_7216_10978# VSUBS sky130_fd_pr__nfet_01v8 ad=0.2436 pd=2.26 as=0.2436 ps=2.26 w=0.84 l=0.6
X26 v3_four_channel_bias_reference_distribution_0/v3_four_channel_phase_distribution_0/v3_four_channel_output_collection_0/v3_four_channel_placement_0/v3_channel_selector_late_promotion_0/v3_channel_input_bias_late_promotion_0/a_7462_11422# v3_four_channel_bias_reference_distribution_0/v3_four_channel_phase_distribution_0/v3_four_channel_output_collection_0/v3_four_channel_placement_0/v3_channel_selector_late_promotion_0/v3_selector_route_pilot_0/group2_lo_n v3_four_channel_bias_reference_distribution_0/v3_four_channel_phase_distribution_0/v3_four_channel_output_collection_0/combined_n_internal VSUBS sky130_fd_pr__nfet_01v8 ad=0.1885 pd=1.88 as=0.1885 ps=1.88 w=0.65 l=0.15
X27 v3_four_channel_bias_reference_distribution_0/v3_four_channel_phase_distribution_0/v3_four_channel_output_collection_0/v3_four_channel_placement_0/v3_channel_selector_late_promotion_0/v3_channel_input_bias_late_promotion_0/a_5774_21688# v3_four_channel_bias_reference_distribution_0/v3_four_channel_phase_distribution_0/v3_four_channel_output_collection_0/v3_four_channel_placement_0/v3_channel_selector_late_promotion_0/element_input v3_four_channel_bias_reference_distribution_0/v3_four_channel_phase_distribution_0/v3_four_channel_output_collection_0/v3_four_channel_placement_0/v3_channel_selector_late_promotion_0/v3_channel_input_bias_late_promotion_0/a_5646_22978# VSUBS sky130_fd_pr__nfet_01v8 ad=0.2436 pd=2.26 as=0.2436 ps=2.26 w=0.84 l=0.6
X28 VSUBS v3_tail_bias_support_block_0/vbias v3_four_channel_bias_reference_distribution_0/v3_four_channel_phase_distribution_0/v3_four_channel_output_collection_0/v3_four_channel_placement_0/v3_channel_selector_late_promotion_0/v3_channel_input_bias_late_promotion_0/a_5774_17688# VSUBS sky130_fd_pr__nfet_01v8 ad=1.4703 pd=10.72 as=1.4703 ps=10.72 w=5.07 l=1
X29 v3_four_channel_bias_reference_distribution_0/v3_four_channel_phase_distribution_0/v3_four_channel_output_collection_0/v3_four_channel_placement_0/v3_channel_selector_late_promotion_0/v3_channel_input_bias_late_promotion_0/a_6070_7422# v3_four_channel_bias_reference_distribution_0/v3_four_channel_phase_distribution_0/v3_four_channel_output_collection_0/v3_four_channel_placement_0/v3_channel_selector_late_promotion_0/element_input v3_four_channel_bias_reference_distribution_0/v3_four_channel_phase_distribution_0/v3_four_channel_output_collection_0/v3_four_channel_placement_0/v3_channel_selector_late_promotion_0/v3_channel_input_bias_late_promotion_0/a_5824_6978# VSUBS sky130_fd_pr__nfet_01v8 ad=0.2436 pd=2.26 as=0.2436 ps=2.26 w=0.84 l=0.6
X30 v3_four_channel_bias_reference_distribution_0/v3_four_channel_phase_distribution_0/v3_four_channel_output_collection_0/v3_four_channel_placement_0/v3_channel_selector_late_promotion_0/v3_channel_input_bias_late_promotion_0/a_6070_7422# v3_four_channel_bias_reference_distribution_0/v3_four_channel_phase_distribution_0/v3_four_channel_output_collection_0/v3_four_channel_placement_0/v3_channel_selector_late_promotion_0/v3_selector_route_pilot_0/group3_lo_n v3_four_channel_bias_reference_distribution_0/v3_four_channel_phase_distribution_0/v3_four_channel_output_collection_0/combined_n_internal VSUBS sky130_fd_pr__nfet_01v8 ad=0.1885 pd=1.88 as=0.1885 ps=1.88 w=0.65 l=0.15
X31 v3_vcm_support_block_0/ref v3_four_channel_bias_reference_distribution_0/v3_four_channel_phase_distribution_0/v3_four_channel_output_collection_0/v3_four_channel_placement_0/v3_channel_selector_late_promotion_0/element_input VSUBS sky130_fd_pr__res_xhigh_po_0p35 l=17.36
X32 v3_four_channel_bias_reference_distribution_0/v3_four_channel_phase_distribution_0/v3_four_channel_output_collection_0/v3_four_channel_placement_0/v3_channel_selector_late_promotion_0/v3_channel_input_bias_late_promotion_0/a_7462_23422# v3_vcm_support_block_0/ref v3_four_channel_bias_reference_distribution_0/v3_four_channel_phase_distribution_0/v3_four_channel_output_collection_0/v3_four_channel_placement_0/v3_channel_selector_late_promotion_0/v3_channel_input_bias_late_promotion_0/a_7166_21688# VSUBS sky130_fd_pr__nfet_01v8 ad=0.2436 pd=2.26 as=0.2436 ps=2.26 w=0.84 l=0.6
X33 v3_four_channel_bias_reference_distribution_0/v3_four_channel_phase_distribution_0/v3_four_channel_output_collection_0/v3_four_channel_placement_0/v3_channel_selector_late_promotion_0/v3_channel_input_bias_late_promotion_0/a_7462_23422# v3_four_channel_bias_reference_distribution_0/v3_four_channel_phase_distribution_0/v3_four_channel_output_collection_0/v3_four_channel_placement_0/v3_channel_selector_late_promotion_0/v3_selector_route_pilot_0/group3_lo_p v3_four_channel_bias_reference_distribution_0/v3_four_channel_phase_distribution_0/v3_four_channel_output_collection_0/combined_n_internal VSUBS sky130_fd_pr__nfet_01v8 ad=0.1885 pd=1.88 as=0.1885 ps=1.88 w=0.65 l=0.15
X34 VSUBS v3_tail_bias_support_block_0/vbias v3_four_channel_bias_reference_distribution_0/v3_four_channel_phase_distribution_0/v3_four_channel_output_collection_0/v3_four_channel_placement_0/v3_channel_selector_late_promotion_0/v3_channel_input_bias_late_promotion_0/a_4382_21688# VSUBS sky130_fd_pr__nfet_01v8 ad=1.4703 pd=10.72 as=1.4703 ps=10.72 w=5.07 l=1
X35 VSUBS v3_tail_bias_support_block_0/vbias v3_four_channel_bias_reference_distribution_0/v3_four_channel_phase_distribution_0/v3_four_channel_output_collection_0/v3_four_channel_placement_0/v3_channel_selector_late_promotion_0/v3_channel_input_bias_late_promotion_0/a_5774_13688# VSUBS sky130_fd_pr__nfet_01v8 ad=1.4703 pd=10.72 as=1.4703 ps=10.72 w=5.07 l=1
X36 VSUBS v3_tail_bias_support_block_0/vbias v3_four_channel_bias_reference_distribution_0/v3_four_channel_phase_distribution_0/v3_four_channel_output_collection_0/v3_four_channel_placement_0/v3_channel_selector_late_promotion_0/v3_channel_input_bias_late_promotion_0/a_7166_17688# VSUBS sky130_fd_pr__nfet_01v8 ad=1.4703 pd=10.72 as=1.4703 ps=10.72 w=5.07 l=1
X37 VSUBS VSUBS VSUBS VSUBS sky130_fd_pr__nfet_01v8 ad=0.1885 pd=1.88 as=176.39079 ps=1.364k w=0.65 l=0.15
X38 v3_four_channel_bias_reference_distribution_0/v3_four_channel_phase_distribution_0/v3_four_channel_output_collection_0/combined_p_internal v3_four_channel_bias_reference_distribution_0/v3_four_channel_phase_distribution_0/v3_four_channel_output_collection_0/v3_four_channel_placement_0/v3_channel_selector_late_promotion_0/v3_selector_route_pilot_0/group3_lo_p v3_four_channel_bias_reference_distribution_0/v3_four_channel_phase_distribution_0/v3_four_channel_output_collection_0/v3_four_channel_placement_0/v3_channel_selector_late_promotion_0/v3_channel_input_bias_late_promotion_0/a_5646_18978# VSUBS sky130_fd_pr__nfet_01v8 ad=0.1885 pd=1.88 as=0.1885 ps=1.88 w=0.65 l=0.15
X39 VSUBS VSUBS VSUBS VSUBS sky130_fd_pr__nfet_01v8 ad=0.1885 pd=1.88 as=0 ps=0 w=0.65 l=0.15
X40 v3_four_channel_bias_reference_distribution_0/v3_four_channel_phase_distribution_0/v3_four_channel_output_collection_0/v3_four_channel_placement_0/v3_channel_selector_late_promotion_0/v3_channel_input_bias_late_promotion_0/a_6070_19422# v3_four_channel_bias_reference_distribution_0/v3_four_channel_phase_distribution_0/v3_four_channel_output_collection_0/v3_four_channel_placement_0/v3_channel_selector_late_promotion_0/v3_selector_route_pilot_0/group3_lo_n v3_four_channel_bias_reference_distribution_0/v3_four_channel_phase_distribution_0/v3_four_channel_output_collection_0/combined_p_internal VSUBS sky130_fd_pr__nfet_01v8 ad=0.1885 pd=1.88 as=0.1885 ps=1.88 w=0.65 l=0.15
X41 VSUBS VSUBS VSUBS VSUBS sky130_fd_pr__nfet_01v8 ad=0.1885 pd=1.88 as=0 ps=0 w=0.65 l=0.15
X42 v3_four_channel_bias_reference_distribution_0/v3_four_channel_phase_distribution_0/v3_four_channel_output_collection_0/combined_p_internal v3_four_channel_bias_reference_distribution_0/v3_four_channel_phase_distribution_0/v3_four_channel_output_collection_0/v3_four_channel_placement_0/v3_channel_selector_late_promotion_0/v3_selector_route_pilot_0/group2_lo_p v3_four_channel_bias_reference_distribution_0/v3_four_channel_phase_distribution_0/v3_four_channel_output_collection_0/v3_four_channel_placement_0/v3_channel_selector_late_promotion_0/v3_channel_input_bias_late_promotion_0/a_4254_18978# VSUBS sky130_fd_pr__nfet_01v8 ad=0.1885 pd=1.88 as=0.1885 ps=1.88 w=0.65 l=0.15
X43 v3_four_channel_bias_reference_distribution_0/v3_four_channel_phase_distribution_0/v3_four_channel_output_collection_0/v3_four_channel_placement_0/v3_channel_selector_late_promotion_0/v3_channel_input_bias_late_promotion_0/a_7216_14978# v3_tail_bias_support_block_0/vbias VSUBS VSUBS sky130_fd_pr__nfet_01v8 ad=1.4703 pd=10.72 as=1.4703 ps=10.72 w=5.07 l=1
X44 VSUBS VSUBS VSUBS VSUBS sky130_fd_pr__nfet_01v8 ad=0.1885 pd=1.88 as=0 ps=0 w=0.65 l=0.15
X45 VSUBS VSUBS VSUBS VSUBS sky130_fd_pr__nfet_01v8 ad=0.1885 pd=1.88 as=0 ps=0 w=0.65 l=0.15
X46 v3_four_channel_bias_reference_distribution_0/v3_four_channel_phase_distribution_0/v3_four_channel_output_collection_0/v3_four_channel_placement_0/v3_channel_selector_late_promotion_0/v3_channel_input_bias_late_promotion_0/a_4382_17688# v3_four_channel_bias_reference_distribution_0/v3_four_channel_phase_distribution_0/v3_four_channel_output_collection_0/v3_four_channel_placement_0/v3_channel_selector_late_promotion_0/element_input v3_four_channel_bias_reference_distribution_0/v3_four_channel_phase_distribution_0/v3_four_channel_output_collection_0/v3_four_channel_placement_0/v3_channel_selector_late_promotion_0/v3_channel_input_bias_late_promotion_0/a_4254_18978# VSUBS sky130_fd_pr__nfet_01v8 ad=0.2436 pd=2.26 as=0.2436 ps=2.26 w=0.84 l=0.6
X47 v3_four_channel_bias_reference_distribution_0/v3_four_channel_phase_distribution_0/v3_four_channel_output_collection_0/v3_four_channel_placement_0/v3_channel_selector_late_promotion_0/v3_channel_input_bias_late_promotion_0/a_4678_19422# v3_four_channel_bias_reference_distribution_0/v3_four_channel_phase_distribution_0/v3_four_channel_output_collection_0/v3_four_channel_placement_0/v3_channel_selector_late_promotion_0/v3_selector_route_pilot_0/group2_lo_n v3_four_channel_bias_reference_distribution_0/v3_four_channel_phase_distribution_0/v3_four_channel_output_collection_0/combined_p_internal VSUBS sky130_fd_pr__nfet_01v8 ad=0.1885 pd=1.88 as=0.1885 ps=1.88 w=0.65 l=0.15
X48 v3_four_channel_bias_reference_distribution_0/v3_four_channel_phase_distribution_0/v3_four_channel_output_collection_0/combined_p_internal v3_four_channel_bias_reference_distribution_0/v3_four_channel_phase_distribution_0/v3_four_channel_output_collection_0/v3_four_channel_placement_0/v3_channel_selector_late_promotion_0/v3_selector_route_pilot_0/group0_lo_p v3_four_channel_bias_reference_distribution_0/v3_four_channel_phase_distribution_0/v3_four_channel_output_collection_0/v3_four_channel_placement_0/v3_channel_selector_late_promotion_0/v3_channel_input_bias_late_promotion_0/a_5646_14978# VSUBS sky130_fd_pr__nfet_01v8 ad=0.1885 pd=1.88 as=0.1885 ps=1.88 w=0.65 l=0.15
X49 v3_four_channel_bias_reference_distribution_0/v3_four_channel_phase_distribution_0/v3_four_channel_output_collection_0/combined_p_internal v3_four_channel_bias_reference_distribution_0/v3_four_channel_phase_distribution_0/v3_four_channel_output_collection_0/v3_four_channel_placement_0/v3_channel_selector_late_promotion_0/v3_selector_route_pilot_0/group2_lo_p v3_four_channel_bias_reference_distribution_0/v3_four_channel_phase_distribution_0/v3_four_channel_output_collection_0/v3_four_channel_placement_0/v3_channel_selector_late_promotion_0/v3_channel_input_bias_late_promotion_0/a_7038_18978# VSUBS sky130_fd_pr__nfet_01v8 ad=0.1885 pd=1.88 as=0.1885 ps=1.88 w=0.65 l=0.15
X50 VSUBS VSUBS VSUBS VSUBS sky130_fd_pr__nfet_01v8 ad=1.4703 pd=10.72 as=0 ps=0 w=5.07 l=1
X51 v3_four_channel_bias_reference_distribution_0/v3_four_channel_phase_distribution_0/v3_four_channel_output_collection_0/v3_four_channel_placement_0/v3_channel_selector_late_promotion_0/v3_channel_input_bias_late_promotion_0/a_6070_15422# v3_four_channel_bias_reference_distribution_0/v3_four_channel_phase_distribution_0/v3_four_channel_output_collection_0/v3_four_channel_placement_0/v3_channel_selector_late_promotion_0/v3_selector_route_pilot_0/group0_lo_n v3_four_channel_bias_reference_distribution_0/v3_four_channel_phase_distribution_0/v3_four_channel_output_collection_0/combined_p_internal VSUBS sky130_fd_pr__nfet_01v8 ad=0.1885 pd=1.88 as=0.1885 ps=1.88 w=0.65 l=0.15
X52 v3_four_channel_bias_reference_distribution_0/v3_four_channel_phase_distribution_0/v3_four_channel_output_collection_0/v3_four_channel_placement_0/v3_channel_selector_late_promotion_0/v3_channel_input_bias_late_promotion_0/a_7166_17688# v3_four_channel_bias_reference_distribution_0/v3_four_channel_phase_distribution_0/v3_four_channel_output_collection_0/v3_four_channel_placement_0/v3_channel_selector_late_promotion_0/element_input v3_four_channel_bias_reference_distribution_0/v3_four_channel_phase_distribution_0/v3_four_channel_output_collection_0/v3_four_channel_placement_0/v3_channel_selector_late_promotion_0/v3_channel_input_bias_late_promotion_0/a_7038_18978# VSUBS sky130_fd_pr__nfet_01v8 ad=0.2436 pd=2.26 as=0.2436 ps=2.26 w=0.84 l=0.6
X53 v3_four_channel_bias_reference_distribution_0/v3_four_channel_phase_distribution_0/v3_four_channel_output_collection_0/combined_n_internal v3_four_channel_bias_reference_distribution_0/v3_four_channel_phase_distribution_0/v3_four_channel_output_collection_0/v3_four_channel_placement_0/v3_channel_selector_late_promotion_0/v3_selector_route_pilot_0/group3_lo_n v3_four_channel_bias_reference_distribution_0/v3_four_channel_phase_distribution_0/v3_four_channel_output_collection_0/v3_four_channel_placement_0/v3_channel_selector_late_promotion_0/v3_channel_input_bias_late_promotion_0/a_5646_18978# VSUBS sky130_fd_pr__nfet_01v8 ad=0.1885 pd=1.88 as=0.1885 ps=1.88 w=0.65 l=0.15
X54 VSUBS v3_tail_bias_support_block_0/vbias v3_four_channel_bias_reference_distribution_0/v3_four_channel_phase_distribution_0/v3_four_channel_output_collection_0/v3_four_channel_placement_0/v3_channel_selector_late_promotion_0/v3_channel_input_bias_late_promotion_0/a_5774_21688# VSUBS sky130_fd_pr__nfet_01v8 ad=1.4703 pd=10.72 as=1.4703 ps=10.72 w=5.07 l=1
X55 v3_four_channel_bias_reference_distribution_0/v3_four_channel_phase_distribution_0/v3_four_channel_output_collection_0/v3_four_channel_placement_0/v3_channel_selector_late_promotion_0/v3_channel_input_bias_late_promotion_0/a_6070_19422# v3_vcm_support_block_0/ref v3_four_channel_bias_reference_distribution_0/v3_four_channel_phase_distribution_0/v3_four_channel_output_collection_0/v3_four_channel_placement_0/v3_channel_selector_late_promotion_0/v3_channel_input_bias_late_promotion_0/a_5774_17688# VSUBS sky130_fd_pr__nfet_01v8 ad=0.2436 pd=2.26 as=0.2436 ps=2.26 w=0.84 l=0.6
X56 VSUBS VSUBS VSUBS VSUBS sky130_fd_pr__nfet_01v8 ad=1.4703 pd=10.72 as=0 ps=0 w=5.07 l=1
X57 v3_four_channel_bias_reference_distribution_0/v3_four_channel_phase_distribution_0/v3_four_channel_output_collection_0/combined_p_internal v3_four_channel_bias_reference_distribution_0/v3_four_channel_phase_distribution_0/v3_four_channel_output_collection_0/v3_four_channel_placement_0/v3_channel_selector_late_promotion_0/v3_selector_route_pilot_0/group1_lo_p v3_four_channel_bias_reference_distribution_0/v3_four_channel_phase_distribution_0/v3_four_channel_output_collection_0/v3_four_channel_placement_0/v3_channel_selector_late_promotion_0/v3_channel_input_bias_late_promotion_0/a_4254_14978# VSUBS sky130_fd_pr__nfet_01v8 ad=0.1885 pd=1.88 as=0.1885 ps=1.88 w=0.65 l=0.15
X58 v3_four_channel_bias_reference_distribution_0/v3_four_channel_phase_distribution_0/v3_four_channel_output_collection_0/v3_four_channel_placement_0/v3_channel_selector_late_promotion_0/v3_channel_input_bias_late_promotion_0/a_6070_19422# v3_four_channel_bias_reference_distribution_0/v3_four_channel_phase_distribution_0/v3_four_channel_output_collection_0/v3_four_channel_placement_0/v3_channel_selector_late_promotion_0/v3_selector_route_pilot_0/group3_lo_p v3_four_channel_bias_reference_distribution_0/v3_four_channel_phase_distribution_0/v3_four_channel_output_collection_0/combined_n_internal VSUBS sky130_fd_pr__nfet_01v8 ad=0.1885 pd=1.88 as=0.1885 ps=1.88 w=0.65 l=0.15
X59 VSUBS VSUBS VSUBS VSUBS sky130_fd_pr__nfet_01v8 ad=0.1885 pd=1.88 as=0 ps=0 w=0.65 l=0.15
X60 v3_four_channel_bias_reference_distribution_0/v3_four_channel_phase_distribution_0/v3_four_channel_output_collection_0/v3_four_channel_placement_0/v3_channel_selector_late_promotion_0/v3_channel_input_bias_late_promotion_0/a_5824_10978# v3_tail_bias_support_block_0/vbias VSUBS VSUBS sky130_fd_pr__nfet_01v8 ad=1.4703 pd=10.72 as=1.4703 ps=10.72 w=5.07 l=1
X61 v3_four_channel_bias_reference_distribution_0/v3_four_channel_phase_distribution_0/v3_four_channel_output_collection_0/v3_four_channel_placement_0/v3_channel_selector_late_promotion_0/v3_channel_input_bias_late_promotion_0/a_4382_13688# v3_four_channel_bias_reference_distribution_0/v3_four_channel_phase_distribution_0/v3_four_channel_output_collection_0/v3_four_channel_placement_0/v3_channel_selector_late_promotion_0/element_input v3_four_channel_bias_reference_distribution_0/v3_four_channel_phase_distribution_0/v3_four_channel_output_collection_0/v3_four_channel_placement_0/v3_channel_selector_late_promotion_0/v3_channel_input_bias_late_promotion_0/a_4254_14978# VSUBS sky130_fd_pr__nfet_01v8 ad=0.2436 pd=2.26 as=0.2436 ps=2.26 w=0.84 l=0.6
X62 v3_four_channel_bias_reference_distribution_0/v3_four_channel_phase_distribution_0/v3_four_channel_output_collection_0/v3_four_channel_placement_0/v3_channel_selector_late_promotion_0/v3_channel_input_bias_late_promotion_0/a_4678_15422# v3_four_channel_bias_reference_distribution_0/v3_four_channel_phase_distribution_0/v3_four_channel_output_collection_0/v3_four_channel_placement_0/v3_channel_selector_late_promotion_0/v3_selector_route_pilot_0/group1_lo_n v3_four_channel_bias_reference_distribution_0/v3_four_channel_phase_distribution_0/v3_four_channel_output_collection_0/combined_p_internal VSUBS sky130_fd_pr__nfet_01v8 ad=0.1885 pd=1.88 as=0.1885 ps=1.88 w=0.65 l=0.15
X63 v3_four_channel_bias_reference_distribution_0/v3_four_channel_phase_distribution_0/v3_four_channel_output_collection_0/combined_n_internal v3_four_channel_bias_reference_distribution_0/v3_four_channel_phase_distribution_0/v3_four_channel_output_collection_0/v3_four_channel_placement_0/v3_channel_selector_late_promotion_0/v3_selector_route_pilot_0/group2_lo_n v3_four_channel_bias_reference_distribution_0/v3_four_channel_phase_distribution_0/v3_four_channel_output_collection_0/v3_four_channel_placement_0/v3_channel_selector_late_promotion_0/v3_channel_input_bias_late_promotion_0/a_4254_18978# VSUBS sky130_fd_pr__nfet_01v8 ad=0.1885 pd=1.88 as=0.1885 ps=1.88 w=0.65 l=0.15
X64 v3_four_channel_bias_reference_distribution_0/v3_four_channel_phase_distribution_0/v3_four_channel_output_collection_0/combined_p_internal v3_four_channel_bias_reference_distribution_0/v3_four_channel_phase_distribution_0/v3_four_channel_output_collection_0/v3_four_channel_placement_0/v3_channel_selector_late_promotion_0/v3_selector_route_pilot_0/group3_lo_n v3_four_channel_bias_reference_distribution_0/v3_four_channel_phase_distribution_0/v3_four_channel_output_collection_0/v3_four_channel_placement_0/v3_channel_selector_late_promotion_0/v3_channel_input_bias_late_promotion_0/a_5646_10978# VSUBS sky130_fd_pr__nfet_01v8 ad=0.1885 pd=1.88 as=0.1885 ps=1.88 w=0.65 l=0.15
X65 v3_four_channel_bias_reference_distribution_0/v3_four_channel_phase_distribution_0/v3_four_channel_output_collection_0/combined_p_internal v3_four_channel_bias_reference_distribution_0/v3_four_channel_phase_distribution_0/v3_four_channel_output_collection_0/v3_four_channel_placement_0/v3_channel_selector_late_promotion_0/v3_selector_route_pilot_0/group1_lo_n v3_four_channel_bias_reference_distribution_0/v3_four_channel_phase_distribution_0/v3_four_channel_output_collection_0/v3_four_channel_placement_0/v3_channel_selector_late_promotion_0/v3_channel_input_bias_late_promotion_0/a_7038_14978# VSUBS sky130_fd_pr__nfet_01v8 ad=0.1885 pd=1.88 as=0.1885 ps=1.88 w=0.65 l=0.15
X66 v3_four_channel_bias_reference_distribution_0/v3_four_channel_phase_distribution_0/v3_four_channel_output_collection_0/v3_four_channel_placement_0/v3_channel_selector_late_promotion_0/v3_channel_input_bias_late_promotion_0/a_7462_19422# v3_four_channel_bias_reference_distribution_0/v3_four_channel_phase_distribution_0/v3_four_channel_output_collection_0/v3_four_channel_placement_0/v3_channel_selector_late_promotion_0/v3_selector_route_pilot_0/group2_lo_n v3_four_channel_bias_reference_distribution_0/v3_four_channel_phase_distribution_0/v3_four_channel_output_collection_0/combined_p_internal VSUBS sky130_fd_pr__nfet_01v8 ad=0.1885 pd=1.88 as=0.1885 ps=1.88 w=0.65 l=0.15
X67 v3_four_channel_bias_reference_distribution_0/v3_four_channel_phase_distribution_0/v3_four_channel_output_collection_0/v3_four_channel_placement_0/v3_channel_selector_late_promotion_0/v3_channel_input_bias_late_promotion_0/a_4678_7422# v3_four_channel_bias_reference_distribution_0/v3_four_channel_phase_distribution_0/v3_four_channel_output_collection_0/v3_four_channel_placement_0/v3_channel_selector_late_promotion_0/v3_selector_route_pilot_0/group3_lo_p v3_four_channel_bias_reference_distribution_0/v3_four_channel_phase_distribution_0/v3_four_channel_output_collection_0/combined_p_internal VSUBS sky130_fd_pr__nfet_01v8 ad=0.1885 pd=1.88 as=0.1885 ps=1.88 w=0.65 l=0.15
X68 v3_four_channel_bias_reference_distribution_0/v3_four_channel_phase_distribution_0/v3_four_channel_output_collection_0/v3_four_channel_placement_0/v3_channel_selector_late_promotion_0/v3_channel_input_bias_late_promotion_0/a_6070_11422# v3_four_channel_bias_reference_distribution_0/v3_four_channel_phase_distribution_0/v3_four_channel_output_collection_0/v3_four_channel_placement_0/v3_channel_selector_late_promotion_0/v3_selector_route_pilot_0/group3_lo_p v3_four_channel_bias_reference_distribution_0/v3_four_channel_phase_distribution_0/v3_four_channel_output_collection_0/combined_p_internal VSUBS sky130_fd_pr__nfet_01v8 ad=0.1885 pd=1.88 as=0.1885 ps=1.88 w=0.65 l=0.15
X69 v3_four_channel_bias_reference_distribution_0/v3_four_channel_phase_distribution_0/v3_four_channel_output_collection_0/v3_four_channel_placement_0/v3_channel_selector_late_promotion_0/v3_channel_input_bias_late_promotion_0/a_7216_10978# v3_tail_bias_support_block_0/vbias VSUBS VSUBS sky130_fd_pr__nfet_01v8 ad=1.4703 pd=10.72 as=1.4703 ps=10.72 w=5.07 l=1
X70 v3_four_channel_bias_reference_distribution_0/v3_four_channel_phase_distribution_0/v3_four_channel_output_collection_0/v3_four_channel_placement_0/v3_channel_selector_late_promotion_0/v3_channel_input_bias_late_promotion_0/a_7216_14978# v3_vcm_support_block_0/ref v3_four_channel_bias_reference_distribution_0/v3_four_channel_phase_distribution_0/v3_four_channel_output_collection_0/v3_four_channel_placement_0/v3_channel_selector_late_promotion_0/v3_channel_input_bias_late_promotion_0/a_7038_14978# VSUBS sky130_fd_pr__nfet_01v8 ad=0.2436 pd=2.26 as=0.2436 ps=2.26 w=0.84 l=0.6
X71 v3_four_channel_bias_reference_distribution_0/v3_four_channel_phase_distribution_0/v3_four_channel_output_collection_0/v3_four_channel_placement_0/v3_channel_selector_late_promotion_0/v3_channel_input_bias_late_promotion_0/a_4678_19422# v3_vcm_support_block_0/ref v3_four_channel_bias_reference_distribution_0/v3_four_channel_phase_distribution_0/v3_four_channel_output_collection_0/v3_four_channel_placement_0/v3_channel_selector_late_promotion_0/v3_channel_input_bias_late_promotion_0/a_4382_17688# VSUBS sky130_fd_pr__nfet_01v8 ad=0.2436 pd=2.26 as=0.2436 ps=2.26 w=0.84 l=0.6
X72 v3_four_channel_bias_reference_distribution_0/v3_four_channel_phase_distribution_0/v3_four_channel_output_collection_0/v3_four_channel_placement_0/v3_channel_selector_late_promotion_0/v3_channel_input_bias_late_promotion_0/a_4678_19422# v3_four_channel_bias_reference_distribution_0/v3_four_channel_phase_distribution_0/v3_four_channel_output_collection_0/v3_four_channel_placement_0/v3_channel_selector_late_promotion_0/v3_selector_route_pilot_0/group2_lo_p v3_four_channel_bias_reference_distribution_0/v3_four_channel_phase_distribution_0/v3_four_channel_output_collection_0/combined_n_internal VSUBS sky130_fd_pr__nfet_01v8 ad=0.1885 pd=1.88 as=0.1885 ps=1.88 w=0.65 l=0.15
X73 v3_four_channel_bias_reference_distribution_0/v3_four_channel_phase_distribution_0/v3_four_channel_output_collection_0/combined_n_internal v3_four_channel_bias_reference_distribution_0/v3_four_channel_phase_distribution_0/v3_four_channel_output_collection_0/v3_four_channel_placement_0/v3_channel_selector_late_promotion_0/v3_selector_route_pilot_0/group0_lo_n v3_four_channel_bias_reference_distribution_0/v3_four_channel_phase_distribution_0/v3_four_channel_output_collection_0/v3_four_channel_placement_0/v3_channel_selector_late_promotion_0/v3_channel_input_bias_late_promotion_0/a_5646_14978# VSUBS sky130_fd_pr__nfet_01v8 ad=0.1885 pd=1.88 as=0.1885 ps=1.88 w=0.65 l=0.15
X74 v3_four_channel_bias_reference_distribution_0/v3_four_channel_phase_distribution_0/v3_four_channel_output_collection_0/combined_n_internal v3_four_channel_bias_reference_distribution_0/v3_four_channel_phase_distribution_0/v3_four_channel_output_collection_0/v3_four_channel_placement_0/v3_channel_selector_late_promotion_0/v3_selector_route_pilot_0/group2_lo_n v3_four_channel_bias_reference_distribution_0/v3_four_channel_phase_distribution_0/v3_four_channel_output_collection_0/v3_four_channel_placement_0/v3_channel_selector_late_promotion_0/v3_channel_input_bias_late_promotion_0/a_7038_18978# VSUBS sky130_fd_pr__nfet_01v8 ad=0.1885 pd=1.88 as=0.1885 ps=1.88 w=0.65 l=0.15
X75 v3_four_channel_bias_reference_distribution_0/v3_four_channel_phase_distribution_0/v3_four_channel_output_collection_0/v3_four_channel_placement_0/v3_channel_selector_late_promotion_0/v3_channel_input_bias_late_promotion_0/a_7462_7422# v3_four_channel_bias_reference_distribution_0/v3_four_channel_phase_distribution_0/v3_four_channel_output_collection_0/v3_four_channel_placement_0/v3_channel_selector_late_promotion_0/v3_selector_route_pilot_0/group3_lo_p v3_four_channel_bias_reference_distribution_0/v3_four_channel_phase_distribution_0/v3_four_channel_output_collection_0/combined_p_internal VSUBS sky130_fd_pr__nfet_01v8 ad=0.1885 pd=1.88 as=0.1885 ps=1.88 w=0.65 l=0.15
X76 VSUBS v3_tail_bias_support_block_0/vbias v3_four_channel_bias_reference_distribution_0/v3_four_channel_phase_distribution_0/v3_four_channel_output_collection_0/v3_four_channel_placement_0/v3_channel_selector_late_promotion_0/v3_channel_input_bias_late_promotion_0/a_7166_21688# VSUBS sky130_fd_pr__nfet_01v8 ad=1.4703 pd=10.72 as=1.4703 ps=10.72 w=5.07 l=1
X77 v3_four_channel_bias_reference_distribution_0/v3_four_channel_phase_distribution_0/v3_four_channel_output_collection_0/v3_four_channel_placement_0/v3_channel_selector_late_promotion_0/v3_channel_input_bias_late_promotion_0/a_6070_15422# v3_vcm_support_block_0/ref v3_four_channel_bias_reference_distribution_0/v3_four_channel_phase_distribution_0/v3_four_channel_output_collection_0/v3_four_channel_placement_0/v3_channel_selector_late_promotion_0/v3_channel_input_bias_late_promotion_0/a_5774_13688# VSUBS sky130_fd_pr__nfet_01v8 ad=0.2436 pd=2.26 as=0.2436 ps=2.26 w=0.84 l=0.6
X78 v3_four_channel_bias_reference_distribution_0/v3_four_channel_phase_distribution_0/v3_four_channel_output_collection_0/combined_p_internal v3_four_channel_bias_reference_distribution_0/v3_four_channel_phase_distribution_0/v3_four_channel_output_collection_0/v3_four_channel_placement_0/v3_channel_selector_late_promotion_0/v3_selector_route_pilot_0/group2_lo_n v3_four_channel_bias_reference_distribution_0/v3_four_channel_phase_distribution_0/v3_four_channel_output_collection_0/v3_four_channel_placement_0/v3_channel_selector_late_promotion_0/v3_channel_input_bias_late_promotion_0/a_4254_10978# VSUBS sky130_fd_pr__nfet_01v8 ad=0.1885 pd=1.88 as=0.1885 ps=1.88 w=0.65 l=0.15
X79 v3_four_channel_bias_reference_distribution_0/v3_four_channel_phase_distribution_0/v3_four_channel_output_collection_0/v3_four_channel_placement_0/v3_channel_selector_late_promotion_0/v3_channel_input_bias_late_promotion_0/a_6070_15422# v3_four_channel_bias_reference_distribution_0/v3_four_channel_phase_distribution_0/v3_four_channel_output_collection_0/v3_four_channel_placement_0/v3_channel_selector_late_promotion_0/v3_selector_route_pilot_0/group0_lo_p v3_four_channel_bias_reference_distribution_0/v3_four_channel_phase_distribution_0/v3_four_channel_output_collection_0/combined_n_internal VSUBS sky130_fd_pr__nfet_01v8 ad=0.1885 pd=1.88 as=0.1885 ps=1.88 w=0.65 l=0.15
X80 v3_four_channel_bias_reference_distribution_0/v3_four_channel_phase_distribution_0/v3_four_channel_output_collection_0/v3_four_channel_placement_0/v3_channel_selector_late_promotion_0/v3_channel_input_bias_late_promotion_0/a_5824_6978# v3_vcm_support_block_0/ref v3_four_channel_bias_reference_distribution_0/v3_four_channel_phase_distribution_0/v3_four_channel_output_collection_0/v3_four_channel_placement_0/v3_channel_selector_late_promotion_0/v3_channel_input_bias_late_promotion_0/a_5646_6978# VSUBS sky130_fd_pr__nfet_01v8 ad=0.2436 pd=2.26 as=0.2436 ps=2.26 w=0.84 l=0.6
X81 v3_four_channel_bias_reference_distribution_0/v3_four_channel_phase_distribution_0/v3_four_channel_output_collection_0/v3_four_channel_placement_0/v3_channel_selector_late_promotion_0/v3_channel_input_bias_late_promotion_0/a_5774_17688# v3_four_channel_bias_reference_distribution_0/v3_four_channel_phase_distribution_0/v3_four_channel_output_collection_0/v3_four_channel_placement_0/v3_channel_selector_late_promotion_0/element_input v3_four_channel_bias_reference_distribution_0/v3_four_channel_phase_distribution_0/v3_four_channel_output_collection_0/v3_four_channel_placement_0/v3_channel_selector_late_promotion_0/v3_channel_input_bias_late_promotion_0/a_5646_18978# VSUBS sky130_fd_pr__nfet_01v8 ad=0.2436 pd=2.26 as=0.2436 ps=2.26 w=0.84 l=0.6
X82 v3_four_channel_bias_reference_distribution_0/v3_four_channel_phase_distribution_0/v3_four_channel_output_collection_0/combined_p_internal v3_four_channel_bias_reference_distribution_0/v3_four_channel_phase_distribution_0/v3_four_channel_output_collection_0/v3_four_channel_placement_0/v3_channel_selector_late_promotion_0/v3_selector_route_pilot_0/group3_lo_p v3_four_channel_bias_reference_distribution_0/v3_four_channel_phase_distribution_0/v3_four_channel_output_collection_0/v3_four_channel_placement_0/v3_channel_selector_late_promotion_0/v3_channel_input_bias_late_promotion_0/a_5646_22978# VSUBS sky130_fd_pr__nfet_01v8 ad=0.1885 pd=1.88 as=0.1885 ps=1.88 w=0.65 l=0.15
X83 v3_four_channel_bias_reference_distribution_0/v3_four_channel_phase_distribution_0/v3_four_channel_output_collection_0/v3_four_channel_placement_0/v3_channel_selector_late_promotion_0/v3_channel_input_bias_late_promotion_0/a_5824_6978# v3_tail_bias_support_block_0/vbias VSUBS VSUBS sky130_fd_pr__nfet_01v8 ad=1.4703 pd=10.72 as=1.4703 ps=10.72 w=5.07 l=1
X84 v3_four_channel_bias_reference_distribution_0/v3_four_channel_phase_distribution_0/v3_four_channel_output_collection_0/v3_four_channel_placement_0/v3_channel_selector_late_promotion_0/v3_channel_input_bias_late_promotion_0/a_4432_10978# v3_vcm_support_block_0/ref v3_four_channel_bias_reference_distribution_0/v3_four_channel_phase_distribution_0/v3_four_channel_output_collection_0/v3_four_channel_placement_0/v3_channel_selector_late_promotion_0/v3_channel_input_bias_late_promotion_0/a_4254_10978# VSUBS sky130_fd_pr__nfet_01v8 ad=0.2436 pd=2.26 as=0.2436 ps=2.26 w=0.84 l=0.6
X85 v3_four_channel_bias_reference_distribution_0/v3_four_channel_phase_distribution_0/v3_four_channel_output_collection_0/v3_four_channel_placement_0/v3_channel_selector_late_promotion_0/v3_channel_input_bias_late_promotion_0/a_4678_11422# v3_four_channel_bias_reference_distribution_0/v3_four_channel_phase_distribution_0/v3_four_channel_output_collection_0/v3_four_channel_placement_0/v3_channel_selector_late_promotion_0/v3_selector_route_pilot_0/group2_lo_p v3_four_channel_bias_reference_distribution_0/v3_four_channel_phase_distribution_0/v3_four_channel_output_collection_0/combined_p_internal VSUBS sky130_fd_pr__nfet_01v8 ad=0.1885 pd=1.88 as=0.1885 ps=1.88 w=0.65 l=0.15
X86 v3_four_channel_bias_reference_distribution_0/v3_four_channel_phase_distribution_0/v3_four_channel_output_collection_0/v3_four_channel_placement_0/v3_channel_selector_late_promotion_0/v3_channel_input_bias_late_promotion_0/a_6070_23422# v3_four_channel_bias_reference_distribution_0/v3_four_channel_phase_distribution_0/v3_four_channel_output_collection_0/v3_four_channel_placement_0/v3_channel_selector_late_promotion_0/v3_selector_route_pilot_0/group3_lo_n v3_four_channel_bias_reference_distribution_0/v3_four_channel_phase_distribution_0/v3_four_channel_output_collection_0/combined_p_internal VSUBS sky130_fd_pr__nfet_01v8 ad=0.1885 pd=1.88 as=0.1885 ps=1.88 w=0.65 l=0.15
X87 v3_four_channel_bias_reference_distribution_0/v3_four_channel_phase_distribution_0/v3_four_channel_output_collection_0/combined_n_internal v3_four_channel_bias_reference_distribution_0/v3_four_channel_phase_distribution_0/v3_four_channel_output_collection_0/v3_four_channel_placement_0/v3_channel_selector_late_promotion_0/v3_selector_route_pilot_0/group1_lo_n v3_four_channel_bias_reference_distribution_0/v3_four_channel_phase_distribution_0/v3_four_channel_output_collection_0/v3_four_channel_placement_0/v3_channel_selector_late_promotion_0/v3_channel_input_bias_late_promotion_0/a_4254_14978# VSUBS sky130_fd_pr__nfet_01v8 ad=0.1885 pd=1.88 as=0.1885 ps=1.88 w=0.65 l=0.15
X88 v3_four_channel_bias_reference_distribution_0/v3_four_channel_phase_distribution_0/v3_four_channel_output_collection_0/combined_p_internal v3_four_channel_bias_reference_distribution_0/v3_four_channel_phase_distribution_0/v3_four_channel_output_collection_0/v3_four_channel_placement_0/v3_channel_selector_late_promotion_0/v3_selector_route_pilot_0/group2_lo_n v3_four_channel_bias_reference_distribution_0/v3_four_channel_phase_distribution_0/v3_four_channel_output_collection_0/v3_four_channel_placement_0/v3_channel_selector_late_promotion_0/v3_channel_input_bias_late_promotion_0/a_7038_10978# VSUBS sky130_fd_pr__nfet_01v8 ad=0.1885 pd=1.88 as=0.1885 ps=1.88 w=0.65 l=0.15
X89 v3_four_channel_bias_reference_distribution_0/v3_four_channel_phase_distribution_0/v3_four_channel_output_collection_0/v3_four_channel_placement_0/v3_channel_selector_late_promotion_0/v3_channel_input_bias_late_promotion_0/a_7462_15422# v3_four_channel_bias_reference_distribution_0/v3_four_channel_phase_distribution_0/v3_four_channel_output_collection_0/v3_four_channel_placement_0/v3_channel_selector_late_promotion_0/v3_selector_route_pilot_0/group1_lo_p v3_four_channel_bias_reference_distribution_0/v3_four_channel_phase_distribution_0/v3_four_channel_output_collection_0/combined_p_internal VSUBS sky130_fd_pr__nfet_01v8 ad=0.1885 pd=1.88 as=0.1885 ps=1.88 w=0.65 l=0.15
X90 VSUBS VSUBS VSUBS VSUBS sky130_fd_pr__nfet_01v8 ad=1.4703 pd=10.72 as=0 ps=0 w=5.07 l=1
X91 v3_four_channel_bias_reference_distribution_0/v3_four_channel_phase_distribution_0/v3_four_channel_output_collection_0/v3_four_channel_placement_0/v3_channel_selector_late_promotion_0/v3_channel_input_bias_late_promotion_0/a_7216_6978# v3_tail_bias_support_block_0/vbias VSUBS VSUBS sky130_fd_pr__nfet_01v8 ad=1.4703 pd=10.72 as=1.4703 ps=10.72 w=5.07 l=1
X92 v3_four_channel_bias_reference_distribution_0/v3_four_channel_phase_distribution_0/v3_four_channel_output_collection_0/v3_four_channel_placement_0/v3_channel_selector_late_promotion_0/v3_channel_input_bias_late_promotion_0/a_7216_10978# v3_vcm_support_block_0/ref v3_four_channel_bias_reference_distribution_0/v3_four_channel_phase_distribution_0/v3_four_channel_output_collection_0/v3_four_channel_placement_0/v3_channel_selector_late_promotion_0/v3_channel_input_bias_late_promotion_0/a_7038_10978# VSUBS sky130_fd_pr__nfet_01v8 ad=0.2436 pd=2.26 as=0.2436 ps=2.26 w=0.84 l=0.6
X93 v3_four_channel_bias_reference_distribution_0/v3_four_channel_phase_distribution_0/v3_four_channel_output_collection_0/v3_four_channel_placement_0/v3_channel_selector_late_promotion_0/v3_channel_input_bias_late_promotion_0/a_4678_15422# v3_vcm_support_block_0/ref v3_four_channel_bias_reference_distribution_0/v3_four_channel_phase_distribution_0/v3_four_channel_output_collection_0/v3_four_channel_placement_0/v3_channel_selector_late_promotion_0/v3_channel_input_bias_late_promotion_0/a_4382_13688# VSUBS sky130_fd_pr__nfet_01v8 ad=0.2436 pd=2.26 as=0.2436 ps=2.26 w=0.84 l=0.6
X94 v3_four_channel_bias_reference_distribution_0/v3_four_channel_phase_distribution_0/v3_four_channel_output_collection_0/v3_four_channel_placement_0/v3_channel_selector_late_promotion_0/v3_channel_input_bias_late_promotion_0/a_4678_15422# v3_four_channel_bias_reference_distribution_0/v3_four_channel_phase_distribution_0/v3_four_channel_output_collection_0/v3_four_channel_placement_0/v3_channel_selector_late_promotion_0/v3_selector_route_pilot_0/group1_lo_p v3_four_channel_bias_reference_distribution_0/v3_four_channel_phase_distribution_0/v3_four_channel_output_collection_0/combined_n_internal VSUBS sky130_fd_pr__nfet_01v8 ad=0.1885 pd=1.88 as=0.1885 ps=1.88 w=0.65 l=0.15
X95 v3_four_channel_bias_reference_distribution_0/v3_four_channel_phase_distribution_0/v3_four_channel_output_collection_0/combined_p_internal v3_four_channel_bias_reference_distribution_0/v3_four_channel_phase_distribution_0/v3_four_channel_output_collection_0/v3_four_channel_placement_0/v3_channel_selector_late_promotion_0/v3_selector_route_pilot_0/group3_lo_p v3_four_channel_bias_reference_distribution_0/v3_four_channel_phase_distribution_0/v3_four_channel_output_collection_0/v3_four_channel_placement_0/v3_channel_selector_late_promotion_0/v3_channel_input_bias_late_promotion_0/a_4254_22978# VSUBS sky130_fd_pr__nfet_01v8 ad=0.1885 pd=1.88 as=0.1885 ps=1.88 w=0.65 l=0.15
X96 v3_four_channel_bias_reference_distribution_0/v3_four_channel_phase_distribution_0/v3_four_channel_output_collection_0/v3_four_channel_placement_0/v3_channel_selector_late_promotion_0/v3_channel_input_bias_late_promotion_0/a_7462_19422# v3_vcm_support_block_0/ref v3_four_channel_bias_reference_distribution_0/v3_four_channel_phase_distribution_0/v3_four_channel_output_collection_0/v3_four_channel_placement_0/v3_channel_selector_late_promotion_0/v3_channel_input_bias_late_promotion_0/a_7166_17688# VSUBS sky130_fd_pr__nfet_01v8 ad=0.2436 pd=2.26 as=0.2436 ps=2.26 w=0.84 l=0.6
X97 v3_four_channel_bias_reference_distribution_0/v3_four_channel_phase_distribution_0/v3_four_channel_output_collection_0/combined_n_internal v3_four_channel_bias_reference_distribution_0/v3_four_channel_phase_distribution_0/v3_four_channel_output_collection_0/v3_four_channel_placement_0/v3_channel_selector_late_promotion_0/v3_selector_route_pilot_0/group3_lo_p v3_four_channel_bias_reference_distribution_0/v3_four_channel_phase_distribution_0/v3_four_channel_output_collection_0/v3_four_channel_placement_0/v3_channel_selector_late_promotion_0/v3_channel_input_bias_late_promotion_0/a_5646_10978# VSUBS sky130_fd_pr__nfet_01v8 ad=0.1885 pd=1.88 as=0.1885 ps=1.88 w=0.65 l=0.15
X98 v3_four_channel_bias_reference_distribution_0/v3_four_channel_phase_distribution_0/v3_four_channel_output_collection_0/combined_n_internal v3_four_channel_bias_reference_distribution_0/v3_four_channel_phase_distribution_0/v3_four_channel_output_collection_0/v3_four_channel_placement_0/v3_channel_selector_late_promotion_0/v3_selector_route_pilot_0/group1_lo_p v3_four_channel_bias_reference_distribution_0/v3_four_channel_phase_distribution_0/v3_four_channel_output_collection_0/v3_four_channel_placement_0/v3_channel_selector_late_promotion_0/v3_channel_input_bias_late_promotion_0/a_7038_14978# VSUBS sky130_fd_pr__nfet_01v8 ad=0.1885 pd=1.88 as=0.1885 ps=1.88 w=0.65 l=0.15
X99 v3_four_channel_bias_reference_distribution_0/v3_four_channel_phase_distribution_0/v3_four_channel_output_collection_0/v3_four_channel_placement_0/v3_channel_selector_late_promotion_0/v3_channel_input_bias_late_promotion_0/a_7462_19422# v3_four_channel_bias_reference_distribution_0/v3_four_channel_phase_distribution_0/v3_four_channel_output_collection_0/v3_four_channel_placement_0/v3_channel_selector_late_promotion_0/v3_selector_route_pilot_0/group2_lo_p v3_four_channel_bias_reference_distribution_0/v3_four_channel_phase_distribution_0/v3_four_channel_output_collection_0/combined_n_internal VSUBS sky130_fd_pr__nfet_01v8 ad=0.1885 pd=1.88 as=0.1885 ps=1.88 w=0.65 l=0.15
X100 v3_four_channel_bias_reference_distribution_0/v3_four_channel_phase_distribution_0/v3_four_channel_output_collection_0/v3_four_channel_placement_0/v3_channel_selector_late_promotion_0/v3_channel_input_bias_late_promotion_0/a_4678_7422# v3_four_channel_bias_reference_distribution_0/v3_four_channel_phase_distribution_0/v3_four_channel_output_collection_0/v3_four_channel_placement_0/v3_channel_selector_late_promotion_0/element_input v3_four_channel_bias_reference_distribution_0/v3_four_channel_phase_distribution_0/v3_four_channel_output_collection_0/v3_four_channel_placement_0/v3_channel_selector_late_promotion_0/v3_channel_input_bias_late_promotion_0/a_4432_6978# VSUBS sky130_fd_pr__nfet_01v8 ad=0.2436 pd=2.26 as=0.2436 ps=2.26 w=0.84 l=0.6
X101 v3_four_channel_bias_reference_distribution_0/v3_four_channel_phase_distribution_0/v3_four_channel_output_collection_0/combined_p_internal v3_four_channel_bias_reference_distribution_0/v3_four_channel_phase_distribution_0/v3_four_channel_output_collection_0/v3_four_channel_placement_0/v3_channel_selector_late_promotion_0/v3_selector_route_pilot_0/group3_lo_n v3_four_channel_bias_reference_distribution_0/v3_four_channel_phase_distribution_0/v3_four_channel_output_collection_0/v3_four_channel_placement_0/v3_channel_selector_late_promotion_0/v3_channel_input_bias_late_promotion_0/a_5646_6978# VSUBS sky130_fd_pr__nfet_01v8 ad=0.1885 pd=1.88 as=0.1885 ps=1.88 w=0.65 l=0.15
X102 v3_four_channel_bias_reference_distribution_0/v3_four_channel_phase_distribution_0/v3_four_channel_output_collection_0/v3_four_channel_placement_0/v3_channel_selector_late_promotion_0/v3_channel_input_bias_late_promotion_0/a_4678_7422# v3_four_channel_bias_reference_distribution_0/v3_four_channel_phase_distribution_0/v3_four_channel_output_collection_0/v3_four_channel_placement_0/v3_channel_selector_late_promotion_0/v3_selector_route_pilot_0/group3_lo_n v3_four_channel_bias_reference_distribution_0/v3_four_channel_phase_distribution_0/v3_four_channel_output_collection_0/combined_n_internal VSUBS sky130_fd_pr__nfet_01v8 ad=0.1885 pd=1.88 as=0.1885 ps=1.88 w=0.65 l=0.15
X103 v3_four_channel_bias_reference_distribution_0/v3_four_channel_phase_distribution_0/v3_four_channel_output_collection_0/v3_four_channel_placement_0/v3_channel_selector_late_promotion_0/v3_channel_input_bias_late_promotion_0/a_6070_11422# v3_four_channel_bias_reference_distribution_0/v3_four_channel_phase_distribution_0/v3_four_channel_output_collection_0/v3_four_channel_placement_0/v3_channel_selector_late_promotion_0/element_input v3_four_channel_bias_reference_distribution_0/v3_four_channel_phase_distribution_0/v3_four_channel_output_collection_0/v3_four_channel_placement_0/v3_channel_selector_late_promotion_0/v3_channel_input_bias_late_promotion_0/a_5824_10978# VSUBS sky130_fd_pr__nfet_01v8 ad=0.2436 pd=2.26 as=0.2436 ps=2.26 w=0.84 l=0.6
X104 v3_four_channel_bias_reference_distribution_0/v3_four_channel_phase_distribution_0/v3_four_channel_output_collection_0/v3_four_channel_placement_0/v3_channel_selector_late_promotion_0/v3_channel_input_bias_late_promotion_0/a_6070_11422# v3_four_channel_bias_reference_distribution_0/v3_four_channel_phase_distribution_0/v3_four_channel_output_collection_0/v3_four_channel_placement_0/v3_channel_selector_late_promotion_0/v3_selector_route_pilot_0/group3_lo_n v3_four_channel_bias_reference_distribution_0/v3_four_channel_phase_distribution_0/v3_four_channel_output_collection_0/combined_n_internal VSUBS sky130_fd_pr__nfet_01v8 ad=0.1885 pd=1.88 as=0.1885 ps=1.88 w=0.65 l=0.15
X105 v3_four_channel_bias_reference_distribution_0/v3_four_channel_phase_distribution_0/v3_four_channel_output_collection_0/v3_four_channel_placement_0/v3_channel_selector_late_promotion_0/v3_channel_input_bias_late_promotion_0/a_4382_21688# v3_four_channel_bias_reference_distribution_0/v3_four_channel_phase_distribution_0/v3_four_channel_output_collection_0/v3_four_channel_placement_0/v3_channel_selector_late_promotion_0/element_input v3_four_channel_bias_reference_distribution_0/v3_four_channel_phase_distribution_0/v3_four_channel_output_collection_0/v3_four_channel_placement_0/v3_channel_selector_late_promotion_0/v3_channel_input_bias_late_promotion_0/a_4254_22978# VSUBS sky130_fd_pr__nfet_01v8 ad=0.2436 pd=2.26 as=0.2436 ps=2.26 w=0.84 l=0.6
X106 v3_four_channel_bias_reference_distribution_0/v3_four_channel_phase_distribution_0/v3_four_channel_output_collection_0/v3_four_channel_placement_0/v3_channel_selector_late_promotion_0/v3_channel_input_bias_late_promotion_0/a_4678_23422# v3_four_channel_bias_reference_distribution_0/v3_four_channel_phase_distribution_0/v3_four_channel_output_collection_0/v3_four_channel_placement_0/v3_channel_selector_late_promotion_0/v3_selector_route_pilot_0/group3_lo_n v3_four_channel_bias_reference_distribution_0/v3_four_channel_phase_distribution_0/v3_four_channel_output_collection_0/combined_p_internal VSUBS sky130_fd_pr__nfet_01v8 ad=0.1885 pd=1.88 as=0.1885 ps=1.88 w=0.65 l=0.15
X107 v3_four_channel_bias_reference_distribution_0/v3_four_channel_phase_distribution_0/v3_four_channel_output_collection_0/combined_p_internal v3_four_channel_bias_reference_distribution_0/v3_four_channel_phase_distribution_0/v3_four_channel_output_collection_0/v3_four_channel_placement_0/v3_channel_selector_late_promotion_0/v3_selector_route_pilot_0/group3_lo_n v3_four_channel_bias_reference_distribution_0/v3_four_channel_phase_distribution_0/v3_four_channel_output_collection_0/v3_four_channel_placement_0/v3_channel_selector_late_promotion_0/v3_channel_input_bias_late_promotion_0/a_4254_6978# VSUBS sky130_fd_pr__nfet_01v8 ad=0.1885 pd=1.88 as=0.1885 ps=1.88 w=0.65 l=0.15
X108 v3_four_channel_bias_reference_distribution_0/v3_four_channel_phase_distribution_0/v3_four_channel_output_collection_0/v3_four_channel_placement_0/v3_channel_selector_late_promotion_0/v3_channel_input_bias_late_promotion_0/a_5774_13688# v3_four_channel_bias_reference_distribution_0/v3_four_channel_phase_distribution_0/v3_four_channel_output_collection_0/v3_four_channel_placement_0/v3_channel_selector_late_promotion_0/element_input v3_four_channel_bias_reference_distribution_0/v3_four_channel_phase_distribution_0/v3_four_channel_output_collection_0/v3_four_channel_placement_0/v3_channel_selector_late_promotion_0/v3_channel_input_bias_late_promotion_0/a_5646_14978# VSUBS sky130_fd_pr__nfet_01v8 ad=0.2436 pd=2.26 as=0.2436 ps=2.26 w=0.84 l=0.6
X109 v3_four_channel_bias_reference_distribution_0/v3_four_channel_phase_distribution_0/v3_four_channel_output_collection_0/combined_p_internal v3_four_channel_bias_reference_distribution_0/v3_four_channel_phase_distribution_0/v3_four_channel_output_collection_0/v3_four_channel_placement_0/v3_channel_selector_late_promotion_0/v3_selector_route_pilot_0/group3_lo_p v3_four_channel_bias_reference_distribution_0/v3_four_channel_phase_distribution_0/v3_four_channel_output_collection_0/v3_four_channel_placement_0/v3_channel_selector_late_promotion_0/v3_channel_input_bias_late_promotion_0/a_7038_22978# VSUBS sky130_fd_pr__nfet_01v8 ad=0.1885 pd=1.88 as=0.1885 ps=1.88 w=0.65 l=0.15
X110 v3_four_channel_bias_reference_distribution_0/v3_four_channel_phase_distribution_0/v3_four_channel_output_collection_0/v3_four_channel_placement_0/v3_channel_selector_late_promotion_0/v3_channel_input_bias_late_promotion_0/a_7462_7422# v3_four_channel_bias_reference_distribution_0/v3_four_channel_phase_distribution_0/v3_four_channel_output_collection_0/v3_four_channel_placement_0/v3_channel_selector_late_promotion_0/element_input v3_four_channel_bias_reference_distribution_0/v3_four_channel_phase_distribution_0/v3_four_channel_output_collection_0/v3_four_channel_placement_0/v3_channel_selector_late_promotion_0/v3_channel_input_bias_late_promotion_0/a_7216_6978# VSUBS sky130_fd_pr__nfet_01v8 ad=0.2436 pd=2.26 as=0.2436 ps=2.26 w=0.84 l=0.6
X111 v3_four_channel_bias_reference_distribution_0/v3_four_channel_phase_distribution_0/v3_four_channel_output_collection_0/v3_four_channel_placement_0/v3_channel_selector_late_promotion_0/v3_channel_input_bias_late_promotion_0/a_4432_10978# v3_tail_bias_support_block_0/vbias VSUBS VSUBS sky130_fd_pr__nfet_01v8 ad=1.4703 pd=10.72 as=1.4703 ps=10.72 w=5.07 l=1
X112 v3_four_channel_bias_reference_distribution_0/v3_four_channel_phase_distribution_0/v3_four_channel_output_collection_0/v3_four_channel_placement_0/v3_channel_selector_late_promotion_0/v3_channel_input_bias_late_promotion_0/a_7462_7422# v3_four_channel_bias_reference_distribution_0/v3_four_channel_phase_distribution_0/v3_four_channel_output_collection_0/v3_four_channel_placement_0/v3_channel_selector_late_promotion_0/v3_selector_route_pilot_0/group3_lo_n v3_four_channel_bias_reference_distribution_0/v3_four_channel_phase_distribution_0/v3_four_channel_output_collection_0/combined_n_internal VSUBS sky130_fd_pr__nfet_01v8 ad=0.1885 pd=1.88 as=0.1885 ps=1.88 w=0.65 l=0.15
X113 VSUBS v3_tail_bias_support_block_0/vbias v3_four_channel_bias_reference_distribution_0/v3_four_channel_phase_distribution_0/v3_four_channel_output_collection_0/v3_four_channel_placement_0/v3_channel_selector_late_promotion_0/v3_channel_input_bias_late_promotion_0/a_4382_17688# VSUBS sky130_fd_pr__nfet_01v8 ad=1.4703 pd=10.72 as=1.4703 ps=10.72 w=5.07 l=1
X114 v3_four_channel_bias_reference_distribution_0/v3_four_channel_phase_distribution_0/v3_four_channel_output_collection_0/combined_p_internal v3_four_channel_bias_reference_distribution_0/v3_four_channel_phase_distribution_0/v3_four_channel_output_collection_0/v3_four_channel_placement_0/v3_channel_selector_late_promotion_0/v3_selector_route_pilot_0/group3_lo_n v3_four_channel_bias_reference_distribution_0/v3_four_channel_phase_distribution_0/v3_four_channel_output_collection_0/v3_four_channel_placement_0/v3_channel_selector_late_promotion_0/v3_channel_input_bias_late_promotion_0/a_7038_6978# VSUBS sky130_fd_pr__nfet_01v8 ad=0.1885 pd=1.88 as=0.1885 ps=1.88 w=0.65 l=0.15
X115 v3_four_channel_bias_reference_distribution_0/v3_four_channel_phase_distribution_0/v3_four_channel_output_collection_0/combined_n_internal v3_four_channel_bias_reference_distribution_0/v3_four_channel_phase_distribution_0/v3_four_channel_output_collection_0/v3_four_channel_placement_0/v3_channel_selector_late_promotion_0/v3_selector_route_pilot_0/group2_lo_p v3_four_channel_bias_reference_distribution_0/v3_four_channel_phase_distribution_0/v3_four_channel_output_collection_0/v3_four_channel_placement_0/v3_channel_selector_late_promotion_0/v3_channel_input_bias_late_promotion_0/a_4254_10978# VSUBS sky130_fd_pr__nfet_01v8 ad=0.1885 pd=1.88 as=0.1885 ps=1.88 w=0.65 l=0.15
X116 v3_four_channel_bias_reference_distribution_0/v3_four_channel_phase_distribution_0/v3_four_channel_output_collection_0/v3_four_channel_placement_0/v3_channel_selector_late_promotion_0/v3_channel_input_bias_late_promotion_0/a_7462_11422# v3_four_channel_bias_reference_distribution_0/v3_four_channel_phase_distribution_0/v3_four_channel_output_collection_0/v3_four_channel_placement_0/v3_channel_selector_late_promotion_0/v3_selector_route_pilot_0/group2_lo_p v3_four_channel_bias_reference_distribution_0/v3_four_channel_phase_distribution_0/v3_four_channel_output_collection_0/combined_p_internal VSUBS sky130_fd_pr__nfet_01v8 ad=0.1885 pd=1.88 as=0.1885 ps=1.88 w=0.65 l=0.15
X117 v3_four_channel_bias_reference_distribution_0/v3_four_channel_phase_distribution_0/v3_four_channel_output_collection_0/v3_four_channel_placement_0/v3_channel_selector_late_promotion_0/v3_channel_input_bias_late_promotion_0/a_7166_21688# v3_four_channel_bias_reference_distribution_0/v3_four_channel_phase_distribution_0/v3_four_channel_output_collection_0/v3_four_channel_placement_0/v3_channel_selector_late_promotion_0/element_input v3_four_channel_bias_reference_distribution_0/v3_four_channel_phase_distribution_0/v3_four_channel_output_collection_0/v3_four_channel_placement_0/v3_channel_selector_late_promotion_0/v3_channel_input_bias_late_promotion_0/a_7038_22978# VSUBS sky130_fd_pr__nfet_01v8 ad=0.2436 pd=2.26 as=0.2436 ps=2.26 w=0.84 l=0.6
X118 v3_four_channel_bias_reference_distribution_0/v3_four_channel_phase_distribution_0/v3_four_channel_output_collection_0/combined_n_internal v3_four_channel_bias_reference_distribution_0/v3_four_channel_phase_distribution_0/v3_four_channel_output_collection_0/v3_four_channel_placement_0/v3_channel_selector_late_promotion_0/v3_selector_route_pilot_0/group3_lo_n v3_four_channel_bias_reference_distribution_0/v3_four_channel_phase_distribution_0/v3_four_channel_output_collection_0/v3_four_channel_placement_0/v3_channel_selector_late_promotion_0/v3_channel_input_bias_late_promotion_0/a_5646_22978# VSUBS sky130_fd_pr__nfet_01v8 ad=0.1885 pd=1.88 as=0.1885 ps=1.88 w=0.65 l=0.15
X119 v3_four_channel_bias_reference_distribution_0/v3_four_channel_phase_distribution_0/v3_four_channel_output_collection_0/v3_four_channel_placement_0/v3_channel_selector_late_promotion_0/v3_channel_input_bias_late_promotion_0/a_4678_11422# v3_four_channel_bias_reference_distribution_0/v3_four_channel_phase_distribution_0/v3_four_channel_output_collection_0/v3_four_channel_placement_0/v3_channel_selector_late_promotion_0/element_input v3_four_channel_bias_reference_distribution_0/v3_four_channel_phase_distribution_0/v3_four_channel_output_collection_0/v3_four_channel_placement_0/v3_channel_selector_late_promotion_0/v3_channel_input_bias_late_promotion_0/a_4432_10978# VSUBS sky130_fd_pr__nfet_01v8 ad=0.2436 pd=2.26 as=0.2436 ps=2.26 w=0.84 l=0.6
X120 v3_four_channel_bias_reference_distribution_0/v3_four_channel_phase_distribution_0/v3_four_channel_output_collection_0/v3_four_channel_placement_0/v3_channel_selector_late_promotion_0/v3_channel_input_bias_late_promotion_0/a_6070_23422# v3_vcm_support_block_0/ref v3_four_channel_bias_reference_distribution_0/v3_four_channel_phase_distribution_0/v3_four_channel_output_collection_0/v3_four_channel_placement_0/v3_channel_selector_late_promotion_0/v3_channel_input_bias_late_promotion_0/a_5774_21688# VSUBS sky130_fd_pr__nfet_01v8 ad=0.2436 pd=2.26 as=0.2436 ps=2.26 w=0.84 l=0.6
X121 v3_four_channel_bias_reference_distribution_0/v3_four_channel_phase_distribution_0/v3_four_channel_output_collection_0/v3_four_channel_placement_0/v3_channel_selector_late_promotion_0/v3_channel_input_bias_late_promotion_0/a_6070_23422# v3_four_channel_bias_reference_distribution_0/v3_four_channel_phase_distribution_0/v3_four_channel_output_collection_0/v3_four_channel_placement_0/v3_channel_selector_late_promotion_0/v3_selector_route_pilot_0/group3_lo_p v3_four_channel_bias_reference_distribution_0/v3_four_channel_phase_distribution_0/v3_four_channel_output_collection_0/combined_n_internal VSUBS sky130_fd_pr__nfet_01v8 ad=0.1885 pd=1.88 as=0.1885 ps=1.88 w=0.65 l=0.15
X122 v3_four_channel_bias_reference_distribution_0/v3_four_channel_phase_distribution_0/v3_four_channel_output_collection_0/v3_four_channel_placement_0/v3_channel_selector_late_promotion_0/v3_channel_input_bias_late_promotion_0/a_4678_11422# v3_four_channel_bias_reference_distribution_0/v3_four_channel_phase_distribution_0/v3_four_channel_output_collection_0/v3_four_channel_placement_0/v3_channel_selector_late_promotion_0/v3_selector_route_pilot_0/group2_lo_n v3_four_channel_bias_reference_distribution_0/v3_four_channel_phase_distribution_0/v3_four_channel_output_collection_0/combined_n_internal VSUBS sky130_fd_pr__nfet_01v8 ad=0.1885 pd=1.88 as=0.1885 ps=1.88 w=0.65 l=0.15
X123 v3_four_channel_bias_reference_distribution_0/v3_four_channel_phase_distribution_0/v3_four_channel_output_collection_0/v3_four_channel_placement_0/v3_channel_selector_late_promotion_0/v3_channel_input_bias_late_promotion_0/a_7462_15422# v3_four_channel_bias_reference_distribution_0/v3_four_channel_phase_distribution_0/v3_four_channel_output_collection_0/v3_four_channel_placement_0/v3_channel_selector_late_promotion_0/element_input v3_four_channel_bias_reference_distribution_0/v3_four_channel_phase_distribution_0/v3_four_channel_output_collection_0/v3_four_channel_placement_0/v3_channel_selector_late_promotion_0/v3_channel_input_bias_late_promotion_0/a_7216_14978# VSUBS sky130_fd_pr__nfet_01v8 ad=0.2436 pd=2.26 as=0.2436 ps=2.26 w=0.84 l=0.6
X124 v3_four_channel_bias_reference_distribution_0/v3_four_channel_phase_distribution_0/v3_four_channel_output_collection_0/v3_four_channel_placement_0/v3_channel_selector_late_promotion_0/v3_channel_input_bias_late_promotion_0/a_6070_7422# v3_four_channel_bias_reference_distribution_0/v3_four_channel_phase_distribution_0/v3_four_channel_output_collection_0/v3_four_channel_placement_0/v3_channel_selector_late_promotion_0/v3_selector_route_pilot_0/group3_lo_p v3_four_channel_bias_reference_distribution_0/v3_four_channel_phase_distribution_0/v3_four_channel_output_collection_0/combined_p_internal VSUBS sky130_fd_pr__nfet_01v8 ad=0.1885 pd=1.88 as=0.1885 ps=1.88 w=0.65 l=0.15
X125 v3_four_channel_bias_reference_distribution_0/v3_four_channel_phase_distribution_0/v3_four_channel_output_collection_0/combined_n_internal v3_four_channel_bias_reference_distribution_0/v3_four_channel_phase_distribution_0/v3_four_channel_output_collection_0/v3_four_channel_placement_0/v3_channel_selector_late_promotion_0/v3_selector_route_pilot_0/group2_lo_p v3_four_channel_bias_reference_distribution_0/v3_four_channel_phase_distribution_0/v3_four_channel_output_collection_0/v3_four_channel_placement_0/v3_channel_selector_late_promotion_0/v3_channel_input_bias_late_promotion_0/a_7038_10978# VSUBS sky130_fd_pr__nfet_01v8 ad=0.1885 pd=1.88 as=0.1885 ps=1.88 w=0.65 l=0.15
X126 v3_four_channel_bias_reference_distribution_0/v3_four_channel_phase_distribution_0/v3_four_channel_output_collection_0/v3_four_channel_placement_0/v3_channel_selector_late_promotion_0/v3_channel_input_bias_late_promotion_0/a_7462_15422# v3_four_channel_bias_reference_distribution_0/v3_four_channel_phase_distribution_0/v3_four_channel_output_collection_0/v3_four_channel_placement_0/v3_channel_selector_late_promotion_0/v3_selector_route_pilot_0/group1_lo_n v3_four_channel_bias_reference_distribution_0/v3_four_channel_phase_distribution_0/v3_four_channel_output_collection_0/combined_n_internal VSUBS sky130_fd_pr__nfet_01v8 ad=0.1885 pd=1.88 as=0.1885 ps=1.88 w=0.65 l=0.15
X127 v3_four_channel_bias_reference_distribution_0/v3_four_channel_phase_distribution_0/v3_four_channel_output_collection_0/v3_four_channel_placement_0/v3_channel_selector_late_promotion_0/v3_channel_input_bias_late_promotion_0/a_4432_6978# v3_vcm_support_block_0/ref v3_four_channel_bias_reference_distribution_0/v3_four_channel_phase_distribution_0/v3_four_channel_output_collection_0/v3_four_channel_placement_0/v3_channel_selector_late_promotion_0/v3_channel_input_bias_late_promotion_0/a_4254_6978# VSUBS sky130_fd_pr__nfet_01v8 ad=0.2436 pd=2.26 as=0.2436 ps=2.26 w=0.84 l=0.6
X128 v3_four_channel_bias_reference_distribution_0/v3_four_channel_phase_distribution_0/v3_four_channel_output_collection_0/v3_four_channel_placement_0/v3_channel_selector_late_promotion_0/v3_channel_input_bias_late_promotion_0/a_5824_10978# v3_vcm_support_block_0/ref v3_four_channel_bias_reference_distribution_0/v3_four_channel_phase_distribution_0/v3_four_channel_output_collection_0/v3_four_channel_placement_0/v3_channel_selector_late_promotion_0/v3_channel_input_bias_late_promotion_0/a_5646_10978# VSUBS sky130_fd_pr__nfet_01v8 ad=0.2436 pd=2.26 as=0.2436 ps=2.26 w=0.84 l=0.6
X129 v3_four_channel_bias_reference_distribution_0/v3_four_channel_phase_distribution_0/v3_four_channel_output_collection_0/combined_n_internal v3_four_channel_bias_reference_distribution_0/v3_four_channel_phase_distribution_0/v3_four_channel_output_collection_0/v3_four_channel_placement_0/v3_channel_selector_late_promotion_0/v3_selector_route_pilot_0/group3_lo_n v3_four_channel_bias_reference_distribution_0/v3_four_channel_phase_distribution_0/v3_four_channel_output_collection_0/v3_four_channel_placement_0/v3_channel_selector_late_promotion_0/v3_channel_input_bias_late_promotion_0/a_4254_22978# VSUBS sky130_fd_pr__nfet_01v8 ad=0.1885 pd=1.88 as=0.1885 ps=1.88 w=0.65 l=0.15
X130 v3_four_channel_bias_reference_distribution_0/v3_four_channel_phase_distribution_0/v3_four_channel_output_collection_0/v3_four_channel_placement_0/v3_channel_selector_late_promotion_0/v3_channel_input_bias_late_promotion_0/a_7462_23422# v3_four_channel_bias_reference_distribution_0/v3_four_channel_phase_distribution_0/v3_four_channel_output_collection_0/v3_four_channel_placement_0/v3_channel_selector_late_promotion_0/v3_selector_route_pilot_0/group3_lo_n v3_four_channel_bias_reference_distribution_0/v3_four_channel_phase_distribution_0/v3_four_channel_output_collection_0/combined_p_internal VSUBS sky130_fd_pr__nfet_01v8 ad=0.1885 pd=1.88 as=0.1885 ps=1.88 w=0.65 l=0.15
X131 v3_four_channel_bias_reference_distribution_0/v3_four_channel_phase_distribution_0/v3_four_channel_output_collection_0/v3_four_channel_placement_0/v3_channel_selector_late_promotion_0/v3_channel_input_bias_late_promotion_0/a_4432_6978# v3_tail_bias_support_block_0/vbias VSUBS VSUBS sky130_fd_pr__nfet_01v8 ad=1.4703 pd=10.72 as=1.4703 ps=10.72 w=5.07 l=1
X132 v3_four_channel_bias_reference_distribution_0/v3_four_channel_phase_distribution_0/v3_four_channel_output_collection_0/v3_four_channel_placement_0/v3_channel_selector_late_promotion_0/v3_channel_input_bias_late_promotion_0/a_7216_6978# v3_vcm_support_block_0/ref v3_four_channel_bias_reference_distribution_0/v3_four_channel_phase_distribution_0/v3_four_channel_output_collection_0/v3_four_channel_placement_0/v3_channel_selector_late_promotion_0/v3_channel_input_bias_late_promotion_0/a_7038_6978# VSUBS sky130_fd_pr__nfet_01v8 ad=0.2436 pd=2.26 as=0.2436 ps=2.26 w=0.84 l=0.6
X133 v3_four_channel_bias_reference_distribution_0/v3_four_channel_phase_distribution_0/v3_four_channel_output_collection_0/combined_n_internal v3_four_channel_bias_reference_distribution_0/v3_four_channel_phase_distribution_0/v3_four_channel_output_collection_0/v3_four_channel_placement_0/v3_channel_selector_late_promotion_0/v3_selector_route_pilot_0/group3_lo_p v3_four_channel_bias_reference_distribution_0/v3_four_channel_phase_distribution_0/v3_four_channel_output_collection_0/v3_four_channel_placement_0/v3_channel_selector_late_promotion_0/v3_channel_input_bias_late_promotion_0/a_5646_6978# VSUBS sky130_fd_pr__nfet_01v8 ad=0.1885 pd=1.88 as=0.1885 ps=1.88 w=0.65 l=0.15
X134 VSUBS v3_tail_bias_support_block_0/vbias v3_four_channel_bias_reference_distribution_0/v3_four_channel_phase_distribution_0/v3_four_channel_output_collection_0/v3_four_channel_placement_0/v3_channel_selector_late_promotion_0/v3_channel_input_bias_late_promotion_0/a_4382_13688# VSUBS sky130_fd_pr__nfet_01v8 ad=1.4703 pd=10.72 as=1.4703 ps=10.72 w=5.07 l=1
X135 v3_four_channel_bias_reference_distribution_0/v3_four_channel_phase_distribution_0/v3_four_channel_output_collection_0/v3_four_channel_placement_0/v3_channel_selector_late_promotion_0/VPWR v3_four_channel_bias_reference_distribution_0/v3_four_channel_phase_distribution_0/v3_four_channel_output_collection_0/v3_four_channel_placement_0/v3_channel_selector_late_promotion_0/v3_selector_route_pilot_0/G1_MUX_POS/a_505_21# v3_four_channel_bias_reference_distribution_0/v3_four_channel_phase_distribution_0/v3_four_channel_output_collection_0/v3_four_channel_placement_0/v3_channel_selector_late_promotion_0/v3_selector_route_pilot_0/G1_MUX_POS/a_535_374# v3_four_channel_bias_reference_distribution_0/v3_four_channel_phase_distribution_0/v3_four_channel_output_collection_0/v3_four_channel_placement_0/v3_channel_selector_late_promotion_0/VPWR sky130_fd_pr__pfet_01v8_hvt ad=0.0693 pd=0.75 as=0.0441 ps=0.63 w=0.42 l=0.15
X136 v3_four_channel_bias_reference_distribution_0/v3_four_channel_phase_distribution_0/v3_four_channel_output_collection_0/v3_four_channel_placement_0/v3_channel_selector_late_promotion_0/v3_selector_route_pilot_0/G1_MUX_POS/a_505_21# v3_four_channel_bias_reference_distribution_0/v3_four_channel_phase_distribution_0/v3_four_channel_output_collection_0/v3_four_channel_placement_0/v3_channel_selector_late_promotion_0/group1_bit0 v3_four_channel_bias_reference_distribution_0/v3_four_channel_phase_distribution_0/v3_four_channel_output_collection_0/v3_four_channel_placement_0/v3_channel_selector_late_promotion_0/VPWR v3_four_channel_bias_reference_distribution_0/v3_four_channel_phase_distribution_0/v3_four_channel_output_collection_0/v3_four_channel_placement_0/v3_channel_selector_late_promotion_0/VPWR sky130_fd_pr__pfet_01v8_hvt ad=0.1176 pd=1.4 as=0.0693 ps=0.75 w=0.42 l=0.15
X137 v3_four_channel_bias_reference_distribution_0/v3_four_channel_phase_distribution_0/v3_four_channel_output_collection_0/v3_four_channel_placement_0/v3_channel_selector_late_promotion_0/v3_selector_route_pilot_0/G1_MUX_POS/a_218_374# v3_four_channel_bias_reference_distribution_0/v3_four_channel_phase_distribution_0/v3_four_channel_output_collection_0/v3_four_channel_placement_0/v3_channel_selector_late_promotion_0/group1_bit0 v3_four_channel_bias_reference_distribution_0/v3_four_channel_phase_distribution_0/v3_four_channel_output_collection_0/v3_four_channel_placement_0/v3_channel_selector_late_promotion_0/VPWR v3_four_channel_bias_reference_distribution_0/v3_four_channel_phase_distribution_0/v3_four_channel_output_collection_0/v3_four_channel_placement_0/v3_channel_selector_late_promotion_0/VPWR sky130_fd_pr__pfet_01v8_hvt ad=0.07665 pd=0.785 as=0.15835 ps=1.395 w=0.42 l=0.15
X138 VSUBS v3_four_channel_bias_reference_distribution_0/v3_four_channel_phase_distribution_0/v3_four_channel_output_collection_0/v3_four_channel_placement_0/v3_channel_selector_late_promotion_0/v3_selector_route_pilot_0/G1_MUX_POS/a_505_21# v3_four_channel_bias_reference_distribution_0/v3_four_channel_phase_distribution_0/v3_four_channel_output_collection_0/v3_four_channel_placement_0/v3_channel_selector_late_promotion_0/v3_selector_route_pilot_0/G1_MUX_POS/a_439_47# VSUBS sky130_fd_pr__nfet_01v8 ad=0.1449 pd=1.11 as=0.0693 ps=0.75 w=0.42 l=0.15
X139 v3_four_channel_bias_reference_distribution_0/v3_four_channel_phase_distribution_0/v3_four_channel_output_collection_0/v3_four_channel_placement_0/v3_channel_selector_late_promotion_0/v3_selector_route_pilot_0/G1_MUX_POS/a_76_199# v3_four_channel_bias_reference_distribution_0/v3_four_channel_phase_distribution_0/phase_0 v3_four_channel_bias_reference_distribution_0/v3_four_channel_phase_distribution_0/v3_four_channel_output_collection_0/v3_four_channel_placement_0/v3_channel_selector_late_promotion_0/v3_selector_route_pilot_0/G1_MUX_POS/a_218_374# v3_four_channel_bias_reference_distribution_0/v3_four_channel_phase_distribution_0/v3_four_channel_output_collection_0/v3_four_channel_placement_0/v3_channel_selector_late_promotion_0/VPWR sky130_fd_pr__pfet_01v8_hvt ad=0.1932 pd=1.34 as=0.07665 ps=0.785 w=0.42 l=0.15
X140 v3_four_channel_bias_reference_distribution_0/v3_four_channel_phase_distribution_0/v3_four_channel_output_collection_0/v3_four_channel_placement_0/v3_channel_selector_late_promotion_0/v3_selector_route_pilot_0/G1_MUX_POS/a_505_21# v3_four_channel_bias_reference_distribution_0/v3_four_channel_phase_distribution_0/v3_four_channel_output_collection_0/v3_four_channel_placement_0/v3_channel_selector_late_promotion_0/group1_bit0 VSUBS VSUBS sky130_fd_pr__nfet_01v8 ad=0.1092 pd=1.36 as=0.1449 ps=1.11 w=0.42 l=0.15
X141 v3_four_channel_bias_reference_distribution_0/v3_four_channel_phase_distribution_0/v3_four_channel_output_collection_0/v3_four_channel_placement_0/v3_channel_selector_late_promotion_0/v3_selector_route_pilot_0/G1_MUX_POS/a_439_47# v3_four_channel_bias_reference_distribution_0/v3_four_channel_phase_distribution_0/phase_0 v3_four_channel_bias_reference_distribution_0/v3_four_channel_phase_distribution_0/v3_four_channel_output_collection_0/v3_four_channel_placement_0/v3_channel_selector_late_promotion_0/v3_selector_route_pilot_0/G1_MUX_POS/a_76_199# VSUBS sky130_fd_pr__nfet_01v8 ad=0.0693 pd=0.75 as=0.09975 ps=0.895 w=0.42 l=0.15
X142 v3_four_channel_bias_reference_distribution_0/v3_four_channel_phase_distribution_0/v3_four_channel_output_collection_0/v3_four_channel_placement_0/v3_channel_selector_late_promotion_0/v3_selector_route_pilot_0/G1_MUX_POS/a_535_374# v3_four_channel_bias_reference_distribution_0/v3_four_channel_phase_distribution_0/phase_90 v3_four_channel_bias_reference_distribution_0/v3_four_channel_phase_distribution_0/v3_four_channel_output_collection_0/v3_four_channel_placement_0/v3_channel_selector_late_promotion_0/v3_selector_route_pilot_0/G1_MUX_POS/a_76_199# v3_four_channel_bias_reference_distribution_0/v3_four_channel_phase_distribution_0/v3_four_channel_output_collection_0/v3_four_channel_placement_0/v3_channel_selector_late_promotion_0/VPWR sky130_fd_pr__pfet_01v8_hvt ad=0.0441 pd=0.63 as=0.1932 ps=1.34 w=0.42 l=0.15
X143 v3_four_channel_bias_reference_distribution_0/v3_four_channel_phase_distribution_0/v3_four_channel_output_collection_0/v3_four_channel_placement_0/v3_channel_selector_late_promotion_0/v3_selector_route_pilot_0/G1_MUX_POS/a_76_199# v3_four_channel_bias_reference_distribution_0/v3_four_channel_phase_distribution_0/phase_90 v3_four_channel_bias_reference_distribution_0/v3_four_channel_phase_distribution_0/v3_four_channel_output_collection_0/v3_four_channel_placement_0/v3_channel_selector_late_promotion_0/v3_selector_route_pilot_0/G1_MUX_POS/a_218_47# VSUBS sky130_fd_pr__nfet_01v8 ad=0.09975 pd=0.895 as=0.0693 ps=0.75 w=0.42 l=0.15
X144 v3_four_channel_bias_reference_distribution_0/v3_four_channel_phase_distribution_0/v3_four_channel_output_collection_0/v3_four_channel_placement_0/v3_channel_selector_late_promotion_0/v3_selector_route_pilot_0/G1_MUX_POS/a_218_47# v3_four_channel_bias_reference_distribution_0/v3_four_channel_phase_distribution_0/v3_four_channel_output_collection_0/v3_four_channel_placement_0/v3_channel_selector_late_promotion_0/group1_bit0 VSUBS VSUBS sky130_fd_pr__nfet_01v8 ad=0.0693 pd=0.75 as=0.11285 ps=1.045 w=0.42 l=0.15
X145 v3_four_channel_bias_reference_distribution_0/v3_four_channel_phase_distribution_0/v3_four_channel_output_collection_0/v3_four_channel_placement_0/v3_channel_selector_late_promotion_0/VPWR v3_four_channel_bias_reference_distribution_0/v3_four_channel_phase_distribution_0/v3_four_channel_output_collection_0/v3_four_channel_placement_0/v3_channel_selector_late_promotion_0/v3_selector_route_pilot_0/G1_MUX_POS/a_76_199# v3_four_channel_bias_reference_distribution_0/v3_four_channel_phase_distribution_0/v3_four_channel_output_collection_0/v3_four_channel_placement_0/v3_channel_selector_late_promotion_0/v3_selector_route_pilot_0/G1_MUX_POS/X v3_four_channel_bias_reference_distribution_0/v3_four_channel_phase_distribution_0/v3_four_channel_output_collection_0/v3_four_channel_placement_0/v3_channel_selector_late_promotion_0/VPWR sky130_fd_pr__pfet_01v8_hvt ad=0.15835 pd=1.395 as=0.26 ps=2.52 w=1 l=0.15
X146 VSUBS v3_four_channel_bias_reference_distribution_0/v3_four_channel_phase_distribution_0/v3_four_channel_output_collection_0/v3_four_channel_placement_0/v3_channel_selector_late_promotion_0/v3_selector_route_pilot_0/G1_MUX_POS/a_76_199# v3_four_channel_bias_reference_distribution_0/v3_four_channel_phase_distribution_0/v3_four_channel_output_collection_0/v3_four_channel_placement_0/v3_channel_selector_late_promotion_0/v3_selector_route_pilot_0/G1_MUX_POS/X VSUBS sky130_fd_pr__nfet_01v8 ad=0.11285 pd=1.045 as=0.169 ps=1.82 w=0.65 l=0.15
X147 v3_four_channel_bias_reference_distribution_0/v3_four_channel_phase_distribution_0/v3_four_channel_output_collection_0/v3_four_channel_placement_0/v3_channel_selector_late_promotion_0/VPWR v3_four_channel_bias_reference_distribution_0/v3_four_channel_phase_distribution_0/v3_four_channel_output_collection_0/v3_four_channel_placement_0/v3_channel_selector_late_promotion_0/v3_selector_route_pilot_0/G3_MUX_AXIS/a_505_21# v3_four_channel_bias_reference_distribution_0/v3_four_channel_phase_distribution_0/v3_four_channel_output_collection_0/v3_four_channel_placement_0/v3_channel_selector_late_promotion_0/v3_selector_route_pilot_0/G3_MUX_AXIS/a_535_374# v3_four_channel_bias_reference_distribution_0/v3_four_channel_phase_distribution_0/v3_four_channel_output_collection_0/v3_four_channel_placement_0/v3_channel_selector_late_promotion_0/VPWR sky130_fd_pr__pfet_01v8_hvt ad=10.2594 pd=93.2 as=0.0882 ps=1.26 w=0.42 l=0.15
X148 v3_four_channel_bias_reference_distribution_0/v3_four_channel_phase_distribution_0/v3_four_channel_output_collection_0/v3_four_channel_placement_0/v3_channel_selector_late_promotion_0/v3_selector_route_pilot_0/G3_MUX_AXIS/a_505_21# v3_four_channel_bias_reference_distribution_0/v3_four_channel_phase_distribution_0/v3_four_channel_output_collection_0/v3_four_channel_placement_0/v3_channel_selector_late_promotion_0/group3_bit1 v3_four_channel_bias_reference_distribution_0/v3_four_channel_phase_distribution_0/v3_four_channel_output_collection_0/v3_four_channel_placement_0/v3_channel_selector_late_promotion_0/VPWR v3_four_channel_bias_reference_distribution_0/v3_four_channel_phase_distribution_0/v3_four_channel_output_collection_0/v3_four_channel_placement_0/v3_channel_selector_late_promotion_0/VPWR sky130_fd_pr__pfet_01v8_hvt ad=0.1176 pd=1.4 as=0 ps=0 w=0.42 l=0.15
X149 v3_four_channel_bias_reference_distribution_0/v3_four_channel_phase_distribution_0/v3_four_channel_output_collection_0/v3_four_channel_placement_0/v3_channel_selector_late_promotion_0/v3_selector_route_pilot_0/G3_MUX_AXIS/a_218_374# v3_four_channel_bias_reference_distribution_0/v3_four_channel_phase_distribution_0/v3_four_channel_output_collection_0/v3_four_channel_placement_0/v3_channel_selector_late_promotion_0/group3_bit1 v3_four_channel_bias_reference_distribution_0/v3_four_channel_phase_distribution_0/v3_four_channel_output_collection_0/v3_four_channel_placement_0/v3_channel_selector_late_promotion_0/VPWR v3_four_channel_bias_reference_distribution_0/v3_four_channel_phase_distribution_0/v3_four_channel_output_collection_0/v3_four_channel_placement_0/v3_channel_selector_late_promotion_0/VPWR sky130_fd_pr__pfet_01v8_hvt ad=0.1533 pd=1.57 as=0 ps=0 w=0.42 l=0.15
X150 VSUBS v3_four_channel_bias_reference_distribution_0/v3_four_channel_phase_distribution_0/v3_four_channel_output_collection_0/v3_four_channel_placement_0/v3_channel_selector_late_promotion_0/v3_selector_route_pilot_0/G3_MUX_AXIS/a_505_21# v3_four_channel_bias_reference_distribution_0/v3_four_channel_phase_distribution_0/v3_four_channel_output_collection_0/v3_four_channel_placement_0/v3_channel_selector_late_promotion_0/v3_selector_route_pilot_0/G3_MUX_AXIS/a_439_47# VSUBS sky130_fd_pr__nfet_01v8 ad=0 pd=0 as=0.1386 ps=1.5 w=0.42 l=0.15
X151 v3_four_channel_bias_reference_distribution_0/v3_four_channel_phase_distribution_0/v3_four_channel_output_collection_0/v3_four_channel_placement_0/v3_channel_selector_late_promotion_0/v3_selector_route_pilot_0/G3_MUX_AXIS/a_76_199# v3_four_channel_bias_reference_distribution_0/v3_four_channel_phase_distribution_0/v3_four_channel_output_collection_0/v3_four_channel_placement_0/v3_channel_selector_late_promotion_0/v3_selector_route_pilot_0/G3_MUX_POS/X v3_four_channel_bias_reference_distribution_0/v3_four_channel_phase_distribution_0/v3_four_channel_output_collection_0/v3_four_channel_placement_0/v3_channel_selector_late_promotion_0/v3_selector_route_pilot_0/G3_MUX_AXIS/a_218_374# v3_four_channel_bias_reference_distribution_0/v3_four_channel_phase_distribution_0/v3_four_channel_output_collection_0/v3_four_channel_placement_0/v3_channel_selector_late_promotion_0/VPWR sky130_fd_pr__pfet_01v8_hvt ad=0.3864 pd=2.68 as=0 ps=0 w=0.42 l=0.15
X152 v3_four_channel_bias_reference_distribution_0/v3_four_channel_phase_distribution_0/v3_four_channel_output_collection_0/v3_four_channel_placement_0/v3_channel_selector_late_promotion_0/v3_selector_route_pilot_0/G3_MUX_AXIS/a_505_21# v3_four_channel_bias_reference_distribution_0/v3_four_channel_phase_distribution_0/v3_four_channel_output_collection_0/v3_four_channel_placement_0/v3_channel_selector_late_promotion_0/group3_bit1 VSUBS VSUBS sky130_fd_pr__nfet_01v8 ad=0.1092 pd=1.36 as=0 ps=0 w=0.42 l=0.15
X153 v3_four_channel_bias_reference_distribution_0/v3_four_channel_phase_distribution_0/v3_four_channel_output_collection_0/v3_four_channel_placement_0/v3_channel_selector_late_promotion_0/v3_selector_route_pilot_0/G3_MUX_AXIS/a_439_47# v3_four_channel_bias_reference_distribution_0/v3_four_channel_phase_distribution_0/v3_four_channel_output_collection_0/v3_four_channel_placement_0/v3_channel_selector_late_promotion_0/v3_selector_route_pilot_0/G3_MUX_POS/X v3_four_channel_bias_reference_distribution_0/v3_four_channel_phase_distribution_0/v3_four_channel_output_collection_0/v3_four_channel_placement_0/v3_channel_selector_late_promotion_0/v3_selector_route_pilot_0/G3_MUX_AXIS/a_76_199# VSUBS sky130_fd_pr__nfet_01v8 ad=0 pd=0 as=0.1995 ps=1.79 w=0.42 l=0.15
X154 v3_four_channel_bias_reference_distribution_0/v3_four_channel_phase_distribution_0/v3_four_channel_output_collection_0/v3_four_channel_placement_0/v3_channel_selector_late_promotion_0/v3_selector_route_pilot_0/G3_MUX_AXIS/a_535_374# v3_four_channel_bias_reference_distribution_0/v3_four_channel_phase_distribution_0/v3_four_channel_output_collection_0/v3_four_channel_placement_0/v3_channel_selector_late_promotion_0/v3_selector_route_pilot_0/G3_MUX_NEG/X v3_four_channel_bias_reference_distribution_0/v3_four_channel_phase_distribution_0/v3_four_channel_output_collection_0/v3_four_channel_placement_0/v3_channel_selector_late_promotion_0/v3_selector_route_pilot_0/G3_MUX_AXIS/a_76_199# v3_four_channel_bias_reference_distribution_0/v3_four_channel_phase_distribution_0/v3_four_channel_output_collection_0/v3_four_channel_placement_0/v3_channel_selector_late_promotion_0/VPWR sky130_fd_pr__pfet_01v8_hvt ad=0 pd=0 as=0 ps=0 w=0.42 l=0.15
X155 v3_four_channel_bias_reference_distribution_0/v3_four_channel_phase_distribution_0/v3_four_channel_output_collection_0/v3_four_channel_placement_0/v3_channel_selector_late_promotion_0/v3_selector_route_pilot_0/G3_MUX_AXIS/a_76_199# v3_four_channel_bias_reference_distribution_0/v3_four_channel_phase_distribution_0/v3_four_channel_output_collection_0/v3_four_channel_placement_0/v3_channel_selector_late_promotion_0/v3_selector_route_pilot_0/G3_MUX_NEG/X v3_four_channel_bias_reference_distribution_0/v3_four_channel_phase_distribution_0/v3_four_channel_output_collection_0/v3_four_channel_placement_0/v3_channel_selector_late_promotion_0/v3_selector_route_pilot_0/G3_MUX_AXIS/a_218_47# VSUBS sky130_fd_pr__nfet_01v8 ad=0 pd=0 as=0.1386 ps=1.5 w=0.42 l=0.15
X156 v3_four_channel_bias_reference_distribution_0/v3_four_channel_phase_distribution_0/v3_four_channel_output_collection_0/v3_four_channel_placement_0/v3_channel_selector_late_promotion_0/v3_selector_route_pilot_0/G3_MUX_AXIS/a_218_47# v3_four_channel_bias_reference_distribution_0/v3_four_channel_phase_distribution_0/v3_four_channel_output_collection_0/v3_four_channel_placement_0/v3_channel_selector_late_promotion_0/group3_bit1 VSUBS VSUBS sky130_fd_pr__nfet_01v8 ad=0 pd=0 as=0 ps=0 w=0.42 l=0.15
X157 v3_four_channel_bias_reference_distribution_0/v3_four_channel_phase_distribution_0/v3_four_channel_output_collection_0/v3_four_channel_placement_0/v3_channel_selector_late_promotion_0/VPWR v3_four_channel_bias_reference_distribution_0/v3_four_channel_phase_distribution_0/v3_four_channel_output_collection_0/v3_four_channel_placement_0/v3_channel_selector_late_promotion_0/v3_selector_route_pilot_0/G3_MUX_AXIS/a_76_199# v3_four_channel_bias_reference_distribution_0/v3_four_channel_phase_distribution_0/v3_four_channel_output_collection_0/v3_four_channel_placement_0/v3_channel_selector_late_promotion_0/v3_selector_route_pilot_0/G3_MUX_AXIS/X v3_four_channel_bias_reference_distribution_0/v3_four_channel_phase_distribution_0/v3_four_channel_output_collection_0/v3_four_channel_placement_0/v3_channel_selector_late_promotion_0/VPWR sky130_fd_pr__pfet_01v8_hvt ad=0 pd=0 as=0.26 ps=2.52 w=1 l=0.15
X158 VSUBS v3_four_channel_bias_reference_distribution_0/v3_four_channel_phase_distribution_0/v3_four_channel_output_collection_0/v3_four_channel_placement_0/v3_channel_selector_late_promotion_0/v3_selector_route_pilot_0/G3_MUX_AXIS/a_76_199# v3_four_channel_bias_reference_distribution_0/v3_four_channel_phase_distribution_0/v3_four_channel_output_collection_0/v3_four_channel_placement_0/v3_channel_selector_late_promotion_0/v3_selector_route_pilot_0/G3_MUX_AXIS/X VSUBS sky130_fd_pr__nfet_01v8 ad=0 pd=0 as=0.169 ps=1.82 w=0.65 l=0.15
X159 v3_four_channel_bias_reference_distribution_0/v3_four_channel_phase_distribution_0/v3_four_channel_output_collection_0/v3_four_channel_placement_0/v3_channel_selector_late_promotion_0/VPWR v3_four_channel_bias_reference_distribution_0/v3_four_channel_phase_distribution_0/v3_four_channel_output_collection_0/v3_four_channel_placement_0/v3_channel_selector_late_promotion_0/channel_enable v3_four_channel_bias_reference_distribution_0/v3_four_channel_phase_distribution_0/v3_four_channel_output_collection_0/v3_four_channel_placement_0/v3_channel_selector_late_promotion_0/v3_selector_route_pilot_0/ENABLE_ANDNOT/a_207_413# v3_four_channel_bias_reference_distribution_0/v3_four_channel_phase_distribution_0/v3_four_channel_output_collection_0/v3_four_channel_placement_0/v3_channel_selector_late_promotion_0/VPWR sky130_fd_pr__pfet_01v8_hvt ad=0.2279 pd=1.74 as=0.0609 ps=0.71 w=0.42 l=0.15
X160 v3_four_channel_bias_reference_distribution_0/v3_four_channel_phase_distribution_0/v3_four_channel_output_collection_0/v3_four_channel_placement_0/v3_channel_selector_late_promotion_0/v3_selector_route_pilot_0/G3_LO_P_AND/B v3_four_channel_bias_reference_distribution_0/v3_four_channel_phase_distribution_0/v3_four_channel_output_collection_0/v3_four_channel_placement_0/v3_channel_selector_late_promotion_0/v3_selector_route_pilot_0/ENABLE_ANDNOT/a_207_413# v3_four_channel_bias_reference_distribution_0/v3_four_channel_phase_distribution_0/v3_four_channel_output_collection_0/v3_four_channel_placement_0/v3_channel_selector_late_promotion_0/VPWR v3_four_channel_bias_reference_distribution_0/v3_four_channel_phase_distribution_0/v3_four_channel_output_collection_0/v3_four_channel_placement_0/v3_channel_selector_late_promotion_0/VPWR sky130_fd_pr__pfet_01v8_hvt ad=0.26 pd=2.52 as=0.2279 ps=1.74 w=1 l=0.15
X161 v3_four_channel_bias_reference_distribution_0/v3_four_channel_phase_distribution_0/v3_four_channel_output_collection_0/v3_four_channel_placement_0/v3_channel_selector_late_promotion_0/v3_selector_route_pilot_0/ENABLE_ANDNOT/a_297_47# v3_four_channel_bias_reference_distribution_0/v3_four_channel_phase_distribution_0/v3_four_channel_output_collection_0/v3_four_channel_placement_0/v3_channel_selector_late_promotion_0/v3_selector_route_pilot_0/ENABLE_ANDNOT/a_27_413# v3_four_channel_bias_reference_distribution_0/v3_four_channel_phase_distribution_0/v3_four_channel_output_collection_0/v3_four_channel_placement_0/v3_channel_selector_late_promotion_0/v3_selector_route_pilot_0/ENABLE_ANDNOT/a_207_413# VSUBS sky130_fd_pr__nfet_01v8 ad=0.0504 pd=0.66 as=0.1092 ps=1.36 w=0.42 l=0.15
X162 v3_four_channel_bias_reference_distribution_0/v3_four_channel_phase_distribution_0/v3_four_channel_output_collection_0/v3_four_channel_placement_0/v3_channel_selector_late_promotion_0/v3_selector_route_pilot_0/G3_LO_P_AND/B v3_four_channel_bias_reference_distribution_0/v3_four_channel_phase_distribution_0/v3_four_channel_output_collection_0/v3_four_channel_placement_0/v3_channel_selector_late_promotion_0/v3_selector_route_pilot_0/ENABLE_ANDNOT/a_207_413# VSUBS VSUBS sky130_fd_pr__nfet_01v8 ad=0.169 pd=1.82 as=0.1013 ps=0.99 w=0.65 l=0.15
X163 v3_four_channel_bias_reference_distribution_0/v3_four_channel_phase_distribution_0/v3_four_channel_output_collection_0/v3_four_channel_placement_0/v3_channel_selector_late_promotion_0/v3_selector_route_pilot_0/ENABLE_ANDNOT/a_207_413# v3_four_channel_bias_reference_distribution_0/v3_four_channel_phase_distribution_0/v3_four_channel_output_collection_0/v3_four_channel_placement_0/v3_channel_selector_late_promotion_0/v3_selector_route_pilot_0/ENABLE_ANDNOT/a_27_413# v3_four_channel_bias_reference_distribution_0/v3_four_channel_phase_distribution_0/v3_four_channel_output_collection_0/v3_four_channel_placement_0/v3_channel_selector_late_promotion_0/VPWR v3_four_channel_bias_reference_distribution_0/v3_four_channel_phase_distribution_0/v3_four_channel_output_collection_0/v3_four_channel_placement_0/v3_channel_selector_late_promotion_0/VPWR sky130_fd_pr__pfet_01v8_hvt ad=0.0609 pd=0.71 as=0.0714 ps=0.76 w=0.42 l=0.15
X164 v3_four_channel_bias_reference_distribution_0/v3_four_channel_phase_distribution_0/v3_four_channel_output_collection_0/v3_four_channel_placement_0/v3_channel_selector_late_promotion_0/VPWR v3_four_channel_bias_reference_distribution_0/v3_four_channel_phase_distribution_0/v3_four_channel_output_collection_0/v3_four_channel_placement_0/v3_channel_selector_late_promotion_0/mixers_blank v3_four_channel_bias_reference_distribution_0/v3_four_channel_phase_distribution_0/v3_four_channel_output_collection_0/v3_four_channel_placement_0/v3_channel_selector_late_promotion_0/v3_selector_route_pilot_0/ENABLE_ANDNOT/a_27_413# v3_four_channel_bias_reference_distribution_0/v3_four_channel_phase_distribution_0/v3_four_channel_output_collection_0/v3_four_channel_placement_0/v3_channel_selector_late_promotion_0/VPWR sky130_fd_pr__pfet_01v8_hvt ad=0.0714 pd=0.76 as=0.1092 ps=1.36 w=0.42 l=0.15
X165 VSUBS v3_four_channel_bias_reference_distribution_0/v3_four_channel_phase_distribution_0/v3_four_channel_output_collection_0/v3_four_channel_placement_0/v3_channel_selector_late_promotion_0/channel_enable v3_four_channel_bias_reference_distribution_0/v3_four_channel_phase_distribution_0/v3_four_channel_output_collection_0/v3_four_channel_placement_0/v3_channel_selector_late_promotion_0/v3_selector_route_pilot_0/ENABLE_ANDNOT/a_297_47# VSUBS sky130_fd_pr__nfet_01v8 ad=0.1013 pd=0.99 as=0.0504 ps=0.66 w=0.42 l=0.15
X166 v3_four_channel_bias_reference_distribution_0/v3_four_channel_phase_distribution_0/v3_four_channel_output_collection_0/v3_four_channel_placement_0/v3_channel_selector_late_promotion_0/v3_selector_route_pilot_0/ENABLE_ANDNOT/a_27_413# v3_four_channel_bias_reference_distribution_0/v3_four_channel_phase_distribution_0/v3_four_channel_output_collection_0/v3_four_channel_placement_0/v3_channel_selector_late_promotion_0/mixers_blank VSUBS VSUBS sky130_fd_pr__nfet_01v8 ad=0.1092 pd=1.36 as=0.1092 ps=1.36 w=0.42 l=0.15
X167 v3_four_channel_bias_reference_distribution_0/v3_four_channel_phase_distribution_0/v3_four_channel_output_collection_0/v3_four_channel_placement_0/v3_channel_selector_late_promotion_0/VPWR v3_four_channel_bias_reference_distribution_0/v3_four_channel_phase_distribution_0/v3_four_channel_output_collection_0/v3_four_channel_placement_0/v3_channel_selector_late_promotion_0/v3_selector_route_pilot_0/G1_MUX_NEG/a_505_21# v3_four_channel_bias_reference_distribution_0/v3_four_channel_phase_distribution_0/v3_four_channel_output_collection_0/v3_four_channel_placement_0/v3_channel_selector_late_promotion_0/v3_selector_route_pilot_0/G1_MUX_NEG/a_535_374# v3_four_channel_bias_reference_distribution_0/v3_four_channel_phase_distribution_0/v3_four_channel_output_collection_0/v3_four_channel_placement_0/v3_channel_selector_late_promotion_0/VPWR sky130_fd_pr__pfet_01v8_hvt ad=0 pd=0 as=0.0882 ps=1.26 w=0.42 l=0.15
X168 v3_four_channel_bias_reference_distribution_0/v3_four_channel_phase_distribution_0/v3_four_channel_output_collection_0/v3_four_channel_placement_0/v3_channel_selector_late_promotion_0/v3_selector_route_pilot_0/G1_MUX_NEG/a_505_21# v3_four_channel_bias_reference_distribution_0/v3_four_channel_phase_distribution_0/v3_four_channel_output_collection_0/v3_four_channel_placement_0/v3_channel_selector_late_promotion_0/group1_bit0 v3_four_channel_bias_reference_distribution_0/v3_four_channel_phase_distribution_0/v3_four_channel_output_collection_0/v3_four_channel_placement_0/v3_channel_selector_late_promotion_0/VPWR v3_four_channel_bias_reference_distribution_0/v3_four_channel_phase_distribution_0/v3_four_channel_output_collection_0/v3_four_channel_placement_0/v3_channel_selector_late_promotion_0/VPWR sky130_fd_pr__pfet_01v8_hvt ad=0.1176 pd=1.4 as=0 ps=0 w=0.42 l=0.15
X169 v3_four_channel_bias_reference_distribution_0/v3_four_channel_phase_distribution_0/v3_four_channel_output_collection_0/v3_four_channel_placement_0/v3_channel_selector_late_promotion_0/v3_selector_route_pilot_0/G1_MUX_NEG/a_218_374# v3_four_channel_bias_reference_distribution_0/v3_four_channel_phase_distribution_0/v3_four_channel_output_collection_0/v3_four_channel_placement_0/v3_channel_selector_late_promotion_0/group1_bit0 v3_four_channel_bias_reference_distribution_0/v3_four_channel_phase_distribution_0/v3_four_channel_output_collection_0/v3_four_channel_placement_0/v3_channel_selector_late_promotion_0/VPWR v3_four_channel_bias_reference_distribution_0/v3_four_channel_phase_distribution_0/v3_four_channel_output_collection_0/v3_four_channel_placement_0/v3_channel_selector_late_promotion_0/VPWR sky130_fd_pr__pfet_01v8_hvt ad=0.1533 pd=1.57 as=0 ps=0 w=0.42 l=0.15
X170 VSUBS v3_four_channel_bias_reference_distribution_0/v3_four_channel_phase_distribution_0/v3_four_channel_output_collection_0/v3_four_channel_placement_0/v3_channel_selector_late_promotion_0/v3_selector_route_pilot_0/G1_MUX_NEG/a_505_21# v3_four_channel_bias_reference_distribution_0/v3_four_channel_phase_distribution_0/v3_four_channel_output_collection_0/v3_four_channel_placement_0/v3_channel_selector_late_promotion_0/v3_selector_route_pilot_0/G1_MUX_NEG/a_439_47# VSUBS sky130_fd_pr__nfet_01v8 ad=0 pd=0 as=0.1386 ps=1.5 w=0.42 l=0.15
X171 v3_four_channel_bias_reference_distribution_0/v3_four_channel_phase_distribution_0/v3_four_channel_output_collection_0/v3_four_channel_placement_0/v3_channel_selector_late_promotion_0/v3_selector_route_pilot_0/G1_MUX_NEG/a_76_199# v3_four_channel_bias_reference_distribution_0/v3_four_channel_phase_distribution_0/phase_180 v3_four_channel_bias_reference_distribution_0/v3_four_channel_phase_distribution_0/v3_four_channel_output_collection_0/v3_four_channel_placement_0/v3_channel_selector_late_promotion_0/v3_selector_route_pilot_0/G1_MUX_NEG/a_218_374# v3_four_channel_bias_reference_distribution_0/v3_four_channel_phase_distribution_0/v3_four_channel_output_collection_0/v3_four_channel_placement_0/v3_channel_selector_late_promotion_0/VPWR sky130_fd_pr__pfet_01v8_hvt ad=0.3864 pd=2.68 as=0 ps=0 w=0.42 l=0.15
X172 v3_four_channel_bias_reference_distribution_0/v3_four_channel_phase_distribution_0/v3_four_channel_output_collection_0/v3_four_channel_placement_0/v3_channel_selector_late_promotion_0/v3_selector_route_pilot_0/G1_MUX_NEG/a_505_21# v3_four_channel_bias_reference_distribution_0/v3_four_channel_phase_distribution_0/v3_four_channel_output_collection_0/v3_four_channel_placement_0/v3_channel_selector_late_promotion_0/group1_bit0 VSUBS VSUBS sky130_fd_pr__nfet_01v8 ad=0.1092 pd=1.36 as=0 ps=0 w=0.42 l=0.15
X173 v3_four_channel_bias_reference_distribution_0/v3_four_channel_phase_distribution_0/v3_four_channel_output_collection_0/v3_four_channel_placement_0/v3_channel_selector_late_promotion_0/v3_selector_route_pilot_0/G1_MUX_NEG/a_439_47# v3_four_channel_bias_reference_distribution_0/v3_four_channel_phase_distribution_0/phase_180 v3_four_channel_bias_reference_distribution_0/v3_four_channel_phase_distribution_0/v3_four_channel_output_collection_0/v3_four_channel_placement_0/v3_channel_selector_late_promotion_0/v3_selector_route_pilot_0/G1_MUX_NEG/a_76_199# VSUBS sky130_fd_pr__nfet_01v8 ad=0 pd=0 as=0.1995 ps=1.79 w=0.42 l=0.15
X174 v3_four_channel_bias_reference_distribution_0/v3_four_channel_phase_distribution_0/v3_four_channel_output_collection_0/v3_four_channel_placement_0/v3_channel_selector_late_promotion_0/v3_selector_route_pilot_0/G1_MUX_NEG/a_535_374# v3_four_channel_bias_reference_distribution_0/v3_four_channel_phase_distribution_0/phase_270 v3_four_channel_bias_reference_distribution_0/v3_four_channel_phase_distribution_0/v3_four_channel_output_collection_0/v3_four_channel_placement_0/v3_channel_selector_late_promotion_0/v3_selector_route_pilot_0/G1_MUX_NEG/a_76_199# v3_four_channel_bias_reference_distribution_0/v3_four_channel_phase_distribution_0/v3_four_channel_output_collection_0/v3_four_channel_placement_0/v3_channel_selector_late_promotion_0/VPWR sky130_fd_pr__pfet_01v8_hvt ad=0 pd=0 as=0 ps=0 w=0.42 l=0.15
X175 v3_four_channel_bias_reference_distribution_0/v3_four_channel_phase_distribution_0/v3_four_channel_output_collection_0/v3_four_channel_placement_0/v3_channel_selector_late_promotion_0/v3_selector_route_pilot_0/G1_MUX_NEG/a_76_199# v3_four_channel_bias_reference_distribution_0/v3_four_channel_phase_distribution_0/phase_270 v3_four_channel_bias_reference_distribution_0/v3_four_channel_phase_distribution_0/v3_four_channel_output_collection_0/v3_four_channel_placement_0/v3_channel_selector_late_promotion_0/v3_selector_route_pilot_0/G1_MUX_NEG/a_218_47# VSUBS sky130_fd_pr__nfet_01v8 ad=0 pd=0 as=0.1386 ps=1.5 w=0.42 l=0.15
X176 v3_four_channel_bias_reference_distribution_0/v3_four_channel_phase_distribution_0/v3_four_channel_output_collection_0/v3_four_channel_placement_0/v3_channel_selector_late_promotion_0/v3_selector_route_pilot_0/G1_MUX_NEG/a_218_47# v3_four_channel_bias_reference_distribution_0/v3_four_channel_phase_distribution_0/v3_four_channel_output_collection_0/v3_four_channel_placement_0/v3_channel_selector_late_promotion_0/group1_bit0 VSUBS VSUBS sky130_fd_pr__nfet_01v8 ad=0 pd=0 as=0 ps=0 w=0.42 l=0.15
X177 v3_four_channel_bias_reference_distribution_0/v3_four_channel_phase_distribution_0/v3_four_channel_output_collection_0/v3_four_channel_placement_0/v3_channel_selector_late_promotion_0/VPWR v3_four_channel_bias_reference_distribution_0/v3_four_channel_phase_distribution_0/v3_four_channel_output_collection_0/v3_four_channel_placement_0/v3_channel_selector_late_promotion_0/v3_selector_route_pilot_0/G1_MUX_NEG/a_76_199# v3_four_channel_bias_reference_distribution_0/v3_four_channel_phase_distribution_0/v3_four_channel_output_collection_0/v3_four_channel_placement_0/v3_channel_selector_late_promotion_0/v3_selector_route_pilot_0/G1_MUX_NEG/X v3_four_channel_bias_reference_distribution_0/v3_four_channel_phase_distribution_0/v3_four_channel_output_collection_0/v3_four_channel_placement_0/v3_channel_selector_late_promotion_0/VPWR sky130_fd_pr__pfet_01v8_hvt ad=0 pd=0 as=0.26 ps=2.52 w=1 l=0.15
X178 VSUBS v3_four_channel_bias_reference_distribution_0/v3_four_channel_phase_distribution_0/v3_four_channel_output_collection_0/v3_four_channel_placement_0/v3_channel_selector_late_promotion_0/v3_selector_route_pilot_0/G1_MUX_NEG/a_76_199# v3_four_channel_bias_reference_distribution_0/v3_four_channel_phase_distribution_0/v3_four_channel_output_collection_0/v3_four_channel_placement_0/v3_channel_selector_late_promotion_0/v3_selector_route_pilot_0/G1_MUX_NEG/X VSUBS sky130_fd_pr__nfet_01v8 ad=0 pd=0 as=0.169 ps=1.82 w=0.65 l=0.15
X179 v3_four_channel_bias_reference_distribution_0/v3_four_channel_phase_distribution_0/v3_four_channel_output_collection_0/v3_four_channel_placement_0/v3_channel_selector_late_promotion_0/VPWR v3_four_channel_bias_reference_distribution_0/v3_four_channel_phase_distribution_0/v3_four_channel_output_collection_0/v3_four_channel_placement_0/v3_channel_selector_late_promotion_0/v3_selector_route_pilot_0/G3_LO_P_AND/B v3_four_channel_bias_reference_distribution_0/v3_four_channel_phase_distribution_0/v3_four_channel_output_collection_0/v3_four_channel_placement_0/v3_channel_selector_late_promotion_0/v3_selector_route_pilot_0/G1_LO_P_AND/a_59_75# v3_four_channel_bias_reference_distribution_0/v3_four_channel_phase_distribution_0/v3_four_channel_output_collection_0/v3_four_channel_placement_0/v3_channel_selector_late_promotion_0/VPWR sky130_fd_pr__pfet_01v8_hvt ad=0.16655 pd=1.39 as=0.0567 ps=0.69 w=0.42 l=0.15
X180 v3_four_channel_bias_reference_distribution_0/v3_four_channel_phase_distribution_0/v3_four_channel_output_collection_0/v3_four_channel_placement_0/v3_channel_selector_late_promotion_0/v3_selector_route_pilot_0/group1_lo_p v3_four_channel_bias_reference_distribution_0/v3_four_channel_phase_distribution_0/v3_four_channel_output_collection_0/v3_four_channel_placement_0/v3_channel_selector_late_promotion_0/v3_selector_route_pilot_0/G1_LO_P_AND/a_59_75# v3_four_channel_bias_reference_distribution_0/v3_four_channel_phase_distribution_0/v3_four_channel_output_collection_0/v3_four_channel_placement_0/v3_channel_selector_late_promotion_0/VPWR v3_four_channel_bias_reference_distribution_0/v3_four_channel_phase_distribution_0/v3_four_channel_output_collection_0/v3_four_channel_placement_0/v3_channel_selector_late_promotion_0/VPWR sky130_fd_pr__pfet_01v8_hvt ad=0.475 pd=2.95 as=0.16655 ps=1.39 w=1 l=0.15
X181 VSUBS v3_four_channel_bias_reference_distribution_0/v3_four_channel_phase_distribution_0/v3_four_channel_output_collection_0/v3_four_channel_placement_0/v3_channel_selector_late_promotion_0/v3_selector_route_pilot_0/G3_LO_P_AND/B v3_four_channel_bias_reference_distribution_0/v3_four_channel_phase_distribution_0/v3_four_channel_output_collection_0/v3_four_channel_placement_0/v3_channel_selector_late_promotion_0/v3_selector_route_pilot_0/G1_LO_P_AND/a_145_75# VSUBS sky130_fd_pr__nfet_01v8 ad=0.1118 pd=1.04 as=0.0567 ps=0.69 w=0.42 l=0.15
X182 v3_four_channel_bias_reference_distribution_0/v3_four_channel_phase_distribution_0/v3_four_channel_output_collection_0/v3_four_channel_placement_0/v3_channel_selector_late_promotion_0/v3_selector_route_pilot_0/G1_LO_P_AND/a_59_75# v3_four_channel_bias_reference_distribution_0/v3_four_channel_phase_distribution_0/v3_four_channel_output_collection_0/v3_four_channel_placement_0/v3_channel_selector_late_promotion_0/v3_selector_route_pilot_0/G1_MUX_AXIS/X v3_four_channel_bias_reference_distribution_0/v3_four_channel_phase_distribution_0/v3_four_channel_output_collection_0/v3_four_channel_placement_0/v3_channel_selector_late_promotion_0/VPWR v3_four_channel_bias_reference_distribution_0/v3_four_channel_phase_distribution_0/v3_four_channel_output_collection_0/v3_four_channel_placement_0/v3_channel_selector_late_promotion_0/VPWR sky130_fd_pr__pfet_01v8_hvt ad=0.0567 pd=0.69 as=0.1176 ps=1.4 w=0.42 l=0.15
X183 v3_four_channel_bias_reference_distribution_0/v3_four_channel_phase_distribution_0/v3_four_channel_output_collection_0/v3_four_channel_placement_0/v3_channel_selector_late_promotion_0/v3_selector_route_pilot_0/group1_lo_p v3_four_channel_bias_reference_distribution_0/v3_four_channel_phase_distribution_0/v3_four_channel_output_collection_0/v3_four_channel_placement_0/v3_channel_selector_late_promotion_0/v3_selector_route_pilot_0/G1_LO_P_AND/a_59_75# VSUBS VSUBS sky130_fd_pr__nfet_01v8 ad=0.182 pd=1.86 as=0.1118 ps=1.04 w=0.65 l=0.15
X184 v3_four_channel_bias_reference_distribution_0/v3_four_channel_phase_distribution_0/v3_four_channel_output_collection_0/v3_four_channel_placement_0/v3_channel_selector_late_promotion_0/v3_selector_route_pilot_0/G1_LO_P_AND/a_145_75# v3_four_channel_bias_reference_distribution_0/v3_four_channel_phase_distribution_0/v3_four_channel_output_collection_0/v3_four_channel_placement_0/v3_channel_selector_late_promotion_0/v3_selector_route_pilot_0/G1_MUX_AXIS/X v3_four_channel_bias_reference_distribution_0/v3_four_channel_phase_distribution_0/v3_four_channel_output_collection_0/v3_four_channel_placement_0/v3_channel_selector_late_promotion_0/v3_selector_route_pilot_0/G1_LO_P_AND/a_59_75# VSUBS sky130_fd_pr__nfet_01v8 ad=0.0567 pd=0.69 as=0.1176 ps=1.4 w=0.42 l=0.15
X185 v3_four_channel_bias_reference_distribution_0/v3_four_channel_phase_distribution_0/v3_four_channel_output_collection_0/v3_four_channel_placement_0/v3_channel_selector_late_promotion_0/VPWR v3_four_channel_bias_reference_distribution_0/v3_four_channel_phase_distribution_0/v3_four_channel_output_collection_0/v3_four_channel_placement_0/v3_channel_selector_late_promotion_0/v3_selector_route_pilot_0/G0_MUX_POS/a_505_21# v3_four_channel_bias_reference_distribution_0/v3_four_channel_phase_distribution_0/v3_four_channel_output_collection_0/v3_four_channel_placement_0/v3_channel_selector_late_promotion_0/v3_selector_route_pilot_0/G0_MUX_POS/a_535_374# v3_four_channel_bias_reference_distribution_0/v3_four_channel_phase_distribution_0/v3_four_channel_output_collection_0/v3_four_channel_placement_0/v3_channel_selector_late_promotion_0/VPWR sky130_fd_pr__pfet_01v8_hvt ad=0 pd=0 as=0.0882 ps=1.26 w=0.42 l=0.15
X186 v3_four_channel_bias_reference_distribution_0/v3_four_channel_phase_distribution_0/v3_four_channel_output_collection_0/v3_four_channel_placement_0/v3_channel_selector_late_promotion_0/v3_selector_route_pilot_0/G0_MUX_POS/a_505_21# v3_four_channel_bias_reference_distribution_0/v3_four_channel_phase_distribution_0/v3_four_channel_output_collection_0/v3_four_channel_placement_0/v3_channel_selector_late_promotion_0/group0_bit0 v3_four_channel_bias_reference_distribution_0/v3_four_channel_phase_distribution_0/v3_four_channel_output_collection_0/v3_four_channel_placement_0/v3_channel_selector_late_promotion_0/VPWR v3_four_channel_bias_reference_distribution_0/v3_four_channel_phase_distribution_0/v3_four_channel_output_collection_0/v3_four_channel_placement_0/v3_channel_selector_late_promotion_0/VPWR sky130_fd_pr__pfet_01v8_hvt ad=0.1176 pd=1.4 as=0 ps=0 w=0.42 l=0.15
X187 v3_four_channel_bias_reference_distribution_0/v3_four_channel_phase_distribution_0/v3_four_channel_output_collection_0/v3_four_channel_placement_0/v3_channel_selector_late_promotion_0/v3_selector_route_pilot_0/G0_MUX_POS/a_218_374# v3_four_channel_bias_reference_distribution_0/v3_four_channel_phase_distribution_0/v3_four_channel_output_collection_0/v3_four_channel_placement_0/v3_channel_selector_late_promotion_0/group0_bit0 v3_four_channel_bias_reference_distribution_0/v3_four_channel_phase_distribution_0/v3_four_channel_output_collection_0/v3_four_channel_placement_0/v3_channel_selector_late_promotion_0/VPWR v3_four_channel_bias_reference_distribution_0/v3_four_channel_phase_distribution_0/v3_four_channel_output_collection_0/v3_four_channel_placement_0/v3_channel_selector_late_promotion_0/VPWR sky130_fd_pr__pfet_01v8_hvt ad=0.1533 pd=1.57 as=0 ps=0 w=0.42 l=0.15
X188 VSUBS v3_four_channel_bias_reference_distribution_0/v3_four_channel_phase_distribution_0/v3_four_channel_output_collection_0/v3_four_channel_placement_0/v3_channel_selector_late_promotion_0/v3_selector_route_pilot_0/G0_MUX_POS/a_505_21# v3_four_channel_bias_reference_distribution_0/v3_four_channel_phase_distribution_0/v3_four_channel_output_collection_0/v3_four_channel_placement_0/v3_channel_selector_late_promotion_0/v3_selector_route_pilot_0/G0_MUX_POS/a_439_47# VSUBS sky130_fd_pr__nfet_01v8 ad=0 pd=0 as=0.1386 ps=1.5 w=0.42 l=0.15
X189 v3_four_channel_bias_reference_distribution_0/v3_four_channel_phase_distribution_0/v3_four_channel_output_collection_0/v3_four_channel_placement_0/v3_channel_selector_late_promotion_0/v3_selector_route_pilot_0/G0_MUX_POS/a_76_199# v3_four_channel_bias_reference_distribution_0/v3_four_channel_phase_distribution_0/phase_0 v3_four_channel_bias_reference_distribution_0/v3_four_channel_phase_distribution_0/v3_four_channel_output_collection_0/v3_four_channel_placement_0/v3_channel_selector_late_promotion_0/v3_selector_route_pilot_0/G0_MUX_POS/a_218_374# v3_four_channel_bias_reference_distribution_0/v3_four_channel_phase_distribution_0/v3_four_channel_output_collection_0/v3_four_channel_placement_0/v3_channel_selector_late_promotion_0/VPWR sky130_fd_pr__pfet_01v8_hvt ad=0.3864 pd=2.68 as=0 ps=0 w=0.42 l=0.15
X190 v3_four_channel_bias_reference_distribution_0/v3_four_channel_phase_distribution_0/v3_four_channel_output_collection_0/v3_four_channel_placement_0/v3_channel_selector_late_promotion_0/v3_selector_route_pilot_0/G0_MUX_POS/a_505_21# v3_four_channel_bias_reference_distribution_0/v3_four_channel_phase_distribution_0/v3_four_channel_output_collection_0/v3_four_channel_placement_0/v3_channel_selector_late_promotion_0/group0_bit0 VSUBS VSUBS sky130_fd_pr__nfet_01v8 ad=0.1092 pd=1.36 as=0 ps=0 w=0.42 l=0.15
X191 v3_four_channel_bias_reference_distribution_0/v3_four_channel_phase_distribution_0/v3_four_channel_output_collection_0/v3_four_channel_placement_0/v3_channel_selector_late_promotion_0/v3_selector_route_pilot_0/G0_MUX_POS/a_439_47# v3_four_channel_bias_reference_distribution_0/v3_four_channel_phase_distribution_0/phase_0 v3_four_channel_bias_reference_distribution_0/v3_four_channel_phase_distribution_0/v3_four_channel_output_collection_0/v3_four_channel_placement_0/v3_channel_selector_late_promotion_0/v3_selector_route_pilot_0/G0_MUX_POS/a_76_199# VSUBS sky130_fd_pr__nfet_01v8 ad=0 pd=0 as=0.1995 ps=1.79 w=0.42 l=0.15
X192 v3_four_channel_bias_reference_distribution_0/v3_four_channel_phase_distribution_0/v3_four_channel_output_collection_0/v3_four_channel_placement_0/v3_channel_selector_late_promotion_0/v3_selector_route_pilot_0/G0_MUX_POS/a_535_374# v3_four_channel_bias_reference_distribution_0/v3_four_channel_phase_distribution_0/phase_90 v3_four_channel_bias_reference_distribution_0/v3_four_channel_phase_distribution_0/v3_four_channel_output_collection_0/v3_four_channel_placement_0/v3_channel_selector_late_promotion_0/v3_selector_route_pilot_0/G0_MUX_POS/a_76_199# v3_four_channel_bias_reference_distribution_0/v3_four_channel_phase_distribution_0/v3_four_channel_output_collection_0/v3_four_channel_placement_0/v3_channel_selector_late_promotion_0/VPWR sky130_fd_pr__pfet_01v8_hvt ad=0 pd=0 as=0 ps=0 w=0.42 l=0.15
X193 v3_four_channel_bias_reference_distribution_0/v3_four_channel_phase_distribution_0/v3_four_channel_output_collection_0/v3_four_channel_placement_0/v3_channel_selector_late_promotion_0/v3_selector_route_pilot_0/G0_MUX_POS/a_76_199# v3_four_channel_bias_reference_distribution_0/v3_four_channel_phase_distribution_0/phase_90 v3_four_channel_bias_reference_distribution_0/v3_four_channel_phase_distribution_0/v3_four_channel_output_collection_0/v3_four_channel_placement_0/v3_channel_selector_late_promotion_0/v3_selector_route_pilot_0/G0_MUX_POS/a_218_47# VSUBS sky130_fd_pr__nfet_01v8 ad=0 pd=0 as=0.1386 ps=1.5 w=0.42 l=0.15
X194 v3_four_channel_bias_reference_distribution_0/v3_four_channel_phase_distribution_0/v3_four_channel_output_collection_0/v3_four_channel_placement_0/v3_channel_selector_late_promotion_0/v3_selector_route_pilot_0/G0_MUX_POS/a_218_47# v3_four_channel_bias_reference_distribution_0/v3_four_channel_phase_distribution_0/v3_four_channel_output_collection_0/v3_four_channel_placement_0/v3_channel_selector_late_promotion_0/group0_bit0 VSUBS VSUBS sky130_fd_pr__nfet_01v8 ad=0 pd=0 as=0 ps=0 w=0.42 l=0.15
X195 v3_four_channel_bias_reference_distribution_0/v3_four_channel_phase_distribution_0/v3_four_channel_output_collection_0/v3_four_channel_placement_0/v3_channel_selector_late_promotion_0/VPWR v3_four_channel_bias_reference_distribution_0/v3_four_channel_phase_distribution_0/v3_four_channel_output_collection_0/v3_four_channel_placement_0/v3_channel_selector_late_promotion_0/v3_selector_route_pilot_0/G0_MUX_POS/a_76_199# v3_four_channel_bias_reference_distribution_0/v3_four_channel_phase_distribution_0/v3_four_channel_output_collection_0/v3_four_channel_placement_0/v3_channel_selector_late_promotion_0/v3_selector_route_pilot_0/G0_MUX_POS/X v3_four_channel_bias_reference_distribution_0/v3_four_channel_phase_distribution_0/v3_four_channel_output_collection_0/v3_four_channel_placement_0/v3_channel_selector_late_promotion_0/VPWR sky130_fd_pr__pfet_01v8_hvt ad=0 pd=0 as=0.26 ps=2.52 w=1 l=0.15
X196 VSUBS v3_four_channel_bias_reference_distribution_0/v3_four_channel_phase_distribution_0/v3_four_channel_output_collection_0/v3_four_channel_placement_0/v3_channel_selector_late_promotion_0/v3_selector_route_pilot_0/G0_MUX_POS/a_76_199# v3_four_channel_bias_reference_distribution_0/v3_four_channel_phase_distribution_0/v3_four_channel_output_collection_0/v3_four_channel_placement_0/v3_channel_selector_late_promotion_0/v3_selector_route_pilot_0/G0_MUX_POS/X VSUBS sky130_fd_pr__nfet_01v8 ad=0 pd=0 as=0.169 ps=1.82 w=0.65 l=0.15
X197 v3_four_channel_bias_reference_distribution_0/v3_four_channel_phase_distribution_0/v3_four_channel_output_collection_0/v3_four_channel_placement_0/v3_channel_selector_late_promotion_0/VPWR v3_four_channel_bias_reference_distribution_0/v3_four_channel_phase_distribution_0/v3_four_channel_output_collection_0/v3_four_channel_placement_0/v3_channel_selector_late_promotion_0/v3_selector_route_pilot_0/G0_MUX_NEG/a_505_21# v3_four_channel_bias_reference_distribution_0/v3_four_channel_phase_distribution_0/v3_four_channel_output_collection_0/v3_four_channel_placement_0/v3_channel_selector_late_promotion_0/v3_selector_route_pilot_0/G0_MUX_NEG/a_535_374# v3_four_channel_bias_reference_distribution_0/v3_four_channel_phase_distribution_0/v3_four_channel_output_collection_0/v3_four_channel_placement_0/v3_channel_selector_late_promotion_0/VPWR sky130_fd_pr__pfet_01v8_hvt ad=0 pd=0 as=0.0882 ps=1.26 w=0.42 l=0.15
X198 v3_four_channel_bias_reference_distribution_0/v3_four_channel_phase_distribution_0/v3_four_channel_output_collection_0/v3_four_channel_placement_0/v3_channel_selector_late_promotion_0/v3_selector_route_pilot_0/G0_MUX_NEG/a_505_21# v3_four_channel_bias_reference_distribution_0/v3_four_channel_phase_distribution_0/v3_four_channel_output_collection_0/v3_four_channel_placement_0/v3_channel_selector_late_promotion_0/group0_bit0 v3_four_channel_bias_reference_distribution_0/v3_four_channel_phase_distribution_0/v3_four_channel_output_collection_0/v3_four_channel_placement_0/v3_channel_selector_late_promotion_0/VPWR v3_four_channel_bias_reference_distribution_0/v3_four_channel_phase_distribution_0/v3_four_channel_output_collection_0/v3_four_channel_placement_0/v3_channel_selector_late_promotion_0/VPWR sky130_fd_pr__pfet_01v8_hvt ad=0.1176 pd=1.4 as=0 ps=0 w=0.42 l=0.15
X199 v3_four_channel_bias_reference_distribution_0/v3_four_channel_phase_distribution_0/v3_four_channel_output_collection_0/v3_four_channel_placement_0/v3_channel_selector_late_promotion_0/v3_selector_route_pilot_0/G0_MUX_NEG/a_218_374# v3_four_channel_bias_reference_distribution_0/v3_four_channel_phase_distribution_0/v3_four_channel_output_collection_0/v3_four_channel_placement_0/v3_channel_selector_late_promotion_0/group0_bit0 v3_four_channel_bias_reference_distribution_0/v3_four_channel_phase_distribution_0/v3_four_channel_output_collection_0/v3_four_channel_placement_0/v3_channel_selector_late_promotion_0/VPWR v3_four_channel_bias_reference_distribution_0/v3_four_channel_phase_distribution_0/v3_four_channel_output_collection_0/v3_four_channel_placement_0/v3_channel_selector_late_promotion_0/VPWR sky130_fd_pr__pfet_01v8_hvt ad=0.1533 pd=1.57 as=0 ps=0 w=0.42 l=0.15
X200 VSUBS v3_four_channel_bias_reference_distribution_0/v3_four_channel_phase_distribution_0/v3_four_channel_output_collection_0/v3_four_channel_placement_0/v3_channel_selector_late_promotion_0/v3_selector_route_pilot_0/G0_MUX_NEG/a_505_21# v3_four_channel_bias_reference_distribution_0/v3_four_channel_phase_distribution_0/v3_four_channel_output_collection_0/v3_four_channel_placement_0/v3_channel_selector_late_promotion_0/v3_selector_route_pilot_0/G0_MUX_NEG/a_439_47# VSUBS sky130_fd_pr__nfet_01v8 ad=0 pd=0 as=0.1386 ps=1.5 w=0.42 l=0.15
X201 v3_four_channel_bias_reference_distribution_0/v3_four_channel_phase_distribution_0/v3_four_channel_output_collection_0/v3_four_channel_placement_0/v3_channel_selector_late_promotion_0/v3_selector_route_pilot_0/G0_MUX_NEG/a_76_199# v3_four_channel_bias_reference_distribution_0/v3_four_channel_phase_distribution_0/phase_180 v3_four_channel_bias_reference_distribution_0/v3_four_channel_phase_distribution_0/v3_four_channel_output_collection_0/v3_four_channel_placement_0/v3_channel_selector_late_promotion_0/v3_selector_route_pilot_0/G0_MUX_NEG/a_218_374# v3_four_channel_bias_reference_distribution_0/v3_four_channel_phase_distribution_0/v3_four_channel_output_collection_0/v3_four_channel_placement_0/v3_channel_selector_late_promotion_0/VPWR sky130_fd_pr__pfet_01v8_hvt ad=0.3864 pd=2.68 as=0 ps=0 w=0.42 l=0.15
X202 v3_four_channel_bias_reference_distribution_0/v3_four_channel_phase_distribution_0/v3_four_channel_output_collection_0/v3_four_channel_placement_0/v3_channel_selector_late_promotion_0/v3_selector_route_pilot_0/G0_MUX_NEG/a_505_21# v3_four_channel_bias_reference_distribution_0/v3_four_channel_phase_distribution_0/v3_four_channel_output_collection_0/v3_four_channel_placement_0/v3_channel_selector_late_promotion_0/group0_bit0 VSUBS VSUBS sky130_fd_pr__nfet_01v8 ad=0.1092 pd=1.36 as=0 ps=0 w=0.42 l=0.15
X203 v3_four_channel_bias_reference_distribution_0/v3_four_channel_phase_distribution_0/v3_four_channel_output_collection_0/v3_four_channel_placement_0/v3_channel_selector_late_promotion_0/v3_selector_route_pilot_0/G0_MUX_NEG/a_439_47# v3_four_channel_bias_reference_distribution_0/v3_four_channel_phase_distribution_0/phase_180 v3_four_channel_bias_reference_distribution_0/v3_four_channel_phase_distribution_0/v3_four_channel_output_collection_0/v3_four_channel_placement_0/v3_channel_selector_late_promotion_0/v3_selector_route_pilot_0/G0_MUX_NEG/a_76_199# VSUBS sky130_fd_pr__nfet_01v8 ad=0 pd=0 as=0.1995 ps=1.79 w=0.42 l=0.15
X204 v3_four_channel_bias_reference_distribution_0/v3_four_channel_phase_distribution_0/v3_four_channel_output_collection_0/v3_four_channel_placement_0/v3_channel_selector_late_promotion_0/v3_selector_route_pilot_0/G0_MUX_NEG/a_535_374# v3_four_channel_bias_reference_distribution_0/v3_four_channel_phase_distribution_0/phase_270 v3_four_channel_bias_reference_distribution_0/v3_four_channel_phase_distribution_0/v3_four_channel_output_collection_0/v3_four_channel_placement_0/v3_channel_selector_late_promotion_0/v3_selector_route_pilot_0/G0_MUX_NEG/a_76_199# v3_four_channel_bias_reference_distribution_0/v3_four_channel_phase_distribution_0/v3_four_channel_output_collection_0/v3_four_channel_placement_0/v3_channel_selector_late_promotion_0/VPWR sky130_fd_pr__pfet_01v8_hvt ad=0 pd=0 as=0 ps=0 w=0.42 l=0.15
X205 v3_four_channel_bias_reference_distribution_0/v3_four_channel_phase_distribution_0/v3_four_channel_output_collection_0/v3_four_channel_placement_0/v3_channel_selector_late_promotion_0/v3_selector_route_pilot_0/G0_MUX_NEG/a_76_199# v3_four_channel_bias_reference_distribution_0/v3_four_channel_phase_distribution_0/phase_270 v3_four_channel_bias_reference_distribution_0/v3_four_channel_phase_distribution_0/v3_four_channel_output_collection_0/v3_four_channel_placement_0/v3_channel_selector_late_promotion_0/v3_selector_route_pilot_0/G0_MUX_NEG/a_218_47# VSUBS sky130_fd_pr__nfet_01v8 ad=0 pd=0 as=0.1386 ps=1.5 w=0.42 l=0.15
X206 v3_four_channel_bias_reference_distribution_0/v3_four_channel_phase_distribution_0/v3_four_channel_output_collection_0/v3_four_channel_placement_0/v3_channel_selector_late_promotion_0/v3_selector_route_pilot_0/G0_MUX_NEG/a_218_47# v3_four_channel_bias_reference_distribution_0/v3_four_channel_phase_distribution_0/v3_four_channel_output_collection_0/v3_four_channel_placement_0/v3_channel_selector_late_promotion_0/group0_bit0 VSUBS VSUBS sky130_fd_pr__nfet_01v8 ad=0 pd=0 as=0 ps=0 w=0.42 l=0.15
X207 v3_four_channel_bias_reference_distribution_0/v3_four_channel_phase_distribution_0/v3_four_channel_output_collection_0/v3_four_channel_placement_0/v3_channel_selector_late_promotion_0/VPWR v3_four_channel_bias_reference_distribution_0/v3_four_channel_phase_distribution_0/v3_four_channel_output_collection_0/v3_four_channel_placement_0/v3_channel_selector_late_promotion_0/v3_selector_route_pilot_0/G0_MUX_NEG/a_76_199# v3_four_channel_bias_reference_distribution_0/v3_four_channel_phase_distribution_0/v3_four_channel_output_collection_0/v3_four_channel_placement_0/v3_channel_selector_late_promotion_0/v3_selector_route_pilot_0/G0_MUX_NEG/X v3_four_channel_bias_reference_distribution_0/v3_four_channel_phase_distribution_0/v3_four_channel_output_collection_0/v3_four_channel_placement_0/v3_channel_selector_late_promotion_0/VPWR sky130_fd_pr__pfet_01v8_hvt ad=0 pd=0 as=0.26 ps=2.52 w=1 l=0.15
X208 VSUBS v3_four_channel_bias_reference_distribution_0/v3_four_channel_phase_distribution_0/v3_four_channel_output_collection_0/v3_four_channel_placement_0/v3_channel_selector_late_promotion_0/v3_selector_route_pilot_0/G0_MUX_NEG/a_76_199# v3_four_channel_bias_reference_distribution_0/v3_four_channel_phase_distribution_0/v3_four_channel_output_collection_0/v3_four_channel_placement_0/v3_channel_selector_late_promotion_0/v3_selector_route_pilot_0/G0_MUX_NEG/X VSUBS sky130_fd_pr__nfet_01v8 ad=0 pd=0 as=0.169 ps=1.82 w=0.65 l=0.15
X209 v3_four_channel_bias_reference_distribution_0/v3_four_channel_phase_distribution_0/v3_four_channel_output_collection_0/v3_four_channel_placement_0/v3_channel_selector_late_promotion_0/VPWR v3_four_channel_bias_reference_distribution_0/v3_four_channel_phase_distribution_0/v3_four_channel_output_collection_0/v3_four_channel_placement_0/v3_channel_selector_late_promotion_0/v3_selector_route_pilot_0/G2_MUX_AXIS/a_505_21# v3_four_channel_bias_reference_distribution_0/v3_four_channel_phase_distribution_0/v3_four_channel_output_collection_0/v3_four_channel_placement_0/v3_channel_selector_late_promotion_0/v3_selector_route_pilot_0/G2_MUX_AXIS/a_535_374# v3_four_channel_bias_reference_distribution_0/v3_four_channel_phase_distribution_0/v3_four_channel_output_collection_0/v3_four_channel_placement_0/v3_channel_selector_late_promotion_0/VPWR sky130_fd_pr__pfet_01v8_hvt ad=0 pd=0 as=0.0882 ps=1.26 w=0.42 l=0.15
X210 v3_four_channel_bias_reference_distribution_0/v3_four_channel_phase_distribution_0/v3_four_channel_output_collection_0/v3_four_channel_placement_0/v3_channel_selector_late_promotion_0/v3_selector_route_pilot_0/G2_MUX_AXIS/a_505_21# v3_four_channel_bias_reference_distribution_0/v3_four_channel_phase_distribution_0/v3_four_channel_output_collection_0/v3_four_channel_placement_0/v3_channel_selector_late_promotion_0/group2_bit1 v3_four_channel_bias_reference_distribution_0/v3_four_channel_phase_distribution_0/v3_four_channel_output_collection_0/v3_four_channel_placement_0/v3_channel_selector_late_promotion_0/VPWR v3_four_channel_bias_reference_distribution_0/v3_four_channel_phase_distribution_0/v3_four_channel_output_collection_0/v3_four_channel_placement_0/v3_channel_selector_late_promotion_0/VPWR sky130_fd_pr__pfet_01v8_hvt ad=0.1176 pd=1.4 as=0 ps=0 w=0.42 l=0.15
X211 v3_four_channel_bias_reference_distribution_0/v3_four_channel_phase_distribution_0/v3_four_channel_output_collection_0/v3_four_channel_placement_0/v3_channel_selector_late_promotion_0/v3_selector_route_pilot_0/G2_MUX_AXIS/a_218_374# v3_four_channel_bias_reference_distribution_0/v3_four_channel_phase_distribution_0/v3_four_channel_output_collection_0/v3_four_channel_placement_0/v3_channel_selector_late_promotion_0/group2_bit1 v3_four_channel_bias_reference_distribution_0/v3_four_channel_phase_distribution_0/v3_four_channel_output_collection_0/v3_four_channel_placement_0/v3_channel_selector_late_promotion_0/VPWR v3_four_channel_bias_reference_distribution_0/v3_four_channel_phase_distribution_0/v3_four_channel_output_collection_0/v3_four_channel_placement_0/v3_channel_selector_late_promotion_0/VPWR sky130_fd_pr__pfet_01v8_hvt ad=0.1533 pd=1.57 as=0 ps=0 w=0.42 l=0.15
X212 VSUBS v3_four_channel_bias_reference_distribution_0/v3_four_channel_phase_distribution_0/v3_four_channel_output_collection_0/v3_four_channel_placement_0/v3_channel_selector_late_promotion_0/v3_selector_route_pilot_0/G2_MUX_AXIS/a_505_21# v3_four_channel_bias_reference_distribution_0/v3_four_channel_phase_distribution_0/v3_four_channel_output_collection_0/v3_four_channel_placement_0/v3_channel_selector_late_promotion_0/v3_selector_route_pilot_0/G2_MUX_AXIS/a_439_47# VSUBS sky130_fd_pr__nfet_01v8 ad=0 pd=0 as=0.1386 ps=1.5 w=0.42 l=0.15
X213 v3_four_channel_bias_reference_distribution_0/v3_four_channel_phase_distribution_0/v3_four_channel_output_collection_0/v3_four_channel_placement_0/v3_channel_selector_late_promotion_0/v3_selector_route_pilot_0/G2_MUX_AXIS/a_76_199# v3_four_channel_bias_reference_distribution_0/v3_four_channel_phase_distribution_0/v3_four_channel_output_collection_0/v3_four_channel_placement_0/v3_channel_selector_late_promotion_0/v3_selector_route_pilot_0/G2_MUX_POS/X v3_four_channel_bias_reference_distribution_0/v3_four_channel_phase_distribution_0/v3_four_channel_output_collection_0/v3_four_channel_placement_0/v3_channel_selector_late_promotion_0/v3_selector_route_pilot_0/G2_MUX_AXIS/a_218_374# v3_four_channel_bias_reference_distribution_0/v3_four_channel_phase_distribution_0/v3_four_channel_output_collection_0/v3_four_channel_placement_0/v3_channel_selector_late_promotion_0/VPWR sky130_fd_pr__pfet_01v8_hvt ad=0.3864 pd=2.68 as=0 ps=0 w=0.42 l=0.15
X214 v3_four_channel_bias_reference_distribution_0/v3_four_channel_phase_distribution_0/v3_four_channel_output_collection_0/v3_four_channel_placement_0/v3_channel_selector_late_promotion_0/v3_selector_route_pilot_0/G2_MUX_AXIS/a_505_21# v3_four_channel_bias_reference_distribution_0/v3_four_channel_phase_distribution_0/v3_four_channel_output_collection_0/v3_four_channel_placement_0/v3_channel_selector_late_promotion_0/group2_bit1 VSUBS VSUBS sky130_fd_pr__nfet_01v8 ad=0.1092 pd=1.36 as=0 ps=0 w=0.42 l=0.15
X215 v3_four_channel_bias_reference_distribution_0/v3_four_channel_phase_distribution_0/v3_four_channel_output_collection_0/v3_four_channel_placement_0/v3_channel_selector_late_promotion_0/v3_selector_route_pilot_0/G2_MUX_AXIS/a_439_47# v3_four_channel_bias_reference_distribution_0/v3_four_channel_phase_distribution_0/v3_four_channel_output_collection_0/v3_four_channel_placement_0/v3_channel_selector_late_promotion_0/v3_selector_route_pilot_0/G2_MUX_POS/X v3_four_channel_bias_reference_distribution_0/v3_four_channel_phase_distribution_0/v3_four_channel_output_collection_0/v3_four_channel_placement_0/v3_channel_selector_late_promotion_0/v3_selector_route_pilot_0/G2_MUX_AXIS/a_76_199# VSUBS sky130_fd_pr__nfet_01v8 ad=0 pd=0 as=0.1995 ps=1.79 w=0.42 l=0.15
X216 v3_four_channel_bias_reference_distribution_0/v3_four_channel_phase_distribution_0/v3_four_channel_output_collection_0/v3_four_channel_placement_0/v3_channel_selector_late_promotion_0/v3_selector_route_pilot_0/G2_MUX_AXIS/a_535_374# v3_four_channel_bias_reference_distribution_0/v3_four_channel_phase_distribution_0/v3_four_channel_output_collection_0/v3_four_channel_placement_0/v3_channel_selector_late_promotion_0/v3_selector_route_pilot_0/G2_MUX_NEG/X v3_four_channel_bias_reference_distribution_0/v3_four_channel_phase_distribution_0/v3_four_channel_output_collection_0/v3_four_channel_placement_0/v3_channel_selector_late_promotion_0/v3_selector_route_pilot_0/G2_MUX_AXIS/a_76_199# v3_four_channel_bias_reference_distribution_0/v3_four_channel_phase_distribution_0/v3_four_channel_output_collection_0/v3_four_channel_placement_0/v3_channel_selector_late_promotion_0/VPWR sky130_fd_pr__pfet_01v8_hvt ad=0 pd=0 as=0 ps=0 w=0.42 l=0.15
X217 v3_four_channel_bias_reference_distribution_0/v3_four_channel_phase_distribution_0/v3_four_channel_output_collection_0/v3_four_channel_placement_0/v3_channel_selector_late_promotion_0/v3_selector_route_pilot_0/G2_MUX_AXIS/a_76_199# v3_four_channel_bias_reference_distribution_0/v3_four_channel_phase_distribution_0/v3_four_channel_output_collection_0/v3_four_channel_placement_0/v3_channel_selector_late_promotion_0/v3_selector_route_pilot_0/G2_MUX_NEG/X v3_four_channel_bias_reference_distribution_0/v3_four_channel_phase_distribution_0/v3_four_channel_output_collection_0/v3_four_channel_placement_0/v3_channel_selector_late_promotion_0/v3_selector_route_pilot_0/G2_MUX_AXIS/a_218_47# VSUBS sky130_fd_pr__nfet_01v8 ad=0 pd=0 as=0.1386 ps=1.5 w=0.42 l=0.15
X218 v3_four_channel_bias_reference_distribution_0/v3_four_channel_phase_distribution_0/v3_four_channel_output_collection_0/v3_four_channel_placement_0/v3_channel_selector_late_promotion_0/v3_selector_route_pilot_0/G2_MUX_AXIS/a_218_47# v3_four_channel_bias_reference_distribution_0/v3_four_channel_phase_distribution_0/v3_four_channel_output_collection_0/v3_four_channel_placement_0/v3_channel_selector_late_promotion_0/group2_bit1 VSUBS VSUBS sky130_fd_pr__nfet_01v8 ad=0 pd=0 as=0 ps=0 w=0.42 l=0.15
X219 v3_four_channel_bias_reference_distribution_0/v3_four_channel_phase_distribution_0/v3_four_channel_output_collection_0/v3_four_channel_placement_0/v3_channel_selector_late_promotion_0/VPWR v3_four_channel_bias_reference_distribution_0/v3_four_channel_phase_distribution_0/v3_four_channel_output_collection_0/v3_four_channel_placement_0/v3_channel_selector_late_promotion_0/v3_selector_route_pilot_0/G2_MUX_AXIS/a_76_199# v3_four_channel_bias_reference_distribution_0/v3_four_channel_phase_distribution_0/v3_four_channel_output_collection_0/v3_four_channel_placement_0/v3_channel_selector_late_promotion_0/v3_selector_route_pilot_0/G2_MUX_AXIS/X v3_four_channel_bias_reference_distribution_0/v3_four_channel_phase_distribution_0/v3_four_channel_output_collection_0/v3_four_channel_placement_0/v3_channel_selector_late_promotion_0/VPWR sky130_fd_pr__pfet_01v8_hvt ad=0 pd=0 as=0.26 ps=2.52 w=1 l=0.15
X220 VSUBS v3_four_channel_bias_reference_distribution_0/v3_four_channel_phase_distribution_0/v3_four_channel_output_collection_0/v3_four_channel_placement_0/v3_channel_selector_late_promotion_0/v3_selector_route_pilot_0/G2_MUX_AXIS/a_76_199# v3_four_channel_bias_reference_distribution_0/v3_four_channel_phase_distribution_0/v3_four_channel_output_collection_0/v3_four_channel_placement_0/v3_channel_selector_late_promotion_0/v3_selector_route_pilot_0/G2_MUX_AXIS/X VSUBS sky130_fd_pr__nfet_01v8 ad=0 pd=0 as=0.169 ps=1.82 w=0.65 l=0.15
X221 v3_four_channel_bias_reference_distribution_0/v3_four_channel_phase_distribution_0/v3_four_channel_output_collection_0/v3_four_channel_placement_0/v3_channel_selector_late_promotion_0/VPWR v3_four_channel_bias_reference_distribution_0/v3_four_channel_phase_distribution_0/v3_four_channel_output_collection_0/v3_four_channel_placement_0/v3_channel_selector_late_promotion_0/v3_selector_route_pilot_0/G3_MUX_POS/a_505_21# v3_four_channel_bias_reference_distribution_0/v3_four_channel_phase_distribution_0/v3_four_channel_output_collection_0/v3_four_channel_placement_0/v3_channel_selector_late_promotion_0/v3_selector_route_pilot_0/G3_MUX_POS/a_535_374# v3_four_channel_bias_reference_distribution_0/v3_four_channel_phase_distribution_0/v3_four_channel_output_collection_0/v3_four_channel_placement_0/v3_channel_selector_late_promotion_0/VPWR sky130_fd_pr__pfet_01v8_hvt ad=0 pd=0 as=0.0882 ps=1.26 w=0.42 l=0.15
X222 v3_four_channel_bias_reference_distribution_0/v3_four_channel_phase_distribution_0/v3_four_channel_output_collection_0/v3_four_channel_placement_0/v3_channel_selector_late_promotion_0/v3_selector_route_pilot_0/G3_MUX_POS/a_505_21# v3_four_channel_bias_reference_distribution_0/v3_four_channel_phase_distribution_0/v3_four_channel_output_collection_0/v3_four_channel_placement_0/v3_channel_selector_late_promotion_0/group3_bit0 v3_four_channel_bias_reference_distribution_0/v3_four_channel_phase_distribution_0/v3_four_channel_output_collection_0/v3_four_channel_placement_0/v3_channel_selector_late_promotion_0/VPWR v3_four_channel_bias_reference_distribution_0/v3_four_channel_phase_distribution_0/v3_four_channel_output_collection_0/v3_four_channel_placement_0/v3_channel_selector_late_promotion_0/VPWR sky130_fd_pr__pfet_01v8_hvt ad=0.1176 pd=1.4 as=0 ps=0 w=0.42 l=0.15
X223 v3_four_channel_bias_reference_distribution_0/v3_four_channel_phase_distribution_0/v3_four_channel_output_collection_0/v3_four_channel_placement_0/v3_channel_selector_late_promotion_0/v3_selector_route_pilot_0/G3_MUX_POS/a_218_374# v3_four_channel_bias_reference_distribution_0/v3_four_channel_phase_distribution_0/v3_four_channel_output_collection_0/v3_four_channel_placement_0/v3_channel_selector_late_promotion_0/group3_bit0 v3_four_channel_bias_reference_distribution_0/v3_four_channel_phase_distribution_0/v3_four_channel_output_collection_0/v3_four_channel_placement_0/v3_channel_selector_late_promotion_0/VPWR v3_four_channel_bias_reference_distribution_0/v3_four_channel_phase_distribution_0/v3_four_channel_output_collection_0/v3_four_channel_placement_0/v3_channel_selector_late_promotion_0/VPWR sky130_fd_pr__pfet_01v8_hvt ad=0.1533 pd=1.57 as=0 ps=0 w=0.42 l=0.15
X224 VSUBS v3_four_channel_bias_reference_distribution_0/v3_four_channel_phase_distribution_0/v3_four_channel_output_collection_0/v3_four_channel_placement_0/v3_channel_selector_late_promotion_0/v3_selector_route_pilot_0/G3_MUX_POS/a_505_21# v3_four_channel_bias_reference_distribution_0/v3_four_channel_phase_distribution_0/v3_four_channel_output_collection_0/v3_four_channel_placement_0/v3_channel_selector_late_promotion_0/v3_selector_route_pilot_0/G3_MUX_POS/a_439_47# VSUBS sky130_fd_pr__nfet_01v8 ad=0 pd=0 as=0.1386 ps=1.5 w=0.42 l=0.15
X225 v3_four_channel_bias_reference_distribution_0/v3_four_channel_phase_distribution_0/v3_four_channel_output_collection_0/v3_four_channel_placement_0/v3_channel_selector_late_promotion_0/v3_selector_route_pilot_0/G3_MUX_POS/a_76_199# v3_four_channel_bias_reference_distribution_0/v3_four_channel_phase_distribution_0/phase_0 v3_four_channel_bias_reference_distribution_0/v3_four_channel_phase_distribution_0/v3_four_channel_output_collection_0/v3_four_channel_placement_0/v3_channel_selector_late_promotion_0/v3_selector_route_pilot_0/G3_MUX_POS/a_218_374# v3_four_channel_bias_reference_distribution_0/v3_four_channel_phase_distribution_0/v3_four_channel_output_collection_0/v3_four_channel_placement_0/v3_channel_selector_late_promotion_0/VPWR sky130_fd_pr__pfet_01v8_hvt ad=0.3864 pd=2.68 as=0 ps=0 w=0.42 l=0.15
X226 v3_four_channel_bias_reference_distribution_0/v3_four_channel_phase_distribution_0/v3_four_channel_output_collection_0/v3_four_channel_placement_0/v3_channel_selector_late_promotion_0/v3_selector_route_pilot_0/G3_MUX_POS/a_505_21# v3_four_channel_bias_reference_distribution_0/v3_four_channel_phase_distribution_0/v3_four_channel_output_collection_0/v3_four_channel_placement_0/v3_channel_selector_late_promotion_0/group3_bit0 VSUBS VSUBS sky130_fd_pr__nfet_01v8 ad=0.1092 pd=1.36 as=0 ps=0 w=0.42 l=0.15
X227 v3_four_channel_bias_reference_distribution_0/v3_four_channel_phase_distribution_0/v3_four_channel_output_collection_0/v3_four_channel_placement_0/v3_channel_selector_late_promotion_0/v3_selector_route_pilot_0/G3_MUX_POS/a_439_47# v3_four_channel_bias_reference_distribution_0/v3_four_channel_phase_distribution_0/phase_0 v3_four_channel_bias_reference_distribution_0/v3_four_channel_phase_distribution_0/v3_four_channel_output_collection_0/v3_four_channel_placement_0/v3_channel_selector_late_promotion_0/v3_selector_route_pilot_0/G3_MUX_POS/a_76_199# VSUBS sky130_fd_pr__nfet_01v8 ad=0 pd=0 as=0.1995 ps=1.79 w=0.42 l=0.15
X228 v3_four_channel_bias_reference_distribution_0/v3_four_channel_phase_distribution_0/v3_four_channel_output_collection_0/v3_four_channel_placement_0/v3_channel_selector_late_promotion_0/v3_selector_route_pilot_0/G3_MUX_POS/a_535_374# v3_four_channel_bias_reference_distribution_0/v3_four_channel_phase_distribution_0/phase_90 v3_four_channel_bias_reference_distribution_0/v3_four_channel_phase_distribution_0/v3_four_channel_output_collection_0/v3_four_channel_placement_0/v3_channel_selector_late_promotion_0/v3_selector_route_pilot_0/G3_MUX_POS/a_76_199# v3_four_channel_bias_reference_distribution_0/v3_four_channel_phase_distribution_0/v3_four_channel_output_collection_0/v3_four_channel_placement_0/v3_channel_selector_late_promotion_0/VPWR sky130_fd_pr__pfet_01v8_hvt ad=0 pd=0 as=0 ps=0 w=0.42 l=0.15
X229 v3_four_channel_bias_reference_distribution_0/v3_four_channel_phase_distribution_0/v3_four_channel_output_collection_0/v3_four_channel_placement_0/v3_channel_selector_late_promotion_0/v3_selector_route_pilot_0/G3_MUX_POS/a_76_199# v3_four_channel_bias_reference_distribution_0/v3_four_channel_phase_distribution_0/phase_90 v3_four_channel_bias_reference_distribution_0/v3_four_channel_phase_distribution_0/v3_four_channel_output_collection_0/v3_four_channel_placement_0/v3_channel_selector_late_promotion_0/v3_selector_route_pilot_0/G3_MUX_POS/a_218_47# VSUBS sky130_fd_pr__nfet_01v8 ad=0 pd=0 as=0.1386 ps=1.5 w=0.42 l=0.15
X230 v3_four_channel_bias_reference_distribution_0/v3_four_channel_phase_distribution_0/v3_four_channel_output_collection_0/v3_four_channel_placement_0/v3_channel_selector_late_promotion_0/v3_selector_route_pilot_0/G3_MUX_POS/a_218_47# v3_four_channel_bias_reference_distribution_0/v3_four_channel_phase_distribution_0/v3_four_channel_output_collection_0/v3_four_channel_placement_0/v3_channel_selector_late_promotion_0/group3_bit0 VSUBS VSUBS sky130_fd_pr__nfet_01v8 ad=0 pd=0 as=0 ps=0 w=0.42 l=0.15
X231 v3_four_channel_bias_reference_distribution_0/v3_four_channel_phase_distribution_0/v3_four_channel_output_collection_0/v3_four_channel_placement_0/v3_channel_selector_late_promotion_0/VPWR v3_four_channel_bias_reference_distribution_0/v3_four_channel_phase_distribution_0/v3_four_channel_output_collection_0/v3_four_channel_placement_0/v3_channel_selector_late_promotion_0/v3_selector_route_pilot_0/G3_MUX_POS/a_76_199# v3_four_channel_bias_reference_distribution_0/v3_four_channel_phase_distribution_0/v3_four_channel_output_collection_0/v3_four_channel_placement_0/v3_channel_selector_late_promotion_0/v3_selector_route_pilot_0/G3_MUX_POS/X v3_four_channel_bias_reference_distribution_0/v3_four_channel_phase_distribution_0/v3_four_channel_output_collection_0/v3_four_channel_placement_0/v3_channel_selector_late_promotion_0/VPWR sky130_fd_pr__pfet_01v8_hvt ad=0 pd=0 as=0.26 ps=2.52 w=1 l=0.15
X232 VSUBS v3_four_channel_bias_reference_distribution_0/v3_four_channel_phase_distribution_0/v3_four_channel_output_collection_0/v3_four_channel_placement_0/v3_channel_selector_late_promotion_0/v3_selector_route_pilot_0/G3_MUX_POS/a_76_199# v3_four_channel_bias_reference_distribution_0/v3_four_channel_phase_distribution_0/v3_four_channel_output_collection_0/v3_four_channel_placement_0/v3_channel_selector_late_promotion_0/v3_selector_route_pilot_0/G3_MUX_POS/X VSUBS sky130_fd_pr__nfet_01v8 ad=0 pd=0 as=0.169 ps=1.82 w=0.65 l=0.15
X233 v3_four_channel_bias_reference_distribution_0/v3_four_channel_phase_distribution_0/v3_four_channel_output_collection_0/v3_four_channel_placement_0/v3_channel_selector_late_promotion_0/VPWR v3_four_channel_bias_reference_distribution_0/v3_four_channel_phase_distribution_0/v3_four_channel_output_collection_0/v3_four_channel_placement_0/v3_channel_selector_late_promotion_0/v3_selector_route_pilot_0/G3_MUX_NEG/a_505_21# v3_four_channel_bias_reference_distribution_0/v3_four_channel_phase_distribution_0/v3_four_channel_output_collection_0/v3_four_channel_placement_0/v3_channel_selector_late_promotion_0/v3_selector_route_pilot_0/G3_MUX_NEG/a_535_374# v3_four_channel_bias_reference_distribution_0/v3_four_channel_phase_distribution_0/v3_four_channel_output_collection_0/v3_four_channel_placement_0/v3_channel_selector_late_promotion_0/VPWR sky130_fd_pr__pfet_01v8_hvt ad=0 pd=0 as=0.0882 ps=1.26 w=0.42 l=0.15
X234 v3_four_channel_bias_reference_distribution_0/v3_four_channel_phase_distribution_0/v3_four_channel_output_collection_0/v3_four_channel_placement_0/v3_channel_selector_late_promotion_0/v3_selector_route_pilot_0/G3_MUX_NEG/a_505_21# v3_four_channel_bias_reference_distribution_0/v3_four_channel_phase_distribution_0/v3_four_channel_output_collection_0/v3_four_channel_placement_0/v3_channel_selector_late_promotion_0/group3_bit0 v3_four_channel_bias_reference_distribution_0/v3_four_channel_phase_distribution_0/v3_four_channel_output_collection_0/v3_four_channel_placement_0/v3_channel_selector_late_promotion_0/VPWR v3_four_channel_bias_reference_distribution_0/v3_four_channel_phase_distribution_0/v3_four_channel_output_collection_0/v3_four_channel_placement_0/v3_channel_selector_late_promotion_0/VPWR sky130_fd_pr__pfet_01v8_hvt ad=0.1176 pd=1.4 as=0 ps=0 w=0.42 l=0.15
X235 v3_four_channel_bias_reference_distribution_0/v3_four_channel_phase_distribution_0/v3_four_channel_output_collection_0/v3_four_channel_placement_0/v3_channel_selector_late_promotion_0/v3_selector_route_pilot_0/G3_MUX_NEG/a_218_374# v3_four_channel_bias_reference_distribution_0/v3_four_channel_phase_distribution_0/v3_four_channel_output_collection_0/v3_four_channel_placement_0/v3_channel_selector_late_promotion_0/group3_bit0 v3_four_channel_bias_reference_distribution_0/v3_four_channel_phase_distribution_0/v3_four_channel_output_collection_0/v3_four_channel_placement_0/v3_channel_selector_late_promotion_0/VPWR v3_four_channel_bias_reference_distribution_0/v3_four_channel_phase_distribution_0/v3_four_channel_output_collection_0/v3_four_channel_placement_0/v3_channel_selector_late_promotion_0/VPWR sky130_fd_pr__pfet_01v8_hvt ad=0.1533 pd=1.57 as=0 ps=0 w=0.42 l=0.15
X236 VSUBS v3_four_channel_bias_reference_distribution_0/v3_four_channel_phase_distribution_0/v3_four_channel_output_collection_0/v3_four_channel_placement_0/v3_channel_selector_late_promotion_0/v3_selector_route_pilot_0/G3_MUX_NEG/a_505_21# v3_four_channel_bias_reference_distribution_0/v3_four_channel_phase_distribution_0/v3_four_channel_output_collection_0/v3_four_channel_placement_0/v3_channel_selector_late_promotion_0/v3_selector_route_pilot_0/G3_MUX_NEG/a_439_47# VSUBS sky130_fd_pr__nfet_01v8 ad=0 pd=0 as=0.1386 ps=1.5 w=0.42 l=0.15
X237 v3_four_channel_bias_reference_distribution_0/v3_four_channel_phase_distribution_0/v3_four_channel_output_collection_0/v3_four_channel_placement_0/v3_channel_selector_late_promotion_0/v3_selector_route_pilot_0/G3_MUX_NEG/a_76_199# v3_four_channel_bias_reference_distribution_0/v3_four_channel_phase_distribution_0/phase_180 v3_four_channel_bias_reference_distribution_0/v3_four_channel_phase_distribution_0/v3_four_channel_output_collection_0/v3_four_channel_placement_0/v3_channel_selector_late_promotion_0/v3_selector_route_pilot_0/G3_MUX_NEG/a_218_374# v3_four_channel_bias_reference_distribution_0/v3_four_channel_phase_distribution_0/v3_four_channel_output_collection_0/v3_four_channel_placement_0/v3_channel_selector_late_promotion_0/VPWR sky130_fd_pr__pfet_01v8_hvt ad=0.3864 pd=2.68 as=0 ps=0 w=0.42 l=0.15
X238 v3_four_channel_bias_reference_distribution_0/v3_four_channel_phase_distribution_0/v3_four_channel_output_collection_0/v3_four_channel_placement_0/v3_channel_selector_late_promotion_0/v3_selector_route_pilot_0/G3_MUX_NEG/a_505_21# v3_four_channel_bias_reference_distribution_0/v3_four_channel_phase_distribution_0/v3_four_channel_output_collection_0/v3_four_channel_placement_0/v3_channel_selector_late_promotion_0/group3_bit0 VSUBS VSUBS sky130_fd_pr__nfet_01v8 ad=0.1092 pd=1.36 as=0 ps=0 w=0.42 l=0.15
X239 v3_four_channel_bias_reference_distribution_0/v3_four_channel_phase_distribution_0/v3_four_channel_output_collection_0/v3_four_channel_placement_0/v3_channel_selector_late_promotion_0/v3_selector_route_pilot_0/G3_MUX_NEG/a_439_47# v3_four_channel_bias_reference_distribution_0/v3_four_channel_phase_distribution_0/phase_180 v3_four_channel_bias_reference_distribution_0/v3_four_channel_phase_distribution_0/v3_four_channel_output_collection_0/v3_four_channel_placement_0/v3_channel_selector_late_promotion_0/v3_selector_route_pilot_0/G3_MUX_NEG/a_76_199# VSUBS sky130_fd_pr__nfet_01v8 ad=0 pd=0 as=0.1995 ps=1.79 w=0.42 l=0.15
X240 v3_four_channel_bias_reference_distribution_0/v3_four_channel_phase_distribution_0/v3_four_channel_output_collection_0/v3_four_channel_placement_0/v3_channel_selector_late_promotion_0/v3_selector_route_pilot_0/G3_MUX_NEG/a_535_374# v3_four_channel_bias_reference_distribution_0/v3_four_channel_phase_distribution_0/phase_270 v3_four_channel_bias_reference_distribution_0/v3_four_channel_phase_distribution_0/v3_four_channel_output_collection_0/v3_four_channel_placement_0/v3_channel_selector_late_promotion_0/v3_selector_route_pilot_0/G3_MUX_NEG/a_76_199# v3_four_channel_bias_reference_distribution_0/v3_four_channel_phase_distribution_0/v3_four_channel_output_collection_0/v3_four_channel_placement_0/v3_channel_selector_late_promotion_0/VPWR sky130_fd_pr__pfet_01v8_hvt ad=0 pd=0 as=0 ps=0 w=0.42 l=0.15
X241 v3_four_channel_bias_reference_distribution_0/v3_four_channel_phase_distribution_0/v3_four_channel_output_collection_0/v3_four_channel_placement_0/v3_channel_selector_late_promotion_0/v3_selector_route_pilot_0/G3_MUX_NEG/a_76_199# v3_four_channel_bias_reference_distribution_0/v3_four_channel_phase_distribution_0/phase_270 v3_four_channel_bias_reference_distribution_0/v3_four_channel_phase_distribution_0/v3_four_channel_output_collection_0/v3_four_channel_placement_0/v3_channel_selector_late_promotion_0/v3_selector_route_pilot_0/G3_MUX_NEG/a_218_47# VSUBS sky130_fd_pr__nfet_01v8 ad=0 pd=0 as=0.1386 ps=1.5 w=0.42 l=0.15
X242 v3_four_channel_bias_reference_distribution_0/v3_four_channel_phase_distribution_0/v3_four_channel_output_collection_0/v3_four_channel_placement_0/v3_channel_selector_late_promotion_0/v3_selector_route_pilot_0/G3_MUX_NEG/a_218_47# v3_four_channel_bias_reference_distribution_0/v3_four_channel_phase_distribution_0/v3_four_channel_output_collection_0/v3_four_channel_placement_0/v3_channel_selector_late_promotion_0/group3_bit0 VSUBS VSUBS sky130_fd_pr__nfet_01v8 ad=0 pd=0 as=0 ps=0 w=0.42 l=0.15
X243 v3_four_channel_bias_reference_distribution_0/v3_four_channel_phase_distribution_0/v3_four_channel_output_collection_0/v3_four_channel_placement_0/v3_channel_selector_late_promotion_0/VPWR v3_four_channel_bias_reference_distribution_0/v3_four_channel_phase_distribution_0/v3_four_channel_output_collection_0/v3_four_channel_placement_0/v3_channel_selector_late_promotion_0/v3_selector_route_pilot_0/G3_MUX_NEG/a_76_199# v3_four_channel_bias_reference_distribution_0/v3_four_channel_phase_distribution_0/v3_four_channel_output_collection_0/v3_four_channel_placement_0/v3_channel_selector_late_promotion_0/v3_selector_route_pilot_0/G3_MUX_NEG/X v3_four_channel_bias_reference_distribution_0/v3_four_channel_phase_distribution_0/v3_four_channel_output_collection_0/v3_four_channel_placement_0/v3_channel_selector_late_promotion_0/VPWR sky130_fd_pr__pfet_01v8_hvt ad=0 pd=0 as=0.26 ps=2.52 w=1 l=0.15
X244 VSUBS v3_four_channel_bias_reference_distribution_0/v3_four_channel_phase_distribution_0/v3_four_channel_output_collection_0/v3_four_channel_placement_0/v3_channel_selector_late_promotion_0/v3_selector_route_pilot_0/G3_MUX_NEG/a_76_199# v3_four_channel_bias_reference_distribution_0/v3_four_channel_phase_distribution_0/v3_four_channel_output_collection_0/v3_four_channel_placement_0/v3_channel_selector_late_promotion_0/v3_selector_route_pilot_0/G3_MUX_NEG/X VSUBS sky130_fd_pr__nfet_01v8 ad=0 pd=0 as=0.169 ps=1.82 w=0.65 l=0.15
X245 v3_four_channel_bias_reference_distribution_0/v3_four_channel_phase_distribution_0/v3_four_channel_output_collection_0/v3_four_channel_placement_0/v3_channel_selector_late_promotion_0/VPWR v3_four_channel_bias_reference_distribution_0/v3_four_channel_phase_distribution_0/v3_four_channel_output_collection_0/v3_four_channel_placement_0/v3_channel_selector_late_promotion_0/v3_selector_route_pilot_0/G3_LO_P_AND/B v3_four_channel_bias_reference_distribution_0/v3_four_channel_phase_distribution_0/v3_four_channel_output_collection_0/v3_four_channel_placement_0/v3_channel_selector_late_promotion_0/v3_selector_route_pilot_0/G0_LO_P_AND/a_59_75# v3_four_channel_bias_reference_distribution_0/v3_four_channel_phase_distribution_0/v3_four_channel_output_collection_0/v3_four_channel_placement_0/v3_channel_selector_late_promotion_0/VPWR sky130_fd_pr__pfet_01v8_hvt ad=0 pd=0 as=0.1134 ps=1.38 w=0.42 l=0.15
X246 v3_four_channel_bias_reference_distribution_0/v3_four_channel_phase_distribution_0/v3_four_channel_output_collection_0/v3_four_channel_placement_0/v3_channel_selector_late_promotion_0/v3_selector_route_pilot_0/group0_lo_p v3_four_channel_bias_reference_distribution_0/v3_four_channel_phase_distribution_0/v3_four_channel_output_collection_0/v3_four_channel_placement_0/v3_channel_selector_late_promotion_0/v3_selector_route_pilot_0/G0_LO_P_AND/a_59_75# v3_four_channel_bias_reference_distribution_0/v3_four_channel_phase_distribution_0/v3_four_channel_output_collection_0/v3_four_channel_placement_0/v3_channel_selector_late_promotion_0/VPWR v3_four_channel_bias_reference_distribution_0/v3_four_channel_phase_distribution_0/v3_four_channel_output_collection_0/v3_four_channel_placement_0/v3_channel_selector_late_promotion_0/VPWR sky130_fd_pr__pfet_01v8_hvt ad=0.475 pd=2.95 as=0 ps=0 w=1 l=0.15
X247 VSUBS v3_four_channel_bias_reference_distribution_0/v3_four_channel_phase_distribution_0/v3_four_channel_output_collection_0/v3_four_channel_placement_0/v3_channel_selector_late_promotion_0/v3_selector_route_pilot_0/G3_LO_P_AND/B v3_four_channel_bias_reference_distribution_0/v3_four_channel_phase_distribution_0/v3_four_channel_output_collection_0/v3_four_channel_placement_0/v3_channel_selector_late_promotion_0/v3_selector_route_pilot_0/G0_LO_P_AND/a_145_75# VSUBS sky130_fd_pr__nfet_01v8 ad=0 pd=0 as=0.1134 ps=1.38 w=0.42 l=0.15
X248 v3_four_channel_bias_reference_distribution_0/v3_four_channel_phase_distribution_0/v3_four_channel_output_collection_0/v3_four_channel_placement_0/v3_channel_selector_late_promotion_0/v3_selector_route_pilot_0/G0_LO_P_AND/a_59_75# v3_four_channel_bias_reference_distribution_0/v3_four_channel_phase_distribution_0/v3_four_channel_output_collection_0/v3_four_channel_placement_0/v3_channel_selector_late_promotion_0/v3_selector_route_pilot_0/G0_MUX_AXIS/X v3_four_channel_bias_reference_distribution_0/v3_four_channel_phase_distribution_0/v3_four_channel_output_collection_0/v3_four_channel_placement_0/v3_channel_selector_late_promotion_0/VPWR v3_four_channel_bias_reference_distribution_0/v3_four_channel_phase_distribution_0/v3_four_channel_output_collection_0/v3_four_channel_placement_0/v3_channel_selector_late_promotion_0/VPWR sky130_fd_pr__pfet_01v8_hvt ad=0 pd=0 as=0 ps=0 w=0.42 l=0.15
X249 v3_four_channel_bias_reference_distribution_0/v3_four_channel_phase_distribution_0/v3_four_channel_output_collection_0/v3_four_channel_placement_0/v3_channel_selector_late_promotion_0/v3_selector_route_pilot_0/group0_lo_p v3_four_channel_bias_reference_distribution_0/v3_four_channel_phase_distribution_0/v3_four_channel_output_collection_0/v3_four_channel_placement_0/v3_channel_selector_late_promotion_0/v3_selector_route_pilot_0/G0_LO_P_AND/a_59_75# VSUBS VSUBS sky130_fd_pr__nfet_01v8 ad=0.182 pd=1.86 as=0 ps=0 w=0.65 l=0.15
X250 v3_four_channel_bias_reference_distribution_0/v3_four_channel_phase_distribution_0/v3_four_channel_output_collection_0/v3_four_channel_placement_0/v3_channel_selector_late_promotion_0/v3_selector_route_pilot_0/G0_LO_P_AND/a_145_75# v3_four_channel_bias_reference_distribution_0/v3_four_channel_phase_distribution_0/v3_four_channel_output_collection_0/v3_four_channel_placement_0/v3_channel_selector_late_promotion_0/v3_selector_route_pilot_0/G0_MUX_AXIS/X v3_four_channel_bias_reference_distribution_0/v3_four_channel_phase_distribution_0/v3_four_channel_output_collection_0/v3_four_channel_placement_0/v3_channel_selector_late_promotion_0/v3_selector_route_pilot_0/G0_LO_P_AND/a_59_75# VSUBS sky130_fd_pr__nfet_01v8 ad=0 pd=0 as=0.1176 ps=1.4 w=0.42 l=0.15
X251 v3_four_channel_bias_reference_distribution_0/v3_four_channel_phase_distribution_0/v3_four_channel_output_collection_0/v3_four_channel_placement_0/v3_channel_selector_late_promotion_0/VPWR v3_four_channel_bias_reference_distribution_0/v3_four_channel_phase_distribution_0/v3_four_channel_output_collection_0/v3_four_channel_placement_0/v3_channel_selector_late_promotion_0/v3_selector_route_pilot_0/G3_LO_P_AND/B v3_four_channel_bias_reference_distribution_0/v3_four_channel_phase_distribution_0/v3_four_channel_output_collection_0/v3_four_channel_placement_0/v3_channel_selector_late_promotion_0/v3_selector_route_pilot_0/G3_LO_N_ANDNOT/a_207_413# v3_four_channel_bias_reference_distribution_0/v3_four_channel_phase_distribution_0/v3_four_channel_output_collection_0/v3_four_channel_placement_0/v3_channel_selector_late_promotion_0/VPWR sky130_fd_pr__pfet_01v8_hvt ad=0 pd=0 as=0.1218 ps=1.42 w=0.42 l=0.15
X252 v3_four_channel_bias_reference_distribution_0/v3_four_channel_phase_distribution_0/v3_four_channel_output_collection_0/v3_four_channel_placement_0/v3_channel_selector_late_promotion_0/v3_selector_route_pilot_0/group3_lo_n v3_four_channel_bias_reference_distribution_0/v3_four_channel_phase_distribution_0/v3_four_channel_output_collection_0/v3_four_channel_placement_0/v3_channel_selector_late_promotion_0/v3_selector_route_pilot_0/G3_LO_N_ANDNOT/a_207_413# v3_four_channel_bias_reference_distribution_0/v3_four_channel_phase_distribution_0/v3_four_channel_output_collection_0/v3_four_channel_placement_0/v3_channel_selector_late_promotion_0/VPWR v3_four_channel_bias_reference_distribution_0/v3_four_channel_phase_distribution_0/v3_four_channel_output_collection_0/v3_four_channel_placement_0/v3_channel_selector_late_promotion_0/VPWR sky130_fd_pr__pfet_01v8_hvt ad=0.26 pd=2.52 as=0 ps=0 w=1 l=0.15
X253 v3_four_channel_bias_reference_distribution_0/v3_four_channel_phase_distribution_0/v3_four_channel_output_collection_0/v3_four_channel_placement_0/v3_channel_selector_late_promotion_0/v3_selector_route_pilot_0/G3_LO_N_ANDNOT/a_297_47# v3_four_channel_bias_reference_distribution_0/v3_four_channel_phase_distribution_0/v3_four_channel_output_collection_0/v3_four_channel_placement_0/v3_channel_selector_late_promotion_0/v3_selector_route_pilot_0/G3_LO_N_ANDNOT/a_27_413# v3_four_channel_bias_reference_distribution_0/v3_four_channel_phase_distribution_0/v3_four_channel_output_collection_0/v3_four_channel_placement_0/v3_channel_selector_late_promotion_0/v3_selector_route_pilot_0/G3_LO_N_ANDNOT/a_207_413# VSUBS sky130_fd_pr__nfet_01v8 ad=0.1008 pd=1.32 as=0.1092 ps=1.36 w=0.42 l=0.15
X254 v3_four_channel_bias_reference_distribution_0/v3_four_channel_phase_distribution_0/v3_four_channel_output_collection_0/v3_four_channel_placement_0/v3_channel_selector_late_promotion_0/v3_selector_route_pilot_0/group3_lo_n v3_four_channel_bias_reference_distribution_0/v3_four_channel_phase_distribution_0/v3_four_channel_output_collection_0/v3_four_channel_placement_0/v3_channel_selector_late_promotion_0/v3_selector_route_pilot_0/G3_LO_N_ANDNOT/a_207_413# VSUBS VSUBS sky130_fd_pr__nfet_01v8 ad=0.169 pd=1.82 as=0 ps=0 w=0.65 l=0.15
X255 v3_four_channel_bias_reference_distribution_0/v3_four_channel_phase_distribution_0/v3_four_channel_output_collection_0/v3_four_channel_placement_0/v3_channel_selector_late_promotion_0/v3_selector_route_pilot_0/G3_LO_N_ANDNOT/a_207_413# v3_four_channel_bias_reference_distribution_0/v3_four_channel_phase_distribution_0/v3_four_channel_output_collection_0/v3_four_channel_placement_0/v3_channel_selector_late_promotion_0/v3_selector_route_pilot_0/G3_LO_N_ANDNOT/a_27_413# v3_four_channel_bias_reference_distribution_0/v3_four_channel_phase_distribution_0/v3_four_channel_output_collection_0/v3_four_channel_placement_0/v3_channel_selector_late_promotion_0/VPWR v3_four_channel_bias_reference_distribution_0/v3_four_channel_phase_distribution_0/v3_four_channel_output_collection_0/v3_four_channel_placement_0/v3_channel_selector_late_promotion_0/VPWR sky130_fd_pr__pfet_01v8_hvt ad=0 pd=0 as=0 ps=0 w=0.42 l=0.15
X256 v3_four_channel_bias_reference_distribution_0/v3_four_channel_phase_distribution_0/v3_four_channel_output_collection_0/v3_four_channel_placement_0/v3_channel_selector_late_promotion_0/VPWR v3_four_channel_bias_reference_distribution_0/v3_four_channel_phase_distribution_0/v3_four_channel_output_collection_0/v3_four_channel_placement_0/v3_channel_selector_late_promotion_0/v3_selector_route_pilot_0/G3_MUX_AXIS/X v3_four_channel_bias_reference_distribution_0/v3_four_channel_phase_distribution_0/v3_four_channel_output_collection_0/v3_four_channel_placement_0/v3_channel_selector_late_promotion_0/v3_selector_route_pilot_0/G3_LO_N_ANDNOT/a_27_413# v3_four_channel_bias_reference_distribution_0/v3_four_channel_phase_distribution_0/v3_four_channel_output_collection_0/v3_four_channel_placement_0/v3_channel_selector_late_promotion_0/VPWR sky130_fd_pr__pfet_01v8_hvt ad=0 pd=0 as=0.1092 ps=1.36 w=0.42 l=0.15
X257 VSUBS v3_four_channel_bias_reference_distribution_0/v3_four_channel_phase_distribution_0/v3_four_channel_output_collection_0/v3_four_channel_placement_0/v3_channel_selector_late_promotion_0/v3_selector_route_pilot_0/G3_LO_P_AND/B v3_four_channel_bias_reference_distribution_0/v3_four_channel_phase_distribution_0/v3_four_channel_output_collection_0/v3_four_channel_placement_0/v3_channel_selector_late_promotion_0/v3_selector_route_pilot_0/G3_LO_N_ANDNOT/a_297_47# VSUBS sky130_fd_pr__nfet_01v8 ad=0 pd=0 as=0 ps=0 w=0.42 l=0.15
X258 v3_four_channel_bias_reference_distribution_0/v3_four_channel_phase_distribution_0/v3_four_channel_output_collection_0/v3_four_channel_placement_0/v3_channel_selector_late_promotion_0/v3_selector_route_pilot_0/G3_LO_N_ANDNOT/a_27_413# v3_four_channel_bias_reference_distribution_0/v3_four_channel_phase_distribution_0/v3_four_channel_output_collection_0/v3_four_channel_placement_0/v3_channel_selector_late_promotion_0/v3_selector_route_pilot_0/G3_MUX_AXIS/X VSUBS VSUBS sky130_fd_pr__nfet_01v8 ad=0.1092 pd=1.36 as=0 ps=0 w=0.42 l=0.15
X259 v3_four_channel_bias_reference_distribution_0/v3_four_channel_phase_distribution_0/v3_four_channel_output_collection_0/v3_four_channel_placement_0/v3_channel_selector_late_promotion_0/VPWR v3_four_channel_bias_reference_distribution_0/v3_four_channel_phase_distribution_0/v3_four_channel_output_collection_0/v3_four_channel_placement_0/v3_channel_selector_late_promotion_0/v3_selector_route_pilot_0/G3_LO_P_AND/B v3_four_channel_bias_reference_distribution_0/v3_four_channel_phase_distribution_0/v3_four_channel_output_collection_0/v3_four_channel_placement_0/v3_channel_selector_late_promotion_0/v3_selector_route_pilot_0/G2_LO_N_ANDNOT/a_207_413# v3_four_channel_bias_reference_distribution_0/v3_four_channel_phase_distribution_0/v3_four_channel_output_collection_0/v3_four_channel_placement_0/v3_channel_selector_late_promotion_0/VPWR sky130_fd_pr__pfet_01v8_hvt ad=0 pd=0 as=0.1218 ps=1.42 w=0.42 l=0.15
X260 v3_four_channel_bias_reference_distribution_0/v3_four_channel_phase_distribution_0/v3_four_channel_output_collection_0/v3_four_channel_placement_0/v3_channel_selector_late_promotion_0/v3_selector_route_pilot_0/group2_lo_n v3_four_channel_bias_reference_distribution_0/v3_four_channel_phase_distribution_0/v3_four_channel_output_collection_0/v3_four_channel_placement_0/v3_channel_selector_late_promotion_0/v3_selector_route_pilot_0/G2_LO_N_ANDNOT/a_207_413# v3_four_channel_bias_reference_distribution_0/v3_four_channel_phase_distribution_0/v3_four_channel_output_collection_0/v3_four_channel_placement_0/v3_channel_selector_late_promotion_0/VPWR v3_four_channel_bias_reference_distribution_0/v3_four_channel_phase_distribution_0/v3_four_channel_output_collection_0/v3_four_channel_placement_0/v3_channel_selector_late_promotion_0/VPWR sky130_fd_pr__pfet_01v8_hvt ad=0.26 pd=2.52 as=0 ps=0 w=1 l=0.15
X261 v3_four_channel_bias_reference_distribution_0/v3_four_channel_phase_distribution_0/v3_four_channel_output_collection_0/v3_four_channel_placement_0/v3_channel_selector_late_promotion_0/v3_selector_route_pilot_0/G2_LO_N_ANDNOT/a_297_47# v3_four_channel_bias_reference_distribution_0/v3_four_channel_phase_distribution_0/v3_four_channel_output_collection_0/v3_four_channel_placement_0/v3_channel_selector_late_promotion_0/v3_selector_route_pilot_0/G2_LO_N_ANDNOT/a_27_413# v3_four_channel_bias_reference_distribution_0/v3_four_channel_phase_distribution_0/v3_four_channel_output_collection_0/v3_four_channel_placement_0/v3_channel_selector_late_promotion_0/v3_selector_route_pilot_0/G2_LO_N_ANDNOT/a_207_413# VSUBS sky130_fd_pr__nfet_01v8 ad=0.1008 pd=1.32 as=0.1092 ps=1.36 w=0.42 l=0.15
X262 v3_four_channel_bias_reference_distribution_0/v3_four_channel_phase_distribution_0/v3_four_channel_output_collection_0/v3_four_channel_placement_0/v3_channel_selector_late_promotion_0/v3_selector_route_pilot_0/group2_lo_n v3_four_channel_bias_reference_distribution_0/v3_four_channel_phase_distribution_0/v3_four_channel_output_collection_0/v3_four_channel_placement_0/v3_channel_selector_late_promotion_0/v3_selector_route_pilot_0/G2_LO_N_ANDNOT/a_207_413# VSUBS VSUBS sky130_fd_pr__nfet_01v8 ad=0.169 pd=1.82 as=0 ps=0 w=0.65 l=0.15
X263 v3_four_channel_bias_reference_distribution_0/v3_four_channel_phase_distribution_0/v3_four_channel_output_collection_0/v3_four_channel_placement_0/v3_channel_selector_late_promotion_0/v3_selector_route_pilot_0/G2_LO_N_ANDNOT/a_207_413# v3_four_channel_bias_reference_distribution_0/v3_four_channel_phase_distribution_0/v3_four_channel_output_collection_0/v3_four_channel_placement_0/v3_channel_selector_late_promotion_0/v3_selector_route_pilot_0/G2_LO_N_ANDNOT/a_27_413# v3_four_channel_bias_reference_distribution_0/v3_four_channel_phase_distribution_0/v3_four_channel_output_collection_0/v3_four_channel_placement_0/v3_channel_selector_late_promotion_0/VPWR v3_four_channel_bias_reference_distribution_0/v3_four_channel_phase_distribution_0/v3_four_channel_output_collection_0/v3_four_channel_placement_0/v3_channel_selector_late_promotion_0/VPWR sky130_fd_pr__pfet_01v8_hvt ad=0 pd=0 as=0 ps=0 w=0.42 l=0.15
X264 v3_four_channel_bias_reference_distribution_0/v3_four_channel_phase_distribution_0/v3_four_channel_output_collection_0/v3_four_channel_placement_0/v3_channel_selector_late_promotion_0/VPWR v3_four_channel_bias_reference_distribution_0/v3_four_channel_phase_distribution_0/v3_four_channel_output_collection_0/v3_four_channel_placement_0/v3_channel_selector_late_promotion_0/v3_selector_route_pilot_0/G2_MUX_AXIS/X v3_four_channel_bias_reference_distribution_0/v3_four_channel_phase_distribution_0/v3_four_channel_output_collection_0/v3_four_channel_placement_0/v3_channel_selector_late_promotion_0/v3_selector_route_pilot_0/G2_LO_N_ANDNOT/a_27_413# v3_four_channel_bias_reference_distribution_0/v3_four_channel_phase_distribution_0/v3_four_channel_output_collection_0/v3_four_channel_placement_0/v3_channel_selector_late_promotion_0/VPWR sky130_fd_pr__pfet_01v8_hvt ad=0 pd=0 as=0.1092 ps=1.36 w=0.42 l=0.15
X265 VSUBS v3_four_channel_bias_reference_distribution_0/v3_four_channel_phase_distribution_0/v3_four_channel_output_collection_0/v3_four_channel_placement_0/v3_channel_selector_late_promotion_0/v3_selector_route_pilot_0/G3_LO_P_AND/B v3_four_channel_bias_reference_distribution_0/v3_four_channel_phase_distribution_0/v3_four_channel_output_collection_0/v3_four_channel_placement_0/v3_channel_selector_late_promotion_0/v3_selector_route_pilot_0/G2_LO_N_ANDNOT/a_297_47# VSUBS sky130_fd_pr__nfet_01v8 ad=0 pd=0 as=0 ps=0 w=0.42 l=0.15
X266 v3_four_channel_bias_reference_distribution_0/v3_four_channel_phase_distribution_0/v3_four_channel_output_collection_0/v3_four_channel_placement_0/v3_channel_selector_late_promotion_0/v3_selector_route_pilot_0/G2_LO_N_ANDNOT/a_27_413# v3_four_channel_bias_reference_distribution_0/v3_four_channel_phase_distribution_0/v3_four_channel_output_collection_0/v3_four_channel_placement_0/v3_channel_selector_late_promotion_0/v3_selector_route_pilot_0/G2_MUX_AXIS/X VSUBS VSUBS sky130_fd_pr__nfet_01v8 ad=0.1092 pd=1.36 as=0 ps=0 w=0.42 l=0.15
X267 v3_four_channel_bias_reference_distribution_0/v3_four_channel_phase_distribution_0/v3_four_channel_output_collection_0/v3_four_channel_placement_0/v3_channel_selector_late_promotion_0/VPWR v3_four_channel_bias_reference_distribution_0/v3_four_channel_phase_distribution_0/v3_four_channel_output_collection_0/v3_four_channel_placement_0/v3_channel_selector_late_promotion_0/v3_selector_route_pilot_0/G3_LO_P_AND/B v3_four_channel_bias_reference_distribution_0/v3_four_channel_phase_distribution_0/v3_four_channel_output_collection_0/v3_four_channel_placement_0/v3_channel_selector_late_promotion_0/v3_selector_route_pilot_0/G0_LO_N_ANDNOT/a_207_413# v3_four_channel_bias_reference_distribution_0/v3_four_channel_phase_distribution_0/v3_four_channel_output_collection_0/v3_four_channel_placement_0/v3_channel_selector_late_promotion_0/VPWR sky130_fd_pr__pfet_01v8_hvt ad=0 pd=0 as=0.1218 ps=1.42 w=0.42 l=0.15
X268 v3_four_channel_bias_reference_distribution_0/v3_four_channel_phase_distribution_0/v3_four_channel_output_collection_0/v3_four_channel_placement_0/v3_channel_selector_late_promotion_0/v3_selector_route_pilot_0/group0_lo_n v3_four_channel_bias_reference_distribution_0/v3_four_channel_phase_distribution_0/v3_four_channel_output_collection_0/v3_four_channel_placement_0/v3_channel_selector_late_promotion_0/v3_selector_route_pilot_0/G0_LO_N_ANDNOT/a_207_413# v3_four_channel_bias_reference_distribution_0/v3_four_channel_phase_distribution_0/v3_four_channel_output_collection_0/v3_four_channel_placement_0/v3_channel_selector_late_promotion_0/VPWR v3_four_channel_bias_reference_distribution_0/v3_four_channel_phase_distribution_0/v3_four_channel_output_collection_0/v3_four_channel_placement_0/v3_channel_selector_late_promotion_0/VPWR sky130_fd_pr__pfet_01v8_hvt ad=0.26 pd=2.52 as=0 ps=0 w=1 l=0.15
X269 v3_four_channel_bias_reference_distribution_0/v3_four_channel_phase_distribution_0/v3_four_channel_output_collection_0/v3_four_channel_placement_0/v3_channel_selector_late_promotion_0/v3_selector_route_pilot_0/G0_LO_N_ANDNOT/a_297_47# v3_four_channel_bias_reference_distribution_0/v3_four_channel_phase_distribution_0/v3_four_channel_output_collection_0/v3_four_channel_placement_0/v3_channel_selector_late_promotion_0/v3_selector_route_pilot_0/G0_LO_N_ANDNOT/a_27_413# v3_four_channel_bias_reference_distribution_0/v3_four_channel_phase_distribution_0/v3_four_channel_output_collection_0/v3_four_channel_placement_0/v3_channel_selector_late_promotion_0/v3_selector_route_pilot_0/G0_LO_N_ANDNOT/a_207_413# VSUBS sky130_fd_pr__nfet_01v8 ad=0.1008 pd=1.32 as=0.1092 ps=1.36 w=0.42 l=0.15
X270 v3_four_channel_bias_reference_distribution_0/v3_four_channel_phase_distribution_0/v3_four_channel_output_collection_0/v3_four_channel_placement_0/v3_channel_selector_late_promotion_0/v3_selector_route_pilot_0/group0_lo_n v3_four_channel_bias_reference_distribution_0/v3_four_channel_phase_distribution_0/v3_four_channel_output_collection_0/v3_four_channel_placement_0/v3_channel_selector_late_promotion_0/v3_selector_route_pilot_0/G0_LO_N_ANDNOT/a_207_413# VSUBS VSUBS sky130_fd_pr__nfet_01v8 ad=0.169 pd=1.82 as=0 ps=0 w=0.65 l=0.15
X271 v3_four_channel_bias_reference_distribution_0/v3_four_channel_phase_distribution_0/v3_four_channel_output_collection_0/v3_four_channel_placement_0/v3_channel_selector_late_promotion_0/v3_selector_route_pilot_0/G0_LO_N_ANDNOT/a_207_413# v3_four_channel_bias_reference_distribution_0/v3_four_channel_phase_distribution_0/v3_four_channel_output_collection_0/v3_four_channel_placement_0/v3_channel_selector_late_promotion_0/v3_selector_route_pilot_0/G0_LO_N_ANDNOT/a_27_413# v3_four_channel_bias_reference_distribution_0/v3_four_channel_phase_distribution_0/v3_four_channel_output_collection_0/v3_four_channel_placement_0/v3_channel_selector_late_promotion_0/VPWR v3_four_channel_bias_reference_distribution_0/v3_four_channel_phase_distribution_0/v3_four_channel_output_collection_0/v3_four_channel_placement_0/v3_channel_selector_late_promotion_0/VPWR sky130_fd_pr__pfet_01v8_hvt ad=0 pd=0 as=0 ps=0 w=0.42 l=0.15
X272 v3_four_channel_bias_reference_distribution_0/v3_four_channel_phase_distribution_0/v3_four_channel_output_collection_0/v3_four_channel_placement_0/v3_channel_selector_late_promotion_0/VPWR v3_four_channel_bias_reference_distribution_0/v3_four_channel_phase_distribution_0/v3_four_channel_output_collection_0/v3_four_channel_placement_0/v3_channel_selector_late_promotion_0/v3_selector_route_pilot_0/G0_MUX_AXIS/X v3_four_channel_bias_reference_distribution_0/v3_four_channel_phase_distribution_0/v3_four_channel_output_collection_0/v3_four_channel_placement_0/v3_channel_selector_late_promotion_0/v3_selector_route_pilot_0/G0_LO_N_ANDNOT/a_27_413# v3_four_channel_bias_reference_distribution_0/v3_four_channel_phase_distribution_0/v3_four_channel_output_collection_0/v3_four_channel_placement_0/v3_channel_selector_late_promotion_0/VPWR sky130_fd_pr__pfet_01v8_hvt ad=0 pd=0 as=0.1092 ps=1.36 w=0.42 l=0.15
X273 VSUBS v3_four_channel_bias_reference_distribution_0/v3_four_channel_phase_distribution_0/v3_four_channel_output_collection_0/v3_four_channel_placement_0/v3_channel_selector_late_promotion_0/v3_selector_route_pilot_0/G3_LO_P_AND/B v3_four_channel_bias_reference_distribution_0/v3_four_channel_phase_distribution_0/v3_four_channel_output_collection_0/v3_four_channel_placement_0/v3_channel_selector_late_promotion_0/v3_selector_route_pilot_0/G0_LO_N_ANDNOT/a_297_47# VSUBS sky130_fd_pr__nfet_01v8 ad=0 pd=0 as=0 ps=0 w=0.42 l=0.15
X274 v3_four_channel_bias_reference_distribution_0/v3_four_channel_phase_distribution_0/v3_four_channel_output_collection_0/v3_four_channel_placement_0/v3_channel_selector_late_promotion_0/v3_selector_route_pilot_0/G0_LO_N_ANDNOT/a_27_413# v3_four_channel_bias_reference_distribution_0/v3_four_channel_phase_distribution_0/v3_four_channel_output_collection_0/v3_four_channel_placement_0/v3_channel_selector_late_promotion_0/v3_selector_route_pilot_0/G0_MUX_AXIS/X VSUBS VSUBS sky130_fd_pr__nfet_01v8 ad=0.1092 pd=1.36 as=0 ps=0 w=0.42 l=0.15
X275 v3_four_channel_bias_reference_distribution_0/v3_four_channel_phase_distribution_0/v3_four_channel_output_collection_0/v3_four_channel_placement_0/v3_channel_selector_late_promotion_0/VPWR v3_four_channel_bias_reference_distribution_0/v3_four_channel_phase_distribution_0/v3_four_channel_output_collection_0/v3_four_channel_placement_0/v3_channel_selector_late_promotion_0/v3_selector_route_pilot_0/G1_MUX_AXIS/a_505_21# v3_four_channel_bias_reference_distribution_0/v3_four_channel_phase_distribution_0/v3_four_channel_output_collection_0/v3_four_channel_placement_0/v3_channel_selector_late_promotion_0/v3_selector_route_pilot_0/G1_MUX_AXIS/a_535_374# v3_four_channel_bias_reference_distribution_0/v3_four_channel_phase_distribution_0/v3_four_channel_output_collection_0/v3_four_channel_placement_0/v3_channel_selector_late_promotion_0/VPWR sky130_fd_pr__pfet_01v8_hvt ad=0 pd=0 as=0.0882 ps=1.26 w=0.42 l=0.15
X276 v3_four_channel_bias_reference_distribution_0/v3_four_channel_phase_distribution_0/v3_four_channel_output_collection_0/v3_four_channel_placement_0/v3_channel_selector_late_promotion_0/v3_selector_route_pilot_0/G1_MUX_AXIS/a_505_21# v3_four_channel_bias_reference_distribution_0/v3_four_channel_phase_distribution_0/v3_four_channel_output_collection_0/v3_four_channel_placement_0/v3_channel_selector_late_promotion_0/group1_bit1 v3_four_channel_bias_reference_distribution_0/v3_four_channel_phase_distribution_0/v3_four_channel_output_collection_0/v3_four_channel_placement_0/v3_channel_selector_late_promotion_0/VPWR v3_four_channel_bias_reference_distribution_0/v3_four_channel_phase_distribution_0/v3_four_channel_output_collection_0/v3_four_channel_placement_0/v3_channel_selector_late_promotion_0/VPWR sky130_fd_pr__pfet_01v8_hvt ad=0.1176 pd=1.4 as=0 ps=0 w=0.42 l=0.15
X277 v3_four_channel_bias_reference_distribution_0/v3_four_channel_phase_distribution_0/v3_four_channel_output_collection_0/v3_four_channel_placement_0/v3_channel_selector_late_promotion_0/v3_selector_route_pilot_0/G1_MUX_AXIS/a_218_374# v3_four_channel_bias_reference_distribution_0/v3_four_channel_phase_distribution_0/v3_four_channel_output_collection_0/v3_four_channel_placement_0/v3_channel_selector_late_promotion_0/group1_bit1 v3_four_channel_bias_reference_distribution_0/v3_four_channel_phase_distribution_0/v3_four_channel_output_collection_0/v3_four_channel_placement_0/v3_channel_selector_late_promotion_0/VPWR v3_four_channel_bias_reference_distribution_0/v3_four_channel_phase_distribution_0/v3_four_channel_output_collection_0/v3_four_channel_placement_0/v3_channel_selector_late_promotion_0/VPWR sky130_fd_pr__pfet_01v8_hvt ad=0.1533 pd=1.57 as=0 ps=0 w=0.42 l=0.15
X278 VSUBS v3_four_channel_bias_reference_distribution_0/v3_four_channel_phase_distribution_0/v3_four_channel_output_collection_0/v3_four_channel_placement_0/v3_channel_selector_late_promotion_0/v3_selector_route_pilot_0/G1_MUX_AXIS/a_505_21# v3_four_channel_bias_reference_distribution_0/v3_four_channel_phase_distribution_0/v3_four_channel_output_collection_0/v3_four_channel_placement_0/v3_channel_selector_late_promotion_0/v3_selector_route_pilot_0/G1_MUX_AXIS/a_439_47# VSUBS sky130_fd_pr__nfet_01v8 ad=0 pd=0 as=0.1386 ps=1.5 w=0.42 l=0.15
X279 v3_four_channel_bias_reference_distribution_0/v3_four_channel_phase_distribution_0/v3_four_channel_output_collection_0/v3_four_channel_placement_0/v3_channel_selector_late_promotion_0/v3_selector_route_pilot_0/G1_MUX_AXIS/a_76_199# v3_four_channel_bias_reference_distribution_0/v3_four_channel_phase_distribution_0/v3_four_channel_output_collection_0/v3_four_channel_placement_0/v3_channel_selector_late_promotion_0/v3_selector_route_pilot_0/G1_MUX_POS/X v3_four_channel_bias_reference_distribution_0/v3_four_channel_phase_distribution_0/v3_four_channel_output_collection_0/v3_four_channel_placement_0/v3_channel_selector_late_promotion_0/v3_selector_route_pilot_0/G1_MUX_AXIS/a_218_374# v3_four_channel_bias_reference_distribution_0/v3_four_channel_phase_distribution_0/v3_four_channel_output_collection_0/v3_four_channel_placement_0/v3_channel_selector_late_promotion_0/VPWR sky130_fd_pr__pfet_01v8_hvt ad=0.3864 pd=2.68 as=0 ps=0 w=0.42 l=0.15
X280 v3_four_channel_bias_reference_distribution_0/v3_four_channel_phase_distribution_0/v3_four_channel_output_collection_0/v3_four_channel_placement_0/v3_channel_selector_late_promotion_0/v3_selector_route_pilot_0/G1_MUX_AXIS/a_505_21# v3_four_channel_bias_reference_distribution_0/v3_four_channel_phase_distribution_0/v3_four_channel_output_collection_0/v3_four_channel_placement_0/v3_channel_selector_late_promotion_0/group1_bit1 VSUBS VSUBS sky130_fd_pr__nfet_01v8 ad=0.1092 pd=1.36 as=0 ps=0 w=0.42 l=0.15
X281 v3_four_channel_bias_reference_distribution_0/v3_four_channel_phase_distribution_0/v3_four_channel_output_collection_0/v3_four_channel_placement_0/v3_channel_selector_late_promotion_0/v3_selector_route_pilot_0/G1_MUX_AXIS/a_439_47# v3_four_channel_bias_reference_distribution_0/v3_four_channel_phase_distribution_0/v3_four_channel_output_collection_0/v3_four_channel_placement_0/v3_channel_selector_late_promotion_0/v3_selector_route_pilot_0/G1_MUX_POS/X v3_four_channel_bias_reference_distribution_0/v3_four_channel_phase_distribution_0/v3_four_channel_output_collection_0/v3_four_channel_placement_0/v3_channel_selector_late_promotion_0/v3_selector_route_pilot_0/G1_MUX_AXIS/a_76_199# VSUBS sky130_fd_pr__nfet_01v8 ad=0 pd=0 as=0.1995 ps=1.79 w=0.42 l=0.15
X282 v3_four_channel_bias_reference_distribution_0/v3_four_channel_phase_distribution_0/v3_four_channel_output_collection_0/v3_four_channel_placement_0/v3_channel_selector_late_promotion_0/v3_selector_route_pilot_0/G1_MUX_AXIS/a_535_374# v3_four_channel_bias_reference_distribution_0/v3_four_channel_phase_distribution_0/v3_four_channel_output_collection_0/v3_four_channel_placement_0/v3_channel_selector_late_promotion_0/v3_selector_route_pilot_0/G1_MUX_NEG/X v3_four_channel_bias_reference_distribution_0/v3_four_channel_phase_distribution_0/v3_four_channel_output_collection_0/v3_four_channel_placement_0/v3_channel_selector_late_promotion_0/v3_selector_route_pilot_0/G1_MUX_AXIS/a_76_199# v3_four_channel_bias_reference_distribution_0/v3_four_channel_phase_distribution_0/v3_four_channel_output_collection_0/v3_four_channel_placement_0/v3_channel_selector_late_promotion_0/VPWR sky130_fd_pr__pfet_01v8_hvt ad=0 pd=0 as=0 ps=0 w=0.42 l=0.15
X283 v3_four_channel_bias_reference_distribution_0/v3_four_channel_phase_distribution_0/v3_four_channel_output_collection_0/v3_four_channel_placement_0/v3_channel_selector_late_promotion_0/v3_selector_route_pilot_0/G1_MUX_AXIS/a_76_199# v3_four_channel_bias_reference_distribution_0/v3_four_channel_phase_distribution_0/v3_four_channel_output_collection_0/v3_four_channel_placement_0/v3_channel_selector_late_promotion_0/v3_selector_route_pilot_0/G1_MUX_NEG/X v3_four_channel_bias_reference_distribution_0/v3_four_channel_phase_distribution_0/v3_four_channel_output_collection_0/v3_four_channel_placement_0/v3_channel_selector_late_promotion_0/v3_selector_route_pilot_0/G1_MUX_AXIS/a_218_47# VSUBS sky130_fd_pr__nfet_01v8 ad=0 pd=0 as=0.1386 ps=1.5 w=0.42 l=0.15
X284 v3_four_channel_bias_reference_distribution_0/v3_four_channel_phase_distribution_0/v3_four_channel_output_collection_0/v3_four_channel_placement_0/v3_channel_selector_late_promotion_0/v3_selector_route_pilot_0/G1_MUX_AXIS/a_218_47# v3_four_channel_bias_reference_distribution_0/v3_four_channel_phase_distribution_0/v3_four_channel_output_collection_0/v3_four_channel_placement_0/v3_channel_selector_late_promotion_0/group1_bit1 VSUBS VSUBS sky130_fd_pr__nfet_01v8 ad=0 pd=0 as=0 ps=0 w=0.42 l=0.15
X285 v3_four_channel_bias_reference_distribution_0/v3_four_channel_phase_distribution_0/v3_four_channel_output_collection_0/v3_four_channel_placement_0/v3_channel_selector_late_promotion_0/VPWR v3_four_channel_bias_reference_distribution_0/v3_four_channel_phase_distribution_0/v3_four_channel_output_collection_0/v3_four_channel_placement_0/v3_channel_selector_late_promotion_0/v3_selector_route_pilot_0/G1_MUX_AXIS/a_76_199# v3_four_channel_bias_reference_distribution_0/v3_four_channel_phase_distribution_0/v3_four_channel_output_collection_0/v3_four_channel_placement_0/v3_channel_selector_late_promotion_0/v3_selector_route_pilot_0/G1_MUX_AXIS/X v3_four_channel_bias_reference_distribution_0/v3_four_channel_phase_distribution_0/v3_four_channel_output_collection_0/v3_four_channel_placement_0/v3_channel_selector_late_promotion_0/VPWR sky130_fd_pr__pfet_01v8_hvt ad=0 pd=0 as=0.26 ps=2.52 w=1 l=0.15
X286 VSUBS v3_four_channel_bias_reference_distribution_0/v3_four_channel_phase_distribution_0/v3_four_channel_output_collection_0/v3_four_channel_placement_0/v3_channel_selector_late_promotion_0/v3_selector_route_pilot_0/G1_MUX_AXIS/a_76_199# v3_four_channel_bias_reference_distribution_0/v3_four_channel_phase_distribution_0/v3_four_channel_output_collection_0/v3_four_channel_placement_0/v3_channel_selector_late_promotion_0/v3_selector_route_pilot_0/G1_MUX_AXIS/X VSUBS sky130_fd_pr__nfet_01v8 ad=0 pd=0 as=0.169 ps=1.82 w=0.65 l=0.15
X287 v3_four_channel_bias_reference_distribution_0/v3_four_channel_phase_distribution_0/v3_four_channel_output_collection_0/v3_four_channel_placement_0/v3_channel_selector_late_promotion_0/VPWR v3_four_channel_bias_reference_distribution_0/v3_four_channel_phase_distribution_0/v3_four_channel_output_collection_0/v3_four_channel_placement_0/v3_channel_selector_late_promotion_0/v3_selector_route_pilot_0/G3_LO_P_AND/B v3_four_channel_bias_reference_distribution_0/v3_four_channel_phase_distribution_0/v3_four_channel_output_collection_0/v3_four_channel_placement_0/v3_channel_selector_late_promotion_0/v3_selector_route_pilot_0/G1_LO_N_ANDNOT/a_207_413# v3_four_channel_bias_reference_distribution_0/v3_four_channel_phase_distribution_0/v3_four_channel_output_collection_0/v3_four_channel_placement_0/v3_channel_selector_late_promotion_0/VPWR sky130_fd_pr__pfet_01v8_hvt ad=0 pd=0 as=0.1218 ps=1.42 w=0.42 l=0.15
X288 v3_four_channel_bias_reference_distribution_0/v3_four_channel_phase_distribution_0/v3_four_channel_output_collection_0/v3_four_channel_placement_0/v3_channel_selector_late_promotion_0/v3_selector_route_pilot_0/group1_lo_n v3_four_channel_bias_reference_distribution_0/v3_four_channel_phase_distribution_0/v3_four_channel_output_collection_0/v3_four_channel_placement_0/v3_channel_selector_late_promotion_0/v3_selector_route_pilot_0/G1_LO_N_ANDNOT/a_207_413# v3_four_channel_bias_reference_distribution_0/v3_four_channel_phase_distribution_0/v3_four_channel_output_collection_0/v3_four_channel_placement_0/v3_channel_selector_late_promotion_0/VPWR v3_four_channel_bias_reference_distribution_0/v3_four_channel_phase_distribution_0/v3_four_channel_output_collection_0/v3_four_channel_placement_0/v3_channel_selector_late_promotion_0/VPWR sky130_fd_pr__pfet_01v8_hvt ad=0.26 pd=2.52 as=0 ps=0 w=1 l=0.15
X289 v3_four_channel_bias_reference_distribution_0/v3_four_channel_phase_distribution_0/v3_four_channel_output_collection_0/v3_four_channel_placement_0/v3_channel_selector_late_promotion_0/v3_selector_route_pilot_0/G1_LO_N_ANDNOT/a_297_47# v3_four_channel_bias_reference_distribution_0/v3_four_channel_phase_distribution_0/v3_four_channel_output_collection_0/v3_four_channel_placement_0/v3_channel_selector_late_promotion_0/v3_selector_route_pilot_0/G1_LO_N_ANDNOT/a_27_413# v3_four_channel_bias_reference_distribution_0/v3_four_channel_phase_distribution_0/v3_four_channel_output_collection_0/v3_four_channel_placement_0/v3_channel_selector_late_promotion_0/v3_selector_route_pilot_0/G1_LO_N_ANDNOT/a_207_413# VSUBS sky130_fd_pr__nfet_01v8 ad=0.1008 pd=1.32 as=0.1092 ps=1.36 w=0.42 l=0.15
X290 v3_four_channel_bias_reference_distribution_0/v3_four_channel_phase_distribution_0/v3_four_channel_output_collection_0/v3_four_channel_placement_0/v3_channel_selector_late_promotion_0/v3_selector_route_pilot_0/group1_lo_n v3_four_channel_bias_reference_distribution_0/v3_four_channel_phase_distribution_0/v3_four_channel_output_collection_0/v3_four_channel_placement_0/v3_channel_selector_late_promotion_0/v3_selector_route_pilot_0/G1_LO_N_ANDNOT/a_207_413# VSUBS VSUBS sky130_fd_pr__nfet_01v8 ad=0.169 pd=1.82 as=0 ps=0 w=0.65 l=0.15
X291 v3_four_channel_bias_reference_distribution_0/v3_four_channel_phase_distribution_0/v3_four_channel_output_collection_0/v3_four_channel_placement_0/v3_channel_selector_late_promotion_0/v3_selector_route_pilot_0/G1_LO_N_ANDNOT/a_207_413# v3_four_channel_bias_reference_distribution_0/v3_four_channel_phase_distribution_0/v3_four_channel_output_collection_0/v3_four_channel_placement_0/v3_channel_selector_late_promotion_0/v3_selector_route_pilot_0/G1_LO_N_ANDNOT/a_27_413# v3_four_channel_bias_reference_distribution_0/v3_four_channel_phase_distribution_0/v3_four_channel_output_collection_0/v3_four_channel_placement_0/v3_channel_selector_late_promotion_0/VPWR v3_four_channel_bias_reference_distribution_0/v3_four_channel_phase_distribution_0/v3_four_channel_output_collection_0/v3_four_channel_placement_0/v3_channel_selector_late_promotion_0/VPWR sky130_fd_pr__pfet_01v8_hvt ad=0 pd=0 as=0 ps=0 w=0.42 l=0.15
X292 v3_four_channel_bias_reference_distribution_0/v3_four_channel_phase_distribution_0/v3_four_channel_output_collection_0/v3_four_channel_placement_0/v3_channel_selector_late_promotion_0/VPWR v3_four_channel_bias_reference_distribution_0/v3_four_channel_phase_distribution_0/v3_four_channel_output_collection_0/v3_four_channel_placement_0/v3_channel_selector_late_promotion_0/v3_selector_route_pilot_0/G1_MUX_AXIS/X v3_four_channel_bias_reference_distribution_0/v3_four_channel_phase_distribution_0/v3_four_channel_output_collection_0/v3_four_channel_placement_0/v3_channel_selector_late_promotion_0/v3_selector_route_pilot_0/G1_LO_N_ANDNOT/a_27_413# v3_four_channel_bias_reference_distribution_0/v3_four_channel_phase_distribution_0/v3_four_channel_output_collection_0/v3_four_channel_placement_0/v3_channel_selector_late_promotion_0/VPWR sky130_fd_pr__pfet_01v8_hvt ad=0 pd=0 as=0.1092 ps=1.36 w=0.42 l=0.15
X293 VSUBS v3_four_channel_bias_reference_distribution_0/v3_four_channel_phase_distribution_0/v3_four_channel_output_collection_0/v3_four_channel_placement_0/v3_channel_selector_late_promotion_0/v3_selector_route_pilot_0/G3_LO_P_AND/B v3_four_channel_bias_reference_distribution_0/v3_four_channel_phase_distribution_0/v3_four_channel_output_collection_0/v3_four_channel_placement_0/v3_channel_selector_late_promotion_0/v3_selector_route_pilot_0/G1_LO_N_ANDNOT/a_297_47# VSUBS sky130_fd_pr__nfet_01v8 ad=0 pd=0 as=0 ps=0 w=0.42 l=0.15
X294 v3_four_channel_bias_reference_distribution_0/v3_four_channel_phase_distribution_0/v3_four_channel_output_collection_0/v3_four_channel_placement_0/v3_channel_selector_late_promotion_0/v3_selector_route_pilot_0/G1_LO_N_ANDNOT/a_27_413# v3_four_channel_bias_reference_distribution_0/v3_four_channel_phase_distribution_0/v3_four_channel_output_collection_0/v3_four_channel_placement_0/v3_channel_selector_late_promotion_0/v3_selector_route_pilot_0/G1_MUX_AXIS/X VSUBS VSUBS sky130_fd_pr__nfet_01v8 ad=0.1092 pd=1.36 as=0 ps=0 w=0.42 l=0.15
X295 v3_four_channel_bias_reference_distribution_0/v3_four_channel_phase_distribution_0/v3_four_channel_output_collection_0/v3_four_channel_placement_0/v3_channel_selector_late_promotion_0/VPWR v3_four_channel_bias_reference_distribution_0/v3_four_channel_phase_distribution_0/v3_four_channel_output_collection_0/v3_four_channel_placement_0/v3_channel_selector_late_promotion_0/v3_selector_route_pilot_0/G3_LO_P_AND/B v3_four_channel_bias_reference_distribution_0/v3_four_channel_phase_distribution_0/v3_four_channel_output_collection_0/v3_four_channel_placement_0/v3_channel_selector_late_promotion_0/v3_selector_route_pilot_0/G3_LO_P_AND/a_59_75# v3_four_channel_bias_reference_distribution_0/v3_four_channel_phase_distribution_0/v3_four_channel_output_collection_0/v3_four_channel_placement_0/v3_channel_selector_late_promotion_0/VPWR sky130_fd_pr__pfet_01v8_hvt ad=0 pd=0 as=0.1134 ps=1.38 w=0.42 l=0.15
X296 v3_four_channel_bias_reference_distribution_0/v3_four_channel_phase_distribution_0/v3_four_channel_output_collection_0/v3_four_channel_placement_0/v3_channel_selector_late_promotion_0/v3_selector_route_pilot_0/group3_lo_p v3_four_channel_bias_reference_distribution_0/v3_four_channel_phase_distribution_0/v3_four_channel_output_collection_0/v3_four_channel_placement_0/v3_channel_selector_late_promotion_0/v3_selector_route_pilot_0/G3_LO_P_AND/a_59_75# v3_four_channel_bias_reference_distribution_0/v3_four_channel_phase_distribution_0/v3_four_channel_output_collection_0/v3_four_channel_placement_0/v3_channel_selector_late_promotion_0/VPWR v3_four_channel_bias_reference_distribution_0/v3_four_channel_phase_distribution_0/v3_four_channel_output_collection_0/v3_four_channel_placement_0/v3_channel_selector_late_promotion_0/VPWR sky130_fd_pr__pfet_01v8_hvt ad=0.475 pd=2.95 as=0 ps=0 w=1 l=0.15
X297 VSUBS v3_four_channel_bias_reference_distribution_0/v3_four_channel_phase_distribution_0/v3_four_channel_output_collection_0/v3_four_channel_placement_0/v3_channel_selector_late_promotion_0/v3_selector_route_pilot_0/G3_LO_P_AND/B v3_four_channel_bias_reference_distribution_0/v3_four_channel_phase_distribution_0/v3_four_channel_output_collection_0/v3_four_channel_placement_0/v3_channel_selector_late_promotion_0/v3_selector_route_pilot_0/G3_LO_P_AND/a_145_75# VSUBS sky130_fd_pr__nfet_01v8 ad=0 pd=0 as=0.1134 ps=1.38 w=0.42 l=0.15
X298 v3_four_channel_bias_reference_distribution_0/v3_four_channel_phase_distribution_0/v3_four_channel_output_collection_0/v3_four_channel_placement_0/v3_channel_selector_late_promotion_0/v3_selector_route_pilot_0/G3_LO_P_AND/a_59_75# v3_four_channel_bias_reference_distribution_0/v3_four_channel_phase_distribution_0/v3_four_channel_output_collection_0/v3_four_channel_placement_0/v3_channel_selector_late_promotion_0/v3_selector_route_pilot_0/G3_MUX_AXIS/X v3_four_channel_bias_reference_distribution_0/v3_four_channel_phase_distribution_0/v3_four_channel_output_collection_0/v3_four_channel_placement_0/v3_channel_selector_late_promotion_0/VPWR v3_four_channel_bias_reference_distribution_0/v3_four_channel_phase_distribution_0/v3_four_channel_output_collection_0/v3_four_channel_placement_0/v3_channel_selector_late_promotion_0/VPWR sky130_fd_pr__pfet_01v8_hvt ad=0 pd=0 as=0 ps=0 w=0.42 l=0.15
X299 v3_four_channel_bias_reference_distribution_0/v3_four_channel_phase_distribution_0/v3_four_channel_output_collection_0/v3_four_channel_placement_0/v3_channel_selector_late_promotion_0/v3_selector_route_pilot_0/group3_lo_p v3_four_channel_bias_reference_distribution_0/v3_four_channel_phase_distribution_0/v3_four_channel_output_collection_0/v3_four_channel_placement_0/v3_channel_selector_late_promotion_0/v3_selector_route_pilot_0/G3_LO_P_AND/a_59_75# VSUBS VSUBS sky130_fd_pr__nfet_01v8 ad=0.182 pd=1.86 as=0 ps=0 w=0.65 l=0.15
X300 v3_four_channel_bias_reference_distribution_0/v3_four_channel_phase_distribution_0/v3_four_channel_output_collection_0/v3_four_channel_placement_0/v3_channel_selector_late_promotion_0/v3_selector_route_pilot_0/G3_LO_P_AND/a_145_75# v3_four_channel_bias_reference_distribution_0/v3_four_channel_phase_distribution_0/v3_four_channel_output_collection_0/v3_four_channel_placement_0/v3_channel_selector_late_promotion_0/v3_selector_route_pilot_0/G3_MUX_AXIS/X v3_four_channel_bias_reference_distribution_0/v3_four_channel_phase_distribution_0/v3_four_channel_output_collection_0/v3_four_channel_placement_0/v3_channel_selector_late_promotion_0/v3_selector_route_pilot_0/G3_LO_P_AND/a_59_75# VSUBS sky130_fd_pr__nfet_01v8 ad=0 pd=0 as=0.1176 ps=1.4 w=0.42 l=0.15
X301 v3_four_channel_bias_reference_distribution_0/v3_four_channel_phase_distribution_0/v3_four_channel_output_collection_0/v3_four_channel_placement_0/v3_channel_selector_late_promotion_0/VPWR v3_four_channel_bias_reference_distribution_0/v3_four_channel_phase_distribution_0/v3_four_channel_output_collection_0/v3_four_channel_placement_0/v3_channel_selector_late_promotion_0/v3_selector_route_pilot_0/G2_MUX_POS/a_505_21# v3_four_channel_bias_reference_distribution_0/v3_four_channel_phase_distribution_0/v3_four_channel_output_collection_0/v3_four_channel_placement_0/v3_channel_selector_late_promotion_0/v3_selector_route_pilot_0/G2_MUX_POS/a_535_374# v3_four_channel_bias_reference_distribution_0/v3_four_channel_phase_distribution_0/v3_four_channel_output_collection_0/v3_four_channel_placement_0/v3_channel_selector_late_promotion_0/VPWR sky130_fd_pr__pfet_01v8_hvt ad=0 pd=0 as=0.0882 ps=1.26 w=0.42 l=0.15
X302 v3_four_channel_bias_reference_distribution_0/v3_four_channel_phase_distribution_0/v3_four_channel_output_collection_0/v3_four_channel_placement_0/v3_channel_selector_late_promotion_0/v3_selector_route_pilot_0/G2_MUX_POS/a_505_21# v3_four_channel_bias_reference_distribution_0/v3_four_channel_phase_distribution_0/v3_four_channel_output_collection_0/v3_four_channel_placement_0/v3_channel_selector_late_promotion_0/group2_bit0 v3_four_channel_bias_reference_distribution_0/v3_four_channel_phase_distribution_0/v3_four_channel_output_collection_0/v3_four_channel_placement_0/v3_channel_selector_late_promotion_0/VPWR v3_four_channel_bias_reference_distribution_0/v3_four_channel_phase_distribution_0/v3_four_channel_output_collection_0/v3_four_channel_placement_0/v3_channel_selector_late_promotion_0/VPWR sky130_fd_pr__pfet_01v8_hvt ad=0.1176 pd=1.4 as=0 ps=0 w=0.42 l=0.15
X303 v3_four_channel_bias_reference_distribution_0/v3_four_channel_phase_distribution_0/v3_four_channel_output_collection_0/v3_four_channel_placement_0/v3_channel_selector_late_promotion_0/v3_selector_route_pilot_0/G2_MUX_POS/a_218_374# v3_four_channel_bias_reference_distribution_0/v3_four_channel_phase_distribution_0/v3_four_channel_output_collection_0/v3_four_channel_placement_0/v3_channel_selector_late_promotion_0/group2_bit0 v3_four_channel_bias_reference_distribution_0/v3_four_channel_phase_distribution_0/v3_four_channel_output_collection_0/v3_four_channel_placement_0/v3_channel_selector_late_promotion_0/VPWR v3_four_channel_bias_reference_distribution_0/v3_four_channel_phase_distribution_0/v3_four_channel_output_collection_0/v3_four_channel_placement_0/v3_channel_selector_late_promotion_0/VPWR sky130_fd_pr__pfet_01v8_hvt ad=0.1533 pd=1.57 as=0 ps=0 w=0.42 l=0.15
X304 VSUBS v3_four_channel_bias_reference_distribution_0/v3_four_channel_phase_distribution_0/v3_four_channel_output_collection_0/v3_four_channel_placement_0/v3_channel_selector_late_promotion_0/v3_selector_route_pilot_0/G2_MUX_POS/a_505_21# v3_four_channel_bias_reference_distribution_0/v3_four_channel_phase_distribution_0/v3_four_channel_output_collection_0/v3_four_channel_placement_0/v3_channel_selector_late_promotion_0/v3_selector_route_pilot_0/G2_MUX_POS/a_439_47# VSUBS sky130_fd_pr__nfet_01v8 ad=0 pd=0 as=0.1386 ps=1.5 w=0.42 l=0.15
X305 v3_four_channel_bias_reference_distribution_0/v3_four_channel_phase_distribution_0/v3_four_channel_output_collection_0/v3_four_channel_placement_0/v3_channel_selector_late_promotion_0/v3_selector_route_pilot_0/G2_MUX_POS/a_76_199# v3_four_channel_bias_reference_distribution_0/v3_four_channel_phase_distribution_0/phase_0 v3_four_channel_bias_reference_distribution_0/v3_four_channel_phase_distribution_0/v3_four_channel_output_collection_0/v3_four_channel_placement_0/v3_channel_selector_late_promotion_0/v3_selector_route_pilot_0/G2_MUX_POS/a_218_374# v3_four_channel_bias_reference_distribution_0/v3_four_channel_phase_distribution_0/v3_four_channel_output_collection_0/v3_four_channel_placement_0/v3_channel_selector_late_promotion_0/VPWR sky130_fd_pr__pfet_01v8_hvt ad=0.3864 pd=2.68 as=0 ps=0 w=0.42 l=0.15
X306 v3_four_channel_bias_reference_distribution_0/v3_four_channel_phase_distribution_0/v3_four_channel_output_collection_0/v3_four_channel_placement_0/v3_channel_selector_late_promotion_0/v3_selector_route_pilot_0/G2_MUX_POS/a_505_21# v3_four_channel_bias_reference_distribution_0/v3_four_channel_phase_distribution_0/v3_four_channel_output_collection_0/v3_four_channel_placement_0/v3_channel_selector_late_promotion_0/group2_bit0 VSUBS VSUBS sky130_fd_pr__nfet_01v8 ad=0.1092 pd=1.36 as=0 ps=0 w=0.42 l=0.15
X307 v3_four_channel_bias_reference_distribution_0/v3_four_channel_phase_distribution_0/v3_four_channel_output_collection_0/v3_four_channel_placement_0/v3_channel_selector_late_promotion_0/v3_selector_route_pilot_0/G2_MUX_POS/a_439_47# v3_four_channel_bias_reference_distribution_0/v3_four_channel_phase_distribution_0/phase_0 v3_four_channel_bias_reference_distribution_0/v3_four_channel_phase_distribution_0/v3_four_channel_output_collection_0/v3_four_channel_placement_0/v3_channel_selector_late_promotion_0/v3_selector_route_pilot_0/G2_MUX_POS/a_76_199# VSUBS sky130_fd_pr__nfet_01v8 ad=0 pd=0 as=0.1995 ps=1.79 w=0.42 l=0.15
X308 v3_four_channel_bias_reference_distribution_0/v3_four_channel_phase_distribution_0/v3_four_channel_output_collection_0/v3_four_channel_placement_0/v3_channel_selector_late_promotion_0/v3_selector_route_pilot_0/G2_MUX_POS/a_535_374# v3_four_channel_bias_reference_distribution_0/v3_four_channel_phase_distribution_0/phase_90 v3_four_channel_bias_reference_distribution_0/v3_four_channel_phase_distribution_0/v3_four_channel_output_collection_0/v3_four_channel_placement_0/v3_channel_selector_late_promotion_0/v3_selector_route_pilot_0/G2_MUX_POS/a_76_199# v3_four_channel_bias_reference_distribution_0/v3_four_channel_phase_distribution_0/v3_four_channel_output_collection_0/v3_four_channel_placement_0/v3_channel_selector_late_promotion_0/VPWR sky130_fd_pr__pfet_01v8_hvt ad=0 pd=0 as=0 ps=0 w=0.42 l=0.15
X309 v3_four_channel_bias_reference_distribution_0/v3_four_channel_phase_distribution_0/v3_four_channel_output_collection_0/v3_four_channel_placement_0/v3_channel_selector_late_promotion_0/v3_selector_route_pilot_0/G2_MUX_POS/a_76_199# v3_four_channel_bias_reference_distribution_0/v3_four_channel_phase_distribution_0/phase_90 v3_four_channel_bias_reference_distribution_0/v3_four_channel_phase_distribution_0/v3_four_channel_output_collection_0/v3_four_channel_placement_0/v3_channel_selector_late_promotion_0/v3_selector_route_pilot_0/G2_MUX_POS/a_218_47# VSUBS sky130_fd_pr__nfet_01v8 ad=0 pd=0 as=0.1386 ps=1.5 w=0.42 l=0.15
X310 v3_four_channel_bias_reference_distribution_0/v3_four_channel_phase_distribution_0/v3_four_channel_output_collection_0/v3_four_channel_placement_0/v3_channel_selector_late_promotion_0/v3_selector_route_pilot_0/G2_MUX_POS/a_218_47# v3_four_channel_bias_reference_distribution_0/v3_four_channel_phase_distribution_0/v3_four_channel_output_collection_0/v3_four_channel_placement_0/v3_channel_selector_late_promotion_0/group2_bit0 VSUBS VSUBS sky130_fd_pr__nfet_01v8 ad=0 pd=0 as=0 ps=0 w=0.42 l=0.15
X311 v3_four_channel_bias_reference_distribution_0/v3_four_channel_phase_distribution_0/v3_four_channel_output_collection_0/v3_four_channel_placement_0/v3_channel_selector_late_promotion_0/VPWR v3_four_channel_bias_reference_distribution_0/v3_four_channel_phase_distribution_0/v3_four_channel_output_collection_0/v3_four_channel_placement_0/v3_channel_selector_late_promotion_0/v3_selector_route_pilot_0/G2_MUX_POS/a_76_199# v3_four_channel_bias_reference_distribution_0/v3_four_channel_phase_distribution_0/v3_four_channel_output_collection_0/v3_four_channel_placement_0/v3_channel_selector_late_promotion_0/v3_selector_route_pilot_0/G2_MUX_POS/X v3_four_channel_bias_reference_distribution_0/v3_four_channel_phase_distribution_0/v3_four_channel_output_collection_0/v3_four_channel_placement_0/v3_channel_selector_late_promotion_0/VPWR sky130_fd_pr__pfet_01v8_hvt ad=0 pd=0 as=0.26 ps=2.52 w=1 l=0.15
X312 VSUBS v3_four_channel_bias_reference_distribution_0/v3_four_channel_phase_distribution_0/v3_four_channel_output_collection_0/v3_four_channel_placement_0/v3_channel_selector_late_promotion_0/v3_selector_route_pilot_0/G2_MUX_POS/a_76_199# v3_four_channel_bias_reference_distribution_0/v3_four_channel_phase_distribution_0/v3_four_channel_output_collection_0/v3_four_channel_placement_0/v3_channel_selector_late_promotion_0/v3_selector_route_pilot_0/G2_MUX_POS/X VSUBS sky130_fd_pr__nfet_01v8 ad=0 pd=0 as=0.169 ps=1.82 w=0.65 l=0.15
X313 v3_four_channel_bias_reference_distribution_0/v3_four_channel_phase_distribution_0/v3_four_channel_output_collection_0/v3_four_channel_placement_0/v3_channel_selector_late_promotion_0/VPWR v3_four_channel_bias_reference_distribution_0/v3_four_channel_phase_distribution_0/v3_four_channel_output_collection_0/v3_four_channel_placement_0/v3_channel_selector_late_promotion_0/v3_selector_route_pilot_0/G2_MUX_NEG/a_505_21# v3_four_channel_bias_reference_distribution_0/v3_four_channel_phase_distribution_0/v3_four_channel_output_collection_0/v3_four_channel_placement_0/v3_channel_selector_late_promotion_0/v3_selector_route_pilot_0/G2_MUX_NEG/a_535_374# v3_four_channel_bias_reference_distribution_0/v3_four_channel_phase_distribution_0/v3_four_channel_output_collection_0/v3_four_channel_placement_0/v3_channel_selector_late_promotion_0/VPWR sky130_fd_pr__pfet_01v8_hvt ad=0 pd=0 as=0.0882 ps=1.26 w=0.42 l=0.15
X314 v3_four_channel_bias_reference_distribution_0/v3_four_channel_phase_distribution_0/v3_four_channel_output_collection_0/v3_four_channel_placement_0/v3_channel_selector_late_promotion_0/v3_selector_route_pilot_0/G2_MUX_NEG/a_505_21# v3_four_channel_bias_reference_distribution_0/v3_four_channel_phase_distribution_0/v3_four_channel_output_collection_0/v3_four_channel_placement_0/v3_channel_selector_late_promotion_0/group2_bit0 v3_four_channel_bias_reference_distribution_0/v3_four_channel_phase_distribution_0/v3_four_channel_output_collection_0/v3_four_channel_placement_0/v3_channel_selector_late_promotion_0/VPWR v3_four_channel_bias_reference_distribution_0/v3_four_channel_phase_distribution_0/v3_four_channel_output_collection_0/v3_four_channel_placement_0/v3_channel_selector_late_promotion_0/VPWR sky130_fd_pr__pfet_01v8_hvt ad=0.1176 pd=1.4 as=0 ps=0 w=0.42 l=0.15
X315 v3_four_channel_bias_reference_distribution_0/v3_four_channel_phase_distribution_0/v3_four_channel_output_collection_0/v3_four_channel_placement_0/v3_channel_selector_late_promotion_0/v3_selector_route_pilot_0/G2_MUX_NEG/a_218_374# v3_four_channel_bias_reference_distribution_0/v3_four_channel_phase_distribution_0/v3_four_channel_output_collection_0/v3_four_channel_placement_0/v3_channel_selector_late_promotion_0/group2_bit0 v3_four_channel_bias_reference_distribution_0/v3_four_channel_phase_distribution_0/v3_four_channel_output_collection_0/v3_four_channel_placement_0/v3_channel_selector_late_promotion_0/VPWR v3_four_channel_bias_reference_distribution_0/v3_four_channel_phase_distribution_0/v3_four_channel_output_collection_0/v3_four_channel_placement_0/v3_channel_selector_late_promotion_0/VPWR sky130_fd_pr__pfet_01v8_hvt ad=0.1533 pd=1.57 as=0 ps=0 w=0.42 l=0.15
X316 VSUBS v3_four_channel_bias_reference_distribution_0/v3_four_channel_phase_distribution_0/v3_four_channel_output_collection_0/v3_four_channel_placement_0/v3_channel_selector_late_promotion_0/v3_selector_route_pilot_0/G2_MUX_NEG/a_505_21# v3_four_channel_bias_reference_distribution_0/v3_four_channel_phase_distribution_0/v3_four_channel_output_collection_0/v3_four_channel_placement_0/v3_channel_selector_late_promotion_0/v3_selector_route_pilot_0/G2_MUX_NEG/a_439_47# VSUBS sky130_fd_pr__nfet_01v8 ad=0 pd=0 as=0.1386 ps=1.5 w=0.42 l=0.15
X317 v3_four_channel_bias_reference_distribution_0/v3_four_channel_phase_distribution_0/v3_four_channel_output_collection_0/v3_four_channel_placement_0/v3_channel_selector_late_promotion_0/v3_selector_route_pilot_0/G2_MUX_NEG/a_76_199# v3_four_channel_bias_reference_distribution_0/v3_four_channel_phase_distribution_0/phase_180 v3_four_channel_bias_reference_distribution_0/v3_four_channel_phase_distribution_0/v3_four_channel_output_collection_0/v3_four_channel_placement_0/v3_channel_selector_late_promotion_0/v3_selector_route_pilot_0/G2_MUX_NEG/a_218_374# v3_four_channel_bias_reference_distribution_0/v3_four_channel_phase_distribution_0/v3_four_channel_output_collection_0/v3_four_channel_placement_0/v3_channel_selector_late_promotion_0/VPWR sky130_fd_pr__pfet_01v8_hvt ad=0.3864 pd=2.68 as=0 ps=0 w=0.42 l=0.15
X318 v3_four_channel_bias_reference_distribution_0/v3_four_channel_phase_distribution_0/v3_four_channel_output_collection_0/v3_four_channel_placement_0/v3_channel_selector_late_promotion_0/v3_selector_route_pilot_0/G2_MUX_NEG/a_505_21# v3_four_channel_bias_reference_distribution_0/v3_four_channel_phase_distribution_0/v3_four_channel_output_collection_0/v3_four_channel_placement_0/v3_channel_selector_late_promotion_0/group2_bit0 VSUBS VSUBS sky130_fd_pr__nfet_01v8 ad=0.1092 pd=1.36 as=0 ps=0 w=0.42 l=0.15
X319 v3_four_channel_bias_reference_distribution_0/v3_four_channel_phase_distribution_0/v3_four_channel_output_collection_0/v3_four_channel_placement_0/v3_channel_selector_late_promotion_0/v3_selector_route_pilot_0/G2_MUX_NEG/a_439_47# v3_four_channel_bias_reference_distribution_0/v3_four_channel_phase_distribution_0/phase_180 v3_four_channel_bias_reference_distribution_0/v3_four_channel_phase_distribution_0/v3_four_channel_output_collection_0/v3_four_channel_placement_0/v3_channel_selector_late_promotion_0/v3_selector_route_pilot_0/G2_MUX_NEG/a_76_199# VSUBS sky130_fd_pr__nfet_01v8 ad=0 pd=0 as=0.1995 ps=1.79 w=0.42 l=0.15
X320 v3_four_channel_bias_reference_distribution_0/v3_four_channel_phase_distribution_0/v3_four_channel_output_collection_0/v3_four_channel_placement_0/v3_channel_selector_late_promotion_0/v3_selector_route_pilot_0/G2_MUX_NEG/a_535_374# v3_four_channel_bias_reference_distribution_0/v3_four_channel_phase_distribution_0/phase_270 v3_four_channel_bias_reference_distribution_0/v3_four_channel_phase_distribution_0/v3_four_channel_output_collection_0/v3_four_channel_placement_0/v3_channel_selector_late_promotion_0/v3_selector_route_pilot_0/G2_MUX_NEG/a_76_199# v3_four_channel_bias_reference_distribution_0/v3_four_channel_phase_distribution_0/v3_four_channel_output_collection_0/v3_four_channel_placement_0/v3_channel_selector_late_promotion_0/VPWR sky130_fd_pr__pfet_01v8_hvt ad=0 pd=0 as=0 ps=0 w=0.42 l=0.15
X321 v3_four_channel_bias_reference_distribution_0/v3_four_channel_phase_distribution_0/v3_four_channel_output_collection_0/v3_four_channel_placement_0/v3_channel_selector_late_promotion_0/v3_selector_route_pilot_0/G2_MUX_NEG/a_76_199# v3_four_channel_bias_reference_distribution_0/v3_four_channel_phase_distribution_0/phase_270 v3_four_channel_bias_reference_distribution_0/v3_four_channel_phase_distribution_0/v3_four_channel_output_collection_0/v3_four_channel_placement_0/v3_channel_selector_late_promotion_0/v3_selector_route_pilot_0/G2_MUX_NEG/a_218_47# VSUBS sky130_fd_pr__nfet_01v8 ad=0 pd=0 as=0.1386 ps=1.5 w=0.42 l=0.15
X322 v3_four_channel_bias_reference_distribution_0/v3_four_channel_phase_distribution_0/v3_four_channel_output_collection_0/v3_four_channel_placement_0/v3_channel_selector_late_promotion_0/v3_selector_route_pilot_0/G2_MUX_NEG/a_218_47# v3_four_channel_bias_reference_distribution_0/v3_four_channel_phase_distribution_0/v3_four_channel_output_collection_0/v3_four_channel_placement_0/v3_channel_selector_late_promotion_0/group2_bit0 VSUBS VSUBS sky130_fd_pr__nfet_01v8 ad=0 pd=0 as=0 ps=0 w=0.42 l=0.15
X323 v3_four_channel_bias_reference_distribution_0/v3_four_channel_phase_distribution_0/v3_four_channel_output_collection_0/v3_four_channel_placement_0/v3_channel_selector_late_promotion_0/VPWR v3_four_channel_bias_reference_distribution_0/v3_four_channel_phase_distribution_0/v3_four_channel_output_collection_0/v3_four_channel_placement_0/v3_channel_selector_late_promotion_0/v3_selector_route_pilot_0/G2_MUX_NEG/a_76_199# v3_four_channel_bias_reference_distribution_0/v3_four_channel_phase_distribution_0/v3_four_channel_output_collection_0/v3_four_channel_placement_0/v3_channel_selector_late_promotion_0/v3_selector_route_pilot_0/G2_MUX_NEG/X v3_four_channel_bias_reference_distribution_0/v3_four_channel_phase_distribution_0/v3_four_channel_output_collection_0/v3_four_channel_placement_0/v3_channel_selector_late_promotion_0/VPWR sky130_fd_pr__pfet_01v8_hvt ad=0 pd=0 as=0.26 ps=2.52 w=1 l=0.15
X324 VSUBS v3_four_channel_bias_reference_distribution_0/v3_four_channel_phase_distribution_0/v3_four_channel_output_collection_0/v3_four_channel_placement_0/v3_channel_selector_late_promotion_0/v3_selector_route_pilot_0/G2_MUX_NEG/a_76_199# v3_four_channel_bias_reference_distribution_0/v3_four_channel_phase_distribution_0/v3_four_channel_output_collection_0/v3_four_channel_placement_0/v3_channel_selector_late_promotion_0/v3_selector_route_pilot_0/G2_MUX_NEG/X VSUBS sky130_fd_pr__nfet_01v8 ad=0 pd=0 as=0.169 ps=1.82 w=0.65 l=0.15
X325 v3_four_channel_bias_reference_distribution_0/v3_four_channel_phase_distribution_0/v3_four_channel_output_collection_0/v3_four_channel_placement_0/v3_channel_selector_late_promotion_0/VPWR v3_four_channel_bias_reference_distribution_0/v3_four_channel_phase_distribution_0/v3_four_channel_output_collection_0/v3_four_channel_placement_0/v3_channel_selector_late_promotion_0/v3_selector_route_pilot_0/G0_MUX_AXIS/a_505_21# v3_four_channel_bias_reference_distribution_0/v3_four_channel_phase_distribution_0/v3_four_channel_output_collection_0/v3_four_channel_placement_0/v3_channel_selector_late_promotion_0/v3_selector_route_pilot_0/G0_MUX_AXIS/a_535_374# v3_four_channel_bias_reference_distribution_0/v3_four_channel_phase_distribution_0/v3_four_channel_output_collection_0/v3_four_channel_placement_0/v3_channel_selector_late_promotion_0/VPWR sky130_fd_pr__pfet_01v8_hvt ad=0 pd=0 as=0.0882 ps=1.26 w=0.42 l=0.15
X326 v3_four_channel_bias_reference_distribution_0/v3_four_channel_phase_distribution_0/v3_four_channel_output_collection_0/v3_four_channel_placement_0/v3_channel_selector_late_promotion_0/v3_selector_route_pilot_0/G0_MUX_AXIS/a_505_21# v3_four_channel_bias_reference_distribution_0/v3_four_channel_phase_distribution_0/v3_four_channel_output_collection_0/v3_four_channel_placement_0/v3_channel_selector_late_promotion_0/group0_bit1 v3_four_channel_bias_reference_distribution_0/v3_four_channel_phase_distribution_0/v3_four_channel_output_collection_0/v3_four_channel_placement_0/v3_channel_selector_late_promotion_0/VPWR v3_four_channel_bias_reference_distribution_0/v3_four_channel_phase_distribution_0/v3_four_channel_output_collection_0/v3_four_channel_placement_0/v3_channel_selector_late_promotion_0/VPWR sky130_fd_pr__pfet_01v8_hvt ad=0.1176 pd=1.4 as=0 ps=0 w=0.42 l=0.15
X327 v3_four_channel_bias_reference_distribution_0/v3_four_channel_phase_distribution_0/v3_four_channel_output_collection_0/v3_four_channel_placement_0/v3_channel_selector_late_promotion_0/v3_selector_route_pilot_0/G0_MUX_AXIS/a_218_374# v3_four_channel_bias_reference_distribution_0/v3_four_channel_phase_distribution_0/v3_four_channel_output_collection_0/v3_four_channel_placement_0/v3_channel_selector_late_promotion_0/group0_bit1 v3_four_channel_bias_reference_distribution_0/v3_four_channel_phase_distribution_0/v3_four_channel_output_collection_0/v3_four_channel_placement_0/v3_channel_selector_late_promotion_0/VPWR v3_four_channel_bias_reference_distribution_0/v3_four_channel_phase_distribution_0/v3_four_channel_output_collection_0/v3_four_channel_placement_0/v3_channel_selector_late_promotion_0/VPWR sky130_fd_pr__pfet_01v8_hvt ad=0.1533 pd=1.57 as=0 ps=0 w=0.42 l=0.15
X328 VSUBS v3_four_channel_bias_reference_distribution_0/v3_four_channel_phase_distribution_0/v3_four_channel_output_collection_0/v3_four_channel_placement_0/v3_channel_selector_late_promotion_0/v3_selector_route_pilot_0/G0_MUX_AXIS/a_505_21# v3_four_channel_bias_reference_distribution_0/v3_four_channel_phase_distribution_0/v3_four_channel_output_collection_0/v3_four_channel_placement_0/v3_channel_selector_late_promotion_0/v3_selector_route_pilot_0/G0_MUX_AXIS/a_439_47# VSUBS sky130_fd_pr__nfet_01v8 ad=0 pd=0 as=0.1386 ps=1.5 w=0.42 l=0.15
X329 v3_four_channel_bias_reference_distribution_0/v3_four_channel_phase_distribution_0/v3_four_channel_output_collection_0/v3_four_channel_placement_0/v3_channel_selector_late_promotion_0/v3_selector_route_pilot_0/G0_MUX_AXIS/a_76_199# v3_four_channel_bias_reference_distribution_0/v3_four_channel_phase_distribution_0/v3_four_channel_output_collection_0/v3_four_channel_placement_0/v3_channel_selector_late_promotion_0/v3_selector_route_pilot_0/G0_MUX_POS/X v3_four_channel_bias_reference_distribution_0/v3_four_channel_phase_distribution_0/v3_four_channel_output_collection_0/v3_four_channel_placement_0/v3_channel_selector_late_promotion_0/v3_selector_route_pilot_0/G0_MUX_AXIS/a_218_374# v3_four_channel_bias_reference_distribution_0/v3_four_channel_phase_distribution_0/v3_four_channel_output_collection_0/v3_four_channel_placement_0/v3_channel_selector_late_promotion_0/VPWR sky130_fd_pr__pfet_01v8_hvt ad=0.3864 pd=2.68 as=0 ps=0 w=0.42 l=0.15
X330 v3_four_channel_bias_reference_distribution_0/v3_four_channel_phase_distribution_0/v3_four_channel_output_collection_0/v3_four_channel_placement_0/v3_channel_selector_late_promotion_0/v3_selector_route_pilot_0/G0_MUX_AXIS/a_505_21# v3_four_channel_bias_reference_distribution_0/v3_four_channel_phase_distribution_0/v3_four_channel_output_collection_0/v3_four_channel_placement_0/v3_channel_selector_late_promotion_0/group0_bit1 VSUBS VSUBS sky130_fd_pr__nfet_01v8 ad=0.1092 pd=1.36 as=0 ps=0 w=0.42 l=0.15
X331 v3_four_channel_bias_reference_distribution_0/v3_four_channel_phase_distribution_0/v3_four_channel_output_collection_0/v3_four_channel_placement_0/v3_channel_selector_late_promotion_0/v3_selector_route_pilot_0/G0_MUX_AXIS/a_439_47# v3_four_channel_bias_reference_distribution_0/v3_four_channel_phase_distribution_0/v3_four_channel_output_collection_0/v3_four_channel_placement_0/v3_channel_selector_late_promotion_0/v3_selector_route_pilot_0/G0_MUX_POS/X v3_four_channel_bias_reference_distribution_0/v3_four_channel_phase_distribution_0/v3_four_channel_output_collection_0/v3_four_channel_placement_0/v3_channel_selector_late_promotion_0/v3_selector_route_pilot_0/G0_MUX_AXIS/a_76_199# VSUBS sky130_fd_pr__nfet_01v8 ad=0 pd=0 as=0.1995 ps=1.79 w=0.42 l=0.15
X332 v3_four_channel_bias_reference_distribution_0/v3_four_channel_phase_distribution_0/v3_four_channel_output_collection_0/v3_four_channel_placement_0/v3_channel_selector_late_promotion_0/v3_selector_route_pilot_0/G0_MUX_AXIS/a_535_374# v3_four_channel_bias_reference_distribution_0/v3_four_channel_phase_distribution_0/v3_four_channel_output_collection_0/v3_four_channel_placement_0/v3_channel_selector_late_promotion_0/v3_selector_route_pilot_0/G0_MUX_NEG/X v3_four_channel_bias_reference_distribution_0/v3_four_channel_phase_distribution_0/v3_four_channel_output_collection_0/v3_four_channel_placement_0/v3_channel_selector_late_promotion_0/v3_selector_route_pilot_0/G0_MUX_AXIS/a_76_199# v3_four_channel_bias_reference_distribution_0/v3_four_channel_phase_distribution_0/v3_four_channel_output_collection_0/v3_four_channel_placement_0/v3_channel_selector_late_promotion_0/VPWR sky130_fd_pr__pfet_01v8_hvt ad=0 pd=0 as=0 ps=0 w=0.42 l=0.15
X333 v3_four_channel_bias_reference_distribution_0/v3_four_channel_phase_distribution_0/v3_four_channel_output_collection_0/v3_four_channel_placement_0/v3_channel_selector_late_promotion_0/v3_selector_route_pilot_0/G0_MUX_AXIS/a_76_199# v3_four_channel_bias_reference_distribution_0/v3_four_channel_phase_distribution_0/v3_four_channel_output_collection_0/v3_four_channel_placement_0/v3_channel_selector_late_promotion_0/v3_selector_route_pilot_0/G0_MUX_NEG/X v3_four_channel_bias_reference_distribution_0/v3_four_channel_phase_distribution_0/v3_four_channel_output_collection_0/v3_four_channel_placement_0/v3_channel_selector_late_promotion_0/v3_selector_route_pilot_0/G0_MUX_AXIS/a_218_47# VSUBS sky130_fd_pr__nfet_01v8 ad=0 pd=0 as=0.1386 ps=1.5 w=0.42 l=0.15
X334 v3_four_channel_bias_reference_distribution_0/v3_four_channel_phase_distribution_0/v3_four_channel_output_collection_0/v3_four_channel_placement_0/v3_channel_selector_late_promotion_0/v3_selector_route_pilot_0/G0_MUX_AXIS/a_218_47# v3_four_channel_bias_reference_distribution_0/v3_four_channel_phase_distribution_0/v3_four_channel_output_collection_0/v3_four_channel_placement_0/v3_channel_selector_late_promotion_0/group0_bit1 VSUBS VSUBS sky130_fd_pr__nfet_01v8 ad=0 pd=0 as=0 ps=0 w=0.42 l=0.15
X335 v3_four_channel_bias_reference_distribution_0/v3_four_channel_phase_distribution_0/v3_four_channel_output_collection_0/v3_four_channel_placement_0/v3_channel_selector_late_promotion_0/VPWR v3_four_channel_bias_reference_distribution_0/v3_four_channel_phase_distribution_0/v3_four_channel_output_collection_0/v3_four_channel_placement_0/v3_channel_selector_late_promotion_0/v3_selector_route_pilot_0/G0_MUX_AXIS/a_76_199# v3_four_channel_bias_reference_distribution_0/v3_four_channel_phase_distribution_0/v3_four_channel_output_collection_0/v3_four_channel_placement_0/v3_channel_selector_late_promotion_0/v3_selector_route_pilot_0/G0_MUX_AXIS/X v3_four_channel_bias_reference_distribution_0/v3_four_channel_phase_distribution_0/v3_four_channel_output_collection_0/v3_four_channel_placement_0/v3_channel_selector_late_promotion_0/VPWR sky130_fd_pr__pfet_01v8_hvt ad=0 pd=0 as=0.26 ps=2.52 w=1 l=0.15
X336 VSUBS v3_four_channel_bias_reference_distribution_0/v3_four_channel_phase_distribution_0/v3_four_channel_output_collection_0/v3_four_channel_placement_0/v3_channel_selector_late_promotion_0/v3_selector_route_pilot_0/G0_MUX_AXIS/a_76_199# v3_four_channel_bias_reference_distribution_0/v3_four_channel_phase_distribution_0/v3_four_channel_output_collection_0/v3_four_channel_placement_0/v3_channel_selector_late_promotion_0/v3_selector_route_pilot_0/G0_MUX_AXIS/X VSUBS sky130_fd_pr__nfet_01v8 ad=0 pd=0 as=0.169 ps=1.82 w=0.65 l=0.15
X337 v3_four_channel_bias_reference_distribution_0/v3_four_channel_phase_distribution_0/v3_four_channel_output_collection_0/v3_four_channel_placement_0/v3_channel_selector_late_promotion_0/VPWR v3_four_channel_bias_reference_distribution_0/v3_four_channel_phase_distribution_0/v3_four_channel_output_collection_0/v3_four_channel_placement_0/v3_channel_selector_late_promotion_0/v3_selector_route_pilot_0/G3_LO_P_AND/B v3_four_channel_bias_reference_distribution_0/v3_four_channel_phase_distribution_0/v3_four_channel_output_collection_0/v3_four_channel_placement_0/v3_channel_selector_late_promotion_0/v3_selector_route_pilot_0/G2_LO_P_AND/a_59_75# v3_four_channel_bias_reference_distribution_0/v3_four_channel_phase_distribution_0/v3_four_channel_output_collection_0/v3_four_channel_placement_0/v3_channel_selector_late_promotion_0/VPWR sky130_fd_pr__pfet_01v8_hvt ad=0 pd=0 as=0.1134 ps=1.38 w=0.42 l=0.15
X338 v3_four_channel_bias_reference_distribution_0/v3_four_channel_phase_distribution_0/v3_four_channel_output_collection_0/v3_four_channel_placement_0/v3_channel_selector_late_promotion_0/v3_selector_route_pilot_0/group2_lo_p v3_four_channel_bias_reference_distribution_0/v3_four_channel_phase_distribution_0/v3_four_channel_output_collection_0/v3_four_channel_placement_0/v3_channel_selector_late_promotion_0/v3_selector_route_pilot_0/G2_LO_P_AND/a_59_75# v3_four_channel_bias_reference_distribution_0/v3_four_channel_phase_distribution_0/v3_four_channel_output_collection_0/v3_four_channel_placement_0/v3_channel_selector_late_promotion_0/VPWR v3_four_channel_bias_reference_distribution_0/v3_four_channel_phase_distribution_0/v3_four_channel_output_collection_0/v3_four_channel_placement_0/v3_channel_selector_late_promotion_0/VPWR sky130_fd_pr__pfet_01v8_hvt ad=0.475 pd=2.95 as=0 ps=0 w=1 l=0.15
X339 VSUBS v3_four_channel_bias_reference_distribution_0/v3_four_channel_phase_distribution_0/v3_four_channel_output_collection_0/v3_four_channel_placement_0/v3_channel_selector_late_promotion_0/v3_selector_route_pilot_0/G3_LO_P_AND/B v3_four_channel_bias_reference_distribution_0/v3_four_channel_phase_distribution_0/v3_four_channel_output_collection_0/v3_four_channel_placement_0/v3_channel_selector_late_promotion_0/v3_selector_route_pilot_0/G2_LO_P_AND/a_145_75# VSUBS sky130_fd_pr__nfet_01v8 ad=0 pd=0 as=0.1134 ps=1.38 w=0.42 l=0.15
X340 v3_four_channel_bias_reference_distribution_0/v3_four_channel_phase_distribution_0/v3_four_channel_output_collection_0/v3_four_channel_placement_0/v3_channel_selector_late_promotion_0/v3_selector_route_pilot_0/G2_LO_P_AND/a_59_75# v3_four_channel_bias_reference_distribution_0/v3_four_channel_phase_distribution_0/v3_four_channel_output_collection_0/v3_four_channel_placement_0/v3_channel_selector_late_promotion_0/v3_selector_route_pilot_0/G2_MUX_AXIS/X v3_four_channel_bias_reference_distribution_0/v3_four_channel_phase_distribution_0/v3_four_channel_output_collection_0/v3_four_channel_placement_0/v3_channel_selector_late_promotion_0/VPWR v3_four_channel_bias_reference_distribution_0/v3_four_channel_phase_distribution_0/v3_four_channel_output_collection_0/v3_four_channel_placement_0/v3_channel_selector_late_promotion_0/VPWR sky130_fd_pr__pfet_01v8_hvt ad=0 pd=0 as=0 ps=0 w=0.42 l=0.15
X341 v3_four_channel_bias_reference_distribution_0/v3_four_channel_phase_distribution_0/v3_four_channel_output_collection_0/v3_four_channel_placement_0/v3_channel_selector_late_promotion_0/v3_selector_route_pilot_0/group2_lo_p v3_four_channel_bias_reference_distribution_0/v3_four_channel_phase_distribution_0/v3_four_channel_output_collection_0/v3_four_channel_placement_0/v3_channel_selector_late_promotion_0/v3_selector_route_pilot_0/G2_LO_P_AND/a_59_75# VSUBS VSUBS sky130_fd_pr__nfet_01v8 ad=0.182 pd=1.86 as=0 ps=0 w=0.65 l=0.15
X342 v3_four_channel_bias_reference_distribution_0/v3_four_channel_phase_distribution_0/v3_four_channel_output_collection_0/v3_four_channel_placement_0/v3_channel_selector_late_promotion_0/v3_selector_route_pilot_0/G2_LO_P_AND/a_145_75# v3_four_channel_bias_reference_distribution_0/v3_four_channel_phase_distribution_0/v3_four_channel_output_collection_0/v3_four_channel_placement_0/v3_channel_selector_late_promotion_0/v3_selector_route_pilot_0/G2_MUX_AXIS/X v3_four_channel_bias_reference_distribution_0/v3_four_channel_phase_distribution_0/v3_four_channel_output_collection_0/v3_four_channel_placement_0/v3_channel_selector_late_promotion_0/v3_selector_route_pilot_0/G2_LO_P_AND/a_59_75# VSUBS sky130_fd_pr__nfet_01v8 ad=0 pd=0 as=0.1176 ps=1.4 w=0.42 l=0.15
X343 v3_four_channel_bias_reference_distribution_0/v3_four_channel_phase_distribution_0/v3_four_channel_output_collection_0/v3_four_channel_placement_0/v3_channel_selector_late_promotion_1/v3_channel_input_bias_late_promotion_0/a_4678_23422# v3_four_channel_bias_reference_distribution_0/v3_four_channel_phase_distribution_0/v3_four_channel_output_collection_0/v3_four_channel_placement_0/v3_channel_selector_late_promotion_1/v3_selector_route_pilot_0/group3_lo_p v3_four_channel_bias_reference_distribution_0/v3_four_channel_phase_distribution_0/v3_four_channel_output_collection_0/combined_n_internal VSUBS sky130_fd_pr__nfet_01v8 ad=0.6206 pd=6.02 as=22.62 ps=225.60001 w=0.65 l=0.15
X344 v3_four_channel_bias_reference_distribution_0/v3_four_channel_phase_distribution_0/v3_four_channel_output_collection_0/combined_n_internal v3_four_channel_bias_reference_distribution_0/v3_four_channel_phase_distribution_0/v3_four_channel_output_collection_0/v3_four_channel_placement_0/v3_channel_selector_late_promotion_1/v3_selector_route_pilot_0/group3_lo_p v3_four_channel_bias_reference_distribution_0/v3_four_channel_phase_distribution_0/v3_four_channel_output_collection_0/v3_four_channel_placement_0/v3_channel_selector_late_promotion_1/v3_channel_input_bias_late_promotion_0/a_4254_6978# VSUBS sky130_fd_pr__nfet_01v8 ad=0 pd=0 as=0.6206 ps=6.02 w=0.65 l=0.15
X345 v3_four_channel_bias_reference_distribution_0/v3_four_channel_phase_distribution_0/v3_four_channel_output_collection_0/v3_four_channel_placement_0/v3_channel_selector_late_promotion_1/v3_channel_input_bias_late_promotion_0/a_4678_23422# v3_vcm_support_block_0/ref v3_four_channel_bias_reference_distribution_0/v3_four_channel_phase_distribution_0/v3_four_channel_output_collection_0/v3_four_channel_placement_0/v3_channel_selector_late_promotion_1/v3_channel_input_bias_late_promotion_0/a_4382_21688# VSUBS sky130_fd_pr__nfet_01v8 ad=0 pd=0 as=1.9575 ps=15.24 w=0.84 l=0.6
X346 v3_four_channel_bias_reference_distribution_0/v3_four_channel_phase_distribution_0/v3_four_channel_output_collection_0/combined_n_internal v3_four_channel_bias_reference_distribution_0/v3_four_channel_phase_distribution_0/v3_four_channel_output_collection_0/v3_four_channel_placement_0/v3_channel_selector_late_promotion_1/v3_selector_route_pilot_0/group3_lo_n v3_four_channel_bias_reference_distribution_0/v3_four_channel_phase_distribution_0/v3_four_channel_output_collection_0/v3_four_channel_placement_0/v3_channel_selector_late_promotion_1/v3_channel_input_bias_late_promotion_0/a_7038_22978# VSUBS sky130_fd_pr__nfet_01v8 ad=0 pd=0 as=0.6206 ps=6.02 w=0.65 l=0.15
X347 v3_four_channel_bias_reference_distribution_0/v3_four_channel_phase_distribution_0/v3_four_channel_output_collection_0/combined_n_internal v3_four_channel_bias_reference_distribution_0/v3_four_channel_phase_distribution_0/v3_four_channel_output_collection_0/v3_four_channel_placement_0/v3_channel_selector_late_promotion_1/v3_selector_route_pilot_0/group3_lo_p v3_four_channel_bias_reference_distribution_0/v3_four_channel_phase_distribution_0/v3_four_channel_output_collection_0/v3_four_channel_placement_0/v3_channel_selector_late_promotion_1/v3_channel_input_bias_late_promotion_0/a_7038_6978# VSUBS sky130_fd_pr__nfet_01v8 ad=0 pd=0 as=0.6206 ps=6.02 w=0.65 l=0.15
X348 v3_four_channel_bias_reference_distribution_0/v3_four_channel_phase_distribution_0/v3_four_channel_output_collection_0/v3_four_channel_placement_0/v3_channel_selector_late_promotion_1/v3_channel_input_bias_late_promotion_0/a_7462_11422# v3_four_channel_bias_reference_distribution_0/v3_four_channel_phase_distribution_0/v3_four_channel_output_collection_0/v3_four_channel_placement_0/v3_channel_selector_late_promotion_1/element_input v3_four_channel_bias_reference_distribution_0/v3_four_channel_phase_distribution_0/v3_four_channel_output_collection_0/v3_four_channel_placement_0/v3_channel_selector_late_promotion_1/v3_channel_input_bias_late_promotion_0/a_7216_10978# VSUBS sky130_fd_pr__nfet_01v8 ad=0.6206 pd=6.02 as=1.9575 ps=15.24 w=0.84 l=0.6
X349 v3_four_channel_bias_reference_distribution_0/v3_four_channel_phase_distribution_0/v3_four_channel_output_collection_0/v3_four_channel_placement_0/v3_channel_selector_late_promotion_1/v3_channel_input_bias_late_promotion_0/a_7462_11422# v3_four_channel_bias_reference_distribution_0/v3_four_channel_phase_distribution_0/v3_four_channel_output_collection_0/v3_four_channel_placement_0/v3_channel_selector_late_promotion_1/v3_selector_route_pilot_0/group2_lo_n v3_four_channel_bias_reference_distribution_0/v3_four_channel_phase_distribution_0/v3_four_channel_output_collection_0/combined_n_internal VSUBS sky130_fd_pr__nfet_01v8 ad=0 pd=0 as=0 ps=0 w=0.65 l=0.15
X350 v3_four_channel_bias_reference_distribution_0/v3_four_channel_phase_distribution_0/v3_four_channel_output_collection_0/v3_four_channel_placement_0/v3_channel_selector_late_promotion_1/v3_channel_input_bias_late_promotion_0/a_5774_21688# v3_four_channel_bias_reference_distribution_0/v3_four_channel_phase_distribution_0/v3_four_channel_output_collection_0/v3_four_channel_placement_0/v3_channel_selector_late_promotion_1/element_input v3_four_channel_bias_reference_distribution_0/v3_four_channel_phase_distribution_0/v3_four_channel_output_collection_0/v3_four_channel_placement_0/v3_channel_selector_late_promotion_1/v3_channel_input_bias_late_promotion_0/a_5646_22978# VSUBS sky130_fd_pr__nfet_01v8 ad=1.9575 pd=15.24 as=0.6206 ps=6.02 w=0.84 l=0.6
X351 VSUBS v3_tail_bias_support_block_0/vbias v3_four_channel_bias_reference_distribution_0/v3_four_channel_phase_distribution_0/v3_four_channel_output_collection_0/v3_four_channel_placement_0/v3_channel_selector_late_promotion_1/v3_channel_input_bias_late_promotion_0/a_5774_17688# VSUBS sky130_fd_pr__nfet_01v8 ad=0 pd=0 as=1.9575 ps=15.24 w=5.07 l=1
X352 v3_four_channel_bias_reference_distribution_0/v3_four_channel_phase_distribution_0/v3_four_channel_output_collection_0/v3_four_channel_placement_0/v3_channel_selector_late_promotion_1/v3_channel_input_bias_late_promotion_0/a_6070_7422# v3_four_channel_bias_reference_distribution_0/v3_four_channel_phase_distribution_0/v3_four_channel_output_collection_0/v3_four_channel_placement_0/v3_channel_selector_late_promotion_1/element_input v3_four_channel_bias_reference_distribution_0/v3_four_channel_phase_distribution_0/v3_four_channel_output_collection_0/v3_four_channel_placement_0/v3_channel_selector_late_promotion_1/v3_channel_input_bias_late_promotion_0/a_5824_6978# VSUBS sky130_fd_pr__nfet_01v8 ad=0.6206 pd=6.02 as=1.9575 ps=15.24 w=0.84 l=0.6
X353 v3_four_channel_bias_reference_distribution_0/v3_four_channel_phase_distribution_0/v3_four_channel_output_collection_0/v3_four_channel_placement_0/v3_channel_selector_late_promotion_1/v3_channel_input_bias_late_promotion_0/a_6070_7422# v3_four_channel_bias_reference_distribution_0/v3_four_channel_phase_distribution_0/v3_four_channel_output_collection_0/v3_four_channel_placement_0/v3_channel_selector_late_promotion_1/v3_selector_route_pilot_0/group3_lo_n v3_four_channel_bias_reference_distribution_0/v3_four_channel_phase_distribution_0/v3_four_channel_output_collection_0/combined_n_internal VSUBS sky130_fd_pr__nfet_01v8 ad=0 pd=0 as=0 ps=0 w=0.65 l=0.15
X354 v3_vcm_support_block_0/ref v3_four_channel_bias_reference_distribution_0/v3_four_channel_phase_distribution_0/v3_four_channel_output_collection_0/v3_four_channel_placement_0/v3_channel_selector_late_promotion_1/element_input VSUBS sky130_fd_pr__res_xhigh_po_0p35 l=17.36
X355 v3_four_channel_bias_reference_distribution_0/v3_four_channel_phase_distribution_0/v3_four_channel_output_collection_0/v3_four_channel_placement_0/v3_channel_selector_late_promotion_1/v3_channel_input_bias_late_promotion_0/a_7462_23422# v3_vcm_support_block_0/ref v3_four_channel_bias_reference_distribution_0/v3_four_channel_phase_distribution_0/v3_four_channel_output_collection_0/v3_four_channel_placement_0/v3_channel_selector_late_promotion_1/v3_channel_input_bias_late_promotion_0/a_7166_21688# VSUBS sky130_fd_pr__nfet_01v8 ad=0.6206 pd=6.02 as=1.9575 ps=15.24 w=0.84 l=0.6
X356 v3_four_channel_bias_reference_distribution_0/v3_four_channel_phase_distribution_0/v3_four_channel_output_collection_0/v3_four_channel_placement_0/v3_channel_selector_late_promotion_1/v3_channel_input_bias_late_promotion_0/a_7462_23422# v3_four_channel_bias_reference_distribution_0/v3_four_channel_phase_distribution_0/v3_four_channel_output_collection_0/v3_four_channel_placement_0/v3_channel_selector_late_promotion_1/v3_selector_route_pilot_0/group3_lo_p v3_four_channel_bias_reference_distribution_0/v3_four_channel_phase_distribution_0/v3_four_channel_output_collection_0/combined_n_internal VSUBS sky130_fd_pr__nfet_01v8 ad=0 pd=0 as=0 ps=0 w=0.65 l=0.15
X357 VSUBS v3_tail_bias_support_block_0/vbias v3_four_channel_bias_reference_distribution_0/v3_four_channel_phase_distribution_0/v3_four_channel_output_collection_0/v3_four_channel_placement_0/v3_channel_selector_late_promotion_1/v3_channel_input_bias_late_promotion_0/a_4382_21688# VSUBS sky130_fd_pr__nfet_01v8 ad=0 pd=0 as=0 ps=0 w=5.07 l=1
X358 VSUBS v3_tail_bias_support_block_0/vbias v3_four_channel_bias_reference_distribution_0/v3_four_channel_phase_distribution_0/v3_four_channel_output_collection_0/v3_four_channel_placement_0/v3_channel_selector_late_promotion_1/v3_channel_input_bias_late_promotion_0/a_5774_13688# VSUBS sky130_fd_pr__nfet_01v8 ad=0 pd=0 as=1.9575 ps=15.24 w=5.07 l=1
X359 VSUBS v3_tail_bias_support_block_0/vbias v3_four_channel_bias_reference_distribution_0/v3_four_channel_phase_distribution_0/v3_four_channel_output_collection_0/v3_four_channel_placement_0/v3_channel_selector_late_promotion_1/v3_channel_input_bias_late_promotion_0/a_7166_17688# VSUBS sky130_fd_pr__nfet_01v8 ad=0 pd=0 as=1.9575 ps=15.24 w=5.07 l=1
X360 VSUBS VSUBS VSUBS VSUBS sky130_fd_pr__nfet_01v8 ad=0 pd=0 as=0 ps=0 w=0.65 l=0.15
X361 v3_four_channel_bias_reference_distribution_0/v3_four_channel_phase_distribution_0/v3_four_channel_output_collection_0/combined_p_internal v3_four_channel_bias_reference_distribution_0/v3_four_channel_phase_distribution_0/v3_four_channel_output_collection_0/v3_four_channel_placement_0/v3_channel_selector_late_promotion_1/v3_selector_route_pilot_0/group3_lo_p v3_four_channel_bias_reference_distribution_0/v3_four_channel_phase_distribution_0/v3_four_channel_output_collection_0/v3_four_channel_placement_0/v3_channel_selector_late_promotion_1/v3_channel_input_bias_late_promotion_0/a_5646_18978# VSUBS sky130_fd_pr__nfet_01v8 ad=22.62 pd=225.60001 as=0.6206 ps=6.02 w=0.65 l=0.15
X362 VSUBS VSUBS VSUBS VSUBS sky130_fd_pr__nfet_01v8 ad=0 pd=0 as=0 ps=0 w=0.65 l=0.15
X363 v3_four_channel_bias_reference_distribution_0/v3_four_channel_phase_distribution_0/v3_four_channel_output_collection_0/v3_four_channel_placement_0/v3_channel_selector_late_promotion_1/v3_channel_input_bias_late_promotion_0/a_6070_19422# v3_four_channel_bias_reference_distribution_0/v3_four_channel_phase_distribution_0/v3_four_channel_output_collection_0/v3_four_channel_placement_0/v3_channel_selector_late_promotion_1/v3_selector_route_pilot_0/group3_lo_n v3_four_channel_bias_reference_distribution_0/v3_four_channel_phase_distribution_0/v3_four_channel_output_collection_0/combined_p_internal VSUBS sky130_fd_pr__nfet_01v8 ad=0.6206 pd=6.02 as=0 ps=0 w=0.65 l=0.15
X364 VSUBS VSUBS VSUBS VSUBS sky130_fd_pr__nfet_01v8 ad=0 pd=0 as=0 ps=0 w=0.65 l=0.15
X365 v3_four_channel_bias_reference_distribution_0/v3_four_channel_phase_distribution_0/v3_four_channel_output_collection_0/combined_p_internal v3_four_channel_bias_reference_distribution_0/v3_four_channel_phase_distribution_0/v3_four_channel_output_collection_0/v3_four_channel_placement_0/v3_channel_selector_late_promotion_1/v3_selector_route_pilot_0/group2_lo_p v3_four_channel_bias_reference_distribution_0/v3_four_channel_phase_distribution_0/v3_four_channel_output_collection_0/v3_four_channel_placement_0/v3_channel_selector_late_promotion_1/v3_channel_input_bias_late_promotion_0/a_4254_18978# VSUBS sky130_fd_pr__nfet_01v8 ad=0 pd=0 as=0.6206 ps=6.02 w=0.65 l=0.15
X366 v3_four_channel_bias_reference_distribution_0/v3_four_channel_phase_distribution_0/v3_four_channel_output_collection_0/v3_four_channel_placement_0/v3_channel_selector_late_promotion_1/v3_channel_input_bias_late_promotion_0/a_7216_14978# v3_tail_bias_support_block_0/vbias VSUBS VSUBS sky130_fd_pr__nfet_01v8 ad=1.9575 pd=15.24 as=0 ps=0 w=5.07 l=1
X367 VSUBS VSUBS VSUBS VSUBS sky130_fd_pr__nfet_01v8 ad=0 pd=0 as=0 ps=0 w=0.65 l=0.15
X368 VSUBS VSUBS VSUBS VSUBS sky130_fd_pr__nfet_01v8 ad=0 pd=0 as=0 ps=0 w=0.65 l=0.15
X369 v3_four_channel_bias_reference_distribution_0/v3_four_channel_phase_distribution_0/v3_four_channel_output_collection_0/v3_four_channel_placement_0/v3_channel_selector_late_promotion_1/v3_channel_input_bias_late_promotion_0/a_4382_17688# v3_four_channel_bias_reference_distribution_0/v3_four_channel_phase_distribution_0/v3_four_channel_output_collection_0/v3_four_channel_placement_0/v3_channel_selector_late_promotion_1/element_input v3_four_channel_bias_reference_distribution_0/v3_four_channel_phase_distribution_0/v3_four_channel_output_collection_0/v3_four_channel_placement_0/v3_channel_selector_late_promotion_1/v3_channel_input_bias_late_promotion_0/a_4254_18978# VSUBS sky130_fd_pr__nfet_01v8 ad=1.9575 pd=15.24 as=0 ps=0 w=0.84 l=0.6
X370 v3_four_channel_bias_reference_distribution_0/v3_four_channel_phase_distribution_0/v3_four_channel_output_collection_0/v3_four_channel_placement_0/v3_channel_selector_late_promotion_1/v3_channel_input_bias_late_promotion_0/a_4678_19422# v3_four_channel_bias_reference_distribution_0/v3_four_channel_phase_distribution_0/v3_four_channel_output_collection_0/v3_four_channel_placement_0/v3_channel_selector_late_promotion_1/v3_selector_route_pilot_0/group2_lo_n v3_four_channel_bias_reference_distribution_0/v3_four_channel_phase_distribution_0/v3_four_channel_output_collection_0/combined_p_internal VSUBS sky130_fd_pr__nfet_01v8 ad=0.6206 pd=6.02 as=0 ps=0 w=0.65 l=0.15
X371 v3_four_channel_bias_reference_distribution_0/v3_four_channel_phase_distribution_0/v3_four_channel_output_collection_0/combined_p_internal v3_four_channel_bias_reference_distribution_0/v3_four_channel_phase_distribution_0/v3_four_channel_output_collection_0/v3_four_channel_placement_0/v3_channel_selector_late_promotion_1/v3_selector_route_pilot_0/group0_lo_p v3_four_channel_bias_reference_distribution_0/v3_four_channel_phase_distribution_0/v3_four_channel_output_collection_0/v3_four_channel_placement_0/v3_channel_selector_late_promotion_1/v3_channel_input_bias_late_promotion_0/a_5646_14978# VSUBS sky130_fd_pr__nfet_01v8 ad=0 pd=0 as=0.6206 ps=6.02 w=0.65 l=0.15
X372 v3_four_channel_bias_reference_distribution_0/v3_four_channel_phase_distribution_0/v3_four_channel_output_collection_0/combined_p_internal v3_four_channel_bias_reference_distribution_0/v3_four_channel_phase_distribution_0/v3_four_channel_output_collection_0/v3_four_channel_placement_0/v3_channel_selector_late_promotion_1/v3_selector_route_pilot_0/group2_lo_p v3_four_channel_bias_reference_distribution_0/v3_four_channel_phase_distribution_0/v3_four_channel_output_collection_0/v3_four_channel_placement_0/v3_channel_selector_late_promotion_1/v3_channel_input_bias_late_promotion_0/a_7038_18978# VSUBS sky130_fd_pr__nfet_01v8 ad=0 pd=0 as=0.6206 ps=6.02 w=0.65 l=0.15
X373 VSUBS VSUBS VSUBS VSUBS sky130_fd_pr__nfet_01v8 ad=0 pd=0 as=0 ps=0 w=5.07 l=1
X374 v3_four_channel_bias_reference_distribution_0/v3_four_channel_phase_distribution_0/v3_four_channel_output_collection_0/v3_four_channel_placement_0/v3_channel_selector_late_promotion_1/v3_channel_input_bias_late_promotion_0/a_6070_15422# v3_four_channel_bias_reference_distribution_0/v3_four_channel_phase_distribution_0/v3_four_channel_output_collection_0/v3_four_channel_placement_0/v3_channel_selector_late_promotion_1/v3_selector_route_pilot_0/group0_lo_n v3_four_channel_bias_reference_distribution_0/v3_four_channel_phase_distribution_0/v3_four_channel_output_collection_0/combined_p_internal VSUBS sky130_fd_pr__nfet_01v8 ad=0.6206 pd=6.02 as=0 ps=0 w=0.65 l=0.15
X375 v3_four_channel_bias_reference_distribution_0/v3_four_channel_phase_distribution_0/v3_four_channel_output_collection_0/v3_four_channel_placement_0/v3_channel_selector_late_promotion_1/v3_channel_input_bias_late_promotion_0/a_7166_17688# v3_four_channel_bias_reference_distribution_0/v3_four_channel_phase_distribution_0/v3_four_channel_output_collection_0/v3_four_channel_placement_0/v3_channel_selector_late_promotion_1/element_input v3_four_channel_bias_reference_distribution_0/v3_four_channel_phase_distribution_0/v3_four_channel_output_collection_0/v3_four_channel_placement_0/v3_channel_selector_late_promotion_1/v3_channel_input_bias_late_promotion_0/a_7038_18978# VSUBS sky130_fd_pr__nfet_01v8 ad=0 pd=0 as=0 ps=0 w=0.84 l=0.6
X376 v3_four_channel_bias_reference_distribution_0/v3_four_channel_phase_distribution_0/v3_four_channel_output_collection_0/combined_n_internal v3_four_channel_bias_reference_distribution_0/v3_four_channel_phase_distribution_0/v3_four_channel_output_collection_0/v3_four_channel_placement_0/v3_channel_selector_late_promotion_1/v3_selector_route_pilot_0/group3_lo_n v3_four_channel_bias_reference_distribution_0/v3_four_channel_phase_distribution_0/v3_four_channel_output_collection_0/v3_four_channel_placement_0/v3_channel_selector_late_promotion_1/v3_channel_input_bias_late_promotion_0/a_5646_18978# VSUBS sky130_fd_pr__nfet_01v8 ad=0 pd=0 as=0 ps=0 w=0.65 l=0.15
X377 VSUBS v3_tail_bias_support_block_0/vbias v3_four_channel_bias_reference_distribution_0/v3_four_channel_phase_distribution_0/v3_four_channel_output_collection_0/v3_four_channel_placement_0/v3_channel_selector_late_promotion_1/v3_channel_input_bias_late_promotion_0/a_5774_21688# VSUBS sky130_fd_pr__nfet_01v8 ad=0 pd=0 as=0 ps=0 w=5.07 l=1
X378 v3_four_channel_bias_reference_distribution_0/v3_four_channel_phase_distribution_0/v3_four_channel_output_collection_0/v3_four_channel_placement_0/v3_channel_selector_late_promotion_1/v3_channel_input_bias_late_promotion_0/a_6070_19422# v3_vcm_support_block_0/ref v3_four_channel_bias_reference_distribution_0/v3_four_channel_phase_distribution_0/v3_four_channel_output_collection_0/v3_four_channel_placement_0/v3_channel_selector_late_promotion_1/v3_channel_input_bias_late_promotion_0/a_5774_17688# VSUBS sky130_fd_pr__nfet_01v8 ad=0 pd=0 as=0 ps=0 w=0.84 l=0.6
X379 VSUBS VSUBS VSUBS VSUBS sky130_fd_pr__nfet_01v8 ad=0 pd=0 as=0 ps=0 w=5.07 l=1
X380 v3_four_channel_bias_reference_distribution_0/v3_four_channel_phase_distribution_0/v3_four_channel_output_collection_0/combined_p_internal v3_four_channel_bias_reference_distribution_0/v3_four_channel_phase_distribution_0/v3_four_channel_output_collection_0/v3_four_channel_placement_0/v3_channel_selector_late_promotion_1/v3_selector_route_pilot_0/group1_lo_p v3_four_channel_bias_reference_distribution_0/v3_four_channel_phase_distribution_0/v3_four_channel_output_collection_0/v3_four_channel_placement_0/v3_channel_selector_late_promotion_1/v3_channel_input_bias_late_promotion_0/a_4254_14978# VSUBS sky130_fd_pr__nfet_01v8 ad=0 pd=0 as=0.6206 ps=6.02 w=0.65 l=0.15
X381 v3_four_channel_bias_reference_distribution_0/v3_four_channel_phase_distribution_0/v3_four_channel_output_collection_0/v3_four_channel_placement_0/v3_channel_selector_late_promotion_1/v3_channel_input_bias_late_promotion_0/a_6070_19422# v3_four_channel_bias_reference_distribution_0/v3_four_channel_phase_distribution_0/v3_four_channel_output_collection_0/v3_four_channel_placement_0/v3_channel_selector_late_promotion_1/v3_selector_route_pilot_0/group3_lo_p v3_four_channel_bias_reference_distribution_0/v3_four_channel_phase_distribution_0/v3_four_channel_output_collection_0/combined_n_internal VSUBS sky130_fd_pr__nfet_01v8 ad=0 pd=0 as=0 ps=0 w=0.65 l=0.15
X382 VSUBS VSUBS VSUBS VSUBS sky130_fd_pr__nfet_01v8 ad=0 pd=0 as=0 ps=0 w=0.65 l=0.15
X383 v3_four_channel_bias_reference_distribution_0/v3_four_channel_phase_distribution_0/v3_four_channel_output_collection_0/v3_four_channel_placement_0/v3_channel_selector_late_promotion_1/v3_channel_input_bias_late_promotion_0/a_5824_10978# v3_tail_bias_support_block_0/vbias VSUBS VSUBS sky130_fd_pr__nfet_01v8 ad=1.9575 pd=15.24 as=0 ps=0 w=5.07 l=1
X384 v3_four_channel_bias_reference_distribution_0/v3_four_channel_phase_distribution_0/v3_four_channel_output_collection_0/v3_four_channel_placement_0/v3_channel_selector_late_promotion_1/v3_channel_input_bias_late_promotion_0/a_4382_13688# v3_four_channel_bias_reference_distribution_0/v3_four_channel_phase_distribution_0/v3_four_channel_output_collection_0/v3_four_channel_placement_0/v3_channel_selector_late_promotion_1/element_input v3_four_channel_bias_reference_distribution_0/v3_four_channel_phase_distribution_0/v3_four_channel_output_collection_0/v3_four_channel_placement_0/v3_channel_selector_late_promotion_1/v3_channel_input_bias_late_promotion_0/a_4254_14978# VSUBS sky130_fd_pr__nfet_01v8 ad=1.9575 pd=15.24 as=0 ps=0 w=0.84 l=0.6
X385 v3_four_channel_bias_reference_distribution_0/v3_four_channel_phase_distribution_0/v3_four_channel_output_collection_0/v3_four_channel_placement_0/v3_channel_selector_late_promotion_1/v3_channel_input_bias_late_promotion_0/a_4678_15422# v3_four_channel_bias_reference_distribution_0/v3_four_channel_phase_distribution_0/v3_four_channel_output_collection_0/v3_four_channel_placement_0/v3_channel_selector_late_promotion_1/v3_selector_route_pilot_0/group1_lo_n v3_four_channel_bias_reference_distribution_0/v3_four_channel_phase_distribution_0/v3_four_channel_output_collection_0/combined_p_internal VSUBS sky130_fd_pr__nfet_01v8 ad=0.6206 pd=6.02 as=0 ps=0 w=0.65 l=0.15
X386 v3_four_channel_bias_reference_distribution_0/v3_four_channel_phase_distribution_0/v3_four_channel_output_collection_0/combined_n_internal v3_four_channel_bias_reference_distribution_0/v3_four_channel_phase_distribution_0/v3_four_channel_output_collection_0/v3_four_channel_placement_0/v3_channel_selector_late_promotion_1/v3_selector_route_pilot_0/group2_lo_n v3_four_channel_bias_reference_distribution_0/v3_four_channel_phase_distribution_0/v3_four_channel_output_collection_0/v3_four_channel_placement_0/v3_channel_selector_late_promotion_1/v3_channel_input_bias_late_promotion_0/a_4254_18978# VSUBS sky130_fd_pr__nfet_01v8 ad=0 pd=0 as=0 ps=0 w=0.65 l=0.15
X387 v3_four_channel_bias_reference_distribution_0/v3_four_channel_phase_distribution_0/v3_four_channel_output_collection_0/combined_p_internal v3_four_channel_bias_reference_distribution_0/v3_four_channel_phase_distribution_0/v3_four_channel_output_collection_0/v3_four_channel_placement_0/v3_channel_selector_late_promotion_1/v3_selector_route_pilot_0/group3_lo_n v3_four_channel_bias_reference_distribution_0/v3_four_channel_phase_distribution_0/v3_four_channel_output_collection_0/v3_four_channel_placement_0/v3_channel_selector_late_promotion_1/v3_channel_input_bias_late_promotion_0/a_5646_10978# VSUBS sky130_fd_pr__nfet_01v8 ad=0 pd=0 as=0.6206 ps=6.02 w=0.65 l=0.15
X388 v3_four_channel_bias_reference_distribution_0/v3_four_channel_phase_distribution_0/v3_four_channel_output_collection_0/combined_p_internal v3_four_channel_bias_reference_distribution_0/v3_four_channel_phase_distribution_0/v3_four_channel_output_collection_0/v3_four_channel_placement_0/v3_channel_selector_late_promotion_1/v3_selector_route_pilot_0/group1_lo_n v3_four_channel_bias_reference_distribution_0/v3_four_channel_phase_distribution_0/v3_four_channel_output_collection_0/v3_four_channel_placement_0/v3_channel_selector_late_promotion_1/v3_channel_input_bias_late_promotion_0/a_7038_14978# VSUBS sky130_fd_pr__nfet_01v8 ad=0 pd=0 as=0.6206 ps=6.02 w=0.65 l=0.15
X389 v3_four_channel_bias_reference_distribution_0/v3_four_channel_phase_distribution_0/v3_four_channel_output_collection_0/v3_four_channel_placement_0/v3_channel_selector_late_promotion_1/v3_channel_input_bias_late_promotion_0/a_7462_19422# v3_four_channel_bias_reference_distribution_0/v3_four_channel_phase_distribution_0/v3_four_channel_output_collection_0/v3_four_channel_placement_0/v3_channel_selector_late_promotion_1/v3_selector_route_pilot_0/group2_lo_n v3_four_channel_bias_reference_distribution_0/v3_four_channel_phase_distribution_0/v3_four_channel_output_collection_0/combined_p_internal VSUBS sky130_fd_pr__nfet_01v8 ad=0.6206 pd=6.02 as=0 ps=0 w=0.65 l=0.15
X390 v3_four_channel_bias_reference_distribution_0/v3_four_channel_phase_distribution_0/v3_four_channel_output_collection_0/v3_four_channel_placement_0/v3_channel_selector_late_promotion_1/v3_channel_input_bias_late_promotion_0/a_4678_7422# v3_four_channel_bias_reference_distribution_0/v3_four_channel_phase_distribution_0/v3_four_channel_output_collection_0/v3_four_channel_placement_0/v3_channel_selector_late_promotion_1/v3_selector_route_pilot_0/group3_lo_p v3_four_channel_bias_reference_distribution_0/v3_four_channel_phase_distribution_0/v3_four_channel_output_collection_0/combined_p_internal VSUBS sky130_fd_pr__nfet_01v8 ad=0.6206 pd=6.02 as=0 ps=0 w=0.65 l=0.15
X391 v3_four_channel_bias_reference_distribution_0/v3_four_channel_phase_distribution_0/v3_four_channel_output_collection_0/v3_four_channel_placement_0/v3_channel_selector_late_promotion_1/v3_channel_input_bias_late_promotion_0/a_6070_11422# v3_four_channel_bias_reference_distribution_0/v3_four_channel_phase_distribution_0/v3_four_channel_output_collection_0/v3_four_channel_placement_0/v3_channel_selector_late_promotion_1/v3_selector_route_pilot_0/group3_lo_p v3_four_channel_bias_reference_distribution_0/v3_four_channel_phase_distribution_0/v3_four_channel_output_collection_0/combined_p_internal VSUBS sky130_fd_pr__nfet_01v8 ad=0.6206 pd=6.02 as=0 ps=0 w=0.65 l=0.15
X392 v3_four_channel_bias_reference_distribution_0/v3_four_channel_phase_distribution_0/v3_four_channel_output_collection_0/v3_four_channel_placement_0/v3_channel_selector_late_promotion_1/v3_channel_input_bias_late_promotion_0/a_7216_10978# v3_tail_bias_support_block_0/vbias VSUBS VSUBS sky130_fd_pr__nfet_01v8 ad=0 pd=0 as=0 ps=0 w=5.07 l=1
X393 v3_four_channel_bias_reference_distribution_0/v3_four_channel_phase_distribution_0/v3_four_channel_output_collection_0/v3_four_channel_placement_0/v3_channel_selector_late_promotion_1/v3_channel_input_bias_late_promotion_0/a_7216_14978# v3_vcm_support_block_0/ref v3_four_channel_bias_reference_distribution_0/v3_four_channel_phase_distribution_0/v3_four_channel_output_collection_0/v3_four_channel_placement_0/v3_channel_selector_late_promotion_1/v3_channel_input_bias_late_promotion_0/a_7038_14978# VSUBS sky130_fd_pr__nfet_01v8 ad=0 pd=0 as=0 ps=0 w=0.84 l=0.6
X394 v3_four_channel_bias_reference_distribution_0/v3_four_channel_phase_distribution_0/v3_four_channel_output_collection_0/v3_four_channel_placement_0/v3_channel_selector_late_promotion_1/v3_channel_input_bias_late_promotion_0/a_4678_19422# v3_vcm_support_block_0/ref v3_four_channel_bias_reference_distribution_0/v3_four_channel_phase_distribution_0/v3_four_channel_output_collection_0/v3_four_channel_placement_0/v3_channel_selector_late_promotion_1/v3_channel_input_bias_late_promotion_0/a_4382_17688# VSUBS sky130_fd_pr__nfet_01v8 ad=0 pd=0 as=0 ps=0 w=0.84 l=0.6
X395 v3_four_channel_bias_reference_distribution_0/v3_four_channel_phase_distribution_0/v3_four_channel_output_collection_0/v3_four_channel_placement_0/v3_channel_selector_late_promotion_1/v3_channel_input_bias_late_promotion_0/a_4678_19422# v3_four_channel_bias_reference_distribution_0/v3_four_channel_phase_distribution_0/v3_four_channel_output_collection_0/v3_four_channel_placement_0/v3_channel_selector_late_promotion_1/v3_selector_route_pilot_0/group2_lo_p v3_four_channel_bias_reference_distribution_0/v3_four_channel_phase_distribution_0/v3_four_channel_output_collection_0/combined_n_internal VSUBS sky130_fd_pr__nfet_01v8 ad=0 pd=0 as=0 ps=0 w=0.65 l=0.15
X396 v3_four_channel_bias_reference_distribution_0/v3_four_channel_phase_distribution_0/v3_four_channel_output_collection_0/combined_n_internal v3_four_channel_bias_reference_distribution_0/v3_four_channel_phase_distribution_0/v3_four_channel_output_collection_0/v3_four_channel_placement_0/v3_channel_selector_late_promotion_1/v3_selector_route_pilot_0/group0_lo_n v3_four_channel_bias_reference_distribution_0/v3_four_channel_phase_distribution_0/v3_four_channel_output_collection_0/v3_four_channel_placement_0/v3_channel_selector_late_promotion_1/v3_channel_input_bias_late_promotion_0/a_5646_14978# VSUBS sky130_fd_pr__nfet_01v8 ad=0 pd=0 as=0 ps=0 w=0.65 l=0.15
X397 v3_four_channel_bias_reference_distribution_0/v3_four_channel_phase_distribution_0/v3_four_channel_output_collection_0/combined_n_internal v3_four_channel_bias_reference_distribution_0/v3_four_channel_phase_distribution_0/v3_four_channel_output_collection_0/v3_four_channel_placement_0/v3_channel_selector_late_promotion_1/v3_selector_route_pilot_0/group2_lo_n v3_four_channel_bias_reference_distribution_0/v3_four_channel_phase_distribution_0/v3_four_channel_output_collection_0/v3_four_channel_placement_0/v3_channel_selector_late_promotion_1/v3_channel_input_bias_late_promotion_0/a_7038_18978# VSUBS sky130_fd_pr__nfet_01v8 ad=0 pd=0 as=0 ps=0 w=0.65 l=0.15
X398 v3_four_channel_bias_reference_distribution_0/v3_four_channel_phase_distribution_0/v3_four_channel_output_collection_0/v3_four_channel_placement_0/v3_channel_selector_late_promotion_1/v3_channel_input_bias_late_promotion_0/a_7462_7422# v3_four_channel_bias_reference_distribution_0/v3_four_channel_phase_distribution_0/v3_four_channel_output_collection_0/v3_four_channel_placement_0/v3_channel_selector_late_promotion_1/v3_selector_route_pilot_0/group3_lo_p v3_four_channel_bias_reference_distribution_0/v3_four_channel_phase_distribution_0/v3_four_channel_output_collection_0/combined_p_internal VSUBS sky130_fd_pr__nfet_01v8 ad=0.6206 pd=6.02 as=0 ps=0 w=0.65 l=0.15
X399 VSUBS v3_tail_bias_support_block_0/vbias v3_four_channel_bias_reference_distribution_0/v3_four_channel_phase_distribution_0/v3_four_channel_output_collection_0/v3_four_channel_placement_0/v3_channel_selector_late_promotion_1/v3_channel_input_bias_late_promotion_0/a_7166_21688# VSUBS sky130_fd_pr__nfet_01v8 ad=0 pd=0 as=0 ps=0 w=5.07 l=1
X400 v3_four_channel_bias_reference_distribution_0/v3_four_channel_phase_distribution_0/v3_four_channel_output_collection_0/v3_four_channel_placement_0/v3_channel_selector_late_promotion_1/v3_channel_input_bias_late_promotion_0/a_6070_15422# v3_vcm_support_block_0/ref v3_four_channel_bias_reference_distribution_0/v3_four_channel_phase_distribution_0/v3_four_channel_output_collection_0/v3_four_channel_placement_0/v3_channel_selector_late_promotion_1/v3_channel_input_bias_late_promotion_0/a_5774_13688# VSUBS sky130_fd_pr__nfet_01v8 ad=0 pd=0 as=0 ps=0 w=0.84 l=0.6
X401 v3_four_channel_bias_reference_distribution_0/v3_four_channel_phase_distribution_0/v3_four_channel_output_collection_0/combined_p_internal v3_four_channel_bias_reference_distribution_0/v3_four_channel_phase_distribution_0/v3_four_channel_output_collection_0/v3_four_channel_placement_0/v3_channel_selector_late_promotion_1/v3_selector_route_pilot_0/group2_lo_n v3_four_channel_bias_reference_distribution_0/v3_four_channel_phase_distribution_0/v3_four_channel_output_collection_0/v3_four_channel_placement_0/v3_channel_selector_late_promotion_1/v3_channel_input_bias_late_promotion_0/a_4254_10978# VSUBS sky130_fd_pr__nfet_01v8 ad=0 pd=0 as=0.6206 ps=6.02 w=0.65 l=0.15
X402 v3_four_channel_bias_reference_distribution_0/v3_four_channel_phase_distribution_0/v3_four_channel_output_collection_0/v3_four_channel_placement_0/v3_channel_selector_late_promotion_1/v3_channel_input_bias_late_promotion_0/a_6070_15422# v3_four_channel_bias_reference_distribution_0/v3_four_channel_phase_distribution_0/v3_four_channel_output_collection_0/v3_four_channel_placement_0/v3_channel_selector_late_promotion_1/v3_selector_route_pilot_0/group0_lo_p v3_four_channel_bias_reference_distribution_0/v3_four_channel_phase_distribution_0/v3_four_channel_output_collection_0/combined_n_internal VSUBS sky130_fd_pr__nfet_01v8 ad=0 pd=0 as=0 ps=0 w=0.65 l=0.15
X403 v3_four_channel_bias_reference_distribution_0/v3_four_channel_phase_distribution_0/v3_four_channel_output_collection_0/v3_four_channel_placement_0/v3_channel_selector_late_promotion_1/v3_channel_input_bias_late_promotion_0/a_5824_6978# v3_vcm_support_block_0/ref v3_four_channel_bias_reference_distribution_0/v3_four_channel_phase_distribution_0/v3_four_channel_output_collection_0/v3_four_channel_placement_0/v3_channel_selector_late_promotion_1/v3_channel_input_bias_late_promotion_0/a_5646_6978# VSUBS sky130_fd_pr__nfet_01v8 ad=0 pd=0 as=0.6206 ps=6.02 w=0.84 l=0.6
X404 v3_four_channel_bias_reference_distribution_0/v3_four_channel_phase_distribution_0/v3_four_channel_output_collection_0/v3_four_channel_placement_0/v3_channel_selector_late_promotion_1/v3_channel_input_bias_late_promotion_0/a_5774_17688# v3_four_channel_bias_reference_distribution_0/v3_four_channel_phase_distribution_0/v3_four_channel_output_collection_0/v3_four_channel_placement_0/v3_channel_selector_late_promotion_1/element_input v3_four_channel_bias_reference_distribution_0/v3_four_channel_phase_distribution_0/v3_four_channel_output_collection_0/v3_four_channel_placement_0/v3_channel_selector_late_promotion_1/v3_channel_input_bias_late_promotion_0/a_5646_18978# VSUBS sky130_fd_pr__nfet_01v8 ad=0 pd=0 as=0 ps=0 w=0.84 l=0.6
X405 v3_four_channel_bias_reference_distribution_0/v3_four_channel_phase_distribution_0/v3_four_channel_output_collection_0/combined_p_internal v3_four_channel_bias_reference_distribution_0/v3_four_channel_phase_distribution_0/v3_four_channel_output_collection_0/v3_four_channel_placement_0/v3_channel_selector_late_promotion_1/v3_selector_route_pilot_0/group3_lo_p v3_four_channel_bias_reference_distribution_0/v3_four_channel_phase_distribution_0/v3_four_channel_output_collection_0/v3_four_channel_placement_0/v3_channel_selector_late_promotion_1/v3_channel_input_bias_late_promotion_0/a_5646_22978# VSUBS sky130_fd_pr__nfet_01v8 ad=0 pd=0 as=0 ps=0 w=0.65 l=0.15
X406 v3_four_channel_bias_reference_distribution_0/v3_four_channel_phase_distribution_0/v3_four_channel_output_collection_0/v3_four_channel_placement_0/v3_channel_selector_late_promotion_1/v3_channel_input_bias_late_promotion_0/a_5824_6978# v3_tail_bias_support_block_0/vbias VSUBS VSUBS sky130_fd_pr__nfet_01v8 ad=0 pd=0 as=0 ps=0 w=5.07 l=1
X407 v3_four_channel_bias_reference_distribution_0/v3_four_channel_phase_distribution_0/v3_four_channel_output_collection_0/v3_four_channel_placement_0/v3_channel_selector_late_promotion_1/v3_channel_input_bias_late_promotion_0/a_4432_10978# v3_vcm_support_block_0/ref v3_four_channel_bias_reference_distribution_0/v3_four_channel_phase_distribution_0/v3_four_channel_output_collection_0/v3_four_channel_placement_0/v3_channel_selector_late_promotion_1/v3_channel_input_bias_late_promotion_0/a_4254_10978# VSUBS sky130_fd_pr__nfet_01v8 ad=1.9575 pd=15.24 as=0 ps=0 w=0.84 l=0.6
X408 v3_four_channel_bias_reference_distribution_0/v3_four_channel_phase_distribution_0/v3_four_channel_output_collection_0/v3_four_channel_placement_0/v3_channel_selector_late_promotion_1/v3_channel_input_bias_late_promotion_0/a_4678_11422# v3_four_channel_bias_reference_distribution_0/v3_four_channel_phase_distribution_0/v3_four_channel_output_collection_0/v3_four_channel_placement_0/v3_channel_selector_late_promotion_1/v3_selector_route_pilot_0/group2_lo_p v3_four_channel_bias_reference_distribution_0/v3_four_channel_phase_distribution_0/v3_four_channel_output_collection_0/combined_p_internal VSUBS sky130_fd_pr__nfet_01v8 ad=0.6206 pd=6.02 as=0 ps=0 w=0.65 l=0.15
X409 v3_four_channel_bias_reference_distribution_0/v3_four_channel_phase_distribution_0/v3_four_channel_output_collection_0/v3_four_channel_placement_0/v3_channel_selector_late_promotion_1/v3_channel_input_bias_late_promotion_0/a_6070_23422# v3_four_channel_bias_reference_distribution_0/v3_four_channel_phase_distribution_0/v3_four_channel_output_collection_0/v3_four_channel_placement_0/v3_channel_selector_late_promotion_1/v3_selector_route_pilot_0/group3_lo_n v3_four_channel_bias_reference_distribution_0/v3_four_channel_phase_distribution_0/v3_four_channel_output_collection_0/combined_p_internal VSUBS sky130_fd_pr__nfet_01v8 ad=0.6206 pd=6.02 as=0 ps=0 w=0.65 l=0.15
X410 v3_four_channel_bias_reference_distribution_0/v3_four_channel_phase_distribution_0/v3_four_channel_output_collection_0/combined_n_internal v3_four_channel_bias_reference_distribution_0/v3_four_channel_phase_distribution_0/v3_four_channel_output_collection_0/v3_four_channel_placement_0/v3_channel_selector_late_promotion_1/v3_selector_route_pilot_0/group1_lo_n v3_four_channel_bias_reference_distribution_0/v3_four_channel_phase_distribution_0/v3_four_channel_output_collection_0/v3_four_channel_placement_0/v3_channel_selector_late_promotion_1/v3_channel_input_bias_late_promotion_0/a_4254_14978# VSUBS sky130_fd_pr__nfet_01v8 ad=0 pd=0 as=0 ps=0 w=0.65 l=0.15
X411 v3_four_channel_bias_reference_distribution_0/v3_four_channel_phase_distribution_0/v3_four_channel_output_collection_0/combined_p_internal v3_four_channel_bias_reference_distribution_0/v3_four_channel_phase_distribution_0/v3_four_channel_output_collection_0/v3_four_channel_placement_0/v3_channel_selector_late_promotion_1/v3_selector_route_pilot_0/group2_lo_n v3_four_channel_bias_reference_distribution_0/v3_four_channel_phase_distribution_0/v3_four_channel_output_collection_0/v3_four_channel_placement_0/v3_channel_selector_late_promotion_1/v3_channel_input_bias_late_promotion_0/a_7038_10978# VSUBS sky130_fd_pr__nfet_01v8 ad=0 pd=0 as=0.6206 ps=6.02 w=0.65 l=0.15
X412 v3_four_channel_bias_reference_distribution_0/v3_four_channel_phase_distribution_0/v3_four_channel_output_collection_0/v3_four_channel_placement_0/v3_channel_selector_late_promotion_1/v3_channel_input_bias_late_promotion_0/a_7462_15422# v3_four_channel_bias_reference_distribution_0/v3_four_channel_phase_distribution_0/v3_four_channel_output_collection_0/v3_four_channel_placement_0/v3_channel_selector_late_promotion_1/v3_selector_route_pilot_0/group1_lo_p v3_four_channel_bias_reference_distribution_0/v3_four_channel_phase_distribution_0/v3_four_channel_output_collection_0/combined_p_internal VSUBS sky130_fd_pr__nfet_01v8 ad=0.6206 pd=6.02 as=0 ps=0 w=0.65 l=0.15
X413 VSUBS VSUBS VSUBS VSUBS sky130_fd_pr__nfet_01v8 ad=0 pd=0 as=0 ps=0 w=5.07 l=1
X414 v3_four_channel_bias_reference_distribution_0/v3_four_channel_phase_distribution_0/v3_four_channel_output_collection_0/v3_four_channel_placement_0/v3_channel_selector_late_promotion_1/v3_channel_input_bias_late_promotion_0/a_7216_6978# v3_tail_bias_support_block_0/vbias VSUBS VSUBS sky130_fd_pr__nfet_01v8 ad=1.9575 pd=15.24 as=0 ps=0 w=5.07 l=1
X415 v3_four_channel_bias_reference_distribution_0/v3_four_channel_phase_distribution_0/v3_four_channel_output_collection_0/v3_four_channel_placement_0/v3_channel_selector_late_promotion_1/v3_channel_input_bias_late_promotion_0/a_7216_10978# v3_vcm_support_block_0/ref v3_four_channel_bias_reference_distribution_0/v3_four_channel_phase_distribution_0/v3_four_channel_output_collection_0/v3_four_channel_placement_0/v3_channel_selector_late_promotion_1/v3_channel_input_bias_late_promotion_0/a_7038_10978# VSUBS sky130_fd_pr__nfet_01v8 ad=0 pd=0 as=0 ps=0 w=0.84 l=0.6
X416 v3_four_channel_bias_reference_distribution_0/v3_four_channel_phase_distribution_0/v3_four_channel_output_collection_0/v3_four_channel_placement_0/v3_channel_selector_late_promotion_1/v3_channel_input_bias_late_promotion_0/a_4678_15422# v3_vcm_support_block_0/ref v3_four_channel_bias_reference_distribution_0/v3_four_channel_phase_distribution_0/v3_four_channel_output_collection_0/v3_four_channel_placement_0/v3_channel_selector_late_promotion_1/v3_channel_input_bias_late_promotion_0/a_4382_13688# VSUBS sky130_fd_pr__nfet_01v8 ad=0 pd=0 as=0 ps=0 w=0.84 l=0.6
X417 v3_four_channel_bias_reference_distribution_0/v3_four_channel_phase_distribution_0/v3_four_channel_output_collection_0/v3_four_channel_placement_0/v3_channel_selector_late_promotion_1/v3_channel_input_bias_late_promotion_0/a_4678_15422# v3_four_channel_bias_reference_distribution_0/v3_four_channel_phase_distribution_0/v3_four_channel_output_collection_0/v3_four_channel_placement_0/v3_channel_selector_late_promotion_1/v3_selector_route_pilot_0/group1_lo_p v3_four_channel_bias_reference_distribution_0/v3_four_channel_phase_distribution_0/v3_four_channel_output_collection_0/combined_n_internal VSUBS sky130_fd_pr__nfet_01v8 ad=0 pd=0 as=0 ps=0 w=0.65 l=0.15
X418 v3_four_channel_bias_reference_distribution_0/v3_four_channel_phase_distribution_0/v3_four_channel_output_collection_0/combined_p_internal v3_four_channel_bias_reference_distribution_0/v3_four_channel_phase_distribution_0/v3_four_channel_output_collection_0/v3_four_channel_placement_0/v3_channel_selector_late_promotion_1/v3_selector_route_pilot_0/group3_lo_p v3_four_channel_bias_reference_distribution_0/v3_four_channel_phase_distribution_0/v3_four_channel_output_collection_0/v3_four_channel_placement_0/v3_channel_selector_late_promotion_1/v3_channel_input_bias_late_promotion_0/a_4254_22978# VSUBS sky130_fd_pr__nfet_01v8 ad=0 pd=0 as=0.6206 ps=6.02 w=0.65 l=0.15
X419 v3_four_channel_bias_reference_distribution_0/v3_four_channel_phase_distribution_0/v3_four_channel_output_collection_0/v3_four_channel_placement_0/v3_channel_selector_late_promotion_1/v3_channel_input_bias_late_promotion_0/a_7462_19422# v3_vcm_support_block_0/ref v3_four_channel_bias_reference_distribution_0/v3_four_channel_phase_distribution_0/v3_four_channel_output_collection_0/v3_four_channel_placement_0/v3_channel_selector_late_promotion_1/v3_channel_input_bias_late_promotion_0/a_7166_17688# VSUBS sky130_fd_pr__nfet_01v8 ad=0 pd=0 as=0 ps=0 w=0.84 l=0.6
X420 v3_four_channel_bias_reference_distribution_0/v3_four_channel_phase_distribution_0/v3_four_channel_output_collection_0/combined_n_internal v3_four_channel_bias_reference_distribution_0/v3_four_channel_phase_distribution_0/v3_four_channel_output_collection_0/v3_four_channel_placement_0/v3_channel_selector_late_promotion_1/v3_selector_route_pilot_0/group3_lo_p v3_four_channel_bias_reference_distribution_0/v3_four_channel_phase_distribution_0/v3_four_channel_output_collection_0/v3_four_channel_placement_0/v3_channel_selector_late_promotion_1/v3_channel_input_bias_late_promotion_0/a_5646_10978# VSUBS sky130_fd_pr__nfet_01v8 ad=0 pd=0 as=0 ps=0 w=0.65 l=0.15
X421 v3_four_channel_bias_reference_distribution_0/v3_four_channel_phase_distribution_0/v3_four_channel_output_collection_0/combined_n_internal v3_four_channel_bias_reference_distribution_0/v3_four_channel_phase_distribution_0/v3_four_channel_output_collection_0/v3_four_channel_placement_0/v3_channel_selector_late_promotion_1/v3_selector_route_pilot_0/group1_lo_p v3_four_channel_bias_reference_distribution_0/v3_four_channel_phase_distribution_0/v3_four_channel_output_collection_0/v3_four_channel_placement_0/v3_channel_selector_late_promotion_1/v3_channel_input_bias_late_promotion_0/a_7038_14978# VSUBS sky130_fd_pr__nfet_01v8 ad=0 pd=0 as=0 ps=0 w=0.65 l=0.15
X422 v3_four_channel_bias_reference_distribution_0/v3_four_channel_phase_distribution_0/v3_four_channel_output_collection_0/v3_four_channel_placement_0/v3_channel_selector_late_promotion_1/v3_channel_input_bias_late_promotion_0/a_7462_19422# v3_four_channel_bias_reference_distribution_0/v3_four_channel_phase_distribution_0/v3_four_channel_output_collection_0/v3_four_channel_placement_0/v3_channel_selector_late_promotion_1/v3_selector_route_pilot_0/group2_lo_p v3_four_channel_bias_reference_distribution_0/v3_four_channel_phase_distribution_0/v3_four_channel_output_collection_0/combined_n_internal VSUBS sky130_fd_pr__nfet_01v8 ad=0 pd=0 as=0 ps=0 w=0.65 l=0.15
X423 v3_four_channel_bias_reference_distribution_0/v3_four_channel_phase_distribution_0/v3_four_channel_output_collection_0/v3_four_channel_placement_0/v3_channel_selector_late_promotion_1/v3_channel_input_bias_late_promotion_0/a_4678_7422# v3_four_channel_bias_reference_distribution_0/v3_four_channel_phase_distribution_0/v3_four_channel_output_collection_0/v3_four_channel_placement_0/v3_channel_selector_late_promotion_1/element_input v3_four_channel_bias_reference_distribution_0/v3_four_channel_phase_distribution_0/v3_four_channel_output_collection_0/v3_four_channel_placement_0/v3_channel_selector_late_promotion_1/v3_channel_input_bias_late_promotion_0/a_4432_6978# VSUBS sky130_fd_pr__nfet_01v8 ad=0 pd=0 as=1.9575 ps=15.24 w=0.84 l=0.6
X424 v3_four_channel_bias_reference_distribution_0/v3_four_channel_phase_distribution_0/v3_four_channel_output_collection_0/combined_p_internal v3_four_channel_bias_reference_distribution_0/v3_four_channel_phase_distribution_0/v3_four_channel_output_collection_0/v3_four_channel_placement_0/v3_channel_selector_late_promotion_1/v3_selector_route_pilot_0/group3_lo_n v3_four_channel_bias_reference_distribution_0/v3_four_channel_phase_distribution_0/v3_four_channel_output_collection_0/v3_four_channel_placement_0/v3_channel_selector_late_promotion_1/v3_channel_input_bias_late_promotion_0/a_5646_6978# VSUBS sky130_fd_pr__nfet_01v8 ad=0 pd=0 as=0 ps=0 w=0.65 l=0.15
X425 v3_four_channel_bias_reference_distribution_0/v3_four_channel_phase_distribution_0/v3_four_channel_output_collection_0/v3_four_channel_placement_0/v3_channel_selector_late_promotion_1/v3_channel_input_bias_late_promotion_0/a_4678_7422# v3_four_channel_bias_reference_distribution_0/v3_four_channel_phase_distribution_0/v3_four_channel_output_collection_0/v3_four_channel_placement_0/v3_channel_selector_late_promotion_1/v3_selector_route_pilot_0/group3_lo_n v3_four_channel_bias_reference_distribution_0/v3_four_channel_phase_distribution_0/v3_four_channel_output_collection_0/combined_n_internal VSUBS sky130_fd_pr__nfet_01v8 ad=0 pd=0 as=0 ps=0 w=0.65 l=0.15
X426 v3_four_channel_bias_reference_distribution_0/v3_four_channel_phase_distribution_0/v3_four_channel_output_collection_0/v3_four_channel_placement_0/v3_channel_selector_late_promotion_1/v3_channel_input_bias_late_promotion_0/a_6070_11422# v3_four_channel_bias_reference_distribution_0/v3_four_channel_phase_distribution_0/v3_four_channel_output_collection_0/v3_four_channel_placement_0/v3_channel_selector_late_promotion_1/element_input v3_four_channel_bias_reference_distribution_0/v3_four_channel_phase_distribution_0/v3_four_channel_output_collection_0/v3_four_channel_placement_0/v3_channel_selector_late_promotion_1/v3_channel_input_bias_late_promotion_0/a_5824_10978# VSUBS sky130_fd_pr__nfet_01v8 ad=0 pd=0 as=0 ps=0 w=0.84 l=0.6
X427 v3_four_channel_bias_reference_distribution_0/v3_four_channel_phase_distribution_0/v3_four_channel_output_collection_0/v3_four_channel_placement_0/v3_channel_selector_late_promotion_1/v3_channel_input_bias_late_promotion_0/a_6070_11422# v3_four_channel_bias_reference_distribution_0/v3_four_channel_phase_distribution_0/v3_four_channel_output_collection_0/v3_four_channel_placement_0/v3_channel_selector_late_promotion_1/v3_selector_route_pilot_0/group3_lo_n v3_four_channel_bias_reference_distribution_0/v3_four_channel_phase_distribution_0/v3_four_channel_output_collection_0/combined_n_internal VSUBS sky130_fd_pr__nfet_01v8 ad=0 pd=0 as=0 ps=0 w=0.65 l=0.15
X428 v3_four_channel_bias_reference_distribution_0/v3_four_channel_phase_distribution_0/v3_four_channel_output_collection_0/v3_four_channel_placement_0/v3_channel_selector_late_promotion_1/v3_channel_input_bias_late_promotion_0/a_4382_21688# v3_four_channel_bias_reference_distribution_0/v3_four_channel_phase_distribution_0/v3_four_channel_output_collection_0/v3_four_channel_placement_0/v3_channel_selector_late_promotion_1/element_input v3_four_channel_bias_reference_distribution_0/v3_four_channel_phase_distribution_0/v3_four_channel_output_collection_0/v3_four_channel_placement_0/v3_channel_selector_late_promotion_1/v3_channel_input_bias_late_promotion_0/a_4254_22978# VSUBS sky130_fd_pr__nfet_01v8 ad=0 pd=0 as=0 ps=0 w=0.84 l=0.6
X429 v3_four_channel_bias_reference_distribution_0/v3_four_channel_phase_distribution_0/v3_four_channel_output_collection_0/v3_four_channel_placement_0/v3_channel_selector_late_promotion_1/v3_channel_input_bias_late_promotion_0/a_4678_23422# v3_four_channel_bias_reference_distribution_0/v3_four_channel_phase_distribution_0/v3_four_channel_output_collection_0/v3_four_channel_placement_0/v3_channel_selector_late_promotion_1/v3_selector_route_pilot_0/group3_lo_n v3_four_channel_bias_reference_distribution_0/v3_four_channel_phase_distribution_0/v3_four_channel_output_collection_0/combined_p_internal VSUBS sky130_fd_pr__nfet_01v8 ad=0 pd=0 as=0 ps=0 w=0.65 l=0.15
X430 v3_four_channel_bias_reference_distribution_0/v3_four_channel_phase_distribution_0/v3_four_channel_output_collection_0/combined_p_internal v3_four_channel_bias_reference_distribution_0/v3_four_channel_phase_distribution_0/v3_four_channel_output_collection_0/v3_four_channel_placement_0/v3_channel_selector_late_promotion_1/v3_selector_route_pilot_0/group3_lo_n v3_four_channel_bias_reference_distribution_0/v3_four_channel_phase_distribution_0/v3_four_channel_output_collection_0/v3_four_channel_placement_0/v3_channel_selector_late_promotion_1/v3_channel_input_bias_late_promotion_0/a_4254_6978# VSUBS sky130_fd_pr__nfet_01v8 ad=0 pd=0 as=0 ps=0 w=0.65 l=0.15
X431 v3_four_channel_bias_reference_distribution_0/v3_four_channel_phase_distribution_0/v3_four_channel_output_collection_0/v3_four_channel_placement_0/v3_channel_selector_late_promotion_1/v3_channel_input_bias_late_promotion_0/a_5774_13688# v3_four_channel_bias_reference_distribution_0/v3_four_channel_phase_distribution_0/v3_four_channel_output_collection_0/v3_four_channel_placement_0/v3_channel_selector_late_promotion_1/element_input v3_four_channel_bias_reference_distribution_0/v3_four_channel_phase_distribution_0/v3_four_channel_output_collection_0/v3_four_channel_placement_0/v3_channel_selector_late_promotion_1/v3_channel_input_bias_late_promotion_0/a_5646_14978# VSUBS sky130_fd_pr__nfet_01v8 ad=0 pd=0 as=0 ps=0 w=0.84 l=0.6
X432 v3_four_channel_bias_reference_distribution_0/v3_four_channel_phase_distribution_0/v3_four_channel_output_collection_0/combined_p_internal v3_four_channel_bias_reference_distribution_0/v3_four_channel_phase_distribution_0/v3_four_channel_output_collection_0/v3_four_channel_placement_0/v3_channel_selector_late_promotion_1/v3_selector_route_pilot_0/group3_lo_p v3_four_channel_bias_reference_distribution_0/v3_four_channel_phase_distribution_0/v3_four_channel_output_collection_0/v3_four_channel_placement_0/v3_channel_selector_late_promotion_1/v3_channel_input_bias_late_promotion_0/a_7038_22978# VSUBS sky130_fd_pr__nfet_01v8 ad=0 pd=0 as=0 ps=0 w=0.65 l=0.15
X433 v3_four_channel_bias_reference_distribution_0/v3_four_channel_phase_distribution_0/v3_four_channel_output_collection_0/v3_four_channel_placement_0/v3_channel_selector_late_promotion_1/v3_channel_input_bias_late_promotion_0/a_7462_7422# v3_four_channel_bias_reference_distribution_0/v3_four_channel_phase_distribution_0/v3_four_channel_output_collection_0/v3_four_channel_placement_0/v3_channel_selector_late_promotion_1/element_input v3_four_channel_bias_reference_distribution_0/v3_four_channel_phase_distribution_0/v3_four_channel_output_collection_0/v3_four_channel_placement_0/v3_channel_selector_late_promotion_1/v3_channel_input_bias_late_promotion_0/a_7216_6978# VSUBS sky130_fd_pr__nfet_01v8 ad=0 pd=0 as=0 ps=0 w=0.84 l=0.6
X434 v3_four_channel_bias_reference_distribution_0/v3_four_channel_phase_distribution_0/v3_four_channel_output_collection_0/v3_four_channel_placement_0/v3_channel_selector_late_promotion_1/v3_channel_input_bias_late_promotion_0/a_4432_10978# v3_tail_bias_support_block_0/vbias VSUBS VSUBS sky130_fd_pr__nfet_01v8 ad=0 pd=0 as=0 ps=0 w=5.07 l=1
X435 v3_four_channel_bias_reference_distribution_0/v3_four_channel_phase_distribution_0/v3_four_channel_output_collection_0/v3_four_channel_placement_0/v3_channel_selector_late_promotion_1/v3_channel_input_bias_late_promotion_0/a_7462_7422# v3_four_channel_bias_reference_distribution_0/v3_four_channel_phase_distribution_0/v3_four_channel_output_collection_0/v3_four_channel_placement_0/v3_channel_selector_late_promotion_1/v3_selector_route_pilot_0/group3_lo_n v3_four_channel_bias_reference_distribution_0/v3_four_channel_phase_distribution_0/v3_four_channel_output_collection_0/combined_n_internal VSUBS sky130_fd_pr__nfet_01v8 ad=0 pd=0 as=0 ps=0 w=0.65 l=0.15
X436 VSUBS v3_tail_bias_support_block_0/vbias v3_four_channel_bias_reference_distribution_0/v3_four_channel_phase_distribution_0/v3_four_channel_output_collection_0/v3_four_channel_placement_0/v3_channel_selector_late_promotion_1/v3_channel_input_bias_late_promotion_0/a_4382_17688# VSUBS sky130_fd_pr__nfet_01v8 ad=0 pd=0 as=0 ps=0 w=5.07 l=1
X437 v3_four_channel_bias_reference_distribution_0/v3_four_channel_phase_distribution_0/v3_four_channel_output_collection_0/combined_p_internal v3_four_channel_bias_reference_distribution_0/v3_four_channel_phase_distribution_0/v3_four_channel_output_collection_0/v3_four_channel_placement_0/v3_channel_selector_late_promotion_1/v3_selector_route_pilot_0/group3_lo_n v3_four_channel_bias_reference_distribution_0/v3_four_channel_phase_distribution_0/v3_four_channel_output_collection_0/v3_four_channel_placement_0/v3_channel_selector_late_promotion_1/v3_channel_input_bias_late_promotion_0/a_7038_6978# VSUBS sky130_fd_pr__nfet_01v8 ad=0 pd=0 as=0 ps=0 w=0.65 l=0.15
X438 v3_four_channel_bias_reference_distribution_0/v3_four_channel_phase_distribution_0/v3_four_channel_output_collection_0/combined_n_internal v3_four_channel_bias_reference_distribution_0/v3_four_channel_phase_distribution_0/v3_four_channel_output_collection_0/v3_four_channel_placement_0/v3_channel_selector_late_promotion_1/v3_selector_route_pilot_0/group2_lo_p v3_four_channel_bias_reference_distribution_0/v3_four_channel_phase_distribution_0/v3_four_channel_output_collection_0/v3_four_channel_placement_0/v3_channel_selector_late_promotion_1/v3_channel_input_bias_late_promotion_0/a_4254_10978# VSUBS sky130_fd_pr__nfet_01v8 ad=0 pd=0 as=0 ps=0 w=0.65 l=0.15
X439 v3_four_channel_bias_reference_distribution_0/v3_four_channel_phase_distribution_0/v3_four_channel_output_collection_0/v3_four_channel_placement_0/v3_channel_selector_late_promotion_1/v3_channel_input_bias_late_promotion_0/a_7462_11422# v3_four_channel_bias_reference_distribution_0/v3_four_channel_phase_distribution_0/v3_four_channel_output_collection_0/v3_four_channel_placement_0/v3_channel_selector_late_promotion_1/v3_selector_route_pilot_0/group2_lo_p v3_four_channel_bias_reference_distribution_0/v3_four_channel_phase_distribution_0/v3_four_channel_output_collection_0/combined_p_internal VSUBS sky130_fd_pr__nfet_01v8 ad=0 pd=0 as=0 ps=0 w=0.65 l=0.15
X440 v3_four_channel_bias_reference_distribution_0/v3_four_channel_phase_distribution_0/v3_four_channel_output_collection_0/v3_four_channel_placement_0/v3_channel_selector_late_promotion_1/v3_channel_input_bias_late_promotion_0/a_7166_21688# v3_four_channel_bias_reference_distribution_0/v3_four_channel_phase_distribution_0/v3_four_channel_output_collection_0/v3_four_channel_placement_0/v3_channel_selector_late_promotion_1/element_input v3_four_channel_bias_reference_distribution_0/v3_four_channel_phase_distribution_0/v3_four_channel_output_collection_0/v3_four_channel_placement_0/v3_channel_selector_late_promotion_1/v3_channel_input_bias_late_promotion_0/a_7038_22978# VSUBS sky130_fd_pr__nfet_01v8 ad=0 pd=0 as=0 ps=0 w=0.84 l=0.6
X441 v3_four_channel_bias_reference_distribution_0/v3_four_channel_phase_distribution_0/v3_four_channel_output_collection_0/combined_n_internal v3_four_channel_bias_reference_distribution_0/v3_four_channel_phase_distribution_0/v3_four_channel_output_collection_0/v3_four_channel_placement_0/v3_channel_selector_late_promotion_1/v3_selector_route_pilot_0/group3_lo_n v3_four_channel_bias_reference_distribution_0/v3_four_channel_phase_distribution_0/v3_four_channel_output_collection_0/v3_four_channel_placement_0/v3_channel_selector_late_promotion_1/v3_channel_input_bias_late_promotion_0/a_5646_22978# VSUBS sky130_fd_pr__nfet_01v8 ad=0 pd=0 as=0 ps=0 w=0.65 l=0.15
X442 v3_four_channel_bias_reference_distribution_0/v3_four_channel_phase_distribution_0/v3_four_channel_output_collection_0/v3_four_channel_placement_0/v3_channel_selector_late_promotion_1/v3_channel_input_bias_late_promotion_0/a_4678_11422# v3_four_channel_bias_reference_distribution_0/v3_four_channel_phase_distribution_0/v3_four_channel_output_collection_0/v3_four_channel_placement_0/v3_channel_selector_late_promotion_1/element_input v3_four_channel_bias_reference_distribution_0/v3_four_channel_phase_distribution_0/v3_four_channel_output_collection_0/v3_four_channel_placement_0/v3_channel_selector_late_promotion_1/v3_channel_input_bias_late_promotion_0/a_4432_10978# VSUBS sky130_fd_pr__nfet_01v8 ad=0 pd=0 as=0 ps=0 w=0.84 l=0.6
X443 v3_four_channel_bias_reference_distribution_0/v3_four_channel_phase_distribution_0/v3_four_channel_output_collection_0/v3_four_channel_placement_0/v3_channel_selector_late_promotion_1/v3_channel_input_bias_late_promotion_0/a_6070_23422# v3_vcm_support_block_0/ref v3_four_channel_bias_reference_distribution_0/v3_four_channel_phase_distribution_0/v3_four_channel_output_collection_0/v3_four_channel_placement_0/v3_channel_selector_late_promotion_1/v3_channel_input_bias_late_promotion_0/a_5774_21688# VSUBS sky130_fd_pr__nfet_01v8 ad=0 pd=0 as=0 ps=0 w=0.84 l=0.6
X444 v3_four_channel_bias_reference_distribution_0/v3_four_channel_phase_distribution_0/v3_four_channel_output_collection_0/v3_four_channel_placement_0/v3_channel_selector_late_promotion_1/v3_channel_input_bias_late_promotion_0/a_6070_23422# v3_four_channel_bias_reference_distribution_0/v3_four_channel_phase_distribution_0/v3_four_channel_output_collection_0/v3_four_channel_placement_0/v3_channel_selector_late_promotion_1/v3_selector_route_pilot_0/group3_lo_p v3_four_channel_bias_reference_distribution_0/v3_four_channel_phase_distribution_0/v3_four_channel_output_collection_0/combined_n_internal VSUBS sky130_fd_pr__nfet_01v8 ad=0 pd=0 as=0 ps=0 w=0.65 l=0.15
X445 v3_four_channel_bias_reference_distribution_0/v3_four_channel_phase_distribution_0/v3_four_channel_output_collection_0/v3_four_channel_placement_0/v3_channel_selector_late_promotion_1/v3_channel_input_bias_late_promotion_0/a_4678_11422# v3_four_channel_bias_reference_distribution_0/v3_four_channel_phase_distribution_0/v3_four_channel_output_collection_0/v3_four_channel_placement_0/v3_channel_selector_late_promotion_1/v3_selector_route_pilot_0/group2_lo_n v3_four_channel_bias_reference_distribution_0/v3_four_channel_phase_distribution_0/v3_four_channel_output_collection_0/combined_n_internal VSUBS sky130_fd_pr__nfet_01v8 ad=0 pd=0 as=0 ps=0 w=0.65 l=0.15
X446 v3_four_channel_bias_reference_distribution_0/v3_four_channel_phase_distribution_0/v3_four_channel_output_collection_0/v3_four_channel_placement_0/v3_channel_selector_late_promotion_1/v3_channel_input_bias_late_promotion_0/a_7462_15422# v3_four_channel_bias_reference_distribution_0/v3_four_channel_phase_distribution_0/v3_four_channel_output_collection_0/v3_four_channel_placement_0/v3_channel_selector_late_promotion_1/element_input v3_four_channel_bias_reference_distribution_0/v3_four_channel_phase_distribution_0/v3_four_channel_output_collection_0/v3_four_channel_placement_0/v3_channel_selector_late_promotion_1/v3_channel_input_bias_late_promotion_0/a_7216_14978# VSUBS sky130_fd_pr__nfet_01v8 ad=0 pd=0 as=0 ps=0 w=0.84 l=0.6
X447 v3_four_channel_bias_reference_distribution_0/v3_four_channel_phase_distribution_0/v3_four_channel_output_collection_0/v3_four_channel_placement_0/v3_channel_selector_late_promotion_1/v3_channel_input_bias_late_promotion_0/a_6070_7422# v3_four_channel_bias_reference_distribution_0/v3_four_channel_phase_distribution_0/v3_four_channel_output_collection_0/v3_four_channel_placement_0/v3_channel_selector_late_promotion_1/v3_selector_route_pilot_0/group3_lo_p v3_four_channel_bias_reference_distribution_0/v3_four_channel_phase_distribution_0/v3_four_channel_output_collection_0/combined_p_internal VSUBS sky130_fd_pr__nfet_01v8 ad=0 pd=0 as=0 ps=0 w=0.65 l=0.15
X448 v3_four_channel_bias_reference_distribution_0/v3_four_channel_phase_distribution_0/v3_four_channel_output_collection_0/combined_n_internal v3_four_channel_bias_reference_distribution_0/v3_four_channel_phase_distribution_0/v3_four_channel_output_collection_0/v3_four_channel_placement_0/v3_channel_selector_late_promotion_1/v3_selector_route_pilot_0/group2_lo_p v3_four_channel_bias_reference_distribution_0/v3_four_channel_phase_distribution_0/v3_four_channel_output_collection_0/v3_four_channel_placement_0/v3_channel_selector_late_promotion_1/v3_channel_input_bias_late_promotion_0/a_7038_10978# VSUBS sky130_fd_pr__nfet_01v8 ad=0 pd=0 as=0 ps=0 w=0.65 l=0.15
X449 v3_four_channel_bias_reference_distribution_0/v3_four_channel_phase_distribution_0/v3_four_channel_output_collection_0/v3_four_channel_placement_0/v3_channel_selector_late_promotion_1/v3_channel_input_bias_late_promotion_0/a_7462_15422# v3_four_channel_bias_reference_distribution_0/v3_four_channel_phase_distribution_0/v3_four_channel_output_collection_0/v3_four_channel_placement_0/v3_channel_selector_late_promotion_1/v3_selector_route_pilot_0/group1_lo_n v3_four_channel_bias_reference_distribution_0/v3_four_channel_phase_distribution_0/v3_four_channel_output_collection_0/combined_n_internal VSUBS sky130_fd_pr__nfet_01v8 ad=0 pd=0 as=0 ps=0 w=0.65 l=0.15
X450 v3_four_channel_bias_reference_distribution_0/v3_four_channel_phase_distribution_0/v3_four_channel_output_collection_0/v3_four_channel_placement_0/v3_channel_selector_late_promotion_1/v3_channel_input_bias_late_promotion_0/a_4432_6978# v3_vcm_support_block_0/ref v3_four_channel_bias_reference_distribution_0/v3_four_channel_phase_distribution_0/v3_four_channel_output_collection_0/v3_four_channel_placement_0/v3_channel_selector_late_promotion_1/v3_channel_input_bias_late_promotion_0/a_4254_6978# VSUBS sky130_fd_pr__nfet_01v8 ad=0 pd=0 as=0 ps=0 w=0.84 l=0.6
X451 v3_four_channel_bias_reference_distribution_0/v3_four_channel_phase_distribution_0/v3_four_channel_output_collection_0/v3_four_channel_placement_0/v3_channel_selector_late_promotion_1/v3_channel_input_bias_late_promotion_0/a_5824_10978# v3_vcm_support_block_0/ref v3_four_channel_bias_reference_distribution_0/v3_four_channel_phase_distribution_0/v3_four_channel_output_collection_0/v3_four_channel_placement_0/v3_channel_selector_late_promotion_1/v3_channel_input_bias_late_promotion_0/a_5646_10978# VSUBS sky130_fd_pr__nfet_01v8 ad=0 pd=0 as=0 ps=0 w=0.84 l=0.6
X452 v3_four_channel_bias_reference_distribution_0/v3_four_channel_phase_distribution_0/v3_four_channel_output_collection_0/combined_n_internal v3_four_channel_bias_reference_distribution_0/v3_four_channel_phase_distribution_0/v3_four_channel_output_collection_0/v3_four_channel_placement_0/v3_channel_selector_late_promotion_1/v3_selector_route_pilot_0/group3_lo_n v3_four_channel_bias_reference_distribution_0/v3_four_channel_phase_distribution_0/v3_four_channel_output_collection_0/v3_four_channel_placement_0/v3_channel_selector_late_promotion_1/v3_channel_input_bias_late_promotion_0/a_4254_22978# VSUBS sky130_fd_pr__nfet_01v8 ad=0 pd=0 as=0 ps=0 w=0.65 l=0.15
X453 v3_four_channel_bias_reference_distribution_0/v3_four_channel_phase_distribution_0/v3_four_channel_output_collection_0/v3_four_channel_placement_0/v3_channel_selector_late_promotion_1/v3_channel_input_bias_late_promotion_0/a_7462_23422# v3_four_channel_bias_reference_distribution_0/v3_four_channel_phase_distribution_0/v3_four_channel_output_collection_0/v3_four_channel_placement_0/v3_channel_selector_late_promotion_1/v3_selector_route_pilot_0/group3_lo_n v3_four_channel_bias_reference_distribution_0/v3_four_channel_phase_distribution_0/v3_four_channel_output_collection_0/combined_p_internal VSUBS sky130_fd_pr__nfet_01v8 ad=0 pd=0 as=0 ps=0 w=0.65 l=0.15
X454 v3_four_channel_bias_reference_distribution_0/v3_four_channel_phase_distribution_0/v3_four_channel_output_collection_0/v3_four_channel_placement_0/v3_channel_selector_late_promotion_1/v3_channel_input_bias_late_promotion_0/a_4432_6978# v3_tail_bias_support_block_0/vbias VSUBS VSUBS sky130_fd_pr__nfet_01v8 ad=0 pd=0 as=0 ps=0 w=5.07 l=1
X455 v3_four_channel_bias_reference_distribution_0/v3_four_channel_phase_distribution_0/v3_four_channel_output_collection_0/v3_four_channel_placement_0/v3_channel_selector_late_promotion_1/v3_channel_input_bias_late_promotion_0/a_7216_6978# v3_vcm_support_block_0/ref v3_four_channel_bias_reference_distribution_0/v3_four_channel_phase_distribution_0/v3_four_channel_output_collection_0/v3_four_channel_placement_0/v3_channel_selector_late_promotion_1/v3_channel_input_bias_late_promotion_0/a_7038_6978# VSUBS sky130_fd_pr__nfet_01v8 ad=0 pd=0 as=0 ps=0 w=0.84 l=0.6
X456 v3_four_channel_bias_reference_distribution_0/v3_four_channel_phase_distribution_0/v3_four_channel_output_collection_0/combined_n_internal v3_four_channel_bias_reference_distribution_0/v3_four_channel_phase_distribution_0/v3_four_channel_output_collection_0/v3_four_channel_placement_0/v3_channel_selector_late_promotion_1/v3_selector_route_pilot_0/group3_lo_p v3_four_channel_bias_reference_distribution_0/v3_four_channel_phase_distribution_0/v3_four_channel_output_collection_0/v3_four_channel_placement_0/v3_channel_selector_late_promotion_1/v3_channel_input_bias_late_promotion_0/a_5646_6978# VSUBS sky130_fd_pr__nfet_01v8 ad=0 pd=0 as=0 ps=0 w=0.65 l=0.15
X457 VSUBS v3_tail_bias_support_block_0/vbias v3_four_channel_bias_reference_distribution_0/v3_four_channel_phase_distribution_0/v3_four_channel_output_collection_0/v3_four_channel_placement_0/v3_channel_selector_late_promotion_1/v3_channel_input_bias_late_promotion_0/a_4382_13688# VSUBS sky130_fd_pr__nfet_01v8 ad=0 pd=0 as=0 ps=0 w=5.07 l=1
X458 v3_four_channel_bias_reference_distribution_0/v3_four_channel_phase_distribution_0/v3_four_channel_output_collection_0/v3_four_channel_placement_0/v3_channel_selector_late_promotion_1/VPWR v3_four_channel_bias_reference_distribution_0/v3_four_channel_phase_distribution_0/v3_four_channel_output_collection_0/v3_four_channel_placement_0/v3_channel_selector_late_promotion_1/v3_selector_route_pilot_0/G1_MUX_POS/a_505_21# v3_four_channel_bias_reference_distribution_0/v3_four_channel_phase_distribution_0/v3_four_channel_output_collection_0/v3_four_channel_placement_0/v3_channel_selector_late_promotion_1/v3_selector_route_pilot_0/G1_MUX_POS/a_535_374# v3_four_channel_bias_reference_distribution_0/v3_four_channel_phase_distribution_0/v3_four_channel_output_collection_0/v3_four_channel_placement_0/v3_channel_selector_late_promotion_1/VPWR sky130_fd_pr__pfet_01v8_hvt ad=10.2594 pd=93.2 as=0.0882 ps=1.26 w=0.42 l=0.15
X459 v3_four_channel_bias_reference_distribution_0/v3_four_channel_phase_distribution_0/v3_four_channel_output_collection_0/v3_four_channel_placement_0/v3_channel_selector_late_promotion_1/v3_selector_route_pilot_0/G1_MUX_POS/a_505_21# v3_four_channel_bias_reference_distribution_0/v3_four_channel_phase_distribution_0/v3_four_channel_output_collection_0/v3_four_channel_placement_0/v3_channel_selector_late_promotion_1/group1_bit0 v3_four_channel_bias_reference_distribution_0/v3_four_channel_phase_distribution_0/v3_four_channel_output_collection_0/v3_four_channel_placement_0/v3_channel_selector_late_promotion_1/VPWR v3_four_channel_bias_reference_distribution_0/v3_four_channel_phase_distribution_0/v3_four_channel_output_collection_0/v3_four_channel_placement_0/v3_channel_selector_late_promotion_1/VPWR sky130_fd_pr__pfet_01v8_hvt ad=0.1176 pd=1.4 as=0 ps=0 w=0.42 l=0.15
X460 v3_four_channel_bias_reference_distribution_0/v3_four_channel_phase_distribution_0/v3_four_channel_output_collection_0/v3_four_channel_placement_0/v3_channel_selector_late_promotion_1/v3_selector_route_pilot_0/G1_MUX_POS/a_218_374# v3_four_channel_bias_reference_distribution_0/v3_four_channel_phase_distribution_0/v3_four_channel_output_collection_0/v3_four_channel_placement_0/v3_channel_selector_late_promotion_1/group1_bit0 v3_four_channel_bias_reference_distribution_0/v3_four_channel_phase_distribution_0/v3_four_channel_output_collection_0/v3_four_channel_placement_0/v3_channel_selector_late_promotion_1/VPWR v3_four_channel_bias_reference_distribution_0/v3_four_channel_phase_distribution_0/v3_four_channel_output_collection_0/v3_four_channel_placement_0/v3_channel_selector_late_promotion_1/VPWR sky130_fd_pr__pfet_01v8_hvt ad=0.1533 pd=1.57 as=0 ps=0 w=0.42 l=0.15
X461 VSUBS v3_four_channel_bias_reference_distribution_0/v3_four_channel_phase_distribution_0/v3_four_channel_output_collection_0/v3_four_channel_placement_0/v3_channel_selector_late_promotion_1/v3_selector_route_pilot_0/G1_MUX_POS/a_505_21# v3_four_channel_bias_reference_distribution_0/v3_four_channel_phase_distribution_0/v3_four_channel_output_collection_0/v3_four_channel_placement_0/v3_channel_selector_late_promotion_1/v3_selector_route_pilot_0/G1_MUX_POS/a_439_47# VSUBS sky130_fd_pr__nfet_01v8 ad=0 pd=0 as=0.1386 ps=1.5 w=0.42 l=0.15
X462 v3_four_channel_bias_reference_distribution_0/v3_four_channel_phase_distribution_0/v3_four_channel_output_collection_0/v3_four_channel_placement_0/v3_channel_selector_late_promotion_1/v3_selector_route_pilot_0/G1_MUX_POS/a_76_199# v3_four_channel_bias_reference_distribution_0/v3_four_channel_phase_distribution_0/phase_0 v3_four_channel_bias_reference_distribution_0/v3_four_channel_phase_distribution_0/v3_four_channel_output_collection_0/v3_four_channel_placement_0/v3_channel_selector_late_promotion_1/v3_selector_route_pilot_0/G1_MUX_POS/a_218_374# v3_four_channel_bias_reference_distribution_0/v3_four_channel_phase_distribution_0/v3_four_channel_output_collection_0/v3_four_channel_placement_0/v3_channel_selector_late_promotion_1/VPWR sky130_fd_pr__pfet_01v8_hvt ad=0.3864 pd=2.68 as=0 ps=0 w=0.42 l=0.15
X463 v3_four_channel_bias_reference_distribution_0/v3_four_channel_phase_distribution_0/v3_four_channel_output_collection_0/v3_four_channel_placement_0/v3_channel_selector_late_promotion_1/v3_selector_route_pilot_0/G1_MUX_POS/a_505_21# v3_four_channel_bias_reference_distribution_0/v3_four_channel_phase_distribution_0/v3_four_channel_output_collection_0/v3_four_channel_placement_0/v3_channel_selector_late_promotion_1/group1_bit0 VSUBS VSUBS sky130_fd_pr__nfet_01v8 ad=0.1092 pd=1.36 as=0 ps=0 w=0.42 l=0.15
X464 v3_four_channel_bias_reference_distribution_0/v3_four_channel_phase_distribution_0/v3_four_channel_output_collection_0/v3_four_channel_placement_0/v3_channel_selector_late_promotion_1/v3_selector_route_pilot_0/G1_MUX_POS/a_439_47# v3_four_channel_bias_reference_distribution_0/v3_four_channel_phase_distribution_0/phase_0 v3_four_channel_bias_reference_distribution_0/v3_four_channel_phase_distribution_0/v3_four_channel_output_collection_0/v3_four_channel_placement_0/v3_channel_selector_late_promotion_1/v3_selector_route_pilot_0/G1_MUX_POS/a_76_199# VSUBS sky130_fd_pr__nfet_01v8 ad=0 pd=0 as=0.1995 ps=1.79 w=0.42 l=0.15
X465 v3_four_channel_bias_reference_distribution_0/v3_four_channel_phase_distribution_0/v3_four_channel_output_collection_0/v3_four_channel_placement_0/v3_channel_selector_late_promotion_1/v3_selector_route_pilot_0/G1_MUX_POS/a_535_374# v3_four_channel_bias_reference_distribution_0/v3_four_channel_phase_distribution_0/phase_90 v3_four_channel_bias_reference_distribution_0/v3_four_channel_phase_distribution_0/v3_four_channel_output_collection_0/v3_four_channel_placement_0/v3_channel_selector_late_promotion_1/v3_selector_route_pilot_0/G1_MUX_POS/a_76_199# v3_four_channel_bias_reference_distribution_0/v3_four_channel_phase_distribution_0/v3_four_channel_output_collection_0/v3_four_channel_placement_0/v3_channel_selector_late_promotion_1/VPWR sky130_fd_pr__pfet_01v8_hvt ad=0 pd=0 as=0 ps=0 w=0.42 l=0.15
X466 v3_four_channel_bias_reference_distribution_0/v3_four_channel_phase_distribution_0/v3_four_channel_output_collection_0/v3_four_channel_placement_0/v3_channel_selector_late_promotion_1/v3_selector_route_pilot_0/G1_MUX_POS/a_76_199# v3_four_channel_bias_reference_distribution_0/v3_four_channel_phase_distribution_0/phase_90 v3_four_channel_bias_reference_distribution_0/v3_four_channel_phase_distribution_0/v3_four_channel_output_collection_0/v3_four_channel_placement_0/v3_channel_selector_late_promotion_1/v3_selector_route_pilot_0/G1_MUX_POS/a_218_47# VSUBS sky130_fd_pr__nfet_01v8 ad=0 pd=0 as=0.1386 ps=1.5 w=0.42 l=0.15
X467 v3_four_channel_bias_reference_distribution_0/v3_four_channel_phase_distribution_0/v3_four_channel_output_collection_0/v3_four_channel_placement_0/v3_channel_selector_late_promotion_1/v3_selector_route_pilot_0/G1_MUX_POS/a_218_47# v3_four_channel_bias_reference_distribution_0/v3_four_channel_phase_distribution_0/v3_four_channel_output_collection_0/v3_four_channel_placement_0/v3_channel_selector_late_promotion_1/group1_bit0 VSUBS VSUBS sky130_fd_pr__nfet_01v8 ad=0 pd=0 as=0 ps=0 w=0.42 l=0.15
X468 v3_four_channel_bias_reference_distribution_0/v3_four_channel_phase_distribution_0/v3_four_channel_output_collection_0/v3_four_channel_placement_0/v3_channel_selector_late_promotion_1/VPWR v3_four_channel_bias_reference_distribution_0/v3_four_channel_phase_distribution_0/v3_four_channel_output_collection_0/v3_four_channel_placement_0/v3_channel_selector_late_promotion_1/v3_selector_route_pilot_0/G1_MUX_POS/a_76_199# v3_four_channel_bias_reference_distribution_0/v3_four_channel_phase_distribution_0/v3_four_channel_output_collection_0/v3_four_channel_placement_0/v3_channel_selector_late_promotion_1/v3_selector_route_pilot_0/G1_MUX_POS/X v3_four_channel_bias_reference_distribution_0/v3_four_channel_phase_distribution_0/v3_four_channel_output_collection_0/v3_four_channel_placement_0/v3_channel_selector_late_promotion_1/VPWR sky130_fd_pr__pfet_01v8_hvt ad=0 pd=0 as=0.26 ps=2.52 w=1 l=0.15
X469 VSUBS v3_four_channel_bias_reference_distribution_0/v3_four_channel_phase_distribution_0/v3_four_channel_output_collection_0/v3_four_channel_placement_0/v3_channel_selector_late_promotion_1/v3_selector_route_pilot_0/G1_MUX_POS/a_76_199# v3_four_channel_bias_reference_distribution_0/v3_four_channel_phase_distribution_0/v3_four_channel_output_collection_0/v3_four_channel_placement_0/v3_channel_selector_late_promotion_1/v3_selector_route_pilot_0/G1_MUX_POS/X VSUBS sky130_fd_pr__nfet_01v8 ad=0 pd=0 as=0.169 ps=1.82 w=0.65 l=0.15
X470 v3_four_channel_bias_reference_distribution_0/v3_four_channel_phase_distribution_0/v3_four_channel_output_collection_0/v3_four_channel_placement_0/v3_channel_selector_late_promotion_1/VPWR v3_four_channel_bias_reference_distribution_0/v3_four_channel_phase_distribution_0/v3_four_channel_output_collection_0/v3_four_channel_placement_0/v3_channel_selector_late_promotion_1/v3_selector_route_pilot_0/G3_MUX_AXIS/a_505_21# v3_four_channel_bias_reference_distribution_0/v3_four_channel_phase_distribution_0/v3_four_channel_output_collection_0/v3_four_channel_placement_0/v3_channel_selector_late_promotion_1/v3_selector_route_pilot_0/G3_MUX_AXIS/a_535_374# v3_four_channel_bias_reference_distribution_0/v3_four_channel_phase_distribution_0/v3_four_channel_output_collection_0/v3_four_channel_placement_0/v3_channel_selector_late_promotion_1/VPWR sky130_fd_pr__pfet_01v8_hvt ad=0 pd=0 as=0.0882 ps=1.26 w=0.42 l=0.15
X471 v3_four_channel_bias_reference_distribution_0/v3_four_channel_phase_distribution_0/v3_four_channel_output_collection_0/v3_four_channel_placement_0/v3_channel_selector_late_promotion_1/v3_selector_route_pilot_0/G3_MUX_AXIS/a_505_21# v3_four_channel_bias_reference_distribution_0/v3_four_channel_phase_distribution_0/v3_four_channel_output_collection_0/v3_four_channel_placement_0/v3_channel_selector_late_promotion_1/group3_bit1 v3_four_channel_bias_reference_distribution_0/v3_four_channel_phase_distribution_0/v3_four_channel_output_collection_0/v3_four_channel_placement_0/v3_channel_selector_late_promotion_1/VPWR v3_four_channel_bias_reference_distribution_0/v3_four_channel_phase_distribution_0/v3_four_channel_output_collection_0/v3_four_channel_placement_0/v3_channel_selector_late_promotion_1/VPWR sky130_fd_pr__pfet_01v8_hvt ad=0.1176 pd=1.4 as=0 ps=0 w=0.42 l=0.15
X472 v3_four_channel_bias_reference_distribution_0/v3_four_channel_phase_distribution_0/v3_four_channel_output_collection_0/v3_four_channel_placement_0/v3_channel_selector_late_promotion_1/v3_selector_route_pilot_0/G3_MUX_AXIS/a_218_374# v3_four_channel_bias_reference_distribution_0/v3_four_channel_phase_distribution_0/v3_four_channel_output_collection_0/v3_four_channel_placement_0/v3_channel_selector_late_promotion_1/group3_bit1 v3_four_channel_bias_reference_distribution_0/v3_four_channel_phase_distribution_0/v3_four_channel_output_collection_0/v3_four_channel_placement_0/v3_channel_selector_late_promotion_1/VPWR v3_four_channel_bias_reference_distribution_0/v3_four_channel_phase_distribution_0/v3_four_channel_output_collection_0/v3_four_channel_placement_0/v3_channel_selector_late_promotion_1/VPWR sky130_fd_pr__pfet_01v8_hvt ad=0.1533 pd=1.57 as=0 ps=0 w=0.42 l=0.15
X473 VSUBS v3_four_channel_bias_reference_distribution_0/v3_four_channel_phase_distribution_0/v3_four_channel_output_collection_0/v3_four_channel_placement_0/v3_channel_selector_late_promotion_1/v3_selector_route_pilot_0/G3_MUX_AXIS/a_505_21# v3_four_channel_bias_reference_distribution_0/v3_four_channel_phase_distribution_0/v3_four_channel_output_collection_0/v3_four_channel_placement_0/v3_channel_selector_late_promotion_1/v3_selector_route_pilot_0/G3_MUX_AXIS/a_439_47# VSUBS sky130_fd_pr__nfet_01v8 ad=0 pd=0 as=0.1386 ps=1.5 w=0.42 l=0.15
X474 v3_four_channel_bias_reference_distribution_0/v3_four_channel_phase_distribution_0/v3_four_channel_output_collection_0/v3_four_channel_placement_0/v3_channel_selector_late_promotion_1/v3_selector_route_pilot_0/G3_MUX_AXIS/a_76_199# v3_four_channel_bias_reference_distribution_0/v3_four_channel_phase_distribution_0/v3_four_channel_output_collection_0/v3_four_channel_placement_0/v3_channel_selector_late_promotion_1/v3_selector_route_pilot_0/G3_MUX_POS/X v3_four_channel_bias_reference_distribution_0/v3_four_channel_phase_distribution_0/v3_four_channel_output_collection_0/v3_four_channel_placement_0/v3_channel_selector_late_promotion_1/v3_selector_route_pilot_0/G3_MUX_AXIS/a_218_374# v3_four_channel_bias_reference_distribution_0/v3_four_channel_phase_distribution_0/v3_four_channel_output_collection_0/v3_four_channel_placement_0/v3_channel_selector_late_promotion_1/VPWR sky130_fd_pr__pfet_01v8_hvt ad=0.3864 pd=2.68 as=0 ps=0 w=0.42 l=0.15
X475 v3_four_channel_bias_reference_distribution_0/v3_four_channel_phase_distribution_0/v3_four_channel_output_collection_0/v3_four_channel_placement_0/v3_channel_selector_late_promotion_1/v3_selector_route_pilot_0/G3_MUX_AXIS/a_505_21# v3_four_channel_bias_reference_distribution_0/v3_four_channel_phase_distribution_0/v3_four_channel_output_collection_0/v3_four_channel_placement_0/v3_channel_selector_late_promotion_1/group3_bit1 VSUBS VSUBS sky130_fd_pr__nfet_01v8 ad=0.1092 pd=1.36 as=0 ps=0 w=0.42 l=0.15
X476 v3_four_channel_bias_reference_distribution_0/v3_four_channel_phase_distribution_0/v3_four_channel_output_collection_0/v3_four_channel_placement_0/v3_channel_selector_late_promotion_1/v3_selector_route_pilot_0/G3_MUX_AXIS/a_439_47# v3_four_channel_bias_reference_distribution_0/v3_four_channel_phase_distribution_0/v3_four_channel_output_collection_0/v3_four_channel_placement_0/v3_channel_selector_late_promotion_1/v3_selector_route_pilot_0/G3_MUX_POS/X v3_four_channel_bias_reference_distribution_0/v3_four_channel_phase_distribution_0/v3_four_channel_output_collection_0/v3_four_channel_placement_0/v3_channel_selector_late_promotion_1/v3_selector_route_pilot_0/G3_MUX_AXIS/a_76_199# VSUBS sky130_fd_pr__nfet_01v8 ad=0 pd=0 as=0.1995 ps=1.79 w=0.42 l=0.15
X477 v3_four_channel_bias_reference_distribution_0/v3_four_channel_phase_distribution_0/v3_four_channel_output_collection_0/v3_four_channel_placement_0/v3_channel_selector_late_promotion_1/v3_selector_route_pilot_0/G3_MUX_AXIS/a_535_374# v3_four_channel_bias_reference_distribution_0/v3_four_channel_phase_distribution_0/v3_four_channel_output_collection_0/v3_four_channel_placement_0/v3_channel_selector_late_promotion_1/v3_selector_route_pilot_0/G3_MUX_NEG/X v3_four_channel_bias_reference_distribution_0/v3_four_channel_phase_distribution_0/v3_four_channel_output_collection_0/v3_four_channel_placement_0/v3_channel_selector_late_promotion_1/v3_selector_route_pilot_0/G3_MUX_AXIS/a_76_199# v3_four_channel_bias_reference_distribution_0/v3_four_channel_phase_distribution_0/v3_four_channel_output_collection_0/v3_four_channel_placement_0/v3_channel_selector_late_promotion_1/VPWR sky130_fd_pr__pfet_01v8_hvt ad=0 pd=0 as=0 ps=0 w=0.42 l=0.15
X478 v3_four_channel_bias_reference_distribution_0/v3_four_channel_phase_distribution_0/v3_four_channel_output_collection_0/v3_four_channel_placement_0/v3_channel_selector_late_promotion_1/v3_selector_route_pilot_0/G3_MUX_AXIS/a_76_199# v3_four_channel_bias_reference_distribution_0/v3_four_channel_phase_distribution_0/v3_four_channel_output_collection_0/v3_four_channel_placement_0/v3_channel_selector_late_promotion_1/v3_selector_route_pilot_0/G3_MUX_NEG/X v3_four_channel_bias_reference_distribution_0/v3_four_channel_phase_distribution_0/v3_four_channel_output_collection_0/v3_four_channel_placement_0/v3_channel_selector_late_promotion_1/v3_selector_route_pilot_0/G3_MUX_AXIS/a_218_47# VSUBS sky130_fd_pr__nfet_01v8 ad=0 pd=0 as=0.1386 ps=1.5 w=0.42 l=0.15
X479 v3_four_channel_bias_reference_distribution_0/v3_four_channel_phase_distribution_0/v3_four_channel_output_collection_0/v3_four_channel_placement_0/v3_channel_selector_late_promotion_1/v3_selector_route_pilot_0/G3_MUX_AXIS/a_218_47# v3_four_channel_bias_reference_distribution_0/v3_four_channel_phase_distribution_0/v3_four_channel_output_collection_0/v3_four_channel_placement_0/v3_channel_selector_late_promotion_1/group3_bit1 VSUBS VSUBS sky130_fd_pr__nfet_01v8 ad=0 pd=0 as=0 ps=0 w=0.42 l=0.15
X480 v3_four_channel_bias_reference_distribution_0/v3_four_channel_phase_distribution_0/v3_four_channel_output_collection_0/v3_four_channel_placement_0/v3_channel_selector_late_promotion_1/VPWR v3_four_channel_bias_reference_distribution_0/v3_four_channel_phase_distribution_0/v3_four_channel_output_collection_0/v3_four_channel_placement_0/v3_channel_selector_late_promotion_1/v3_selector_route_pilot_0/G3_MUX_AXIS/a_76_199# v3_four_channel_bias_reference_distribution_0/v3_four_channel_phase_distribution_0/v3_four_channel_output_collection_0/v3_four_channel_placement_0/v3_channel_selector_late_promotion_1/v3_selector_route_pilot_0/G3_MUX_AXIS/X v3_four_channel_bias_reference_distribution_0/v3_four_channel_phase_distribution_0/v3_four_channel_output_collection_0/v3_four_channel_placement_0/v3_channel_selector_late_promotion_1/VPWR sky130_fd_pr__pfet_01v8_hvt ad=0 pd=0 as=0.26 ps=2.52 w=1 l=0.15
X481 VSUBS v3_four_channel_bias_reference_distribution_0/v3_four_channel_phase_distribution_0/v3_four_channel_output_collection_0/v3_four_channel_placement_0/v3_channel_selector_late_promotion_1/v3_selector_route_pilot_0/G3_MUX_AXIS/a_76_199# v3_four_channel_bias_reference_distribution_0/v3_four_channel_phase_distribution_0/v3_four_channel_output_collection_0/v3_four_channel_placement_0/v3_channel_selector_late_promotion_1/v3_selector_route_pilot_0/G3_MUX_AXIS/X VSUBS sky130_fd_pr__nfet_01v8 ad=0 pd=0 as=0.169 ps=1.82 w=0.65 l=0.15
X482 v3_four_channel_bias_reference_distribution_0/v3_four_channel_phase_distribution_0/v3_four_channel_output_collection_0/v3_four_channel_placement_0/v3_channel_selector_late_promotion_1/VPWR v3_four_channel_bias_reference_distribution_0/v3_four_channel_phase_distribution_0/v3_four_channel_output_collection_0/v3_four_channel_placement_0/v3_channel_selector_late_promotion_1/channel_enable v3_four_channel_bias_reference_distribution_0/v3_four_channel_phase_distribution_0/v3_four_channel_output_collection_0/v3_four_channel_placement_0/v3_channel_selector_late_promotion_1/v3_selector_route_pilot_0/ENABLE_ANDNOT/a_207_413# v3_four_channel_bias_reference_distribution_0/v3_four_channel_phase_distribution_0/v3_four_channel_output_collection_0/v3_four_channel_placement_0/v3_channel_selector_late_promotion_1/VPWR sky130_fd_pr__pfet_01v8_hvt ad=0 pd=0 as=0.1218 ps=1.42 w=0.42 l=0.15
X483 v3_four_channel_bias_reference_distribution_0/v3_four_channel_phase_distribution_0/v3_four_channel_output_collection_0/v3_four_channel_placement_0/v3_channel_selector_late_promotion_1/v3_selector_route_pilot_0/G3_LO_P_AND/B v3_four_channel_bias_reference_distribution_0/v3_four_channel_phase_distribution_0/v3_four_channel_output_collection_0/v3_four_channel_placement_0/v3_channel_selector_late_promotion_1/v3_selector_route_pilot_0/ENABLE_ANDNOT/a_207_413# v3_four_channel_bias_reference_distribution_0/v3_four_channel_phase_distribution_0/v3_four_channel_output_collection_0/v3_four_channel_placement_0/v3_channel_selector_late_promotion_1/VPWR v3_four_channel_bias_reference_distribution_0/v3_four_channel_phase_distribution_0/v3_four_channel_output_collection_0/v3_four_channel_placement_0/v3_channel_selector_late_promotion_1/VPWR sky130_fd_pr__pfet_01v8_hvt ad=0.26 pd=2.52 as=0 ps=0 w=1 l=0.15
X484 v3_four_channel_bias_reference_distribution_0/v3_four_channel_phase_distribution_0/v3_four_channel_output_collection_0/v3_four_channel_placement_0/v3_channel_selector_late_promotion_1/v3_selector_route_pilot_0/ENABLE_ANDNOT/a_297_47# v3_four_channel_bias_reference_distribution_0/v3_four_channel_phase_distribution_0/v3_four_channel_output_collection_0/v3_four_channel_placement_0/v3_channel_selector_late_promotion_1/v3_selector_route_pilot_0/ENABLE_ANDNOT/a_27_413# v3_four_channel_bias_reference_distribution_0/v3_four_channel_phase_distribution_0/v3_four_channel_output_collection_0/v3_four_channel_placement_0/v3_channel_selector_late_promotion_1/v3_selector_route_pilot_0/ENABLE_ANDNOT/a_207_413# VSUBS sky130_fd_pr__nfet_01v8 ad=0.1008 pd=1.32 as=0.1092 ps=1.36 w=0.42 l=0.15
X485 v3_four_channel_bias_reference_distribution_0/v3_four_channel_phase_distribution_0/v3_four_channel_output_collection_0/v3_four_channel_placement_0/v3_channel_selector_late_promotion_1/v3_selector_route_pilot_0/G3_LO_P_AND/B v3_four_channel_bias_reference_distribution_0/v3_four_channel_phase_distribution_0/v3_four_channel_output_collection_0/v3_four_channel_placement_0/v3_channel_selector_late_promotion_1/v3_selector_route_pilot_0/ENABLE_ANDNOT/a_207_413# VSUBS VSUBS sky130_fd_pr__nfet_01v8 ad=0.169 pd=1.82 as=0 ps=0 w=0.65 l=0.15
X486 v3_four_channel_bias_reference_distribution_0/v3_four_channel_phase_distribution_0/v3_four_channel_output_collection_0/v3_four_channel_placement_0/v3_channel_selector_late_promotion_1/v3_selector_route_pilot_0/ENABLE_ANDNOT/a_207_413# v3_four_channel_bias_reference_distribution_0/v3_four_channel_phase_distribution_0/v3_four_channel_output_collection_0/v3_four_channel_placement_0/v3_channel_selector_late_promotion_1/v3_selector_route_pilot_0/ENABLE_ANDNOT/a_27_413# v3_four_channel_bias_reference_distribution_0/v3_four_channel_phase_distribution_0/v3_four_channel_output_collection_0/v3_four_channel_placement_0/v3_channel_selector_late_promotion_1/VPWR v3_four_channel_bias_reference_distribution_0/v3_four_channel_phase_distribution_0/v3_four_channel_output_collection_0/v3_four_channel_placement_0/v3_channel_selector_late_promotion_1/VPWR sky130_fd_pr__pfet_01v8_hvt ad=0 pd=0 as=0 ps=0 w=0.42 l=0.15
X487 v3_four_channel_bias_reference_distribution_0/v3_four_channel_phase_distribution_0/v3_four_channel_output_collection_0/v3_four_channel_placement_0/v3_channel_selector_late_promotion_1/VPWR v3_four_channel_bias_reference_distribution_0/v3_four_channel_phase_distribution_0/v3_four_channel_output_collection_0/v3_four_channel_placement_0/v3_channel_selector_late_promotion_1/mixers_blank v3_four_channel_bias_reference_distribution_0/v3_four_channel_phase_distribution_0/v3_four_channel_output_collection_0/v3_four_channel_placement_0/v3_channel_selector_late_promotion_1/v3_selector_route_pilot_0/ENABLE_ANDNOT/a_27_413# v3_four_channel_bias_reference_distribution_0/v3_four_channel_phase_distribution_0/v3_four_channel_output_collection_0/v3_four_channel_placement_0/v3_channel_selector_late_promotion_1/VPWR sky130_fd_pr__pfet_01v8_hvt ad=0 pd=0 as=0.1092 ps=1.36 w=0.42 l=0.15
X488 VSUBS v3_four_channel_bias_reference_distribution_0/v3_four_channel_phase_distribution_0/v3_four_channel_output_collection_0/v3_four_channel_placement_0/v3_channel_selector_late_promotion_1/channel_enable v3_four_channel_bias_reference_distribution_0/v3_four_channel_phase_distribution_0/v3_four_channel_output_collection_0/v3_four_channel_placement_0/v3_channel_selector_late_promotion_1/v3_selector_route_pilot_0/ENABLE_ANDNOT/a_297_47# VSUBS sky130_fd_pr__nfet_01v8 ad=0 pd=0 as=0 ps=0 w=0.42 l=0.15
X489 v3_four_channel_bias_reference_distribution_0/v3_four_channel_phase_distribution_0/v3_four_channel_output_collection_0/v3_four_channel_placement_0/v3_channel_selector_late_promotion_1/v3_selector_route_pilot_0/ENABLE_ANDNOT/a_27_413# v3_four_channel_bias_reference_distribution_0/v3_four_channel_phase_distribution_0/v3_four_channel_output_collection_0/v3_four_channel_placement_0/v3_channel_selector_late_promotion_1/mixers_blank VSUBS VSUBS sky130_fd_pr__nfet_01v8 ad=0.1092 pd=1.36 as=0 ps=0 w=0.42 l=0.15
X490 v3_four_channel_bias_reference_distribution_0/v3_four_channel_phase_distribution_0/v3_four_channel_output_collection_0/v3_four_channel_placement_0/v3_channel_selector_late_promotion_1/VPWR v3_four_channel_bias_reference_distribution_0/v3_four_channel_phase_distribution_0/v3_four_channel_output_collection_0/v3_four_channel_placement_0/v3_channel_selector_late_promotion_1/v3_selector_route_pilot_0/G1_MUX_NEG/a_505_21# v3_four_channel_bias_reference_distribution_0/v3_four_channel_phase_distribution_0/v3_four_channel_output_collection_0/v3_four_channel_placement_0/v3_channel_selector_late_promotion_1/v3_selector_route_pilot_0/G1_MUX_NEG/a_535_374# v3_four_channel_bias_reference_distribution_0/v3_four_channel_phase_distribution_0/v3_four_channel_output_collection_0/v3_four_channel_placement_0/v3_channel_selector_late_promotion_1/VPWR sky130_fd_pr__pfet_01v8_hvt ad=0 pd=0 as=0.0882 ps=1.26 w=0.42 l=0.15
X491 v3_four_channel_bias_reference_distribution_0/v3_four_channel_phase_distribution_0/v3_four_channel_output_collection_0/v3_four_channel_placement_0/v3_channel_selector_late_promotion_1/v3_selector_route_pilot_0/G1_MUX_NEG/a_505_21# v3_four_channel_bias_reference_distribution_0/v3_four_channel_phase_distribution_0/v3_four_channel_output_collection_0/v3_four_channel_placement_0/v3_channel_selector_late_promotion_1/group1_bit0 v3_four_channel_bias_reference_distribution_0/v3_four_channel_phase_distribution_0/v3_four_channel_output_collection_0/v3_four_channel_placement_0/v3_channel_selector_late_promotion_1/VPWR v3_four_channel_bias_reference_distribution_0/v3_four_channel_phase_distribution_0/v3_four_channel_output_collection_0/v3_four_channel_placement_0/v3_channel_selector_late_promotion_1/VPWR sky130_fd_pr__pfet_01v8_hvt ad=0.1176 pd=1.4 as=0 ps=0 w=0.42 l=0.15
X492 v3_four_channel_bias_reference_distribution_0/v3_four_channel_phase_distribution_0/v3_four_channel_output_collection_0/v3_four_channel_placement_0/v3_channel_selector_late_promotion_1/v3_selector_route_pilot_0/G1_MUX_NEG/a_218_374# v3_four_channel_bias_reference_distribution_0/v3_four_channel_phase_distribution_0/v3_four_channel_output_collection_0/v3_four_channel_placement_0/v3_channel_selector_late_promotion_1/group1_bit0 v3_four_channel_bias_reference_distribution_0/v3_four_channel_phase_distribution_0/v3_four_channel_output_collection_0/v3_four_channel_placement_0/v3_channel_selector_late_promotion_1/VPWR v3_four_channel_bias_reference_distribution_0/v3_four_channel_phase_distribution_0/v3_four_channel_output_collection_0/v3_four_channel_placement_0/v3_channel_selector_late_promotion_1/VPWR sky130_fd_pr__pfet_01v8_hvt ad=0.1533 pd=1.57 as=0 ps=0 w=0.42 l=0.15
X493 VSUBS v3_four_channel_bias_reference_distribution_0/v3_four_channel_phase_distribution_0/v3_four_channel_output_collection_0/v3_four_channel_placement_0/v3_channel_selector_late_promotion_1/v3_selector_route_pilot_0/G1_MUX_NEG/a_505_21# v3_four_channel_bias_reference_distribution_0/v3_four_channel_phase_distribution_0/v3_four_channel_output_collection_0/v3_four_channel_placement_0/v3_channel_selector_late_promotion_1/v3_selector_route_pilot_0/G1_MUX_NEG/a_439_47# VSUBS sky130_fd_pr__nfet_01v8 ad=0 pd=0 as=0.1386 ps=1.5 w=0.42 l=0.15
X494 v3_four_channel_bias_reference_distribution_0/v3_four_channel_phase_distribution_0/v3_four_channel_output_collection_0/v3_four_channel_placement_0/v3_channel_selector_late_promotion_1/v3_selector_route_pilot_0/G1_MUX_NEG/a_76_199# v3_four_channel_bias_reference_distribution_0/v3_four_channel_phase_distribution_0/phase_180 v3_four_channel_bias_reference_distribution_0/v3_four_channel_phase_distribution_0/v3_four_channel_output_collection_0/v3_four_channel_placement_0/v3_channel_selector_late_promotion_1/v3_selector_route_pilot_0/G1_MUX_NEG/a_218_374# v3_four_channel_bias_reference_distribution_0/v3_four_channel_phase_distribution_0/v3_four_channel_output_collection_0/v3_four_channel_placement_0/v3_channel_selector_late_promotion_1/VPWR sky130_fd_pr__pfet_01v8_hvt ad=0.3864 pd=2.68 as=0 ps=0 w=0.42 l=0.15
X495 v3_four_channel_bias_reference_distribution_0/v3_four_channel_phase_distribution_0/v3_four_channel_output_collection_0/v3_four_channel_placement_0/v3_channel_selector_late_promotion_1/v3_selector_route_pilot_0/G1_MUX_NEG/a_505_21# v3_four_channel_bias_reference_distribution_0/v3_four_channel_phase_distribution_0/v3_four_channel_output_collection_0/v3_four_channel_placement_0/v3_channel_selector_late_promotion_1/group1_bit0 VSUBS VSUBS sky130_fd_pr__nfet_01v8 ad=0.1092 pd=1.36 as=0 ps=0 w=0.42 l=0.15
X496 v3_four_channel_bias_reference_distribution_0/v3_four_channel_phase_distribution_0/v3_four_channel_output_collection_0/v3_four_channel_placement_0/v3_channel_selector_late_promotion_1/v3_selector_route_pilot_0/G1_MUX_NEG/a_439_47# v3_four_channel_bias_reference_distribution_0/v3_four_channel_phase_distribution_0/phase_180 v3_four_channel_bias_reference_distribution_0/v3_four_channel_phase_distribution_0/v3_four_channel_output_collection_0/v3_four_channel_placement_0/v3_channel_selector_late_promotion_1/v3_selector_route_pilot_0/G1_MUX_NEG/a_76_199# VSUBS sky130_fd_pr__nfet_01v8 ad=0 pd=0 as=0.1995 ps=1.79 w=0.42 l=0.15
X497 v3_four_channel_bias_reference_distribution_0/v3_four_channel_phase_distribution_0/v3_four_channel_output_collection_0/v3_four_channel_placement_0/v3_channel_selector_late_promotion_1/v3_selector_route_pilot_0/G1_MUX_NEG/a_535_374# v3_four_channel_bias_reference_distribution_0/v3_four_channel_phase_distribution_0/phase_270 v3_four_channel_bias_reference_distribution_0/v3_four_channel_phase_distribution_0/v3_four_channel_output_collection_0/v3_four_channel_placement_0/v3_channel_selector_late_promotion_1/v3_selector_route_pilot_0/G1_MUX_NEG/a_76_199# v3_four_channel_bias_reference_distribution_0/v3_four_channel_phase_distribution_0/v3_four_channel_output_collection_0/v3_four_channel_placement_0/v3_channel_selector_late_promotion_1/VPWR sky130_fd_pr__pfet_01v8_hvt ad=0 pd=0 as=0 ps=0 w=0.42 l=0.15
X498 v3_four_channel_bias_reference_distribution_0/v3_four_channel_phase_distribution_0/v3_four_channel_output_collection_0/v3_four_channel_placement_0/v3_channel_selector_late_promotion_1/v3_selector_route_pilot_0/G1_MUX_NEG/a_76_199# v3_four_channel_bias_reference_distribution_0/v3_four_channel_phase_distribution_0/phase_270 v3_four_channel_bias_reference_distribution_0/v3_four_channel_phase_distribution_0/v3_four_channel_output_collection_0/v3_four_channel_placement_0/v3_channel_selector_late_promotion_1/v3_selector_route_pilot_0/G1_MUX_NEG/a_218_47# VSUBS sky130_fd_pr__nfet_01v8 ad=0 pd=0 as=0.1386 ps=1.5 w=0.42 l=0.15
X499 v3_four_channel_bias_reference_distribution_0/v3_four_channel_phase_distribution_0/v3_four_channel_output_collection_0/v3_four_channel_placement_0/v3_channel_selector_late_promotion_1/v3_selector_route_pilot_0/G1_MUX_NEG/a_218_47# v3_four_channel_bias_reference_distribution_0/v3_four_channel_phase_distribution_0/v3_four_channel_output_collection_0/v3_four_channel_placement_0/v3_channel_selector_late_promotion_1/group1_bit0 VSUBS VSUBS sky130_fd_pr__nfet_01v8 ad=0 pd=0 as=0 ps=0 w=0.42 l=0.15
X500 v3_four_channel_bias_reference_distribution_0/v3_four_channel_phase_distribution_0/v3_four_channel_output_collection_0/v3_four_channel_placement_0/v3_channel_selector_late_promotion_1/VPWR v3_four_channel_bias_reference_distribution_0/v3_four_channel_phase_distribution_0/v3_four_channel_output_collection_0/v3_four_channel_placement_0/v3_channel_selector_late_promotion_1/v3_selector_route_pilot_0/G1_MUX_NEG/a_76_199# v3_four_channel_bias_reference_distribution_0/v3_four_channel_phase_distribution_0/v3_four_channel_output_collection_0/v3_four_channel_placement_0/v3_channel_selector_late_promotion_1/v3_selector_route_pilot_0/G1_MUX_NEG/X v3_four_channel_bias_reference_distribution_0/v3_four_channel_phase_distribution_0/v3_four_channel_output_collection_0/v3_four_channel_placement_0/v3_channel_selector_late_promotion_1/VPWR sky130_fd_pr__pfet_01v8_hvt ad=0 pd=0 as=0.26 ps=2.52 w=1 l=0.15
X501 VSUBS v3_four_channel_bias_reference_distribution_0/v3_four_channel_phase_distribution_0/v3_four_channel_output_collection_0/v3_four_channel_placement_0/v3_channel_selector_late_promotion_1/v3_selector_route_pilot_0/G1_MUX_NEG/a_76_199# v3_four_channel_bias_reference_distribution_0/v3_four_channel_phase_distribution_0/v3_four_channel_output_collection_0/v3_four_channel_placement_0/v3_channel_selector_late_promotion_1/v3_selector_route_pilot_0/G1_MUX_NEG/X VSUBS sky130_fd_pr__nfet_01v8 ad=0 pd=0 as=0.169 ps=1.82 w=0.65 l=0.15
X502 v3_four_channel_bias_reference_distribution_0/v3_four_channel_phase_distribution_0/v3_four_channel_output_collection_0/v3_four_channel_placement_0/v3_channel_selector_late_promotion_1/VPWR v3_four_channel_bias_reference_distribution_0/v3_four_channel_phase_distribution_0/v3_four_channel_output_collection_0/v3_four_channel_placement_0/v3_channel_selector_late_promotion_1/v3_selector_route_pilot_0/G3_LO_P_AND/B v3_four_channel_bias_reference_distribution_0/v3_four_channel_phase_distribution_0/v3_four_channel_output_collection_0/v3_four_channel_placement_0/v3_channel_selector_late_promotion_1/v3_selector_route_pilot_0/G1_LO_P_AND/a_59_75# v3_four_channel_bias_reference_distribution_0/v3_four_channel_phase_distribution_0/v3_four_channel_output_collection_0/v3_four_channel_placement_0/v3_channel_selector_late_promotion_1/VPWR sky130_fd_pr__pfet_01v8_hvt ad=0 pd=0 as=0.1134 ps=1.38 w=0.42 l=0.15
X503 v3_four_channel_bias_reference_distribution_0/v3_four_channel_phase_distribution_0/v3_four_channel_output_collection_0/v3_four_channel_placement_0/v3_channel_selector_late_promotion_1/v3_selector_route_pilot_0/group1_lo_p v3_four_channel_bias_reference_distribution_0/v3_four_channel_phase_distribution_0/v3_four_channel_output_collection_0/v3_four_channel_placement_0/v3_channel_selector_late_promotion_1/v3_selector_route_pilot_0/G1_LO_P_AND/a_59_75# v3_four_channel_bias_reference_distribution_0/v3_four_channel_phase_distribution_0/v3_four_channel_output_collection_0/v3_four_channel_placement_0/v3_channel_selector_late_promotion_1/VPWR v3_four_channel_bias_reference_distribution_0/v3_four_channel_phase_distribution_0/v3_four_channel_output_collection_0/v3_four_channel_placement_0/v3_channel_selector_late_promotion_1/VPWR sky130_fd_pr__pfet_01v8_hvt ad=0.475 pd=2.95 as=0 ps=0 w=1 l=0.15
X504 VSUBS v3_four_channel_bias_reference_distribution_0/v3_four_channel_phase_distribution_0/v3_four_channel_output_collection_0/v3_four_channel_placement_0/v3_channel_selector_late_promotion_1/v3_selector_route_pilot_0/G3_LO_P_AND/B v3_four_channel_bias_reference_distribution_0/v3_four_channel_phase_distribution_0/v3_four_channel_output_collection_0/v3_four_channel_placement_0/v3_channel_selector_late_promotion_1/v3_selector_route_pilot_0/G1_LO_P_AND/a_145_75# VSUBS sky130_fd_pr__nfet_01v8 ad=0 pd=0 as=0.1134 ps=1.38 w=0.42 l=0.15
X505 v3_four_channel_bias_reference_distribution_0/v3_four_channel_phase_distribution_0/v3_four_channel_output_collection_0/v3_four_channel_placement_0/v3_channel_selector_late_promotion_1/v3_selector_route_pilot_0/G1_LO_P_AND/a_59_75# v3_four_channel_bias_reference_distribution_0/v3_four_channel_phase_distribution_0/v3_four_channel_output_collection_0/v3_four_channel_placement_0/v3_channel_selector_late_promotion_1/v3_selector_route_pilot_0/G1_MUX_AXIS/X v3_four_channel_bias_reference_distribution_0/v3_four_channel_phase_distribution_0/v3_four_channel_output_collection_0/v3_four_channel_placement_0/v3_channel_selector_late_promotion_1/VPWR v3_four_channel_bias_reference_distribution_0/v3_four_channel_phase_distribution_0/v3_four_channel_output_collection_0/v3_four_channel_placement_0/v3_channel_selector_late_promotion_1/VPWR sky130_fd_pr__pfet_01v8_hvt ad=0 pd=0 as=0 ps=0 w=0.42 l=0.15
X506 v3_four_channel_bias_reference_distribution_0/v3_four_channel_phase_distribution_0/v3_four_channel_output_collection_0/v3_four_channel_placement_0/v3_channel_selector_late_promotion_1/v3_selector_route_pilot_0/group1_lo_p v3_four_channel_bias_reference_distribution_0/v3_four_channel_phase_distribution_0/v3_four_channel_output_collection_0/v3_four_channel_placement_0/v3_channel_selector_late_promotion_1/v3_selector_route_pilot_0/G1_LO_P_AND/a_59_75# VSUBS VSUBS sky130_fd_pr__nfet_01v8 ad=0.182 pd=1.86 as=0 ps=0 w=0.65 l=0.15
X507 v3_four_channel_bias_reference_distribution_0/v3_four_channel_phase_distribution_0/v3_four_channel_output_collection_0/v3_four_channel_placement_0/v3_channel_selector_late_promotion_1/v3_selector_route_pilot_0/G1_LO_P_AND/a_145_75# v3_four_channel_bias_reference_distribution_0/v3_four_channel_phase_distribution_0/v3_four_channel_output_collection_0/v3_four_channel_placement_0/v3_channel_selector_late_promotion_1/v3_selector_route_pilot_0/G1_MUX_AXIS/X v3_four_channel_bias_reference_distribution_0/v3_four_channel_phase_distribution_0/v3_four_channel_output_collection_0/v3_four_channel_placement_0/v3_channel_selector_late_promotion_1/v3_selector_route_pilot_0/G1_LO_P_AND/a_59_75# VSUBS sky130_fd_pr__nfet_01v8 ad=0 pd=0 as=0.1176 ps=1.4 w=0.42 l=0.15
X508 v3_four_channel_bias_reference_distribution_0/v3_four_channel_phase_distribution_0/v3_four_channel_output_collection_0/v3_four_channel_placement_0/v3_channel_selector_late_promotion_1/VPWR v3_four_channel_bias_reference_distribution_0/v3_four_channel_phase_distribution_0/v3_four_channel_output_collection_0/v3_four_channel_placement_0/v3_channel_selector_late_promotion_1/v3_selector_route_pilot_0/G0_MUX_POS/a_505_21# v3_four_channel_bias_reference_distribution_0/v3_four_channel_phase_distribution_0/v3_four_channel_output_collection_0/v3_four_channel_placement_0/v3_channel_selector_late_promotion_1/v3_selector_route_pilot_0/G0_MUX_POS/a_535_374# v3_four_channel_bias_reference_distribution_0/v3_four_channel_phase_distribution_0/v3_four_channel_output_collection_0/v3_four_channel_placement_0/v3_channel_selector_late_promotion_1/VPWR sky130_fd_pr__pfet_01v8_hvt ad=0 pd=0 as=0.0882 ps=1.26 w=0.42 l=0.15
X509 v3_four_channel_bias_reference_distribution_0/v3_four_channel_phase_distribution_0/v3_four_channel_output_collection_0/v3_four_channel_placement_0/v3_channel_selector_late_promotion_1/v3_selector_route_pilot_0/G0_MUX_POS/a_505_21# v3_four_channel_bias_reference_distribution_0/v3_four_channel_phase_distribution_0/v3_four_channel_output_collection_0/v3_four_channel_placement_0/v3_channel_selector_late_promotion_1/group0_bit0 v3_four_channel_bias_reference_distribution_0/v3_four_channel_phase_distribution_0/v3_four_channel_output_collection_0/v3_four_channel_placement_0/v3_channel_selector_late_promotion_1/VPWR v3_four_channel_bias_reference_distribution_0/v3_four_channel_phase_distribution_0/v3_four_channel_output_collection_0/v3_four_channel_placement_0/v3_channel_selector_late_promotion_1/VPWR sky130_fd_pr__pfet_01v8_hvt ad=0.1176 pd=1.4 as=0 ps=0 w=0.42 l=0.15
X510 v3_four_channel_bias_reference_distribution_0/v3_four_channel_phase_distribution_0/v3_four_channel_output_collection_0/v3_four_channel_placement_0/v3_channel_selector_late_promotion_1/v3_selector_route_pilot_0/G0_MUX_POS/a_218_374# v3_four_channel_bias_reference_distribution_0/v3_four_channel_phase_distribution_0/v3_four_channel_output_collection_0/v3_four_channel_placement_0/v3_channel_selector_late_promotion_1/group0_bit0 v3_four_channel_bias_reference_distribution_0/v3_four_channel_phase_distribution_0/v3_four_channel_output_collection_0/v3_four_channel_placement_0/v3_channel_selector_late_promotion_1/VPWR v3_four_channel_bias_reference_distribution_0/v3_four_channel_phase_distribution_0/v3_four_channel_output_collection_0/v3_four_channel_placement_0/v3_channel_selector_late_promotion_1/VPWR sky130_fd_pr__pfet_01v8_hvt ad=0.1533 pd=1.57 as=0 ps=0 w=0.42 l=0.15
X511 VSUBS v3_four_channel_bias_reference_distribution_0/v3_four_channel_phase_distribution_0/v3_four_channel_output_collection_0/v3_four_channel_placement_0/v3_channel_selector_late_promotion_1/v3_selector_route_pilot_0/G0_MUX_POS/a_505_21# v3_four_channel_bias_reference_distribution_0/v3_four_channel_phase_distribution_0/v3_four_channel_output_collection_0/v3_four_channel_placement_0/v3_channel_selector_late_promotion_1/v3_selector_route_pilot_0/G0_MUX_POS/a_439_47# VSUBS sky130_fd_pr__nfet_01v8 ad=0 pd=0 as=0.1386 ps=1.5 w=0.42 l=0.15
X512 v3_four_channel_bias_reference_distribution_0/v3_four_channel_phase_distribution_0/v3_four_channel_output_collection_0/v3_four_channel_placement_0/v3_channel_selector_late_promotion_1/v3_selector_route_pilot_0/G0_MUX_POS/a_76_199# v3_four_channel_bias_reference_distribution_0/v3_four_channel_phase_distribution_0/phase_0 v3_four_channel_bias_reference_distribution_0/v3_four_channel_phase_distribution_0/v3_four_channel_output_collection_0/v3_four_channel_placement_0/v3_channel_selector_late_promotion_1/v3_selector_route_pilot_0/G0_MUX_POS/a_218_374# v3_four_channel_bias_reference_distribution_0/v3_four_channel_phase_distribution_0/v3_four_channel_output_collection_0/v3_four_channel_placement_0/v3_channel_selector_late_promotion_1/VPWR sky130_fd_pr__pfet_01v8_hvt ad=0.3864 pd=2.68 as=0 ps=0 w=0.42 l=0.15
X513 v3_four_channel_bias_reference_distribution_0/v3_four_channel_phase_distribution_0/v3_four_channel_output_collection_0/v3_four_channel_placement_0/v3_channel_selector_late_promotion_1/v3_selector_route_pilot_0/G0_MUX_POS/a_505_21# v3_four_channel_bias_reference_distribution_0/v3_four_channel_phase_distribution_0/v3_four_channel_output_collection_0/v3_four_channel_placement_0/v3_channel_selector_late_promotion_1/group0_bit0 VSUBS VSUBS sky130_fd_pr__nfet_01v8 ad=0.1092 pd=1.36 as=0 ps=0 w=0.42 l=0.15
X514 v3_four_channel_bias_reference_distribution_0/v3_four_channel_phase_distribution_0/v3_four_channel_output_collection_0/v3_four_channel_placement_0/v3_channel_selector_late_promotion_1/v3_selector_route_pilot_0/G0_MUX_POS/a_439_47# v3_four_channel_bias_reference_distribution_0/v3_four_channel_phase_distribution_0/phase_0 v3_four_channel_bias_reference_distribution_0/v3_four_channel_phase_distribution_0/v3_four_channel_output_collection_0/v3_four_channel_placement_0/v3_channel_selector_late_promotion_1/v3_selector_route_pilot_0/G0_MUX_POS/a_76_199# VSUBS sky130_fd_pr__nfet_01v8 ad=0 pd=0 as=0.1995 ps=1.79 w=0.42 l=0.15
X515 v3_four_channel_bias_reference_distribution_0/v3_four_channel_phase_distribution_0/v3_four_channel_output_collection_0/v3_four_channel_placement_0/v3_channel_selector_late_promotion_1/v3_selector_route_pilot_0/G0_MUX_POS/a_535_374# v3_four_channel_bias_reference_distribution_0/v3_four_channel_phase_distribution_0/phase_90 v3_four_channel_bias_reference_distribution_0/v3_four_channel_phase_distribution_0/v3_four_channel_output_collection_0/v3_four_channel_placement_0/v3_channel_selector_late_promotion_1/v3_selector_route_pilot_0/G0_MUX_POS/a_76_199# v3_four_channel_bias_reference_distribution_0/v3_four_channel_phase_distribution_0/v3_four_channel_output_collection_0/v3_four_channel_placement_0/v3_channel_selector_late_promotion_1/VPWR sky130_fd_pr__pfet_01v8_hvt ad=0 pd=0 as=0 ps=0 w=0.42 l=0.15
X516 v3_four_channel_bias_reference_distribution_0/v3_four_channel_phase_distribution_0/v3_four_channel_output_collection_0/v3_four_channel_placement_0/v3_channel_selector_late_promotion_1/v3_selector_route_pilot_0/G0_MUX_POS/a_76_199# v3_four_channel_bias_reference_distribution_0/v3_four_channel_phase_distribution_0/phase_90 v3_four_channel_bias_reference_distribution_0/v3_four_channel_phase_distribution_0/v3_four_channel_output_collection_0/v3_four_channel_placement_0/v3_channel_selector_late_promotion_1/v3_selector_route_pilot_0/G0_MUX_POS/a_218_47# VSUBS sky130_fd_pr__nfet_01v8 ad=0 pd=0 as=0.1386 ps=1.5 w=0.42 l=0.15
X517 v3_four_channel_bias_reference_distribution_0/v3_four_channel_phase_distribution_0/v3_four_channel_output_collection_0/v3_four_channel_placement_0/v3_channel_selector_late_promotion_1/v3_selector_route_pilot_0/G0_MUX_POS/a_218_47# v3_four_channel_bias_reference_distribution_0/v3_four_channel_phase_distribution_0/v3_four_channel_output_collection_0/v3_four_channel_placement_0/v3_channel_selector_late_promotion_1/group0_bit0 VSUBS VSUBS sky130_fd_pr__nfet_01v8 ad=0 pd=0 as=0 ps=0 w=0.42 l=0.15
X518 v3_four_channel_bias_reference_distribution_0/v3_four_channel_phase_distribution_0/v3_four_channel_output_collection_0/v3_four_channel_placement_0/v3_channel_selector_late_promotion_1/VPWR v3_four_channel_bias_reference_distribution_0/v3_four_channel_phase_distribution_0/v3_four_channel_output_collection_0/v3_four_channel_placement_0/v3_channel_selector_late_promotion_1/v3_selector_route_pilot_0/G0_MUX_POS/a_76_199# v3_four_channel_bias_reference_distribution_0/v3_four_channel_phase_distribution_0/v3_four_channel_output_collection_0/v3_four_channel_placement_0/v3_channel_selector_late_promotion_1/v3_selector_route_pilot_0/G0_MUX_POS/X v3_four_channel_bias_reference_distribution_0/v3_four_channel_phase_distribution_0/v3_four_channel_output_collection_0/v3_four_channel_placement_0/v3_channel_selector_late_promotion_1/VPWR sky130_fd_pr__pfet_01v8_hvt ad=0 pd=0 as=0.26 ps=2.52 w=1 l=0.15
X519 VSUBS v3_four_channel_bias_reference_distribution_0/v3_four_channel_phase_distribution_0/v3_four_channel_output_collection_0/v3_four_channel_placement_0/v3_channel_selector_late_promotion_1/v3_selector_route_pilot_0/G0_MUX_POS/a_76_199# v3_four_channel_bias_reference_distribution_0/v3_four_channel_phase_distribution_0/v3_four_channel_output_collection_0/v3_four_channel_placement_0/v3_channel_selector_late_promotion_1/v3_selector_route_pilot_0/G0_MUX_POS/X VSUBS sky130_fd_pr__nfet_01v8 ad=0 pd=0 as=0.169 ps=1.82 w=0.65 l=0.15
X520 v3_four_channel_bias_reference_distribution_0/v3_four_channel_phase_distribution_0/v3_four_channel_output_collection_0/v3_four_channel_placement_0/v3_channel_selector_late_promotion_1/VPWR v3_four_channel_bias_reference_distribution_0/v3_four_channel_phase_distribution_0/v3_four_channel_output_collection_0/v3_four_channel_placement_0/v3_channel_selector_late_promotion_1/v3_selector_route_pilot_0/G0_MUX_NEG/a_505_21# v3_four_channel_bias_reference_distribution_0/v3_four_channel_phase_distribution_0/v3_four_channel_output_collection_0/v3_four_channel_placement_0/v3_channel_selector_late_promotion_1/v3_selector_route_pilot_0/G0_MUX_NEG/a_535_374# v3_four_channel_bias_reference_distribution_0/v3_four_channel_phase_distribution_0/v3_four_channel_output_collection_0/v3_four_channel_placement_0/v3_channel_selector_late_promotion_1/VPWR sky130_fd_pr__pfet_01v8_hvt ad=0 pd=0 as=0.0882 ps=1.26 w=0.42 l=0.15
X521 v3_four_channel_bias_reference_distribution_0/v3_four_channel_phase_distribution_0/v3_four_channel_output_collection_0/v3_four_channel_placement_0/v3_channel_selector_late_promotion_1/v3_selector_route_pilot_0/G0_MUX_NEG/a_505_21# v3_four_channel_bias_reference_distribution_0/v3_four_channel_phase_distribution_0/v3_four_channel_output_collection_0/v3_four_channel_placement_0/v3_channel_selector_late_promotion_1/group0_bit0 v3_four_channel_bias_reference_distribution_0/v3_four_channel_phase_distribution_0/v3_four_channel_output_collection_0/v3_four_channel_placement_0/v3_channel_selector_late_promotion_1/VPWR v3_four_channel_bias_reference_distribution_0/v3_four_channel_phase_distribution_0/v3_four_channel_output_collection_0/v3_four_channel_placement_0/v3_channel_selector_late_promotion_1/VPWR sky130_fd_pr__pfet_01v8_hvt ad=0.1176 pd=1.4 as=0 ps=0 w=0.42 l=0.15
X522 v3_four_channel_bias_reference_distribution_0/v3_four_channel_phase_distribution_0/v3_four_channel_output_collection_0/v3_four_channel_placement_0/v3_channel_selector_late_promotion_1/v3_selector_route_pilot_0/G0_MUX_NEG/a_218_374# v3_four_channel_bias_reference_distribution_0/v3_four_channel_phase_distribution_0/v3_four_channel_output_collection_0/v3_four_channel_placement_0/v3_channel_selector_late_promotion_1/group0_bit0 v3_four_channel_bias_reference_distribution_0/v3_four_channel_phase_distribution_0/v3_four_channel_output_collection_0/v3_four_channel_placement_0/v3_channel_selector_late_promotion_1/VPWR v3_four_channel_bias_reference_distribution_0/v3_four_channel_phase_distribution_0/v3_four_channel_output_collection_0/v3_four_channel_placement_0/v3_channel_selector_late_promotion_1/VPWR sky130_fd_pr__pfet_01v8_hvt ad=0.1533 pd=1.57 as=0 ps=0 w=0.42 l=0.15
X523 VSUBS v3_four_channel_bias_reference_distribution_0/v3_four_channel_phase_distribution_0/v3_four_channel_output_collection_0/v3_four_channel_placement_0/v3_channel_selector_late_promotion_1/v3_selector_route_pilot_0/G0_MUX_NEG/a_505_21# v3_four_channel_bias_reference_distribution_0/v3_four_channel_phase_distribution_0/v3_four_channel_output_collection_0/v3_four_channel_placement_0/v3_channel_selector_late_promotion_1/v3_selector_route_pilot_0/G0_MUX_NEG/a_439_47# VSUBS sky130_fd_pr__nfet_01v8 ad=0 pd=0 as=0.1386 ps=1.5 w=0.42 l=0.15
X524 v3_four_channel_bias_reference_distribution_0/v3_four_channel_phase_distribution_0/v3_four_channel_output_collection_0/v3_four_channel_placement_0/v3_channel_selector_late_promotion_1/v3_selector_route_pilot_0/G0_MUX_NEG/a_76_199# v3_four_channel_bias_reference_distribution_0/v3_four_channel_phase_distribution_0/phase_180 v3_four_channel_bias_reference_distribution_0/v3_four_channel_phase_distribution_0/v3_four_channel_output_collection_0/v3_four_channel_placement_0/v3_channel_selector_late_promotion_1/v3_selector_route_pilot_0/G0_MUX_NEG/a_218_374# v3_four_channel_bias_reference_distribution_0/v3_four_channel_phase_distribution_0/v3_four_channel_output_collection_0/v3_four_channel_placement_0/v3_channel_selector_late_promotion_1/VPWR sky130_fd_pr__pfet_01v8_hvt ad=0.3864 pd=2.68 as=0 ps=0 w=0.42 l=0.15
X525 v3_four_channel_bias_reference_distribution_0/v3_four_channel_phase_distribution_0/v3_four_channel_output_collection_0/v3_four_channel_placement_0/v3_channel_selector_late_promotion_1/v3_selector_route_pilot_0/G0_MUX_NEG/a_505_21# v3_four_channel_bias_reference_distribution_0/v3_four_channel_phase_distribution_0/v3_four_channel_output_collection_0/v3_four_channel_placement_0/v3_channel_selector_late_promotion_1/group0_bit0 VSUBS VSUBS sky130_fd_pr__nfet_01v8 ad=0.1092 pd=1.36 as=0 ps=0 w=0.42 l=0.15
X526 v3_four_channel_bias_reference_distribution_0/v3_four_channel_phase_distribution_0/v3_four_channel_output_collection_0/v3_four_channel_placement_0/v3_channel_selector_late_promotion_1/v3_selector_route_pilot_0/G0_MUX_NEG/a_439_47# v3_four_channel_bias_reference_distribution_0/v3_four_channel_phase_distribution_0/phase_180 v3_four_channel_bias_reference_distribution_0/v3_four_channel_phase_distribution_0/v3_four_channel_output_collection_0/v3_four_channel_placement_0/v3_channel_selector_late_promotion_1/v3_selector_route_pilot_0/G0_MUX_NEG/a_76_199# VSUBS sky130_fd_pr__nfet_01v8 ad=0 pd=0 as=0.1995 ps=1.79 w=0.42 l=0.15
X527 v3_four_channel_bias_reference_distribution_0/v3_four_channel_phase_distribution_0/v3_four_channel_output_collection_0/v3_four_channel_placement_0/v3_channel_selector_late_promotion_1/v3_selector_route_pilot_0/G0_MUX_NEG/a_535_374# v3_four_channel_bias_reference_distribution_0/v3_four_channel_phase_distribution_0/phase_270 v3_four_channel_bias_reference_distribution_0/v3_four_channel_phase_distribution_0/v3_four_channel_output_collection_0/v3_four_channel_placement_0/v3_channel_selector_late_promotion_1/v3_selector_route_pilot_0/G0_MUX_NEG/a_76_199# v3_four_channel_bias_reference_distribution_0/v3_four_channel_phase_distribution_0/v3_four_channel_output_collection_0/v3_four_channel_placement_0/v3_channel_selector_late_promotion_1/VPWR sky130_fd_pr__pfet_01v8_hvt ad=0 pd=0 as=0 ps=0 w=0.42 l=0.15
X528 v3_four_channel_bias_reference_distribution_0/v3_four_channel_phase_distribution_0/v3_four_channel_output_collection_0/v3_four_channel_placement_0/v3_channel_selector_late_promotion_1/v3_selector_route_pilot_0/G0_MUX_NEG/a_76_199# v3_four_channel_bias_reference_distribution_0/v3_four_channel_phase_distribution_0/phase_270 v3_four_channel_bias_reference_distribution_0/v3_four_channel_phase_distribution_0/v3_four_channel_output_collection_0/v3_four_channel_placement_0/v3_channel_selector_late_promotion_1/v3_selector_route_pilot_0/G0_MUX_NEG/a_218_47# VSUBS sky130_fd_pr__nfet_01v8 ad=0 pd=0 as=0.1386 ps=1.5 w=0.42 l=0.15
X529 v3_four_channel_bias_reference_distribution_0/v3_four_channel_phase_distribution_0/v3_four_channel_output_collection_0/v3_four_channel_placement_0/v3_channel_selector_late_promotion_1/v3_selector_route_pilot_0/G0_MUX_NEG/a_218_47# v3_four_channel_bias_reference_distribution_0/v3_four_channel_phase_distribution_0/v3_four_channel_output_collection_0/v3_four_channel_placement_0/v3_channel_selector_late_promotion_1/group0_bit0 VSUBS VSUBS sky130_fd_pr__nfet_01v8 ad=0 pd=0 as=0 ps=0 w=0.42 l=0.15
X530 v3_four_channel_bias_reference_distribution_0/v3_four_channel_phase_distribution_0/v3_four_channel_output_collection_0/v3_four_channel_placement_0/v3_channel_selector_late_promotion_1/VPWR v3_four_channel_bias_reference_distribution_0/v3_four_channel_phase_distribution_0/v3_four_channel_output_collection_0/v3_four_channel_placement_0/v3_channel_selector_late_promotion_1/v3_selector_route_pilot_0/G0_MUX_NEG/a_76_199# v3_four_channel_bias_reference_distribution_0/v3_four_channel_phase_distribution_0/v3_four_channel_output_collection_0/v3_four_channel_placement_0/v3_channel_selector_late_promotion_1/v3_selector_route_pilot_0/G0_MUX_NEG/X v3_four_channel_bias_reference_distribution_0/v3_four_channel_phase_distribution_0/v3_four_channel_output_collection_0/v3_four_channel_placement_0/v3_channel_selector_late_promotion_1/VPWR sky130_fd_pr__pfet_01v8_hvt ad=0 pd=0 as=0.26 ps=2.52 w=1 l=0.15
X531 VSUBS v3_four_channel_bias_reference_distribution_0/v3_four_channel_phase_distribution_0/v3_four_channel_output_collection_0/v3_four_channel_placement_0/v3_channel_selector_late_promotion_1/v3_selector_route_pilot_0/G0_MUX_NEG/a_76_199# v3_four_channel_bias_reference_distribution_0/v3_four_channel_phase_distribution_0/v3_four_channel_output_collection_0/v3_four_channel_placement_0/v3_channel_selector_late_promotion_1/v3_selector_route_pilot_0/G0_MUX_NEG/X VSUBS sky130_fd_pr__nfet_01v8 ad=0 pd=0 as=0.169 ps=1.82 w=0.65 l=0.15
X532 v3_four_channel_bias_reference_distribution_0/v3_four_channel_phase_distribution_0/v3_four_channel_output_collection_0/v3_four_channel_placement_0/v3_channel_selector_late_promotion_1/VPWR v3_four_channel_bias_reference_distribution_0/v3_four_channel_phase_distribution_0/v3_four_channel_output_collection_0/v3_four_channel_placement_0/v3_channel_selector_late_promotion_1/v3_selector_route_pilot_0/G2_MUX_AXIS/a_505_21# v3_four_channel_bias_reference_distribution_0/v3_four_channel_phase_distribution_0/v3_four_channel_output_collection_0/v3_four_channel_placement_0/v3_channel_selector_late_promotion_1/v3_selector_route_pilot_0/G2_MUX_AXIS/a_535_374# v3_four_channel_bias_reference_distribution_0/v3_four_channel_phase_distribution_0/v3_four_channel_output_collection_0/v3_four_channel_placement_0/v3_channel_selector_late_promotion_1/VPWR sky130_fd_pr__pfet_01v8_hvt ad=0 pd=0 as=0.0882 ps=1.26 w=0.42 l=0.15
X533 v3_four_channel_bias_reference_distribution_0/v3_four_channel_phase_distribution_0/v3_four_channel_output_collection_0/v3_four_channel_placement_0/v3_channel_selector_late_promotion_1/v3_selector_route_pilot_0/G2_MUX_AXIS/a_505_21# v3_four_channel_bias_reference_distribution_0/v3_four_channel_phase_distribution_0/v3_four_channel_output_collection_0/v3_four_channel_placement_0/v3_channel_selector_late_promotion_1/group2_bit1 v3_four_channel_bias_reference_distribution_0/v3_four_channel_phase_distribution_0/v3_four_channel_output_collection_0/v3_four_channel_placement_0/v3_channel_selector_late_promotion_1/VPWR v3_four_channel_bias_reference_distribution_0/v3_four_channel_phase_distribution_0/v3_four_channel_output_collection_0/v3_four_channel_placement_0/v3_channel_selector_late_promotion_1/VPWR sky130_fd_pr__pfet_01v8_hvt ad=0.1176 pd=1.4 as=0 ps=0 w=0.42 l=0.15
X534 v3_four_channel_bias_reference_distribution_0/v3_four_channel_phase_distribution_0/v3_four_channel_output_collection_0/v3_four_channel_placement_0/v3_channel_selector_late_promotion_1/v3_selector_route_pilot_0/G2_MUX_AXIS/a_218_374# v3_four_channel_bias_reference_distribution_0/v3_four_channel_phase_distribution_0/v3_four_channel_output_collection_0/v3_four_channel_placement_0/v3_channel_selector_late_promotion_1/group2_bit1 v3_four_channel_bias_reference_distribution_0/v3_four_channel_phase_distribution_0/v3_four_channel_output_collection_0/v3_four_channel_placement_0/v3_channel_selector_late_promotion_1/VPWR v3_four_channel_bias_reference_distribution_0/v3_four_channel_phase_distribution_0/v3_four_channel_output_collection_0/v3_four_channel_placement_0/v3_channel_selector_late_promotion_1/VPWR sky130_fd_pr__pfet_01v8_hvt ad=0.1533 pd=1.57 as=0 ps=0 w=0.42 l=0.15
X535 VSUBS v3_four_channel_bias_reference_distribution_0/v3_four_channel_phase_distribution_0/v3_four_channel_output_collection_0/v3_four_channel_placement_0/v3_channel_selector_late_promotion_1/v3_selector_route_pilot_0/G2_MUX_AXIS/a_505_21# v3_four_channel_bias_reference_distribution_0/v3_four_channel_phase_distribution_0/v3_four_channel_output_collection_0/v3_four_channel_placement_0/v3_channel_selector_late_promotion_1/v3_selector_route_pilot_0/G2_MUX_AXIS/a_439_47# VSUBS sky130_fd_pr__nfet_01v8 ad=0 pd=0 as=0.1386 ps=1.5 w=0.42 l=0.15
X536 v3_four_channel_bias_reference_distribution_0/v3_four_channel_phase_distribution_0/v3_four_channel_output_collection_0/v3_four_channel_placement_0/v3_channel_selector_late_promotion_1/v3_selector_route_pilot_0/G2_MUX_AXIS/a_76_199# v3_four_channel_bias_reference_distribution_0/v3_four_channel_phase_distribution_0/v3_four_channel_output_collection_0/v3_four_channel_placement_0/v3_channel_selector_late_promotion_1/v3_selector_route_pilot_0/G2_MUX_POS/X v3_four_channel_bias_reference_distribution_0/v3_four_channel_phase_distribution_0/v3_four_channel_output_collection_0/v3_four_channel_placement_0/v3_channel_selector_late_promotion_1/v3_selector_route_pilot_0/G2_MUX_AXIS/a_218_374# v3_four_channel_bias_reference_distribution_0/v3_four_channel_phase_distribution_0/v3_four_channel_output_collection_0/v3_four_channel_placement_0/v3_channel_selector_late_promotion_1/VPWR sky130_fd_pr__pfet_01v8_hvt ad=0.3864 pd=2.68 as=0 ps=0 w=0.42 l=0.15
X537 v3_four_channel_bias_reference_distribution_0/v3_four_channel_phase_distribution_0/v3_four_channel_output_collection_0/v3_four_channel_placement_0/v3_channel_selector_late_promotion_1/v3_selector_route_pilot_0/G2_MUX_AXIS/a_505_21# v3_four_channel_bias_reference_distribution_0/v3_four_channel_phase_distribution_0/v3_four_channel_output_collection_0/v3_four_channel_placement_0/v3_channel_selector_late_promotion_1/group2_bit1 VSUBS VSUBS sky130_fd_pr__nfet_01v8 ad=0.1092 pd=1.36 as=0 ps=0 w=0.42 l=0.15
X538 v3_four_channel_bias_reference_distribution_0/v3_four_channel_phase_distribution_0/v3_four_channel_output_collection_0/v3_four_channel_placement_0/v3_channel_selector_late_promotion_1/v3_selector_route_pilot_0/G2_MUX_AXIS/a_439_47# v3_four_channel_bias_reference_distribution_0/v3_four_channel_phase_distribution_0/v3_four_channel_output_collection_0/v3_four_channel_placement_0/v3_channel_selector_late_promotion_1/v3_selector_route_pilot_0/G2_MUX_POS/X v3_four_channel_bias_reference_distribution_0/v3_four_channel_phase_distribution_0/v3_four_channel_output_collection_0/v3_four_channel_placement_0/v3_channel_selector_late_promotion_1/v3_selector_route_pilot_0/G2_MUX_AXIS/a_76_199# VSUBS sky130_fd_pr__nfet_01v8 ad=0 pd=0 as=0.1995 ps=1.79 w=0.42 l=0.15
X539 v3_four_channel_bias_reference_distribution_0/v3_four_channel_phase_distribution_0/v3_four_channel_output_collection_0/v3_four_channel_placement_0/v3_channel_selector_late_promotion_1/v3_selector_route_pilot_0/G2_MUX_AXIS/a_535_374# v3_four_channel_bias_reference_distribution_0/v3_four_channel_phase_distribution_0/v3_four_channel_output_collection_0/v3_four_channel_placement_0/v3_channel_selector_late_promotion_1/v3_selector_route_pilot_0/G2_MUX_NEG/X v3_four_channel_bias_reference_distribution_0/v3_four_channel_phase_distribution_0/v3_four_channel_output_collection_0/v3_four_channel_placement_0/v3_channel_selector_late_promotion_1/v3_selector_route_pilot_0/G2_MUX_AXIS/a_76_199# v3_four_channel_bias_reference_distribution_0/v3_four_channel_phase_distribution_0/v3_four_channel_output_collection_0/v3_four_channel_placement_0/v3_channel_selector_late_promotion_1/VPWR sky130_fd_pr__pfet_01v8_hvt ad=0 pd=0 as=0 ps=0 w=0.42 l=0.15
X540 v3_four_channel_bias_reference_distribution_0/v3_four_channel_phase_distribution_0/v3_four_channel_output_collection_0/v3_four_channel_placement_0/v3_channel_selector_late_promotion_1/v3_selector_route_pilot_0/G2_MUX_AXIS/a_76_199# v3_four_channel_bias_reference_distribution_0/v3_four_channel_phase_distribution_0/v3_four_channel_output_collection_0/v3_four_channel_placement_0/v3_channel_selector_late_promotion_1/v3_selector_route_pilot_0/G2_MUX_NEG/X v3_four_channel_bias_reference_distribution_0/v3_four_channel_phase_distribution_0/v3_four_channel_output_collection_0/v3_four_channel_placement_0/v3_channel_selector_late_promotion_1/v3_selector_route_pilot_0/G2_MUX_AXIS/a_218_47# VSUBS sky130_fd_pr__nfet_01v8 ad=0 pd=0 as=0.1386 ps=1.5 w=0.42 l=0.15
X541 v3_four_channel_bias_reference_distribution_0/v3_four_channel_phase_distribution_0/v3_four_channel_output_collection_0/v3_four_channel_placement_0/v3_channel_selector_late_promotion_1/v3_selector_route_pilot_0/G2_MUX_AXIS/a_218_47# v3_four_channel_bias_reference_distribution_0/v3_four_channel_phase_distribution_0/v3_four_channel_output_collection_0/v3_four_channel_placement_0/v3_channel_selector_late_promotion_1/group2_bit1 VSUBS VSUBS sky130_fd_pr__nfet_01v8 ad=0 pd=0 as=0 ps=0 w=0.42 l=0.15
X542 v3_four_channel_bias_reference_distribution_0/v3_four_channel_phase_distribution_0/v3_four_channel_output_collection_0/v3_four_channel_placement_0/v3_channel_selector_late_promotion_1/VPWR v3_four_channel_bias_reference_distribution_0/v3_four_channel_phase_distribution_0/v3_four_channel_output_collection_0/v3_four_channel_placement_0/v3_channel_selector_late_promotion_1/v3_selector_route_pilot_0/G2_MUX_AXIS/a_76_199# v3_four_channel_bias_reference_distribution_0/v3_four_channel_phase_distribution_0/v3_four_channel_output_collection_0/v3_four_channel_placement_0/v3_channel_selector_late_promotion_1/v3_selector_route_pilot_0/G2_MUX_AXIS/X v3_four_channel_bias_reference_distribution_0/v3_four_channel_phase_distribution_0/v3_four_channel_output_collection_0/v3_four_channel_placement_0/v3_channel_selector_late_promotion_1/VPWR sky130_fd_pr__pfet_01v8_hvt ad=0 pd=0 as=0.26 ps=2.52 w=1 l=0.15
X543 VSUBS v3_four_channel_bias_reference_distribution_0/v3_four_channel_phase_distribution_0/v3_four_channel_output_collection_0/v3_four_channel_placement_0/v3_channel_selector_late_promotion_1/v3_selector_route_pilot_0/G2_MUX_AXIS/a_76_199# v3_four_channel_bias_reference_distribution_0/v3_four_channel_phase_distribution_0/v3_four_channel_output_collection_0/v3_four_channel_placement_0/v3_channel_selector_late_promotion_1/v3_selector_route_pilot_0/G2_MUX_AXIS/X VSUBS sky130_fd_pr__nfet_01v8 ad=0 pd=0 as=0.169 ps=1.82 w=0.65 l=0.15
X544 v3_four_channel_bias_reference_distribution_0/v3_four_channel_phase_distribution_0/v3_four_channel_output_collection_0/v3_four_channel_placement_0/v3_channel_selector_late_promotion_1/VPWR v3_four_channel_bias_reference_distribution_0/v3_four_channel_phase_distribution_0/v3_four_channel_output_collection_0/v3_four_channel_placement_0/v3_channel_selector_late_promotion_1/v3_selector_route_pilot_0/G3_MUX_POS/a_505_21# v3_four_channel_bias_reference_distribution_0/v3_four_channel_phase_distribution_0/v3_four_channel_output_collection_0/v3_four_channel_placement_0/v3_channel_selector_late_promotion_1/v3_selector_route_pilot_0/G3_MUX_POS/a_535_374# v3_four_channel_bias_reference_distribution_0/v3_four_channel_phase_distribution_0/v3_four_channel_output_collection_0/v3_four_channel_placement_0/v3_channel_selector_late_promotion_1/VPWR sky130_fd_pr__pfet_01v8_hvt ad=0 pd=0 as=0.0882 ps=1.26 w=0.42 l=0.15
X545 v3_four_channel_bias_reference_distribution_0/v3_four_channel_phase_distribution_0/v3_four_channel_output_collection_0/v3_four_channel_placement_0/v3_channel_selector_late_promotion_1/v3_selector_route_pilot_0/G3_MUX_POS/a_505_21# v3_four_channel_bias_reference_distribution_0/v3_four_channel_phase_distribution_0/v3_four_channel_output_collection_0/v3_four_channel_placement_0/v3_channel_selector_late_promotion_1/group3_bit0 v3_four_channel_bias_reference_distribution_0/v3_four_channel_phase_distribution_0/v3_four_channel_output_collection_0/v3_four_channel_placement_0/v3_channel_selector_late_promotion_1/VPWR v3_four_channel_bias_reference_distribution_0/v3_four_channel_phase_distribution_0/v3_four_channel_output_collection_0/v3_four_channel_placement_0/v3_channel_selector_late_promotion_1/VPWR sky130_fd_pr__pfet_01v8_hvt ad=0.1176 pd=1.4 as=0 ps=0 w=0.42 l=0.15
X546 v3_four_channel_bias_reference_distribution_0/v3_four_channel_phase_distribution_0/v3_four_channel_output_collection_0/v3_four_channel_placement_0/v3_channel_selector_late_promotion_1/v3_selector_route_pilot_0/G3_MUX_POS/a_218_374# v3_four_channel_bias_reference_distribution_0/v3_four_channel_phase_distribution_0/v3_four_channel_output_collection_0/v3_four_channel_placement_0/v3_channel_selector_late_promotion_1/group3_bit0 v3_four_channel_bias_reference_distribution_0/v3_four_channel_phase_distribution_0/v3_four_channel_output_collection_0/v3_four_channel_placement_0/v3_channel_selector_late_promotion_1/VPWR v3_four_channel_bias_reference_distribution_0/v3_four_channel_phase_distribution_0/v3_four_channel_output_collection_0/v3_four_channel_placement_0/v3_channel_selector_late_promotion_1/VPWR sky130_fd_pr__pfet_01v8_hvt ad=0.1533 pd=1.57 as=0 ps=0 w=0.42 l=0.15
X547 VSUBS v3_four_channel_bias_reference_distribution_0/v3_four_channel_phase_distribution_0/v3_four_channel_output_collection_0/v3_four_channel_placement_0/v3_channel_selector_late_promotion_1/v3_selector_route_pilot_0/G3_MUX_POS/a_505_21# v3_four_channel_bias_reference_distribution_0/v3_four_channel_phase_distribution_0/v3_four_channel_output_collection_0/v3_four_channel_placement_0/v3_channel_selector_late_promotion_1/v3_selector_route_pilot_0/G3_MUX_POS/a_439_47# VSUBS sky130_fd_pr__nfet_01v8 ad=0 pd=0 as=0.1386 ps=1.5 w=0.42 l=0.15
X548 v3_four_channel_bias_reference_distribution_0/v3_four_channel_phase_distribution_0/v3_four_channel_output_collection_0/v3_four_channel_placement_0/v3_channel_selector_late_promotion_1/v3_selector_route_pilot_0/G3_MUX_POS/a_76_199# v3_four_channel_bias_reference_distribution_0/v3_four_channel_phase_distribution_0/phase_0 v3_four_channel_bias_reference_distribution_0/v3_four_channel_phase_distribution_0/v3_four_channel_output_collection_0/v3_four_channel_placement_0/v3_channel_selector_late_promotion_1/v3_selector_route_pilot_0/G3_MUX_POS/a_218_374# v3_four_channel_bias_reference_distribution_0/v3_four_channel_phase_distribution_0/v3_four_channel_output_collection_0/v3_four_channel_placement_0/v3_channel_selector_late_promotion_1/VPWR sky130_fd_pr__pfet_01v8_hvt ad=0.3864 pd=2.68 as=0 ps=0 w=0.42 l=0.15
X549 v3_four_channel_bias_reference_distribution_0/v3_four_channel_phase_distribution_0/v3_four_channel_output_collection_0/v3_four_channel_placement_0/v3_channel_selector_late_promotion_1/v3_selector_route_pilot_0/G3_MUX_POS/a_505_21# v3_four_channel_bias_reference_distribution_0/v3_four_channel_phase_distribution_0/v3_four_channel_output_collection_0/v3_four_channel_placement_0/v3_channel_selector_late_promotion_1/group3_bit0 VSUBS VSUBS sky130_fd_pr__nfet_01v8 ad=0.1092 pd=1.36 as=0 ps=0 w=0.42 l=0.15
X550 v3_four_channel_bias_reference_distribution_0/v3_four_channel_phase_distribution_0/v3_four_channel_output_collection_0/v3_four_channel_placement_0/v3_channel_selector_late_promotion_1/v3_selector_route_pilot_0/G3_MUX_POS/a_439_47# v3_four_channel_bias_reference_distribution_0/v3_four_channel_phase_distribution_0/phase_0 v3_four_channel_bias_reference_distribution_0/v3_four_channel_phase_distribution_0/v3_four_channel_output_collection_0/v3_four_channel_placement_0/v3_channel_selector_late_promotion_1/v3_selector_route_pilot_0/G3_MUX_POS/a_76_199# VSUBS sky130_fd_pr__nfet_01v8 ad=0 pd=0 as=0.1995 ps=1.79 w=0.42 l=0.15
X551 v3_four_channel_bias_reference_distribution_0/v3_four_channel_phase_distribution_0/v3_four_channel_output_collection_0/v3_four_channel_placement_0/v3_channel_selector_late_promotion_1/v3_selector_route_pilot_0/G3_MUX_POS/a_535_374# v3_four_channel_bias_reference_distribution_0/v3_four_channel_phase_distribution_0/phase_90 v3_four_channel_bias_reference_distribution_0/v3_four_channel_phase_distribution_0/v3_four_channel_output_collection_0/v3_four_channel_placement_0/v3_channel_selector_late_promotion_1/v3_selector_route_pilot_0/G3_MUX_POS/a_76_199# v3_four_channel_bias_reference_distribution_0/v3_four_channel_phase_distribution_0/v3_four_channel_output_collection_0/v3_four_channel_placement_0/v3_channel_selector_late_promotion_1/VPWR sky130_fd_pr__pfet_01v8_hvt ad=0 pd=0 as=0 ps=0 w=0.42 l=0.15
X552 v3_four_channel_bias_reference_distribution_0/v3_four_channel_phase_distribution_0/v3_four_channel_output_collection_0/v3_four_channel_placement_0/v3_channel_selector_late_promotion_1/v3_selector_route_pilot_0/G3_MUX_POS/a_76_199# v3_four_channel_bias_reference_distribution_0/v3_four_channel_phase_distribution_0/phase_90 v3_four_channel_bias_reference_distribution_0/v3_four_channel_phase_distribution_0/v3_four_channel_output_collection_0/v3_four_channel_placement_0/v3_channel_selector_late_promotion_1/v3_selector_route_pilot_0/G3_MUX_POS/a_218_47# VSUBS sky130_fd_pr__nfet_01v8 ad=0 pd=0 as=0.1386 ps=1.5 w=0.42 l=0.15
X553 v3_four_channel_bias_reference_distribution_0/v3_four_channel_phase_distribution_0/v3_four_channel_output_collection_0/v3_four_channel_placement_0/v3_channel_selector_late_promotion_1/v3_selector_route_pilot_0/G3_MUX_POS/a_218_47# v3_four_channel_bias_reference_distribution_0/v3_four_channel_phase_distribution_0/v3_four_channel_output_collection_0/v3_four_channel_placement_0/v3_channel_selector_late_promotion_1/group3_bit0 VSUBS VSUBS sky130_fd_pr__nfet_01v8 ad=0 pd=0 as=0 ps=0 w=0.42 l=0.15
X554 v3_four_channel_bias_reference_distribution_0/v3_four_channel_phase_distribution_0/v3_four_channel_output_collection_0/v3_four_channel_placement_0/v3_channel_selector_late_promotion_1/VPWR v3_four_channel_bias_reference_distribution_0/v3_four_channel_phase_distribution_0/v3_four_channel_output_collection_0/v3_four_channel_placement_0/v3_channel_selector_late_promotion_1/v3_selector_route_pilot_0/G3_MUX_POS/a_76_199# v3_four_channel_bias_reference_distribution_0/v3_four_channel_phase_distribution_0/v3_four_channel_output_collection_0/v3_four_channel_placement_0/v3_channel_selector_late_promotion_1/v3_selector_route_pilot_0/G3_MUX_POS/X v3_four_channel_bias_reference_distribution_0/v3_four_channel_phase_distribution_0/v3_four_channel_output_collection_0/v3_four_channel_placement_0/v3_channel_selector_late_promotion_1/VPWR sky130_fd_pr__pfet_01v8_hvt ad=0 pd=0 as=0.26 ps=2.52 w=1 l=0.15
X555 VSUBS v3_four_channel_bias_reference_distribution_0/v3_four_channel_phase_distribution_0/v3_four_channel_output_collection_0/v3_four_channel_placement_0/v3_channel_selector_late_promotion_1/v3_selector_route_pilot_0/G3_MUX_POS/a_76_199# v3_four_channel_bias_reference_distribution_0/v3_four_channel_phase_distribution_0/v3_four_channel_output_collection_0/v3_four_channel_placement_0/v3_channel_selector_late_promotion_1/v3_selector_route_pilot_0/G3_MUX_POS/X VSUBS sky130_fd_pr__nfet_01v8 ad=0 pd=0 as=0.169 ps=1.82 w=0.65 l=0.15
X556 v3_four_channel_bias_reference_distribution_0/v3_four_channel_phase_distribution_0/v3_four_channel_output_collection_0/v3_four_channel_placement_0/v3_channel_selector_late_promotion_1/VPWR v3_four_channel_bias_reference_distribution_0/v3_four_channel_phase_distribution_0/v3_four_channel_output_collection_0/v3_four_channel_placement_0/v3_channel_selector_late_promotion_1/v3_selector_route_pilot_0/G3_MUX_NEG/a_505_21# v3_four_channel_bias_reference_distribution_0/v3_four_channel_phase_distribution_0/v3_four_channel_output_collection_0/v3_four_channel_placement_0/v3_channel_selector_late_promotion_1/v3_selector_route_pilot_0/G3_MUX_NEG/a_535_374# v3_four_channel_bias_reference_distribution_0/v3_four_channel_phase_distribution_0/v3_four_channel_output_collection_0/v3_four_channel_placement_0/v3_channel_selector_late_promotion_1/VPWR sky130_fd_pr__pfet_01v8_hvt ad=0 pd=0 as=0.0882 ps=1.26 w=0.42 l=0.15
X557 v3_four_channel_bias_reference_distribution_0/v3_four_channel_phase_distribution_0/v3_four_channel_output_collection_0/v3_four_channel_placement_0/v3_channel_selector_late_promotion_1/v3_selector_route_pilot_0/G3_MUX_NEG/a_505_21# v3_four_channel_bias_reference_distribution_0/v3_four_channel_phase_distribution_0/v3_four_channel_output_collection_0/v3_four_channel_placement_0/v3_channel_selector_late_promotion_1/group3_bit0 v3_four_channel_bias_reference_distribution_0/v3_four_channel_phase_distribution_0/v3_four_channel_output_collection_0/v3_four_channel_placement_0/v3_channel_selector_late_promotion_1/VPWR v3_four_channel_bias_reference_distribution_0/v3_four_channel_phase_distribution_0/v3_four_channel_output_collection_0/v3_four_channel_placement_0/v3_channel_selector_late_promotion_1/VPWR sky130_fd_pr__pfet_01v8_hvt ad=0.1176 pd=1.4 as=0 ps=0 w=0.42 l=0.15
X558 v3_four_channel_bias_reference_distribution_0/v3_four_channel_phase_distribution_0/v3_four_channel_output_collection_0/v3_four_channel_placement_0/v3_channel_selector_late_promotion_1/v3_selector_route_pilot_0/G3_MUX_NEG/a_218_374# v3_four_channel_bias_reference_distribution_0/v3_four_channel_phase_distribution_0/v3_four_channel_output_collection_0/v3_four_channel_placement_0/v3_channel_selector_late_promotion_1/group3_bit0 v3_four_channel_bias_reference_distribution_0/v3_four_channel_phase_distribution_0/v3_four_channel_output_collection_0/v3_four_channel_placement_0/v3_channel_selector_late_promotion_1/VPWR v3_four_channel_bias_reference_distribution_0/v3_four_channel_phase_distribution_0/v3_four_channel_output_collection_0/v3_four_channel_placement_0/v3_channel_selector_late_promotion_1/VPWR sky130_fd_pr__pfet_01v8_hvt ad=0.1533 pd=1.57 as=0 ps=0 w=0.42 l=0.15
X559 VSUBS v3_four_channel_bias_reference_distribution_0/v3_four_channel_phase_distribution_0/v3_four_channel_output_collection_0/v3_four_channel_placement_0/v3_channel_selector_late_promotion_1/v3_selector_route_pilot_0/G3_MUX_NEG/a_505_21# v3_four_channel_bias_reference_distribution_0/v3_four_channel_phase_distribution_0/v3_four_channel_output_collection_0/v3_four_channel_placement_0/v3_channel_selector_late_promotion_1/v3_selector_route_pilot_0/G3_MUX_NEG/a_439_47# VSUBS sky130_fd_pr__nfet_01v8 ad=0 pd=0 as=0.1386 ps=1.5 w=0.42 l=0.15
X560 v3_four_channel_bias_reference_distribution_0/v3_four_channel_phase_distribution_0/v3_four_channel_output_collection_0/v3_four_channel_placement_0/v3_channel_selector_late_promotion_1/v3_selector_route_pilot_0/G3_MUX_NEG/a_76_199# v3_four_channel_bias_reference_distribution_0/v3_four_channel_phase_distribution_0/phase_180 v3_four_channel_bias_reference_distribution_0/v3_four_channel_phase_distribution_0/v3_four_channel_output_collection_0/v3_four_channel_placement_0/v3_channel_selector_late_promotion_1/v3_selector_route_pilot_0/G3_MUX_NEG/a_218_374# v3_four_channel_bias_reference_distribution_0/v3_four_channel_phase_distribution_0/v3_four_channel_output_collection_0/v3_four_channel_placement_0/v3_channel_selector_late_promotion_1/VPWR sky130_fd_pr__pfet_01v8_hvt ad=0.3864 pd=2.68 as=0 ps=0 w=0.42 l=0.15
X561 v3_four_channel_bias_reference_distribution_0/v3_four_channel_phase_distribution_0/v3_four_channel_output_collection_0/v3_four_channel_placement_0/v3_channel_selector_late_promotion_1/v3_selector_route_pilot_0/G3_MUX_NEG/a_505_21# v3_four_channel_bias_reference_distribution_0/v3_four_channel_phase_distribution_0/v3_four_channel_output_collection_0/v3_four_channel_placement_0/v3_channel_selector_late_promotion_1/group3_bit0 VSUBS VSUBS sky130_fd_pr__nfet_01v8 ad=0.1092 pd=1.36 as=0 ps=0 w=0.42 l=0.15
X562 v3_four_channel_bias_reference_distribution_0/v3_four_channel_phase_distribution_0/v3_four_channel_output_collection_0/v3_four_channel_placement_0/v3_channel_selector_late_promotion_1/v3_selector_route_pilot_0/G3_MUX_NEG/a_439_47# v3_four_channel_bias_reference_distribution_0/v3_four_channel_phase_distribution_0/phase_180 v3_four_channel_bias_reference_distribution_0/v3_four_channel_phase_distribution_0/v3_four_channel_output_collection_0/v3_four_channel_placement_0/v3_channel_selector_late_promotion_1/v3_selector_route_pilot_0/G3_MUX_NEG/a_76_199# VSUBS sky130_fd_pr__nfet_01v8 ad=0 pd=0 as=0.1995 ps=1.79 w=0.42 l=0.15
X563 v3_four_channel_bias_reference_distribution_0/v3_four_channel_phase_distribution_0/v3_four_channel_output_collection_0/v3_four_channel_placement_0/v3_channel_selector_late_promotion_1/v3_selector_route_pilot_0/G3_MUX_NEG/a_535_374# v3_four_channel_bias_reference_distribution_0/v3_four_channel_phase_distribution_0/phase_270 v3_four_channel_bias_reference_distribution_0/v3_four_channel_phase_distribution_0/v3_four_channel_output_collection_0/v3_four_channel_placement_0/v3_channel_selector_late_promotion_1/v3_selector_route_pilot_0/G3_MUX_NEG/a_76_199# v3_four_channel_bias_reference_distribution_0/v3_four_channel_phase_distribution_0/v3_four_channel_output_collection_0/v3_four_channel_placement_0/v3_channel_selector_late_promotion_1/VPWR sky130_fd_pr__pfet_01v8_hvt ad=0 pd=0 as=0 ps=0 w=0.42 l=0.15
X564 v3_four_channel_bias_reference_distribution_0/v3_four_channel_phase_distribution_0/v3_four_channel_output_collection_0/v3_four_channel_placement_0/v3_channel_selector_late_promotion_1/v3_selector_route_pilot_0/G3_MUX_NEG/a_76_199# v3_four_channel_bias_reference_distribution_0/v3_four_channel_phase_distribution_0/phase_270 v3_four_channel_bias_reference_distribution_0/v3_four_channel_phase_distribution_0/v3_four_channel_output_collection_0/v3_four_channel_placement_0/v3_channel_selector_late_promotion_1/v3_selector_route_pilot_0/G3_MUX_NEG/a_218_47# VSUBS sky130_fd_pr__nfet_01v8 ad=0 pd=0 as=0.1386 ps=1.5 w=0.42 l=0.15
X565 v3_four_channel_bias_reference_distribution_0/v3_four_channel_phase_distribution_0/v3_four_channel_output_collection_0/v3_four_channel_placement_0/v3_channel_selector_late_promotion_1/v3_selector_route_pilot_0/G3_MUX_NEG/a_218_47# v3_four_channel_bias_reference_distribution_0/v3_four_channel_phase_distribution_0/v3_four_channel_output_collection_0/v3_four_channel_placement_0/v3_channel_selector_late_promotion_1/group3_bit0 VSUBS VSUBS sky130_fd_pr__nfet_01v8 ad=0 pd=0 as=0 ps=0 w=0.42 l=0.15
X566 v3_four_channel_bias_reference_distribution_0/v3_four_channel_phase_distribution_0/v3_four_channel_output_collection_0/v3_four_channel_placement_0/v3_channel_selector_late_promotion_1/VPWR v3_four_channel_bias_reference_distribution_0/v3_four_channel_phase_distribution_0/v3_four_channel_output_collection_0/v3_four_channel_placement_0/v3_channel_selector_late_promotion_1/v3_selector_route_pilot_0/G3_MUX_NEG/a_76_199# v3_four_channel_bias_reference_distribution_0/v3_four_channel_phase_distribution_0/v3_four_channel_output_collection_0/v3_four_channel_placement_0/v3_channel_selector_late_promotion_1/v3_selector_route_pilot_0/G3_MUX_NEG/X v3_four_channel_bias_reference_distribution_0/v3_four_channel_phase_distribution_0/v3_four_channel_output_collection_0/v3_four_channel_placement_0/v3_channel_selector_late_promotion_1/VPWR sky130_fd_pr__pfet_01v8_hvt ad=0 pd=0 as=0.26 ps=2.52 w=1 l=0.15
X567 VSUBS v3_four_channel_bias_reference_distribution_0/v3_four_channel_phase_distribution_0/v3_four_channel_output_collection_0/v3_four_channel_placement_0/v3_channel_selector_late_promotion_1/v3_selector_route_pilot_0/G3_MUX_NEG/a_76_199# v3_four_channel_bias_reference_distribution_0/v3_four_channel_phase_distribution_0/v3_four_channel_output_collection_0/v3_four_channel_placement_0/v3_channel_selector_late_promotion_1/v3_selector_route_pilot_0/G3_MUX_NEG/X VSUBS sky130_fd_pr__nfet_01v8 ad=0 pd=0 as=0.169 ps=1.82 w=0.65 l=0.15
X568 v3_four_channel_bias_reference_distribution_0/v3_four_channel_phase_distribution_0/v3_four_channel_output_collection_0/v3_four_channel_placement_0/v3_channel_selector_late_promotion_1/VPWR v3_four_channel_bias_reference_distribution_0/v3_four_channel_phase_distribution_0/v3_four_channel_output_collection_0/v3_four_channel_placement_0/v3_channel_selector_late_promotion_1/v3_selector_route_pilot_0/G3_LO_P_AND/B v3_four_channel_bias_reference_distribution_0/v3_four_channel_phase_distribution_0/v3_four_channel_output_collection_0/v3_four_channel_placement_0/v3_channel_selector_late_promotion_1/v3_selector_route_pilot_0/G0_LO_P_AND/a_59_75# v3_four_channel_bias_reference_distribution_0/v3_four_channel_phase_distribution_0/v3_four_channel_output_collection_0/v3_four_channel_placement_0/v3_channel_selector_late_promotion_1/VPWR sky130_fd_pr__pfet_01v8_hvt ad=0 pd=0 as=0.1134 ps=1.38 w=0.42 l=0.15
X569 v3_four_channel_bias_reference_distribution_0/v3_four_channel_phase_distribution_0/v3_four_channel_output_collection_0/v3_four_channel_placement_0/v3_channel_selector_late_promotion_1/v3_selector_route_pilot_0/group0_lo_p v3_four_channel_bias_reference_distribution_0/v3_four_channel_phase_distribution_0/v3_four_channel_output_collection_0/v3_four_channel_placement_0/v3_channel_selector_late_promotion_1/v3_selector_route_pilot_0/G0_LO_P_AND/a_59_75# v3_four_channel_bias_reference_distribution_0/v3_four_channel_phase_distribution_0/v3_four_channel_output_collection_0/v3_four_channel_placement_0/v3_channel_selector_late_promotion_1/VPWR v3_four_channel_bias_reference_distribution_0/v3_four_channel_phase_distribution_0/v3_four_channel_output_collection_0/v3_four_channel_placement_0/v3_channel_selector_late_promotion_1/VPWR sky130_fd_pr__pfet_01v8_hvt ad=0.475 pd=2.95 as=0 ps=0 w=1 l=0.15
X570 VSUBS v3_four_channel_bias_reference_distribution_0/v3_four_channel_phase_distribution_0/v3_four_channel_output_collection_0/v3_four_channel_placement_0/v3_channel_selector_late_promotion_1/v3_selector_route_pilot_0/G3_LO_P_AND/B v3_four_channel_bias_reference_distribution_0/v3_four_channel_phase_distribution_0/v3_four_channel_output_collection_0/v3_four_channel_placement_0/v3_channel_selector_late_promotion_1/v3_selector_route_pilot_0/G0_LO_P_AND/a_145_75# VSUBS sky130_fd_pr__nfet_01v8 ad=0 pd=0 as=0.1134 ps=1.38 w=0.42 l=0.15
X571 v3_four_channel_bias_reference_distribution_0/v3_four_channel_phase_distribution_0/v3_four_channel_output_collection_0/v3_four_channel_placement_0/v3_channel_selector_late_promotion_1/v3_selector_route_pilot_0/G0_LO_P_AND/a_59_75# v3_four_channel_bias_reference_distribution_0/v3_four_channel_phase_distribution_0/v3_four_channel_output_collection_0/v3_four_channel_placement_0/v3_channel_selector_late_promotion_1/v3_selector_route_pilot_0/G0_MUX_AXIS/X v3_four_channel_bias_reference_distribution_0/v3_four_channel_phase_distribution_0/v3_four_channel_output_collection_0/v3_four_channel_placement_0/v3_channel_selector_late_promotion_1/VPWR v3_four_channel_bias_reference_distribution_0/v3_four_channel_phase_distribution_0/v3_four_channel_output_collection_0/v3_four_channel_placement_0/v3_channel_selector_late_promotion_1/VPWR sky130_fd_pr__pfet_01v8_hvt ad=0 pd=0 as=0 ps=0 w=0.42 l=0.15
X572 v3_four_channel_bias_reference_distribution_0/v3_four_channel_phase_distribution_0/v3_four_channel_output_collection_0/v3_four_channel_placement_0/v3_channel_selector_late_promotion_1/v3_selector_route_pilot_0/group0_lo_p v3_four_channel_bias_reference_distribution_0/v3_four_channel_phase_distribution_0/v3_four_channel_output_collection_0/v3_four_channel_placement_0/v3_channel_selector_late_promotion_1/v3_selector_route_pilot_0/G0_LO_P_AND/a_59_75# VSUBS VSUBS sky130_fd_pr__nfet_01v8 ad=0.182 pd=1.86 as=0 ps=0 w=0.65 l=0.15
X573 v3_four_channel_bias_reference_distribution_0/v3_four_channel_phase_distribution_0/v3_four_channel_output_collection_0/v3_four_channel_placement_0/v3_channel_selector_late_promotion_1/v3_selector_route_pilot_0/G0_LO_P_AND/a_145_75# v3_four_channel_bias_reference_distribution_0/v3_four_channel_phase_distribution_0/v3_four_channel_output_collection_0/v3_four_channel_placement_0/v3_channel_selector_late_promotion_1/v3_selector_route_pilot_0/G0_MUX_AXIS/X v3_four_channel_bias_reference_distribution_0/v3_four_channel_phase_distribution_0/v3_four_channel_output_collection_0/v3_four_channel_placement_0/v3_channel_selector_late_promotion_1/v3_selector_route_pilot_0/G0_LO_P_AND/a_59_75# VSUBS sky130_fd_pr__nfet_01v8 ad=0 pd=0 as=0.1176 ps=1.4 w=0.42 l=0.15
X574 v3_four_channel_bias_reference_distribution_0/v3_four_channel_phase_distribution_0/v3_four_channel_output_collection_0/v3_four_channel_placement_0/v3_channel_selector_late_promotion_1/VPWR v3_four_channel_bias_reference_distribution_0/v3_four_channel_phase_distribution_0/v3_four_channel_output_collection_0/v3_four_channel_placement_0/v3_channel_selector_late_promotion_1/v3_selector_route_pilot_0/G3_LO_P_AND/B v3_four_channel_bias_reference_distribution_0/v3_four_channel_phase_distribution_0/v3_four_channel_output_collection_0/v3_four_channel_placement_0/v3_channel_selector_late_promotion_1/v3_selector_route_pilot_0/G3_LO_N_ANDNOT/a_207_413# v3_four_channel_bias_reference_distribution_0/v3_four_channel_phase_distribution_0/v3_four_channel_output_collection_0/v3_four_channel_placement_0/v3_channel_selector_late_promotion_1/VPWR sky130_fd_pr__pfet_01v8_hvt ad=0 pd=0 as=0.1218 ps=1.42 w=0.42 l=0.15
X575 v3_four_channel_bias_reference_distribution_0/v3_four_channel_phase_distribution_0/v3_four_channel_output_collection_0/v3_four_channel_placement_0/v3_channel_selector_late_promotion_1/v3_selector_route_pilot_0/group3_lo_n v3_four_channel_bias_reference_distribution_0/v3_four_channel_phase_distribution_0/v3_four_channel_output_collection_0/v3_four_channel_placement_0/v3_channel_selector_late_promotion_1/v3_selector_route_pilot_0/G3_LO_N_ANDNOT/a_207_413# v3_four_channel_bias_reference_distribution_0/v3_four_channel_phase_distribution_0/v3_four_channel_output_collection_0/v3_four_channel_placement_0/v3_channel_selector_late_promotion_1/VPWR v3_four_channel_bias_reference_distribution_0/v3_four_channel_phase_distribution_0/v3_four_channel_output_collection_0/v3_four_channel_placement_0/v3_channel_selector_late_promotion_1/VPWR sky130_fd_pr__pfet_01v8_hvt ad=0.26 pd=2.52 as=0 ps=0 w=1 l=0.15
X576 v3_four_channel_bias_reference_distribution_0/v3_four_channel_phase_distribution_0/v3_four_channel_output_collection_0/v3_four_channel_placement_0/v3_channel_selector_late_promotion_1/v3_selector_route_pilot_0/G3_LO_N_ANDNOT/a_297_47# v3_four_channel_bias_reference_distribution_0/v3_four_channel_phase_distribution_0/v3_four_channel_output_collection_0/v3_four_channel_placement_0/v3_channel_selector_late_promotion_1/v3_selector_route_pilot_0/G3_LO_N_ANDNOT/a_27_413# v3_four_channel_bias_reference_distribution_0/v3_four_channel_phase_distribution_0/v3_four_channel_output_collection_0/v3_four_channel_placement_0/v3_channel_selector_late_promotion_1/v3_selector_route_pilot_0/G3_LO_N_ANDNOT/a_207_413# VSUBS sky130_fd_pr__nfet_01v8 ad=0.1008 pd=1.32 as=0.1092 ps=1.36 w=0.42 l=0.15
X577 v3_four_channel_bias_reference_distribution_0/v3_four_channel_phase_distribution_0/v3_four_channel_output_collection_0/v3_four_channel_placement_0/v3_channel_selector_late_promotion_1/v3_selector_route_pilot_0/group3_lo_n v3_four_channel_bias_reference_distribution_0/v3_four_channel_phase_distribution_0/v3_four_channel_output_collection_0/v3_four_channel_placement_0/v3_channel_selector_late_promotion_1/v3_selector_route_pilot_0/G3_LO_N_ANDNOT/a_207_413# VSUBS VSUBS sky130_fd_pr__nfet_01v8 ad=0.169 pd=1.82 as=0 ps=0 w=0.65 l=0.15
X578 v3_four_channel_bias_reference_distribution_0/v3_four_channel_phase_distribution_0/v3_four_channel_output_collection_0/v3_four_channel_placement_0/v3_channel_selector_late_promotion_1/v3_selector_route_pilot_0/G3_LO_N_ANDNOT/a_207_413# v3_four_channel_bias_reference_distribution_0/v3_four_channel_phase_distribution_0/v3_four_channel_output_collection_0/v3_four_channel_placement_0/v3_channel_selector_late_promotion_1/v3_selector_route_pilot_0/G3_LO_N_ANDNOT/a_27_413# v3_four_channel_bias_reference_distribution_0/v3_four_channel_phase_distribution_0/v3_four_channel_output_collection_0/v3_four_channel_placement_0/v3_channel_selector_late_promotion_1/VPWR v3_four_channel_bias_reference_distribution_0/v3_four_channel_phase_distribution_0/v3_four_channel_output_collection_0/v3_four_channel_placement_0/v3_channel_selector_late_promotion_1/VPWR sky130_fd_pr__pfet_01v8_hvt ad=0 pd=0 as=0 ps=0 w=0.42 l=0.15
X579 v3_four_channel_bias_reference_distribution_0/v3_four_channel_phase_distribution_0/v3_four_channel_output_collection_0/v3_four_channel_placement_0/v3_channel_selector_late_promotion_1/VPWR v3_four_channel_bias_reference_distribution_0/v3_four_channel_phase_distribution_0/v3_four_channel_output_collection_0/v3_four_channel_placement_0/v3_channel_selector_late_promotion_1/v3_selector_route_pilot_0/G3_MUX_AXIS/X v3_four_channel_bias_reference_distribution_0/v3_four_channel_phase_distribution_0/v3_four_channel_output_collection_0/v3_four_channel_placement_0/v3_channel_selector_late_promotion_1/v3_selector_route_pilot_0/G3_LO_N_ANDNOT/a_27_413# v3_four_channel_bias_reference_distribution_0/v3_four_channel_phase_distribution_0/v3_four_channel_output_collection_0/v3_four_channel_placement_0/v3_channel_selector_late_promotion_1/VPWR sky130_fd_pr__pfet_01v8_hvt ad=0 pd=0 as=0.1092 ps=1.36 w=0.42 l=0.15
X580 VSUBS v3_four_channel_bias_reference_distribution_0/v3_four_channel_phase_distribution_0/v3_four_channel_output_collection_0/v3_four_channel_placement_0/v3_channel_selector_late_promotion_1/v3_selector_route_pilot_0/G3_LO_P_AND/B v3_four_channel_bias_reference_distribution_0/v3_four_channel_phase_distribution_0/v3_four_channel_output_collection_0/v3_four_channel_placement_0/v3_channel_selector_late_promotion_1/v3_selector_route_pilot_0/G3_LO_N_ANDNOT/a_297_47# VSUBS sky130_fd_pr__nfet_01v8 ad=0 pd=0 as=0 ps=0 w=0.42 l=0.15
X581 v3_four_channel_bias_reference_distribution_0/v3_four_channel_phase_distribution_0/v3_four_channel_output_collection_0/v3_four_channel_placement_0/v3_channel_selector_late_promotion_1/v3_selector_route_pilot_0/G3_LO_N_ANDNOT/a_27_413# v3_four_channel_bias_reference_distribution_0/v3_four_channel_phase_distribution_0/v3_four_channel_output_collection_0/v3_four_channel_placement_0/v3_channel_selector_late_promotion_1/v3_selector_route_pilot_0/G3_MUX_AXIS/X VSUBS VSUBS sky130_fd_pr__nfet_01v8 ad=0.1092 pd=1.36 as=0 ps=0 w=0.42 l=0.15
X582 v3_four_channel_bias_reference_distribution_0/v3_four_channel_phase_distribution_0/v3_four_channel_output_collection_0/v3_four_channel_placement_0/v3_channel_selector_late_promotion_1/VPWR v3_four_channel_bias_reference_distribution_0/v3_four_channel_phase_distribution_0/v3_four_channel_output_collection_0/v3_four_channel_placement_0/v3_channel_selector_late_promotion_1/v3_selector_route_pilot_0/G3_LO_P_AND/B v3_four_channel_bias_reference_distribution_0/v3_four_channel_phase_distribution_0/v3_four_channel_output_collection_0/v3_four_channel_placement_0/v3_channel_selector_late_promotion_1/v3_selector_route_pilot_0/G2_LO_N_ANDNOT/a_207_413# v3_four_channel_bias_reference_distribution_0/v3_four_channel_phase_distribution_0/v3_four_channel_output_collection_0/v3_four_channel_placement_0/v3_channel_selector_late_promotion_1/VPWR sky130_fd_pr__pfet_01v8_hvt ad=0 pd=0 as=0.1218 ps=1.42 w=0.42 l=0.15
X583 v3_four_channel_bias_reference_distribution_0/v3_four_channel_phase_distribution_0/v3_four_channel_output_collection_0/v3_four_channel_placement_0/v3_channel_selector_late_promotion_1/v3_selector_route_pilot_0/group2_lo_n v3_four_channel_bias_reference_distribution_0/v3_four_channel_phase_distribution_0/v3_four_channel_output_collection_0/v3_four_channel_placement_0/v3_channel_selector_late_promotion_1/v3_selector_route_pilot_0/G2_LO_N_ANDNOT/a_207_413# v3_four_channel_bias_reference_distribution_0/v3_four_channel_phase_distribution_0/v3_four_channel_output_collection_0/v3_four_channel_placement_0/v3_channel_selector_late_promotion_1/VPWR v3_four_channel_bias_reference_distribution_0/v3_four_channel_phase_distribution_0/v3_four_channel_output_collection_0/v3_four_channel_placement_0/v3_channel_selector_late_promotion_1/VPWR sky130_fd_pr__pfet_01v8_hvt ad=0.26 pd=2.52 as=0 ps=0 w=1 l=0.15
X584 v3_four_channel_bias_reference_distribution_0/v3_four_channel_phase_distribution_0/v3_four_channel_output_collection_0/v3_four_channel_placement_0/v3_channel_selector_late_promotion_1/v3_selector_route_pilot_0/G2_LO_N_ANDNOT/a_297_47# v3_four_channel_bias_reference_distribution_0/v3_four_channel_phase_distribution_0/v3_four_channel_output_collection_0/v3_four_channel_placement_0/v3_channel_selector_late_promotion_1/v3_selector_route_pilot_0/G2_LO_N_ANDNOT/a_27_413# v3_four_channel_bias_reference_distribution_0/v3_four_channel_phase_distribution_0/v3_four_channel_output_collection_0/v3_four_channel_placement_0/v3_channel_selector_late_promotion_1/v3_selector_route_pilot_0/G2_LO_N_ANDNOT/a_207_413# VSUBS sky130_fd_pr__nfet_01v8 ad=0.1008 pd=1.32 as=0.1092 ps=1.36 w=0.42 l=0.15
X585 v3_four_channel_bias_reference_distribution_0/v3_four_channel_phase_distribution_0/v3_four_channel_output_collection_0/v3_four_channel_placement_0/v3_channel_selector_late_promotion_1/v3_selector_route_pilot_0/group2_lo_n v3_four_channel_bias_reference_distribution_0/v3_four_channel_phase_distribution_0/v3_four_channel_output_collection_0/v3_four_channel_placement_0/v3_channel_selector_late_promotion_1/v3_selector_route_pilot_0/G2_LO_N_ANDNOT/a_207_413# VSUBS VSUBS sky130_fd_pr__nfet_01v8 ad=0.169 pd=1.82 as=0 ps=0 w=0.65 l=0.15
X586 v3_four_channel_bias_reference_distribution_0/v3_four_channel_phase_distribution_0/v3_four_channel_output_collection_0/v3_four_channel_placement_0/v3_channel_selector_late_promotion_1/v3_selector_route_pilot_0/G2_LO_N_ANDNOT/a_207_413# v3_four_channel_bias_reference_distribution_0/v3_four_channel_phase_distribution_0/v3_four_channel_output_collection_0/v3_four_channel_placement_0/v3_channel_selector_late_promotion_1/v3_selector_route_pilot_0/G2_LO_N_ANDNOT/a_27_413# v3_four_channel_bias_reference_distribution_0/v3_four_channel_phase_distribution_0/v3_four_channel_output_collection_0/v3_four_channel_placement_0/v3_channel_selector_late_promotion_1/VPWR v3_four_channel_bias_reference_distribution_0/v3_four_channel_phase_distribution_0/v3_four_channel_output_collection_0/v3_four_channel_placement_0/v3_channel_selector_late_promotion_1/VPWR sky130_fd_pr__pfet_01v8_hvt ad=0 pd=0 as=0 ps=0 w=0.42 l=0.15
X587 v3_four_channel_bias_reference_distribution_0/v3_four_channel_phase_distribution_0/v3_four_channel_output_collection_0/v3_four_channel_placement_0/v3_channel_selector_late_promotion_1/VPWR v3_four_channel_bias_reference_distribution_0/v3_four_channel_phase_distribution_0/v3_four_channel_output_collection_0/v3_four_channel_placement_0/v3_channel_selector_late_promotion_1/v3_selector_route_pilot_0/G2_MUX_AXIS/X v3_four_channel_bias_reference_distribution_0/v3_four_channel_phase_distribution_0/v3_four_channel_output_collection_0/v3_four_channel_placement_0/v3_channel_selector_late_promotion_1/v3_selector_route_pilot_0/G2_LO_N_ANDNOT/a_27_413# v3_four_channel_bias_reference_distribution_0/v3_four_channel_phase_distribution_0/v3_four_channel_output_collection_0/v3_four_channel_placement_0/v3_channel_selector_late_promotion_1/VPWR sky130_fd_pr__pfet_01v8_hvt ad=0 pd=0 as=0.1092 ps=1.36 w=0.42 l=0.15
X588 VSUBS v3_four_channel_bias_reference_distribution_0/v3_four_channel_phase_distribution_0/v3_four_channel_output_collection_0/v3_four_channel_placement_0/v3_channel_selector_late_promotion_1/v3_selector_route_pilot_0/G3_LO_P_AND/B v3_four_channel_bias_reference_distribution_0/v3_four_channel_phase_distribution_0/v3_four_channel_output_collection_0/v3_four_channel_placement_0/v3_channel_selector_late_promotion_1/v3_selector_route_pilot_0/G2_LO_N_ANDNOT/a_297_47# VSUBS sky130_fd_pr__nfet_01v8 ad=0 pd=0 as=0 ps=0 w=0.42 l=0.15
X589 v3_four_channel_bias_reference_distribution_0/v3_four_channel_phase_distribution_0/v3_four_channel_output_collection_0/v3_four_channel_placement_0/v3_channel_selector_late_promotion_1/v3_selector_route_pilot_0/G2_LO_N_ANDNOT/a_27_413# v3_four_channel_bias_reference_distribution_0/v3_four_channel_phase_distribution_0/v3_four_channel_output_collection_0/v3_four_channel_placement_0/v3_channel_selector_late_promotion_1/v3_selector_route_pilot_0/G2_MUX_AXIS/X VSUBS VSUBS sky130_fd_pr__nfet_01v8 ad=0.1092 pd=1.36 as=0 ps=0 w=0.42 l=0.15
X590 v3_four_channel_bias_reference_distribution_0/v3_four_channel_phase_distribution_0/v3_four_channel_output_collection_0/v3_four_channel_placement_0/v3_channel_selector_late_promotion_1/VPWR v3_four_channel_bias_reference_distribution_0/v3_four_channel_phase_distribution_0/v3_four_channel_output_collection_0/v3_four_channel_placement_0/v3_channel_selector_late_promotion_1/v3_selector_route_pilot_0/G3_LO_P_AND/B v3_four_channel_bias_reference_distribution_0/v3_four_channel_phase_distribution_0/v3_four_channel_output_collection_0/v3_four_channel_placement_0/v3_channel_selector_late_promotion_1/v3_selector_route_pilot_0/G0_LO_N_ANDNOT/a_207_413# v3_four_channel_bias_reference_distribution_0/v3_four_channel_phase_distribution_0/v3_four_channel_output_collection_0/v3_four_channel_placement_0/v3_channel_selector_late_promotion_1/VPWR sky130_fd_pr__pfet_01v8_hvt ad=0 pd=0 as=0.1218 ps=1.42 w=0.42 l=0.15
X591 v3_four_channel_bias_reference_distribution_0/v3_four_channel_phase_distribution_0/v3_four_channel_output_collection_0/v3_four_channel_placement_0/v3_channel_selector_late_promotion_1/v3_selector_route_pilot_0/group0_lo_n v3_four_channel_bias_reference_distribution_0/v3_four_channel_phase_distribution_0/v3_four_channel_output_collection_0/v3_four_channel_placement_0/v3_channel_selector_late_promotion_1/v3_selector_route_pilot_0/G0_LO_N_ANDNOT/a_207_413# v3_four_channel_bias_reference_distribution_0/v3_four_channel_phase_distribution_0/v3_four_channel_output_collection_0/v3_four_channel_placement_0/v3_channel_selector_late_promotion_1/VPWR v3_four_channel_bias_reference_distribution_0/v3_four_channel_phase_distribution_0/v3_four_channel_output_collection_0/v3_four_channel_placement_0/v3_channel_selector_late_promotion_1/VPWR sky130_fd_pr__pfet_01v8_hvt ad=0.26 pd=2.52 as=0 ps=0 w=1 l=0.15
X592 v3_four_channel_bias_reference_distribution_0/v3_four_channel_phase_distribution_0/v3_four_channel_output_collection_0/v3_four_channel_placement_0/v3_channel_selector_late_promotion_1/v3_selector_route_pilot_0/G0_LO_N_ANDNOT/a_297_47# v3_four_channel_bias_reference_distribution_0/v3_four_channel_phase_distribution_0/v3_four_channel_output_collection_0/v3_four_channel_placement_0/v3_channel_selector_late_promotion_1/v3_selector_route_pilot_0/G0_LO_N_ANDNOT/a_27_413# v3_four_channel_bias_reference_distribution_0/v3_four_channel_phase_distribution_0/v3_four_channel_output_collection_0/v3_four_channel_placement_0/v3_channel_selector_late_promotion_1/v3_selector_route_pilot_0/G0_LO_N_ANDNOT/a_207_413# VSUBS sky130_fd_pr__nfet_01v8 ad=0.1008 pd=1.32 as=0.1092 ps=1.36 w=0.42 l=0.15
X593 v3_four_channel_bias_reference_distribution_0/v3_four_channel_phase_distribution_0/v3_four_channel_output_collection_0/v3_four_channel_placement_0/v3_channel_selector_late_promotion_1/v3_selector_route_pilot_0/group0_lo_n v3_four_channel_bias_reference_distribution_0/v3_four_channel_phase_distribution_0/v3_four_channel_output_collection_0/v3_four_channel_placement_0/v3_channel_selector_late_promotion_1/v3_selector_route_pilot_0/G0_LO_N_ANDNOT/a_207_413# VSUBS VSUBS sky130_fd_pr__nfet_01v8 ad=0.169 pd=1.82 as=0 ps=0 w=0.65 l=0.15
X594 v3_four_channel_bias_reference_distribution_0/v3_four_channel_phase_distribution_0/v3_four_channel_output_collection_0/v3_four_channel_placement_0/v3_channel_selector_late_promotion_1/v3_selector_route_pilot_0/G0_LO_N_ANDNOT/a_207_413# v3_four_channel_bias_reference_distribution_0/v3_four_channel_phase_distribution_0/v3_four_channel_output_collection_0/v3_four_channel_placement_0/v3_channel_selector_late_promotion_1/v3_selector_route_pilot_0/G0_LO_N_ANDNOT/a_27_413# v3_four_channel_bias_reference_distribution_0/v3_four_channel_phase_distribution_0/v3_four_channel_output_collection_0/v3_four_channel_placement_0/v3_channel_selector_late_promotion_1/VPWR v3_four_channel_bias_reference_distribution_0/v3_four_channel_phase_distribution_0/v3_four_channel_output_collection_0/v3_four_channel_placement_0/v3_channel_selector_late_promotion_1/VPWR sky130_fd_pr__pfet_01v8_hvt ad=0 pd=0 as=0 ps=0 w=0.42 l=0.15
X595 v3_four_channel_bias_reference_distribution_0/v3_four_channel_phase_distribution_0/v3_four_channel_output_collection_0/v3_four_channel_placement_0/v3_channel_selector_late_promotion_1/VPWR v3_four_channel_bias_reference_distribution_0/v3_four_channel_phase_distribution_0/v3_four_channel_output_collection_0/v3_four_channel_placement_0/v3_channel_selector_late_promotion_1/v3_selector_route_pilot_0/G0_MUX_AXIS/X v3_four_channel_bias_reference_distribution_0/v3_four_channel_phase_distribution_0/v3_four_channel_output_collection_0/v3_four_channel_placement_0/v3_channel_selector_late_promotion_1/v3_selector_route_pilot_0/G0_LO_N_ANDNOT/a_27_413# v3_four_channel_bias_reference_distribution_0/v3_four_channel_phase_distribution_0/v3_four_channel_output_collection_0/v3_four_channel_placement_0/v3_channel_selector_late_promotion_1/VPWR sky130_fd_pr__pfet_01v8_hvt ad=0 pd=0 as=0.1092 ps=1.36 w=0.42 l=0.15
X596 VSUBS v3_four_channel_bias_reference_distribution_0/v3_four_channel_phase_distribution_0/v3_four_channel_output_collection_0/v3_four_channel_placement_0/v3_channel_selector_late_promotion_1/v3_selector_route_pilot_0/G3_LO_P_AND/B v3_four_channel_bias_reference_distribution_0/v3_four_channel_phase_distribution_0/v3_four_channel_output_collection_0/v3_four_channel_placement_0/v3_channel_selector_late_promotion_1/v3_selector_route_pilot_0/G0_LO_N_ANDNOT/a_297_47# VSUBS sky130_fd_pr__nfet_01v8 ad=0 pd=0 as=0 ps=0 w=0.42 l=0.15
X597 v3_four_channel_bias_reference_distribution_0/v3_four_channel_phase_distribution_0/v3_four_channel_output_collection_0/v3_four_channel_placement_0/v3_channel_selector_late_promotion_1/v3_selector_route_pilot_0/G0_LO_N_ANDNOT/a_27_413# v3_four_channel_bias_reference_distribution_0/v3_four_channel_phase_distribution_0/v3_four_channel_output_collection_0/v3_four_channel_placement_0/v3_channel_selector_late_promotion_1/v3_selector_route_pilot_0/G0_MUX_AXIS/X VSUBS VSUBS sky130_fd_pr__nfet_01v8 ad=0.1092 pd=1.36 as=0 ps=0 w=0.42 l=0.15
X598 v3_four_channel_bias_reference_distribution_0/v3_four_channel_phase_distribution_0/v3_four_channel_output_collection_0/v3_four_channel_placement_0/v3_channel_selector_late_promotion_1/VPWR v3_four_channel_bias_reference_distribution_0/v3_four_channel_phase_distribution_0/v3_four_channel_output_collection_0/v3_four_channel_placement_0/v3_channel_selector_late_promotion_1/v3_selector_route_pilot_0/G1_MUX_AXIS/a_505_21# v3_four_channel_bias_reference_distribution_0/v3_four_channel_phase_distribution_0/v3_four_channel_output_collection_0/v3_four_channel_placement_0/v3_channel_selector_late_promotion_1/v3_selector_route_pilot_0/G1_MUX_AXIS/a_535_374# v3_four_channel_bias_reference_distribution_0/v3_four_channel_phase_distribution_0/v3_four_channel_output_collection_0/v3_four_channel_placement_0/v3_channel_selector_late_promotion_1/VPWR sky130_fd_pr__pfet_01v8_hvt ad=0 pd=0 as=0.0882 ps=1.26 w=0.42 l=0.15
X599 v3_four_channel_bias_reference_distribution_0/v3_four_channel_phase_distribution_0/v3_four_channel_output_collection_0/v3_four_channel_placement_0/v3_channel_selector_late_promotion_1/v3_selector_route_pilot_0/G1_MUX_AXIS/a_505_21# v3_four_channel_bias_reference_distribution_0/v3_four_channel_phase_distribution_0/v3_four_channel_output_collection_0/v3_four_channel_placement_0/v3_channel_selector_late_promotion_1/group1_bit1 v3_four_channel_bias_reference_distribution_0/v3_four_channel_phase_distribution_0/v3_four_channel_output_collection_0/v3_four_channel_placement_0/v3_channel_selector_late_promotion_1/VPWR v3_four_channel_bias_reference_distribution_0/v3_four_channel_phase_distribution_0/v3_four_channel_output_collection_0/v3_four_channel_placement_0/v3_channel_selector_late_promotion_1/VPWR sky130_fd_pr__pfet_01v8_hvt ad=0.1176 pd=1.4 as=0 ps=0 w=0.42 l=0.15
X600 v3_four_channel_bias_reference_distribution_0/v3_four_channel_phase_distribution_0/v3_four_channel_output_collection_0/v3_four_channel_placement_0/v3_channel_selector_late_promotion_1/v3_selector_route_pilot_0/G1_MUX_AXIS/a_218_374# v3_four_channel_bias_reference_distribution_0/v3_four_channel_phase_distribution_0/v3_four_channel_output_collection_0/v3_four_channel_placement_0/v3_channel_selector_late_promotion_1/group1_bit1 v3_four_channel_bias_reference_distribution_0/v3_four_channel_phase_distribution_0/v3_four_channel_output_collection_0/v3_four_channel_placement_0/v3_channel_selector_late_promotion_1/VPWR v3_four_channel_bias_reference_distribution_0/v3_four_channel_phase_distribution_0/v3_four_channel_output_collection_0/v3_four_channel_placement_0/v3_channel_selector_late_promotion_1/VPWR sky130_fd_pr__pfet_01v8_hvt ad=0.1533 pd=1.57 as=0 ps=0 w=0.42 l=0.15
X601 VSUBS v3_four_channel_bias_reference_distribution_0/v3_four_channel_phase_distribution_0/v3_four_channel_output_collection_0/v3_four_channel_placement_0/v3_channel_selector_late_promotion_1/v3_selector_route_pilot_0/G1_MUX_AXIS/a_505_21# v3_four_channel_bias_reference_distribution_0/v3_four_channel_phase_distribution_0/v3_four_channel_output_collection_0/v3_four_channel_placement_0/v3_channel_selector_late_promotion_1/v3_selector_route_pilot_0/G1_MUX_AXIS/a_439_47# VSUBS sky130_fd_pr__nfet_01v8 ad=0 pd=0 as=0.1386 ps=1.5 w=0.42 l=0.15
X602 v3_four_channel_bias_reference_distribution_0/v3_four_channel_phase_distribution_0/v3_four_channel_output_collection_0/v3_four_channel_placement_0/v3_channel_selector_late_promotion_1/v3_selector_route_pilot_0/G1_MUX_AXIS/a_76_199# v3_four_channel_bias_reference_distribution_0/v3_four_channel_phase_distribution_0/v3_four_channel_output_collection_0/v3_four_channel_placement_0/v3_channel_selector_late_promotion_1/v3_selector_route_pilot_0/G1_MUX_POS/X v3_four_channel_bias_reference_distribution_0/v3_four_channel_phase_distribution_0/v3_four_channel_output_collection_0/v3_four_channel_placement_0/v3_channel_selector_late_promotion_1/v3_selector_route_pilot_0/G1_MUX_AXIS/a_218_374# v3_four_channel_bias_reference_distribution_0/v3_four_channel_phase_distribution_0/v3_four_channel_output_collection_0/v3_four_channel_placement_0/v3_channel_selector_late_promotion_1/VPWR sky130_fd_pr__pfet_01v8_hvt ad=0.3864 pd=2.68 as=0 ps=0 w=0.42 l=0.15
X603 v3_four_channel_bias_reference_distribution_0/v3_four_channel_phase_distribution_0/v3_four_channel_output_collection_0/v3_four_channel_placement_0/v3_channel_selector_late_promotion_1/v3_selector_route_pilot_0/G1_MUX_AXIS/a_505_21# v3_four_channel_bias_reference_distribution_0/v3_four_channel_phase_distribution_0/v3_four_channel_output_collection_0/v3_four_channel_placement_0/v3_channel_selector_late_promotion_1/group1_bit1 VSUBS VSUBS sky130_fd_pr__nfet_01v8 ad=0.1092 pd=1.36 as=0 ps=0 w=0.42 l=0.15
X604 v3_four_channel_bias_reference_distribution_0/v3_four_channel_phase_distribution_0/v3_four_channel_output_collection_0/v3_four_channel_placement_0/v3_channel_selector_late_promotion_1/v3_selector_route_pilot_0/G1_MUX_AXIS/a_439_47# v3_four_channel_bias_reference_distribution_0/v3_four_channel_phase_distribution_0/v3_four_channel_output_collection_0/v3_four_channel_placement_0/v3_channel_selector_late_promotion_1/v3_selector_route_pilot_0/G1_MUX_POS/X v3_four_channel_bias_reference_distribution_0/v3_four_channel_phase_distribution_0/v3_four_channel_output_collection_0/v3_four_channel_placement_0/v3_channel_selector_late_promotion_1/v3_selector_route_pilot_0/G1_MUX_AXIS/a_76_199# VSUBS sky130_fd_pr__nfet_01v8 ad=0 pd=0 as=0.1995 ps=1.79 w=0.42 l=0.15
X605 v3_four_channel_bias_reference_distribution_0/v3_four_channel_phase_distribution_0/v3_four_channel_output_collection_0/v3_four_channel_placement_0/v3_channel_selector_late_promotion_1/v3_selector_route_pilot_0/G1_MUX_AXIS/a_535_374# v3_four_channel_bias_reference_distribution_0/v3_four_channel_phase_distribution_0/v3_four_channel_output_collection_0/v3_four_channel_placement_0/v3_channel_selector_late_promotion_1/v3_selector_route_pilot_0/G1_MUX_NEG/X v3_four_channel_bias_reference_distribution_0/v3_four_channel_phase_distribution_0/v3_four_channel_output_collection_0/v3_four_channel_placement_0/v3_channel_selector_late_promotion_1/v3_selector_route_pilot_0/G1_MUX_AXIS/a_76_199# v3_four_channel_bias_reference_distribution_0/v3_four_channel_phase_distribution_0/v3_four_channel_output_collection_0/v3_four_channel_placement_0/v3_channel_selector_late_promotion_1/VPWR sky130_fd_pr__pfet_01v8_hvt ad=0 pd=0 as=0 ps=0 w=0.42 l=0.15
X606 v3_four_channel_bias_reference_distribution_0/v3_four_channel_phase_distribution_0/v3_four_channel_output_collection_0/v3_four_channel_placement_0/v3_channel_selector_late_promotion_1/v3_selector_route_pilot_0/G1_MUX_AXIS/a_76_199# v3_four_channel_bias_reference_distribution_0/v3_four_channel_phase_distribution_0/v3_four_channel_output_collection_0/v3_four_channel_placement_0/v3_channel_selector_late_promotion_1/v3_selector_route_pilot_0/G1_MUX_NEG/X v3_four_channel_bias_reference_distribution_0/v3_four_channel_phase_distribution_0/v3_four_channel_output_collection_0/v3_four_channel_placement_0/v3_channel_selector_late_promotion_1/v3_selector_route_pilot_0/G1_MUX_AXIS/a_218_47# VSUBS sky130_fd_pr__nfet_01v8 ad=0 pd=0 as=0.1386 ps=1.5 w=0.42 l=0.15
X607 v3_four_channel_bias_reference_distribution_0/v3_four_channel_phase_distribution_0/v3_four_channel_output_collection_0/v3_four_channel_placement_0/v3_channel_selector_late_promotion_1/v3_selector_route_pilot_0/G1_MUX_AXIS/a_218_47# v3_four_channel_bias_reference_distribution_0/v3_four_channel_phase_distribution_0/v3_four_channel_output_collection_0/v3_four_channel_placement_0/v3_channel_selector_late_promotion_1/group1_bit1 VSUBS VSUBS sky130_fd_pr__nfet_01v8 ad=0 pd=0 as=0 ps=0 w=0.42 l=0.15
X608 v3_four_channel_bias_reference_distribution_0/v3_four_channel_phase_distribution_0/v3_four_channel_output_collection_0/v3_four_channel_placement_0/v3_channel_selector_late_promotion_1/VPWR v3_four_channel_bias_reference_distribution_0/v3_four_channel_phase_distribution_0/v3_four_channel_output_collection_0/v3_four_channel_placement_0/v3_channel_selector_late_promotion_1/v3_selector_route_pilot_0/G1_MUX_AXIS/a_76_199# v3_four_channel_bias_reference_distribution_0/v3_four_channel_phase_distribution_0/v3_four_channel_output_collection_0/v3_four_channel_placement_0/v3_channel_selector_late_promotion_1/v3_selector_route_pilot_0/G1_MUX_AXIS/X v3_four_channel_bias_reference_distribution_0/v3_four_channel_phase_distribution_0/v3_four_channel_output_collection_0/v3_four_channel_placement_0/v3_channel_selector_late_promotion_1/VPWR sky130_fd_pr__pfet_01v8_hvt ad=0 pd=0 as=0.26 ps=2.52 w=1 l=0.15
X609 VSUBS v3_four_channel_bias_reference_distribution_0/v3_four_channel_phase_distribution_0/v3_four_channel_output_collection_0/v3_four_channel_placement_0/v3_channel_selector_late_promotion_1/v3_selector_route_pilot_0/G1_MUX_AXIS/a_76_199# v3_four_channel_bias_reference_distribution_0/v3_four_channel_phase_distribution_0/v3_four_channel_output_collection_0/v3_four_channel_placement_0/v3_channel_selector_late_promotion_1/v3_selector_route_pilot_0/G1_MUX_AXIS/X VSUBS sky130_fd_pr__nfet_01v8 ad=0 pd=0 as=0.169 ps=1.82 w=0.65 l=0.15
X610 v3_four_channel_bias_reference_distribution_0/v3_four_channel_phase_distribution_0/v3_four_channel_output_collection_0/v3_four_channel_placement_0/v3_channel_selector_late_promotion_1/VPWR v3_four_channel_bias_reference_distribution_0/v3_four_channel_phase_distribution_0/v3_four_channel_output_collection_0/v3_four_channel_placement_0/v3_channel_selector_late_promotion_1/v3_selector_route_pilot_0/G3_LO_P_AND/B v3_four_channel_bias_reference_distribution_0/v3_four_channel_phase_distribution_0/v3_four_channel_output_collection_0/v3_four_channel_placement_0/v3_channel_selector_late_promotion_1/v3_selector_route_pilot_0/G1_LO_N_ANDNOT/a_207_413# v3_four_channel_bias_reference_distribution_0/v3_four_channel_phase_distribution_0/v3_four_channel_output_collection_0/v3_four_channel_placement_0/v3_channel_selector_late_promotion_1/VPWR sky130_fd_pr__pfet_01v8_hvt ad=0 pd=0 as=0.1218 ps=1.42 w=0.42 l=0.15
X611 v3_four_channel_bias_reference_distribution_0/v3_four_channel_phase_distribution_0/v3_four_channel_output_collection_0/v3_four_channel_placement_0/v3_channel_selector_late_promotion_1/v3_selector_route_pilot_0/group1_lo_n v3_four_channel_bias_reference_distribution_0/v3_four_channel_phase_distribution_0/v3_four_channel_output_collection_0/v3_four_channel_placement_0/v3_channel_selector_late_promotion_1/v3_selector_route_pilot_0/G1_LO_N_ANDNOT/a_207_413# v3_four_channel_bias_reference_distribution_0/v3_four_channel_phase_distribution_0/v3_four_channel_output_collection_0/v3_four_channel_placement_0/v3_channel_selector_late_promotion_1/VPWR v3_four_channel_bias_reference_distribution_0/v3_four_channel_phase_distribution_0/v3_four_channel_output_collection_0/v3_four_channel_placement_0/v3_channel_selector_late_promotion_1/VPWR sky130_fd_pr__pfet_01v8_hvt ad=0.26 pd=2.52 as=0 ps=0 w=1 l=0.15
X612 v3_four_channel_bias_reference_distribution_0/v3_four_channel_phase_distribution_0/v3_four_channel_output_collection_0/v3_four_channel_placement_0/v3_channel_selector_late_promotion_1/v3_selector_route_pilot_0/G1_LO_N_ANDNOT/a_297_47# v3_four_channel_bias_reference_distribution_0/v3_four_channel_phase_distribution_0/v3_four_channel_output_collection_0/v3_four_channel_placement_0/v3_channel_selector_late_promotion_1/v3_selector_route_pilot_0/G1_LO_N_ANDNOT/a_27_413# v3_four_channel_bias_reference_distribution_0/v3_four_channel_phase_distribution_0/v3_four_channel_output_collection_0/v3_four_channel_placement_0/v3_channel_selector_late_promotion_1/v3_selector_route_pilot_0/G1_LO_N_ANDNOT/a_207_413# VSUBS sky130_fd_pr__nfet_01v8 ad=0.1008 pd=1.32 as=0.1092 ps=1.36 w=0.42 l=0.15
X613 v3_four_channel_bias_reference_distribution_0/v3_four_channel_phase_distribution_0/v3_four_channel_output_collection_0/v3_four_channel_placement_0/v3_channel_selector_late_promotion_1/v3_selector_route_pilot_0/group1_lo_n v3_four_channel_bias_reference_distribution_0/v3_four_channel_phase_distribution_0/v3_four_channel_output_collection_0/v3_four_channel_placement_0/v3_channel_selector_late_promotion_1/v3_selector_route_pilot_0/G1_LO_N_ANDNOT/a_207_413# VSUBS VSUBS sky130_fd_pr__nfet_01v8 ad=0.169 pd=1.82 as=0 ps=0 w=0.65 l=0.15
X614 v3_four_channel_bias_reference_distribution_0/v3_four_channel_phase_distribution_0/v3_four_channel_output_collection_0/v3_four_channel_placement_0/v3_channel_selector_late_promotion_1/v3_selector_route_pilot_0/G1_LO_N_ANDNOT/a_207_413# v3_four_channel_bias_reference_distribution_0/v3_four_channel_phase_distribution_0/v3_four_channel_output_collection_0/v3_four_channel_placement_0/v3_channel_selector_late_promotion_1/v3_selector_route_pilot_0/G1_LO_N_ANDNOT/a_27_413# v3_four_channel_bias_reference_distribution_0/v3_four_channel_phase_distribution_0/v3_four_channel_output_collection_0/v3_four_channel_placement_0/v3_channel_selector_late_promotion_1/VPWR v3_four_channel_bias_reference_distribution_0/v3_four_channel_phase_distribution_0/v3_four_channel_output_collection_0/v3_four_channel_placement_0/v3_channel_selector_late_promotion_1/VPWR sky130_fd_pr__pfet_01v8_hvt ad=0 pd=0 as=0 ps=0 w=0.42 l=0.15
X615 v3_four_channel_bias_reference_distribution_0/v3_four_channel_phase_distribution_0/v3_four_channel_output_collection_0/v3_four_channel_placement_0/v3_channel_selector_late_promotion_1/VPWR v3_four_channel_bias_reference_distribution_0/v3_four_channel_phase_distribution_0/v3_four_channel_output_collection_0/v3_four_channel_placement_0/v3_channel_selector_late_promotion_1/v3_selector_route_pilot_0/G1_MUX_AXIS/X v3_four_channel_bias_reference_distribution_0/v3_four_channel_phase_distribution_0/v3_four_channel_output_collection_0/v3_four_channel_placement_0/v3_channel_selector_late_promotion_1/v3_selector_route_pilot_0/G1_LO_N_ANDNOT/a_27_413# v3_four_channel_bias_reference_distribution_0/v3_four_channel_phase_distribution_0/v3_four_channel_output_collection_0/v3_four_channel_placement_0/v3_channel_selector_late_promotion_1/VPWR sky130_fd_pr__pfet_01v8_hvt ad=0 pd=0 as=0.1092 ps=1.36 w=0.42 l=0.15
X616 VSUBS v3_four_channel_bias_reference_distribution_0/v3_four_channel_phase_distribution_0/v3_four_channel_output_collection_0/v3_four_channel_placement_0/v3_channel_selector_late_promotion_1/v3_selector_route_pilot_0/G3_LO_P_AND/B v3_four_channel_bias_reference_distribution_0/v3_four_channel_phase_distribution_0/v3_four_channel_output_collection_0/v3_four_channel_placement_0/v3_channel_selector_late_promotion_1/v3_selector_route_pilot_0/G1_LO_N_ANDNOT/a_297_47# VSUBS sky130_fd_pr__nfet_01v8 ad=0 pd=0 as=0 ps=0 w=0.42 l=0.15
X617 v3_four_channel_bias_reference_distribution_0/v3_four_channel_phase_distribution_0/v3_four_channel_output_collection_0/v3_four_channel_placement_0/v3_channel_selector_late_promotion_1/v3_selector_route_pilot_0/G1_LO_N_ANDNOT/a_27_413# v3_four_channel_bias_reference_distribution_0/v3_four_channel_phase_distribution_0/v3_four_channel_output_collection_0/v3_four_channel_placement_0/v3_channel_selector_late_promotion_1/v3_selector_route_pilot_0/G1_MUX_AXIS/X VSUBS VSUBS sky130_fd_pr__nfet_01v8 ad=0.1092 pd=1.36 as=0 ps=0 w=0.42 l=0.15
X618 v3_four_channel_bias_reference_distribution_0/v3_four_channel_phase_distribution_0/v3_four_channel_output_collection_0/v3_four_channel_placement_0/v3_channel_selector_late_promotion_1/VPWR v3_four_channel_bias_reference_distribution_0/v3_four_channel_phase_distribution_0/v3_four_channel_output_collection_0/v3_four_channel_placement_0/v3_channel_selector_late_promotion_1/v3_selector_route_pilot_0/G3_LO_P_AND/B v3_four_channel_bias_reference_distribution_0/v3_four_channel_phase_distribution_0/v3_four_channel_output_collection_0/v3_four_channel_placement_0/v3_channel_selector_late_promotion_1/v3_selector_route_pilot_0/G3_LO_P_AND/a_59_75# v3_four_channel_bias_reference_distribution_0/v3_four_channel_phase_distribution_0/v3_four_channel_output_collection_0/v3_four_channel_placement_0/v3_channel_selector_late_promotion_1/VPWR sky130_fd_pr__pfet_01v8_hvt ad=0 pd=0 as=0.1134 ps=1.38 w=0.42 l=0.15
X619 v3_four_channel_bias_reference_distribution_0/v3_four_channel_phase_distribution_0/v3_four_channel_output_collection_0/v3_four_channel_placement_0/v3_channel_selector_late_promotion_1/v3_selector_route_pilot_0/group3_lo_p v3_four_channel_bias_reference_distribution_0/v3_four_channel_phase_distribution_0/v3_four_channel_output_collection_0/v3_four_channel_placement_0/v3_channel_selector_late_promotion_1/v3_selector_route_pilot_0/G3_LO_P_AND/a_59_75# v3_four_channel_bias_reference_distribution_0/v3_four_channel_phase_distribution_0/v3_four_channel_output_collection_0/v3_four_channel_placement_0/v3_channel_selector_late_promotion_1/VPWR v3_four_channel_bias_reference_distribution_0/v3_four_channel_phase_distribution_0/v3_four_channel_output_collection_0/v3_four_channel_placement_0/v3_channel_selector_late_promotion_1/VPWR sky130_fd_pr__pfet_01v8_hvt ad=0.475 pd=2.95 as=0 ps=0 w=1 l=0.15
X620 VSUBS v3_four_channel_bias_reference_distribution_0/v3_four_channel_phase_distribution_0/v3_four_channel_output_collection_0/v3_four_channel_placement_0/v3_channel_selector_late_promotion_1/v3_selector_route_pilot_0/G3_LO_P_AND/B v3_four_channel_bias_reference_distribution_0/v3_four_channel_phase_distribution_0/v3_four_channel_output_collection_0/v3_four_channel_placement_0/v3_channel_selector_late_promotion_1/v3_selector_route_pilot_0/G3_LO_P_AND/a_145_75# VSUBS sky130_fd_pr__nfet_01v8 ad=0 pd=0 as=0.1134 ps=1.38 w=0.42 l=0.15
X621 v3_four_channel_bias_reference_distribution_0/v3_four_channel_phase_distribution_0/v3_four_channel_output_collection_0/v3_four_channel_placement_0/v3_channel_selector_late_promotion_1/v3_selector_route_pilot_0/G3_LO_P_AND/a_59_75# v3_four_channel_bias_reference_distribution_0/v3_four_channel_phase_distribution_0/v3_four_channel_output_collection_0/v3_four_channel_placement_0/v3_channel_selector_late_promotion_1/v3_selector_route_pilot_0/G3_MUX_AXIS/X v3_four_channel_bias_reference_distribution_0/v3_four_channel_phase_distribution_0/v3_four_channel_output_collection_0/v3_four_channel_placement_0/v3_channel_selector_late_promotion_1/VPWR v3_four_channel_bias_reference_distribution_0/v3_four_channel_phase_distribution_0/v3_four_channel_output_collection_0/v3_four_channel_placement_0/v3_channel_selector_late_promotion_1/VPWR sky130_fd_pr__pfet_01v8_hvt ad=0 pd=0 as=0 ps=0 w=0.42 l=0.15
X622 v3_four_channel_bias_reference_distribution_0/v3_four_channel_phase_distribution_0/v3_four_channel_output_collection_0/v3_four_channel_placement_0/v3_channel_selector_late_promotion_1/v3_selector_route_pilot_0/group3_lo_p v3_four_channel_bias_reference_distribution_0/v3_four_channel_phase_distribution_0/v3_four_channel_output_collection_0/v3_four_channel_placement_0/v3_channel_selector_late_promotion_1/v3_selector_route_pilot_0/G3_LO_P_AND/a_59_75# VSUBS VSUBS sky130_fd_pr__nfet_01v8 ad=0.182 pd=1.86 as=0 ps=0 w=0.65 l=0.15
X623 v3_four_channel_bias_reference_distribution_0/v3_four_channel_phase_distribution_0/v3_four_channel_output_collection_0/v3_four_channel_placement_0/v3_channel_selector_late_promotion_1/v3_selector_route_pilot_0/G3_LO_P_AND/a_145_75# v3_four_channel_bias_reference_distribution_0/v3_four_channel_phase_distribution_0/v3_four_channel_output_collection_0/v3_four_channel_placement_0/v3_channel_selector_late_promotion_1/v3_selector_route_pilot_0/G3_MUX_AXIS/X v3_four_channel_bias_reference_distribution_0/v3_four_channel_phase_distribution_0/v3_four_channel_output_collection_0/v3_four_channel_placement_0/v3_channel_selector_late_promotion_1/v3_selector_route_pilot_0/G3_LO_P_AND/a_59_75# VSUBS sky130_fd_pr__nfet_01v8 ad=0 pd=0 as=0.1176 ps=1.4 w=0.42 l=0.15
X624 v3_four_channel_bias_reference_distribution_0/v3_four_channel_phase_distribution_0/v3_four_channel_output_collection_0/v3_four_channel_placement_0/v3_channel_selector_late_promotion_1/VPWR v3_four_channel_bias_reference_distribution_0/v3_four_channel_phase_distribution_0/v3_four_channel_output_collection_0/v3_four_channel_placement_0/v3_channel_selector_late_promotion_1/v3_selector_route_pilot_0/G2_MUX_POS/a_505_21# v3_four_channel_bias_reference_distribution_0/v3_four_channel_phase_distribution_0/v3_four_channel_output_collection_0/v3_four_channel_placement_0/v3_channel_selector_late_promotion_1/v3_selector_route_pilot_0/G2_MUX_POS/a_535_374# v3_four_channel_bias_reference_distribution_0/v3_four_channel_phase_distribution_0/v3_four_channel_output_collection_0/v3_four_channel_placement_0/v3_channel_selector_late_promotion_1/VPWR sky130_fd_pr__pfet_01v8_hvt ad=0 pd=0 as=0.0882 ps=1.26 w=0.42 l=0.15
X625 v3_four_channel_bias_reference_distribution_0/v3_four_channel_phase_distribution_0/v3_four_channel_output_collection_0/v3_four_channel_placement_0/v3_channel_selector_late_promotion_1/v3_selector_route_pilot_0/G2_MUX_POS/a_505_21# v3_four_channel_bias_reference_distribution_0/v3_four_channel_phase_distribution_0/v3_four_channel_output_collection_0/v3_four_channel_placement_0/v3_channel_selector_late_promotion_1/group2_bit0 v3_four_channel_bias_reference_distribution_0/v3_four_channel_phase_distribution_0/v3_four_channel_output_collection_0/v3_four_channel_placement_0/v3_channel_selector_late_promotion_1/VPWR v3_four_channel_bias_reference_distribution_0/v3_four_channel_phase_distribution_0/v3_four_channel_output_collection_0/v3_four_channel_placement_0/v3_channel_selector_late_promotion_1/VPWR sky130_fd_pr__pfet_01v8_hvt ad=0.1176 pd=1.4 as=0 ps=0 w=0.42 l=0.15
X626 v3_four_channel_bias_reference_distribution_0/v3_four_channel_phase_distribution_0/v3_four_channel_output_collection_0/v3_four_channel_placement_0/v3_channel_selector_late_promotion_1/v3_selector_route_pilot_0/G2_MUX_POS/a_218_374# v3_four_channel_bias_reference_distribution_0/v3_four_channel_phase_distribution_0/v3_four_channel_output_collection_0/v3_four_channel_placement_0/v3_channel_selector_late_promotion_1/group2_bit0 v3_four_channel_bias_reference_distribution_0/v3_four_channel_phase_distribution_0/v3_four_channel_output_collection_0/v3_four_channel_placement_0/v3_channel_selector_late_promotion_1/VPWR v3_four_channel_bias_reference_distribution_0/v3_four_channel_phase_distribution_0/v3_four_channel_output_collection_0/v3_four_channel_placement_0/v3_channel_selector_late_promotion_1/VPWR sky130_fd_pr__pfet_01v8_hvt ad=0.1533 pd=1.57 as=0 ps=0 w=0.42 l=0.15
X627 VSUBS v3_four_channel_bias_reference_distribution_0/v3_four_channel_phase_distribution_0/v3_four_channel_output_collection_0/v3_four_channel_placement_0/v3_channel_selector_late_promotion_1/v3_selector_route_pilot_0/G2_MUX_POS/a_505_21# v3_four_channel_bias_reference_distribution_0/v3_four_channel_phase_distribution_0/v3_four_channel_output_collection_0/v3_four_channel_placement_0/v3_channel_selector_late_promotion_1/v3_selector_route_pilot_0/G2_MUX_POS/a_439_47# VSUBS sky130_fd_pr__nfet_01v8 ad=0 pd=0 as=0.1386 ps=1.5 w=0.42 l=0.15
X628 v3_four_channel_bias_reference_distribution_0/v3_four_channel_phase_distribution_0/v3_four_channel_output_collection_0/v3_four_channel_placement_0/v3_channel_selector_late_promotion_1/v3_selector_route_pilot_0/G2_MUX_POS/a_76_199# v3_four_channel_bias_reference_distribution_0/v3_four_channel_phase_distribution_0/phase_0 v3_four_channel_bias_reference_distribution_0/v3_four_channel_phase_distribution_0/v3_four_channel_output_collection_0/v3_four_channel_placement_0/v3_channel_selector_late_promotion_1/v3_selector_route_pilot_0/G2_MUX_POS/a_218_374# v3_four_channel_bias_reference_distribution_0/v3_four_channel_phase_distribution_0/v3_four_channel_output_collection_0/v3_four_channel_placement_0/v3_channel_selector_late_promotion_1/VPWR sky130_fd_pr__pfet_01v8_hvt ad=0.3864 pd=2.68 as=0 ps=0 w=0.42 l=0.15
X629 v3_four_channel_bias_reference_distribution_0/v3_four_channel_phase_distribution_0/v3_four_channel_output_collection_0/v3_four_channel_placement_0/v3_channel_selector_late_promotion_1/v3_selector_route_pilot_0/G2_MUX_POS/a_505_21# v3_four_channel_bias_reference_distribution_0/v3_four_channel_phase_distribution_0/v3_four_channel_output_collection_0/v3_four_channel_placement_0/v3_channel_selector_late_promotion_1/group2_bit0 VSUBS VSUBS sky130_fd_pr__nfet_01v8 ad=0.1092 pd=1.36 as=0 ps=0 w=0.42 l=0.15
X630 v3_four_channel_bias_reference_distribution_0/v3_four_channel_phase_distribution_0/v3_four_channel_output_collection_0/v3_four_channel_placement_0/v3_channel_selector_late_promotion_1/v3_selector_route_pilot_0/G2_MUX_POS/a_439_47# v3_four_channel_bias_reference_distribution_0/v3_four_channel_phase_distribution_0/phase_0 v3_four_channel_bias_reference_distribution_0/v3_four_channel_phase_distribution_0/v3_four_channel_output_collection_0/v3_four_channel_placement_0/v3_channel_selector_late_promotion_1/v3_selector_route_pilot_0/G2_MUX_POS/a_76_199# VSUBS sky130_fd_pr__nfet_01v8 ad=0 pd=0 as=0.1995 ps=1.79 w=0.42 l=0.15
X631 v3_four_channel_bias_reference_distribution_0/v3_four_channel_phase_distribution_0/v3_four_channel_output_collection_0/v3_four_channel_placement_0/v3_channel_selector_late_promotion_1/v3_selector_route_pilot_0/G2_MUX_POS/a_535_374# v3_four_channel_bias_reference_distribution_0/v3_four_channel_phase_distribution_0/phase_90 v3_four_channel_bias_reference_distribution_0/v3_four_channel_phase_distribution_0/v3_four_channel_output_collection_0/v3_four_channel_placement_0/v3_channel_selector_late_promotion_1/v3_selector_route_pilot_0/G2_MUX_POS/a_76_199# v3_four_channel_bias_reference_distribution_0/v3_four_channel_phase_distribution_0/v3_four_channel_output_collection_0/v3_four_channel_placement_0/v3_channel_selector_late_promotion_1/VPWR sky130_fd_pr__pfet_01v8_hvt ad=0 pd=0 as=0 ps=0 w=0.42 l=0.15
X632 v3_four_channel_bias_reference_distribution_0/v3_four_channel_phase_distribution_0/v3_four_channel_output_collection_0/v3_four_channel_placement_0/v3_channel_selector_late_promotion_1/v3_selector_route_pilot_0/G2_MUX_POS/a_76_199# v3_four_channel_bias_reference_distribution_0/v3_four_channel_phase_distribution_0/phase_90 v3_four_channel_bias_reference_distribution_0/v3_four_channel_phase_distribution_0/v3_four_channel_output_collection_0/v3_four_channel_placement_0/v3_channel_selector_late_promotion_1/v3_selector_route_pilot_0/G2_MUX_POS/a_218_47# VSUBS sky130_fd_pr__nfet_01v8 ad=0 pd=0 as=0.1386 ps=1.5 w=0.42 l=0.15
X633 v3_four_channel_bias_reference_distribution_0/v3_four_channel_phase_distribution_0/v3_four_channel_output_collection_0/v3_four_channel_placement_0/v3_channel_selector_late_promotion_1/v3_selector_route_pilot_0/G2_MUX_POS/a_218_47# v3_four_channel_bias_reference_distribution_0/v3_four_channel_phase_distribution_0/v3_four_channel_output_collection_0/v3_four_channel_placement_0/v3_channel_selector_late_promotion_1/group2_bit0 VSUBS VSUBS sky130_fd_pr__nfet_01v8 ad=0 pd=0 as=0 ps=0 w=0.42 l=0.15
X634 v3_four_channel_bias_reference_distribution_0/v3_four_channel_phase_distribution_0/v3_four_channel_output_collection_0/v3_four_channel_placement_0/v3_channel_selector_late_promotion_1/VPWR v3_four_channel_bias_reference_distribution_0/v3_four_channel_phase_distribution_0/v3_four_channel_output_collection_0/v3_four_channel_placement_0/v3_channel_selector_late_promotion_1/v3_selector_route_pilot_0/G2_MUX_POS/a_76_199# v3_four_channel_bias_reference_distribution_0/v3_four_channel_phase_distribution_0/v3_four_channel_output_collection_0/v3_four_channel_placement_0/v3_channel_selector_late_promotion_1/v3_selector_route_pilot_0/G2_MUX_POS/X v3_four_channel_bias_reference_distribution_0/v3_four_channel_phase_distribution_0/v3_four_channel_output_collection_0/v3_four_channel_placement_0/v3_channel_selector_late_promotion_1/VPWR sky130_fd_pr__pfet_01v8_hvt ad=0 pd=0 as=0.26 ps=2.52 w=1 l=0.15
X635 VSUBS v3_four_channel_bias_reference_distribution_0/v3_four_channel_phase_distribution_0/v3_four_channel_output_collection_0/v3_four_channel_placement_0/v3_channel_selector_late_promotion_1/v3_selector_route_pilot_0/G2_MUX_POS/a_76_199# v3_four_channel_bias_reference_distribution_0/v3_four_channel_phase_distribution_0/v3_four_channel_output_collection_0/v3_four_channel_placement_0/v3_channel_selector_late_promotion_1/v3_selector_route_pilot_0/G2_MUX_POS/X VSUBS sky130_fd_pr__nfet_01v8 ad=0 pd=0 as=0.169 ps=1.82 w=0.65 l=0.15
X636 v3_four_channel_bias_reference_distribution_0/v3_four_channel_phase_distribution_0/v3_four_channel_output_collection_0/v3_four_channel_placement_0/v3_channel_selector_late_promotion_1/VPWR v3_four_channel_bias_reference_distribution_0/v3_four_channel_phase_distribution_0/v3_four_channel_output_collection_0/v3_four_channel_placement_0/v3_channel_selector_late_promotion_1/v3_selector_route_pilot_0/G2_MUX_NEG/a_505_21# v3_four_channel_bias_reference_distribution_0/v3_four_channel_phase_distribution_0/v3_four_channel_output_collection_0/v3_four_channel_placement_0/v3_channel_selector_late_promotion_1/v3_selector_route_pilot_0/G2_MUX_NEG/a_535_374# v3_four_channel_bias_reference_distribution_0/v3_four_channel_phase_distribution_0/v3_four_channel_output_collection_0/v3_four_channel_placement_0/v3_channel_selector_late_promotion_1/VPWR sky130_fd_pr__pfet_01v8_hvt ad=0 pd=0 as=0.0882 ps=1.26 w=0.42 l=0.15
X637 v3_four_channel_bias_reference_distribution_0/v3_four_channel_phase_distribution_0/v3_four_channel_output_collection_0/v3_four_channel_placement_0/v3_channel_selector_late_promotion_1/v3_selector_route_pilot_0/G2_MUX_NEG/a_505_21# v3_four_channel_bias_reference_distribution_0/v3_four_channel_phase_distribution_0/v3_four_channel_output_collection_0/v3_four_channel_placement_0/v3_channel_selector_late_promotion_1/group2_bit0 v3_four_channel_bias_reference_distribution_0/v3_four_channel_phase_distribution_0/v3_four_channel_output_collection_0/v3_four_channel_placement_0/v3_channel_selector_late_promotion_1/VPWR v3_four_channel_bias_reference_distribution_0/v3_four_channel_phase_distribution_0/v3_four_channel_output_collection_0/v3_four_channel_placement_0/v3_channel_selector_late_promotion_1/VPWR sky130_fd_pr__pfet_01v8_hvt ad=0.1176 pd=1.4 as=0 ps=0 w=0.42 l=0.15
X638 v3_four_channel_bias_reference_distribution_0/v3_four_channel_phase_distribution_0/v3_four_channel_output_collection_0/v3_four_channel_placement_0/v3_channel_selector_late_promotion_1/v3_selector_route_pilot_0/G2_MUX_NEG/a_218_374# v3_four_channel_bias_reference_distribution_0/v3_four_channel_phase_distribution_0/v3_four_channel_output_collection_0/v3_four_channel_placement_0/v3_channel_selector_late_promotion_1/group2_bit0 v3_four_channel_bias_reference_distribution_0/v3_four_channel_phase_distribution_0/v3_four_channel_output_collection_0/v3_four_channel_placement_0/v3_channel_selector_late_promotion_1/VPWR v3_four_channel_bias_reference_distribution_0/v3_four_channel_phase_distribution_0/v3_four_channel_output_collection_0/v3_four_channel_placement_0/v3_channel_selector_late_promotion_1/VPWR sky130_fd_pr__pfet_01v8_hvt ad=0.1533 pd=1.57 as=0 ps=0 w=0.42 l=0.15
X639 VSUBS v3_four_channel_bias_reference_distribution_0/v3_four_channel_phase_distribution_0/v3_four_channel_output_collection_0/v3_four_channel_placement_0/v3_channel_selector_late_promotion_1/v3_selector_route_pilot_0/G2_MUX_NEG/a_505_21# v3_four_channel_bias_reference_distribution_0/v3_four_channel_phase_distribution_0/v3_four_channel_output_collection_0/v3_four_channel_placement_0/v3_channel_selector_late_promotion_1/v3_selector_route_pilot_0/G2_MUX_NEG/a_439_47# VSUBS sky130_fd_pr__nfet_01v8 ad=0 pd=0 as=0.1386 ps=1.5 w=0.42 l=0.15
X640 v3_four_channel_bias_reference_distribution_0/v3_four_channel_phase_distribution_0/v3_four_channel_output_collection_0/v3_four_channel_placement_0/v3_channel_selector_late_promotion_1/v3_selector_route_pilot_0/G2_MUX_NEG/a_76_199# v3_four_channel_bias_reference_distribution_0/v3_four_channel_phase_distribution_0/phase_180 v3_four_channel_bias_reference_distribution_0/v3_four_channel_phase_distribution_0/v3_four_channel_output_collection_0/v3_four_channel_placement_0/v3_channel_selector_late_promotion_1/v3_selector_route_pilot_0/G2_MUX_NEG/a_218_374# v3_four_channel_bias_reference_distribution_0/v3_four_channel_phase_distribution_0/v3_four_channel_output_collection_0/v3_four_channel_placement_0/v3_channel_selector_late_promotion_1/VPWR sky130_fd_pr__pfet_01v8_hvt ad=0.3864 pd=2.68 as=0 ps=0 w=0.42 l=0.15
X641 v3_four_channel_bias_reference_distribution_0/v3_four_channel_phase_distribution_0/v3_four_channel_output_collection_0/v3_four_channel_placement_0/v3_channel_selector_late_promotion_1/v3_selector_route_pilot_0/G2_MUX_NEG/a_505_21# v3_four_channel_bias_reference_distribution_0/v3_four_channel_phase_distribution_0/v3_four_channel_output_collection_0/v3_four_channel_placement_0/v3_channel_selector_late_promotion_1/group2_bit0 VSUBS VSUBS sky130_fd_pr__nfet_01v8 ad=0.1092 pd=1.36 as=0 ps=0 w=0.42 l=0.15
X642 v3_four_channel_bias_reference_distribution_0/v3_four_channel_phase_distribution_0/v3_four_channel_output_collection_0/v3_four_channel_placement_0/v3_channel_selector_late_promotion_1/v3_selector_route_pilot_0/G2_MUX_NEG/a_439_47# v3_four_channel_bias_reference_distribution_0/v3_four_channel_phase_distribution_0/phase_180 v3_four_channel_bias_reference_distribution_0/v3_four_channel_phase_distribution_0/v3_four_channel_output_collection_0/v3_four_channel_placement_0/v3_channel_selector_late_promotion_1/v3_selector_route_pilot_0/G2_MUX_NEG/a_76_199# VSUBS sky130_fd_pr__nfet_01v8 ad=0 pd=0 as=0.1995 ps=1.79 w=0.42 l=0.15
X643 v3_four_channel_bias_reference_distribution_0/v3_four_channel_phase_distribution_0/v3_four_channel_output_collection_0/v3_four_channel_placement_0/v3_channel_selector_late_promotion_1/v3_selector_route_pilot_0/G2_MUX_NEG/a_535_374# v3_four_channel_bias_reference_distribution_0/v3_four_channel_phase_distribution_0/phase_270 v3_four_channel_bias_reference_distribution_0/v3_four_channel_phase_distribution_0/v3_four_channel_output_collection_0/v3_four_channel_placement_0/v3_channel_selector_late_promotion_1/v3_selector_route_pilot_0/G2_MUX_NEG/a_76_199# v3_four_channel_bias_reference_distribution_0/v3_four_channel_phase_distribution_0/v3_four_channel_output_collection_0/v3_four_channel_placement_0/v3_channel_selector_late_promotion_1/VPWR sky130_fd_pr__pfet_01v8_hvt ad=0 pd=0 as=0 ps=0 w=0.42 l=0.15
X644 v3_four_channel_bias_reference_distribution_0/v3_four_channel_phase_distribution_0/v3_four_channel_output_collection_0/v3_four_channel_placement_0/v3_channel_selector_late_promotion_1/v3_selector_route_pilot_0/G2_MUX_NEG/a_76_199# v3_four_channel_bias_reference_distribution_0/v3_four_channel_phase_distribution_0/phase_270 v3_four_channel_bias_reference_distribution_0/v3_four_channel_phase_distribution_0/v3_four_channel_output_collection_0/v3_four_channel_placement_0/v3_channel_selector_late_promotion_1/v3_selector_route_pilot_0/G2_MUX_NEG/a_218_47# VSUBS sky130_fd_pr__nfet_01v8 ad=0 pd=0 as=0.1386 ps=1.5 w=0.42 l=0.15
X645 v3_four_channel_bias_reference_distribution_0/v3_four_channel_phase_distribution_0/v3_four_channel_output_collection_0/v3_four_channel_placement_0/v3_channel_selector_late_promotion_1/v3_selector_route_pilot_0/G2_MUX_NEG/a_218_47# v3_four_channel_bias_reference_distribution_0/v3_four_channel_phase_distribution_0/v3_four_channel_output_collection_0/v3_four_channel_placement_0/v3_channel_selector_late_promotion_1/group2_bit0 VSUBS VSUBS sky130_fd_pr__nfet_01v8 ad=0 pd=0 as=0 ps=0 w=0.42 l=0.15
X646 v3_four_channel_bias_reference_distribution_0/v3_four_channel_phase_distribution_0/v3_four_channel_output_collection_0/v3_four_channel_placement_0/v3_channel_selector_late_promotion_1/VPWR v3_four_channel_bias_reference_distribution_0/v3_four_channel_phase_distribution_0/v3_four_channel_output_collection_0/v3_four_channel_placement_0/v3_channel_selector_late_promotion_1/v3_selector_route_pilot_0/G2_MUX_NEG/a_76_199# v3_four_channel_bias_reference_distribution_0/v3_four_channel_phase_distribution_0/v3_four_channel_output_collection_0/v3_four_channel_placement_0/v3_channel_selector_late_promotion_1/v3_selector_route_pilot_0/G2_MUX_NEG/X v3_four_channel_bias_reference_distribution_0/v3_four_channel_phase_distribution_0/v3_four_channel_output_collection_0/v3_four_channel_placement_0/v3_channel_selector_late_promotion_1/VPWR sky130_fd_pr__pfet_01v8_hvt ad=0 pd=0 as=0.26 ps=2.52 w=1 l=0.15
X647 VSUBS v3_four_channel_bias_reference_distribution_0/v3_four_channel_phase_distribution_0/v3_four_channel_output_collection_0/v3_four_channel_placement_0/v3_channel_selector_late_promotion_1/v3_selector_route_pilot_0/G2_MUX_NEG/a_76_199# v3_four_channel_bias_reference_distribution_0/v3_four_channel_phase_distribution_0/v3_four_channel_output_collection_0/v3_four_channel_placement_0/v3_channel_selector_late_promotion_1/v3_selector_route_pilot_0/G2_MUX_NEG/X VSUBS sky130_fd_pr__nfet_01v8 ad=0 pd=0 as=0.169 ps=1.82 w=0.65 l=0.15
X648 v3_four_channel_bias_reference_distribution_0/v3_four_channel_phase_distribution_0/v3_four_channel_output_collection_0/v3_four_channel_placement_0/v3_channel_selector_late_promotion_1/VPWR v3_four_channel_bias_reference_distribution_0/v3_four_channel_phase_distribution_0/v3_four_channel_output_collection_0/v3_four_channel_placement_0/v3_channel_selector_late_promotion_1/v3_selector_route_pilot_0/G0_MUX_AXIS/a_505_21# v3_four_channel_bias_reference_distribution_0/v3_four_channel_phase_distribution_0/v3_four_channel_output_collection_0/v3_four_channel_placement_0/v3_channel_selector_late_promotion_1/v3_selector_route_pilot_0/G0_MUX_AXIS/a_535_374# v3_four_channel_bias_reference_distribution_0/v3_four_channel_phase_distribution_0/v3_four_channel_output_collection_0/v3_four_channel_placement_0/v3_channel_selector_late_promotion_1/VPWR sky130_fd_pr__pfet_01v8_hvt ad=0 pd=0 as=0.0882 ps=1.26 w=0.42 l=0.15
X649 v3_four_channel_bias_reference_distribution_0/v3_four_channel_phase_distribution_0/v3_four_channel_output_collection_0/v3_four_channel_placement_0/v3_channel_selector_late_promotion_1/v3_selector_route_pilot_0/G0_MUX_AXIS/a_505_21# v3_four_channel_bias_reference_distribution_0/v3_four_channel_phase_distribution_0/v3_four_channel_output_collection_0/v3_four_channel_placement_0/v3_channel_selector_late_promotion_1/group0_bit1 v3_four_channel_bias_reference_distribution_0/v3_four_channel_phase_distribution_0/v3_four_channel_output_collection_0/v3_four_channel_placement_0/v3_channel_selector_late_promotion_1/VPWR v3_four_channel_bias_reference_distribution_0/v3_four_channel_phase_distribution_0/v3_four_channel_output_collection_0/v3_four_channel_placement_0/v3_channel_selector_late_promotion_1/VPWR sky130_fd_pr__pfet_01v8_hvt ad=0.1176 pd=1.4 as=0 ps=0 w=0.42 l=0.15
X650 v3_four_channel_bias_reference_distribution_0/v3_four_channel_phase_distribution_0/v3_four_channel_output_collection_0/v3_four_channel_placement_0/v3_channel_selector_late_promotion_1/v3_selector_route_pilot_0/G0_MUX_AXIS/a_218_374# v3_four_channel_bias_reference_distribution_0/v3_four_channel_phase_distribution_0/v3_four_channel_output_collection_0/v3_four_channel_placement_0/v3_channel_selector_late_promotion_1/group0_bit1 v3_four_channel_bias_reference_distribution_0/v3_four_channel_phase_distribution_0/v3_four_channel_output_collection_0/v3_four_channel_placement_0/v3_channel_selector_late_promotion_1/VPWR v3_four_channel_bias_reference_distribution_0/v3_four_channel_phase_distribution_0/v3_four_channel_output_collection_0/v3_four_channel_placement_0/v3_channel_selector_late_promotion_1/VPWR sky130_fd_pr__pfet_01v8_hvt ad=0.1533 pd=1.57 as=0 ps=0 w=0.42 l=0.15
X651 VSUBS v3_four_channel_bias_reference_distribution_0/v3_four_channel_phase_distribution_0/v3_four_channel_output_collection_0/v3_four_channel_placement_0/v3_channel_selector_late_promotion_1/v3_selector_route_pilot_0/G0_MUX_AXIS/a_505_21# v3_four_channel_bias_reference_distribution_0/v3_four_channel_phase_distribution_0/v3_four_channel_output_collection_0/v3_four_channel_placement_0/v3_channel_selector_late_promotion_1/v3_selector_route_pilot_0/G0_MUX_AXIS/a_439_47# VSUBS sky130_fd_pr__nfet_01v8 ad=0 pd=0 as=0.1386 ps=1.5 w=0.42 l=0.15
X652 v3_four_channel_bias_reference_distribution_0/v3_four_channel_phase_distribution_0/v3_four_channel_output_collection_0/v3_four_channel_placement_0/v3_channel_selector_late_promotion_1/v3_selector_route_pilot_0/G0_MUX_AXIS/a_76_199# v3_four_channel_bias_reference_distribution_0/v3_four_channel_phase_distribution_0/v3_four_channel_output_collection_0/v3_four_channel_placement_0/v3_channel_selector_late_promotion_1/v3_selector_route_pilot_0/G0_MUX_POS/X v3_four_channel_bias_reference_distribution_0/v3_four_channel_phase_distribution_0/v3_four_channel_output_collection_0/v3_four_channel_placement_0/v3_channel_selector_late_promotion_1/v3_selector_route_pilot_0/G0_MUX_AXIS/a_218_374# v3_four_channel_bias_reference_distribution_0/v3_four_channel_phase_distribution_0/v3_four_channel_output_collection_0/v3_four_channel_placement_0/v3_channel_selector_late_promotion_1/VPWR sky130_fd_pr__pfet_01v8_hvt ad=0.3864 pd=2.68 as=0 ps=0 w=0.42 l=0.15
X653 v3_four_channel_bias_reference_distribution_0/v3_four_channel_phase_distribution_0/v3_four_channel_output_collection_0/v3_four_channel_placement_0/v3_channel_selector_late_promotion_1/v3_selector_route_pilot_0/G0_MUX_AXIS/a_505_21# v3_four_channel_bias_reference_distribution_0/v3_four_channel_phase_distribution_0/v3_four_channel_output_collection_0/v3_four_channel_placement_0/v3_channel_selector_late_promotion_1/group0_bit1 VSUBS VSUBS sky130_fd_pr__nfet_01v8 ad=0.1092 pd=1.36 as=0 ps=0 w=0.42 l=0.15
X654 v3_four_channel_bias_reference_distribution_0/v3_four_channel_phase_distribution_0/v3_four_channel_output_collection_0/v3_four_channel_placement_0/v3_channel_selector_late_promotion_1/v3_selector_route_pilot_0/G0_MUX_AXIS/a_439_47# v3_four_channel_bias_reference_distribution_0/v3_four_channel_phase_distribution_0/v3_four_channel_output_collection_0/v3_four_channel_placement_0/v3_channel_selector_late_promotion_1/v3_selector_route_pilot_0/G0_MUX_POS/X v3_four_channel_bias_reference_distribution_0/v3_four_channel_phase_distribution_0/v3_four_channel_output_collection_0/v3_four_channel_placement_0/v3_channel_selector_late_promotion_1/v3_selector_route_pilot_0/G0_MUX_AXIS/a_76_199# VSUBS sky130_fd_pr__nfet_01v8 ad=0 pd=0 as=0.1995 ps=1.79 w=0.42 l=0.15
X655 v3_four_channel_bias_reference_distribution_0/v3_four_channel_phase_distribution_0/v3_four_channel_output_collection_0/v3_four_channel_placement_0/v3_channel_selector_late_promotion_1/v3_selector_route_pilot_0/G0_MUX_AXIS/a_535_374# v3_four_channel_bias_reference_distribution_0/v3_four_channel_phase_distribution_0/v3_four_channel_output_collection_0/v3_four_channel_placement_0/v3_channel_selector_late_promotion_1/v3_selector_route_pilot_0/G0_MUX_NEG/X v3_four_channel_bias_reference_distribution_0/v3_four_channel_phase_distribution_0/v3_four_channel_output_collection_0/v3_four_channel_placement_0/v3_channel_selector_late_promotion_1/v3_selector_route_pilot_0/G0_MUX_AXIS/a_76_199# v3_four_channel_bias_reference_distribution_0/v3_four_channel_phase_distribution_0/v3_four_channel_output_collection_0/v3_four_channel_placement_0/v3_channel_selector_late_promotion_1/VPWR sky130_fd_pr__pfet_01v8_hvt ad=0 pd=0 as=0 ps=0 w=0.42 l=0.15
X656 v3_four_channel_bias_reference_distribution_0/v3_four_channel_phase_distribution_0/v3_four_channel_output_collection_0/v3_four_channel_placement_0/v3_channel_selector_late_promotion_1/v3_selector_route_pilot_0/G0_MUX_AXIS/a_76_199# v3_four_channel_bias_reference_distribution_0/v3_four_channel_phase_distribution_0/v3_four_channel_output_collection_0/v3_four_channel_placement_0/v3_channel_selector_late_promotion_1/v3_selector_route_pilot_0/G0_MUX_NEG/X v3_four_channel_bias_reference_distribution_0/v3_four_channel_phase_distribution_0/v3_four_channel_output_collection_0/v3_four_channel_placement_0/v3_channel_selector_late_promotion_1/v3_selector_route_pilot_0/G0_MUX_AXIS/a_218_47# VSUBS sky130_fd_pr__nfet_01v8 ad=0 pd=0 as=0.1386 ps=1.5 w=0.42 l=0.15
X657 v3_four_channel_bias_reference_distribution_0/v3_four_channel_phase_distribution_0/v3_four_channel_output_collection_0/v3_four_channel_placement_0/v3_channel_selector_late_promotion_1/v3_selector_route_pilot_0/G0_MUX_AXIS/a_218_47# v3_four_channel_bias_reference_distribution_0/v3_four_channel_phase_distribution_0/v3_four_channel_output_collection_0/v3_four_channel_placement_0/v3_channel_selector_late_promotion_1/group0_bit1 VSUBS VSUBS sky130_fd_pr__nfet_01v8 ad=0 pd=0 as=0 ps=0 w=0.42 l=0.15
X658 v3_four_channel_bias_reference_distribution_0/v3_four_channel_phase_distribution_0/v3_four_channel_output_collection_0/v3_four_channel_placement_0/v3_channel_selector_late_promotion_1/VPWR v3_four_channel_bias_reference_distribution_0/v3_four_channel_phase_distribution_0/v3_four_channel_output_collection_0/v3_four_channel_placement_0/v3_channel_selector_late_promotion_1/v3_selector_route_pilot_0/G0_MUX_AXIS/a_76_199# v3_four_channel_bias_reference_distribution_0/v3_four_channel_phase_distribution_0/v3_four_channel_output_collection_0/v3_four_channel_placement_0/v3_channel_selector_late_promotion_1/v3_selector_route_pilot_0/G0_MUX_AXIS/X v3_four_channel_bias_reference_distribution_0/v3_four_channel_phase_distribution_0/v3_four_channel_output_collection_0/v3_four_channel_placement_0/v3_channel_selector_late_promotion_1/VPWR sky130_fd_pr__pfet_01v8_hvt ad=0 pd=0 as=0.26 ps=2.52 w=1 l=0.15
X659 VSUBS v3_four_channel_bias_reference_distribution_0/v3_four_channel_phase_distribution_0/v3_four_channel_output_collection_0/v3_four_channel_placement_0/v3_channel_selector_late_promotion_1/v3_selector_route_pilot_0/G0_MUX_AXIS/a_76_199# v3_four_channel_bias_reference_distribution_0/v3_four_channel_phase_distribution_0/v3_four_channel_output_collection_0/v3_four_channel_placement_0/v3_channel_selector_late_promotion_1/v3_selector_route_pilot_0/G0_MUX_AXIS/X VSUBS sky130_fd_pr__nfet_01v8 ad=0 pd=0 as=0.169 ps=1.82 w=0.65 l=0.15
X660 v3_four_channel_bias_reference_distribution_0/v3_four_channel_phase_distribution_0/v3_four_channel_output_collection_0/v3_four_channel_placement_0/v3_channel_selector_late_promotion_1/VPWR v3_four_channel_bias_reference_distribution_0/v3_four_channel_phase_distribution_0/v3_four_channel_output_collection_0/v3_four_channel_placement_0/v3_channel_selector_late_promotion_1/v3_selector_route_pilot_0/G3_LO_P_AND/B v3_four_channel_bias_reference_distribution_0/v3_four_channel_phase_distribution_0/v3_four_channel_output_collection_0/v3_four_channel_placement_0/v3_channel_selector_late_promotion_1/v3_selector_route_pilot_0/G2_LO_P_AND/a_59_75# v3_four_channel_bias_reference_distribution_0/v3_four_channel_phase_distribution_0/v3_four_channel_output_collection_0/v3_four_channel_placement_0/v3_channel_selector_late_promotion_1/VPWR sky130_fd_pr__pfet_01v8_hvt ad=0 pd=0 as=0.1134 ps=1.38 w=0.42 l=0.15
X661 v3_four_channel_bias_reference_distribution_0/v3_four_channel_phase_distribution_0/v3_four_channel_output_collection_0/v3_four_channel_placement_0/v3_channel_selector_late_promotion_1/v3_selector_route_pilot_0/group2_lo_p v3_four_channel_bias_reference_distribution_0/v3_four_channel_phase_distribution_0/v3_four_channel_output_collection_0/v3_four_channel_placement_0/v3_channel_selector_late_promotion_1/v3_selector_route_pilot_0/G2_LO_P_AND/a_59_75# v3_four_channel_bias_reference_distribution_0/v3_four_channel_phase_distribution_0/v3_four_channel_output_collection_0/v3_four_channel_placement_0/v3_channel_selector_late_promotion_1/VPWR v3_four_channel_bias_reference_distribution_0/v3_four_channel_phase_distribution_0/v3_four_channel_output_collection_0/v3_four_channel_placement_0/v3_channel_selector_late_promotion_1/VPWR sky130_fd_pr__pfet_01v8_hvt ad=0.475 pd=2.95 as=0 ps=0 w=1 l=0.15
X662 VSUBS v3_four_channel_bias_reference_distribution_0/v3_four_channel_phase_distribution_0/v3_four_channel_output_collection_0/v3_four_channel_placement_0/v3_channel_selector_late_promotion_1/v3_selector_route_pilot_0/G3_LO_P_AND/B v3_four_channel_bias_reference_distribution_0/v3_four_channel_phase_distribution_0/v3_four_channel_output_collection_0/v3_four_channel_placement_0/v3_channel_selector_late_promotion_1/v3_selector_route_pilot_0/G2_LO_P_AND/a_145_75# VSUBS sky130_fd_pr__nfet_01v8 ad=0 pd=0 as=0.1134 ps=1.38 w=0.42 l=0.15
X663 v3_four_channel_bias_reference_distribution_0/v3_four_channel_phase_distribution_0/v3_four_channel_output_collection_0/v3_four_channel_placement_0/v3_channel_selector_late_promotion_1/v3_selector_route_pilot_0/G2_LO_P_AND/a_59_75# v3_four_channel_bias_reference_distribution_0/v3_four_channel_phase_distribution_0/v3_four_channel_output_collection_0/v3_four_channel_placement_0/v3_channel_selector_late_promotion_1/v3_selector_route_pilot_0/G2_MUX_AXIS/X v3_four_channel_bias_reference_distribution_0/v3_four_channel_phase_distribution_0/v3_four_channel_output_collection_0/v3_four_channel_placement_0/v3_channel_selector_late_promotion_1/VPWR v3_four_channel_bias_reference_distribution_0/v3_four_channel_phase_distribution_0/v3_four_channel_output_collection_0/v3_four_channel_placement_0/v3_channel_selector_late_promotion_1/VPWR sky130_fd_pr__pfet_01v8_hvt ad=0 pd=0 as=0 ps=0 w=0.42 l=0.15
X664 v3_four_channel_bias_reference_distribution_0/v3_four_channel_phase_distribution_0/v3_four_channel_output_collection_0/v3_four_channel_placement_0/v3_channel_selector_late_promotion_1/v3_selector_route_pilot_0/group2_lo_p v3_four_channel_bias_reference_distribution_0/v3_four_channel_phase_distribution_0/v3_four_channel_output_collection_0/v3_four_channel_placement_0/v3_channel_selector_late_promotion_1/v3_selector_route_pilot_0/G2_LO_P_AND/a_59_75# VSUBS VSUBS sky130_fd_pr__nfet_01v8 ad=0.182 pd=1.86 as=0 ps=0 w=0.65 l=0.15
X665 v3_four_channel_bias_reference_distribution_0/v3_four_channel_phase_distribution_0/v3_four_channel_output_collection_0/v3_four_channel_placement_0/v3_channel_selector_late_promotion_1/v3_selector_route_pilot_0/G2_LO_P_AND/a_145_75# v3_four_channel_bias_reference_distribution_0/v3_four_channel_phase_distribution_0/v3_four_channel_output_collection_0/v3_four_channel_placement_0/v3_channel_selector_late_promotion_1/v3_selector_route_pilot_0/G2_MUX_AXIS/X v3_four_channel_bias_reference_distribution_0/v3_four_channel_phase_distribution_0/v3_four_channel_output_collection_0/v3_four_channel_placement_0/v3_channel_selector_late_promotion_1/v3_selector_route_pilot_0/G2_LO_P_AND/a_59_75# VSUBS sky130_fd_pr__nfet_01v8 ad=0 pd=0 as=0.1176 ps=1.4 w=0.42 l=0.15
X666 v3_four_channel_bias_reference_distribution_0/v3_four_channel_phase_distribution_0/v3_four_channel_output_collection_0/v3_four_channel_placement_0/v3_channel_selector_late_promotion_2/v3_channel_input_bias_late_promotion_0/a_4678_23422# v3_four_channel_bias_reference_distribution_0/v3_four_channel_phase_distribution_0/v3_four_channel_output_collection_0/v3_four_channel_placement_0/v3_channel_selector_late_promotion_2/v3_selector_route_pilot_0/group3_lo_p v3_four_channel_bias_reference_distribution_0/v3_four_channel_phase_distribution_0/v3_four_channel_output_collection_0/combined_n_internal VSUBS sky130_fd_pr__nfet_01v8 ad=0.6206 pd=6.02 as=0 ps=0 w=0.65 l=0.15
X667 v3_four_channel_bias_reference_distribution_0/v3_four_channel_phase_distribution_0/v3_four_channel_output_collection_0/combined_n_internal v3_four_channel_bias_reference_distribution_0/v3_four_channel_phase_distribution_0/v3_four_channel_output_collection_0/v3_four_channel_placement_0/v3_channel_selector_late_promotion_2/v3_selector_route_pilot_0/group3_lo_p v3_four_channel_bias_reference_distribution_0/v3_four_channel_phase_distribution_0/v3_four_channel_output_collection_0/v3_four_channel_placement_0/v3_channel_selector_late_promotion_2/v3_channel_input_bias_late_promotion_0/a_4254_6978# VSUBS sky130_fd_pr__nfet_01v8 ad=0 pd=0 as=0.6206 ps=6.02 w=0.65 l=0.15
X668 v3_four_channel_bias_reference_distribution_0/v3_four_channel_phase_distribution_0/v3_four_channel_output_collection_0/v3_four_channel_placement_0/v3_channel_selector_late_promotion_2/v3_channel_input_bias_late_promotion_0/a_4678_23422# v3_vcm_support_block_0/ref v3_four_channel_bias_reference_distribution_0/v3_four_channel_phase_distribution_0/v3_four_channel_output_collection_0/v3_four_channel_placement_0/v3_channel_selector_late_promotion_2/v3_channel_input_bias_late_promotion_0/a_4382_21688# VSUBS sky130_fd_pr__nfet_01v8 ad=0 pd=0 as=1.9575 ps=15.24 w=0.84 l=0.6
X669 v3_four_channel_bias_reference_distribution_0/v3_four_channel_phase_distribution_0/v3_four_channel_output_collection_0/combined_n_internal v3_four_channel_bias_reference_distribution_0/v3_four_channel_phase_distribution_0/v3_four_channel_output_collection_0/v3_four_channel_placement_0/v3_channel_selector_late_promotion_2/v3_selector_route_pilot_0/group3_lo_n v3_four_channel_bias_reference_distribution_0/v3_four_channel_phase_distribution_0/v3_four_channel_output_collection_0/v3_four_channel_placement_0/v3_channel_selector_late_promotion_2/v3_channel_input_bias_late_promotion_0/a_7038_22978# VSUBS sky130_fd_pr__nfet_01v8 ad=0 pd=0 as=0.6206 ps=6.02 w=0.65 l=0.15
X670 v3_four_channel_bias_reference_distribution_0/v3_four_channel_phase_distribution_0/v3_four_channel_output_collection_0/combined_n_internal v3_four_channel_bias_reference_distribution_0/v3_four_channel_phase_distribution_0/v3_four_channel_output_collection_0/v3_four_channel_placement_0/v3_channel_selector_late_promotion_2/v3_selector_route_pilot_0/group3_lo_p v3_four_channel_bias_reference_distribution_0/v3_four_channel_phase_distribution_0/v3_four_channel_output_collection_0/v3_four_channel_placement_0/v3_channel_selector_late_promotion_2/v3_channel_input_bias_late_promotion_0/a_7038_6978# VSUBS sky130_fd_pr__nfet_01v8 ad=0 pd=0 as=0.6206 ps=6.02 w=0.65 l=0.15
X671 v3_four_channel_bias_reference_distribution_0/v3_four_channel_phase_distribution_0/v3_four_channel_output_collection_0/v3_four_channel_placement_0/v3_channel_selector_late_promotion_2/v3_channel_input_bias_late_promotion_0/a_7462_11422# v3_four_channel_bias_reference_distribution_0/v3_four_channel_phase_distribution_0/v3_four_channel_output_collection_0/v3_four_channel_placement_0/v3_channel_selector_late_promotion_2/element_input v3_four_channel_bias_reference_distribution_0/v3_four_channel_phase_distribution_0/v3_four_channel_output_collection_0/v3_four_channel_placement_0/v3_channel_selector_late_promotion_2/v3_channel_input_bias_late_promotion_0/a_7216_10978# VSUBS sky130_fd_pr__nfet_01v8 ad=0.6206 pd=6.02 as=1.9575 ps=15.24 w=0.84 l=0.6
X672 v3_four_channel_bias_reference_distribution_0/v3_four_channel_phase_distribution_0/v3_four_channel_output_collection_0/v3_four_channel_placement_0/v3_channel_selector_late_promotion_2/v3_channel_input_bias_late_promotion_0/a_7462_11422# v3_four_channel_bias_reference_distribution_0/v3_four_channel_phase_distribution_0/v3_four_channel_output_collection_0/v3_four_channel_placement_0/v3_channel_selector_late_promotion_2/v3_selector_route_pilot_0/group2_lo_n v3_four_channel_bias_reference_distribution_0/v3_four_channel_phase_distribution_0/v3_four_channel_output_collection_0/combined_n_internal VSUBS sky130_fd_pr__nfet_01v8 ad=0 pd=0 as=0 ps=0 w=0.65 l=0.15
X673 v3_four_channel_bias_reference_distribution_0/v3_four_channel_phase_distribution_0/v3_four_channel_output_collection_0/v3_four_channel_placement_0/v3_channel_selector_late_promotion_2/v3_channel_input_bias_late_promotion_0/a_5774_21688# v3_four_channel_bias_reference_distribution_0/v3_four_channel_phase_distribution_0/v3_four_channel_output_collection_0/v3_four_channel_placement_0/v3_channel_selector_late_promotion_2/element_input v3_four_channel_bias_reference_distribution_0/v3_four_channel_phase_distribution_0/v3_four_channel_output_collection_0/v3_four_channel_placement_0/v3_channel_selector_late_promotion_2/v3_channel_input_bias_late_promotion_0/a_5646_22978# VSUBS sky130_fd_pr__nfet_01v8 ad=1.9575 pd=15.24 as=0.6206 ps=6.02 w=0.84 l=0.6
X674 VSUBS v3_tail_bias_support_block_0/vbias v3_four_channel_bias_reference_distribution_0/v3_four_channel_phase_distribution_0/v3_four_channel_output_collection_0/v3_four_channel_placement_0/v3_channel_selector_late_promotion_2/v3_channel_input_bias_late_promotion_0/a_5774_17688# VSUBS sky130_fd_pr__nfet_01v8 ad=0 pd=0 as=1.9575 ps=15.24 w=5.07 l=1
X675 v3_four_channel_bias_reference_distribution_0/v3_four_channel_phase_distribution_0/v3_four_channel_output_collection_0/v3_four_channel_placement_0/v3_channel_selector_late_promotion_2/v3_channel_input_bias_late_promotion_0/a_6070_7422# v3_four_channel_bias_reference_distribution_0/v3_four_channel_phase_distribution_0/v3_four_channel_output_collection_0/v3_four_channel_placement_0/v3_channel_selector_late_promotion_2/element_input v3_four_channel_bias_reference_distribution_0/v3_four_channel_phase_distribution_0/v3_four_channel_output_collection_0/v3_four_channel_placement_0/v3_channel_selector_late_promotion_2/v3_channel_input_bias_late_promotion_0/a_5824_6978# VSUBS sky130_fd_pr__nfet_01v8 ad=0.6206 pd=6.02 as=1.9575 ps=15.24 w=0.84 l=0.6
X676 v3_four_channel_bias_reference_distribution_0/v3_four_channel_phase_distribution_0/v3_four_channel_output_collection_0/v3_four_channel_placement_0/v3_channel_selector_late_promotion_2/v3_channel_input_bias_late_promotion_0/a_6070_7422# v3_four_channel_bias_reference_distribution_0/v3_four_channel_phase_distribution_0/v3_four_channel_output_collection_0/v3_four_channel_placement_0/v3_channel_selector_late_promotion_2/v3_selector_route_pilot_0/group3_lo_n v3_four_channel_bias_reference_distribution_0/v3_four_channel_phase_distribution_0/v3_four_channel_output_collection_0/combined_n_internal VSUBS sky130_fd_pr__nfet_01v8 ad=0 pd=0 as=0 ps=0 w=0.65 l=0.15
X677 v3_vcm_support_block_0/ref v3_four_channel_bias_reference_distribution_0/v3_four_channel_phase_distribution_0/v3_four_channel_output_collection_0/v3_four_channel_placement_0/v3_channel_selector_late_promotion_2/element_input VSUBS sky130_fd_pr__res_xhigh_po_0p35 l=17.36
X678 v3_four_channel_bias_reference_distribution_0/v3_four_channel_phase_distribution_0/v3_four_channel_output_collection_0/v3_four_channel_placement_0/v3_channel_selector_late_promotion_2/v3_channel_input_bias_late_promotion_0/a_7462_23422# v3_vcm_support_block_0/ref v3_four_channel_bias_reference_distribution_0/v3_four_channel_phase_distribution_0/v3_four_channel_output_collection_0/v3_four_channel_placement_0/v3_channel_selector_late_promotion_2/v3_channel_input_bias_late_promotion_0/a_7166_21688# VSUBS sky130_fd_pr__nfet_01v8 ad=0.6206 pd=6.02 as=1.9575 ps=15.24 w=0.84 l=0.6
X679 v3_four_channel_bias_reference_distribution_0/v3_four_channel_phase_distribution_0/v3_four_channel_output_collection_0/v3_four_channel_placement_0/v3_channel_selector_late_promotion_2/v3_channel_input_bias_late_promotion_0/a_7462_23422# v3_four_channel_bias_reference_distribution_0/v3_four_channel_phase_distribution_0/v3_four_channel_output_collection_0/v3_four_channel_placement_0/v3_channel_selector_late_promotion_2/v3_selector_route_pilot_0/group3_lo_p v3_four_channel_bias_reference_distribution_0/v3_four_channel_phase_distribution_0/v3_four_channel_output_collection_0/combined_n_internal VSUBS sky130_fd_pr__nfet_01v8 ad=0 pd=0 as=0 ps=0 w=0.65 l=0.15
X680 VSUBS v3_tail_bias_support_block_0/vbias v3_four_channel_bias_reference_distribution_0/v3_four_channel_phase_distribution_0/v3_four_channel_output_collection_0/v3_four_channel_placement_0/v3_channel_selector_late_promotion_2/v3_channel_input_bias_late_promotion_0/a_4382_21688# VSUBS sky130_fd_pr__nfet_01v8 ad=0 pd=0 as=0 ps=0 w=5.07 l=1
X681 VSUBS v3_tail_bias_support_block_0/vbias v3_four_channel_bias_reference_distribution_0/v3_four_channel_phase_distribution_0/v3_four_channel_output_collection_0/v3_four_channel_placement_0/v3_channel_selector_late_promotion_2/v3_channel_input_bias_late_promotion_0/a_5774_13688# VSUBS sky130_fd_pr__nfet_01v8 ad=0 pd=0 as=1.9575 ps=15.24 w=5.07 l=1
X682 VSUBS v3_tail_bias_support_block_0/vbias v3_four_channel_bias_reference_distribution_0/v3_four_channel_phase_distribution_0/v3_four_channel_output_collection_0/v3_four_channel_placement_0/v3_channel_selector_late_promotion_2/v3_channel_input_bias_late_promotion_0/a_7166_17688# VSUBS sky130_fd_pr__nfet_01v8 ad=0 pd=0 as=1.9575 ps=15.24 w=5.07 l=1
X683 VSUBS VSUBS VSUBS VSUBS sky130_fd_pr__nfet_01v8 ad=0 pd=0 as=0 ps=0 w=0.65 l=0.15
X684 v3_four_channel_bias_reference_distribution_0/v3_four_channel_phase_distribution_0/v3_four_channel_output_collection_0/combined_p_internal v3_four_channel_bias_reference_distribution_0/v3_four_channel_phase_distribution_0/v3_four_channel_output_collection_0/v3_four_channel_placement_0/v3_channel_selector_late_promotion_2/v3_selector_route_pilot_0/group3_lo_p v3_four_channel_bias_reference_distribution_0/v3_four_channel_phase_distribution_0/v3_four_channel_output_collection_0/v3_four_channel_placement_0/v3_channel_selector_late_promotion_2/v3_channel_input_bias_late_promotion_0/a_5646_18978# VSUBS sky130_fd_pr__nfet_01v8 ad=0 pd=0 as=0.6206 ps=6.02 w=0.65 l=0.15
X685 VSUBS VSUBS VSUBS VSUBS sky130_fd_pr__nfet_01v8 ad=0 pd=0 as=0 ps=0 w=0.65 l=0.15
X686 v3_four_channel_bias_reference_distribution_0/v3_four_channel_phase_distribution_0/v3_four_channel_output_collection_0/v3_four_channel_placement_0/v3_channel_selector_late_promotion_2/v3_channel_input_bias_late_promotion_0/a_6070_19422# v3_four_channel_bias_reference_distribution_0/v3_four_channel_phase_distribution_0/v3_four_channel_output_collection_0/v3_four_channel_placement_0/v3_channel_selector_late_promotion_2/v3_selector_route_pilot_0/group3_lo_n v3_four_channel_bias_reference_distribution_0/v3_four_channel_phase_distribution_0/v3_four_channel_output_collection_0/combined_p_internal VSUBS sky130_fd_pr__nfet_01v8 ad=0.6206 pd=6.02 as=0 ps=0 w=0.65 l=0.15
X687 VSUBS VSUBS VSUBS VSUBS sky130_fd_pr__nfet_01v8 ad=0 pd=0 as=0 ps=0 w=0.65 l=0.15
X688 v3_four_channel_bias_reference_distribution_0/v3_four_channel_phase_distribution_0/v3_four_channel_output_collection_0/combined_p_internal v3_four_channel_bias_reference_distribution_0/v3_four_channel_phase_distribution_0/v3_four_channel_output_collection_0/v3_four_channel_placement_0/v3_channel_selector_late_promotion_2/v3_selector_route_pilot_0/group2_lo_p v3_four_channel_bias_reference_distribution_0/v3_four_channel_phase_distribution_0/v3_four_channel_output_collection_0/v3_four_channel_placement_0/v3_channel_selector_late_promotion_2/v3_channel_input_bias_late_promotion_0/a_4254_18978# VSUBS sky130_fd_pr__nfet_01v8 ad=0 pd=0 as=0.6206 ps=6.02 w=0.65 l=0.15
X689 v3_four_channel_bias_reference_distribution_0/v3_four_channel_phase_distribution_0/v3_four_channel_output_collection_0/v3_four_channel_placement_0/v3_channel_selector_late_promotion_2/v3_channel_input_bias_late_promotion_0/a_7216_14978# v3_tail_bias_support_block_0/vbias VSUBS VSUBS sky130_fd_pr__nfet_01v8 ad=1.9575 pd=15.24 as=0 ps=0 w=5.07 l=1
X690 VSUBS VSUBS VSUBS VSUBS sky130_fd_pr__nfet_01v8 ad=0 pd=0 as=0 ps=0 w=0.65 l=0.15
X691 VSUBS VSUBS VSUBS VSUBS sky130_fd_pr__nfet_01v8 ad=0 pd=0 as=0 ps=0 w=0.65 l=0.15
X692 v3_four_channel_bias_reference_distribution_0/v3_four_channel_phase_distribution_0/v3_four_channel_output_collection_0/v3_four_channel_placement_0/v3_channel_selector_late_promotion_2/v3_channel_input_bias_late_promotion_0/a_4382_17688# v3_four_channel_bias_reference_distribution_0/v3_four_channel_phase_distribution_0/v3_four_channel_output_collection_0/v3_four_channel_placement_0/v3_channel_selector_late_promotion_2/element_input v3_four_channel_bias_reference_distribution_0/v3_four_channel_phase_distribution_0/v3_four_channel_output_collection_0/v3_four_channel_placement_0/v3_channel_selector_late_promotion_2/v3_channel_input_bias_late_promotion_0/a_4254_18978# VSUBS sky130_fd_pr__nfet_01v8 ad=1.9575 pd=15.24 as=0 ps=0 w=0.84 l=0.6
X693 v3_four_channel_bias_reference_distribution_0/v3_four_channel_phase_distribution_0/v3_four_channel_output_collection_0/v3_four_channel_placement_0/v3_channel_selector_late_promotion_2/v3_channel_input_bias_late_promotion_0/a_4678_19422# v3_four_channel_bias_reference_distribution_0/v3_four_channel_phase_distribution_0/v3_four_channel_output_collection_0/v3_four_channel_placement_0/v3_channel_selector_late_promotion_2/v3_selector_route_pilot_0/group2_lo_n v3_four_channel_bias_reference_distribution_0/v3_four_channel_phase_distribution_0/v3_four_channel_output_collection_0/combined_p_internal VSUBS sky130_fd_pr__nfet_01v8 ad=0.6206 pd=6.02 as=0 ps=0 w=0.65 l=0.15
X694 v3_four_channel_bias_reference_distribution_0/v3_four_channel_phase_distribution_0/v3_four_channel_output_collection_0/combined_p_internal v3_four_channel_bias_reference_distribution_0/v3_four_channel_phase_distribution_0/v3_four_channel_output_collection_0/v3_four_channel_placement_0/v3_channel_selector_late_promotion_2/v3_selector_route_pilot_0/group0_lo_p v3_four_channel_bias_reference_distribution_0/v3_four_channel_phase_distribution_0/v3_four_channel_output_collection_0/v3_four_channel_placement_0/v3_channel_selector_late_promotion_2/v3_channel_input_bias_late_promotion_0/a_5646_14978# VSUBS sky130_fd_pr__nfet_01v8 ad=0 pd=0 as=0.6206 ps=6.02 w=0.65 l=0.15
X695 v3_four_channel_bias_reference_distribution_0/v3_four_channel_phase_distribution_0/v3_four_channel_output_collection_0/combined_p_internal v3_four_channel_bias_reference_distribution_0/v3_four_channel_phase_distribution_0/v3_four_channel_output_collection_0/v3_four_channel_placement_0/v3_channel_selector_late_promotion_2/v3_selector_route_pilot_0/group2_lo_p v3_four_channel_bias_reference_distribution_0/v3_four_channel_phase_distribution_0/v3_four_channel_output_collection_0/v3_four_channel_placement_0/v3_channel_selector_late_promotion_2/v3_channel_input_bias_late_promotion_0/a_7038_18978# VSUBS sky130_fd_pr__nfet_01v8 ad=0 pd=0 as=0.6206 ps=6.02 w=0.65 l=0.15
X696 VSUBS VSUBS VSUBS VSUBS sky130_fd_pr__nfet_01v8 ad=0 pd=0 as=0 ps=0 w=5.07 l=1
X697 v3_four_channel_bias_reference_distribution_0/v3_four_channel_phase_distribution_0/v3_four_channel_output_collection_0/v3_four_channel_placement_0/v3_channel_selector_late_promotion_2/v3_channel_input_bias_late_promotion_0/a_6070_15422# v3_four_channel_bias_reference_distribution_0/v3_four_channel_phase_distribution_0/v3_four_channel_output_collection_0/v3_four_channel_placement_0/v3_channel_selector_late_promotion_2/v3_selector_route_pilot_0/group0_lo_n v3_four_channel_bias_reference_distribution_0/v3_four_channel_phase_distribution_0/v3_four_channel_output_collection_0/combined_p_internal VSUBS sky130_fd_pr__nfet_01v8 ad=0.6206 pd=6.02 as=0 ps=0 w=0.65 l=0.15
X698 v3_four_channel_bias_reference_distribution_0/v3_four_channel_phase_distribution_0/v3_four_channel_output_collection_0/v3_four_channel_placement_0/v3_channel_selector_late_promotion_2/v3_channel_input_bias_late_promotion_0/a_7166_17688# v3_four_channel_bias_reference_distribution_0/v3_four_channel_phase_distribution_0/v3_four_channel_output_collection_0/v3_four_channel_placement_0/v3_channel_selector_late_promotion_2/element_input v3_four_channel_bias_reference_distribution_0/v3_four_channel_phase_distribution_0/v3_four_channel_output_collection_0/v3_four_channel_placement_0/v3_channel_selector_late_promotion_2/v3_channel_input_bias_late_promotion_0/a_7038_18978# VSUBS sky130_fd_pr__nfet_01v8 ad=0 pd=0 as=0 ps=0 w=0.84 l=0.6
X699 v3_four_channel_bias_reference_distribution_0/v3_four_channel_phase_distribution_0/v3_four_channel_output_collection_0/combined_n_internal v3_four_channel_bias_reference_distribution_0/v3_four_channel_phase_distribution_0/v3_four_channel_output_collection_0/v3_four_channel_placement_0/v3_channel_selector_late_promotion_2/v3_selector_route_pilot_0/group3_lo_n v3_four_channel_bias_reference_distribution_0/v3_four_channel_phase_distribution_0/v3_four_channel_output_collection_0/v3_four_channel_placement_0/v3_channel_selector_late_promotion_2/v3_channel_input_bias_late_promotion_0/a_5646_18978# VSUBS sky130_fd_pr__nfet_01v8 ad=0 pd=0 as=0 ps=0 w=0.65 l=0.15
X700 VSUBS v3_tail_bias_support_block_0/vbias v3_four_channel_bias_reference_distribution_0/v3_four_channel_phase_distribution_0/v3_four_channel_output_collection_0/v3_four_channel_placement_0/v3_channel_selector_late_promotion_2/v3_channel_input_bias_late_promotion_0/a_5774_21688# VSUBS sky130_fd_pr__nfet_01v8 ad=0 pd=0 as=0 ps=0 w=5.07 l=1
X701 v3_four_channel_bias_reference_distribution_0/v3_four_channel_phase_distribution_0/v3_four_channel_output_collection_0/v3_four_channel_placement_0/v3_channel_selector_late_promotion_2/v3_channel_input_bias_late_promotion_0/a_6070_19422# v3_vcm_support_block_0/ref v3_four_channel_bias_reference_distribution_0/v3_four_channel_phase_distribution_0/v3_four_channel_output_collection_0/v3_four_channel_placement_0/v3_channel_selector_late_promotion_2/v3_channel_input_bias_late_promotion_0/a_5774_17688# VSUBS sky130_fd_pr__nfet_01v8 ad=0 pd=0 as=0 ps=0 w=0.84 l=0.6
X702 VSUBS VSUBS VSUBS VSUBS sky130_fd_pr__nfet_01v8 ad=0 pd=0 as=0 ps=0 w=5.07 l=1
X703 v3_four_channel_bias_reference_distribution_0/v3_four_channel_phase_distribution_0/v3_four_channel_output_collection_0/combined_p_internal v3_four_channel_bias_reference_distribution_0/v3_four_channel_phase_distribution_0/v3_four_channel_output_collection_0/v3_four_channel_placement_0/v3_channel_selector_late_promotion_2/v3_selector_route_pilot_0/group1_lo_p v3_four_channel_bias_reference_distribution_0/v3_four_channel_phase_distribution_0/v3_four_channel_output_collection_0/v3_four_channel_placement_0/v3_channel_selector_late_promotion_2/v3_channel_input_bias_late_promotion_0/a_4254_14978# VSUBS sky130_fd_pr__nfet_01v8 ad=0 pd=0 as=0.6206 ps=6.02 w=0.65 l=0.15
X704 v3_four_channel_bias_reference_distribution_0/v3_four_channel_phase_distribution_0/v3_four_channel_output_collection_0/v3_four_channel_placement_0/v3_channel_selector_late_promotion_2/v3_channel_input_bias_late_promotion_0/a_6070_19422# v3_four_channel_bias_reference_distribution_0/v3_four_channel_phase_distribution_0/v3_four_channel_output_collection_0/v3_four_channel_placement_0/v3_channel_selector_late_promotion_2/v3_selector_route_pilot_0/group3_lo_p v3_four_channel_bias_reference_distribution_0/v3_four_channel_phase_distribution_0/v3_four_channel_output_collection_0/combined_n_internal VSUBS sky130_fd_pr__nfet_01v8 ad=0 pd=0 as=0 ps=0 w=0.65 l=0.15
X705 VSUBS VSUBS VSUBS VSUBS sky130_fd_pr__nfet_01v8 ad=0 pd=0 as=0 ps=0 w=0.65 l=0.15
X706 v3_four_channel_bias_reference_distribution_0/v3_four_channel_phase_distribution_0/v3_four_channel_output_collection_0/v3_four_channel_placement_0/v3_channel_selector_late_promotion_2/v3_channel_input_bias_late_promotion_0/a_5824_10978# v3_tail_bias_support_block_0/vbias VSUBS VSUBS sky130_fd_pr__nfet_01v8 ad=1.9575 pd=15.24 as=0 ps=0 w=5.07 l=1
X707 v3_four_channel_bias_reference_distribution_0/v3_four_channel_phase_distribution_0/v3_four_channel_output_collection_0/v3_four_channel_placement_0/v3_channel_selector_late_promotion_2/v3_channel_input_bias_late_promotion_0/a_4382_13688# v3_four_channel_bias_reference_distribution_0/v3_four_channel_phase_distribution_0/v3_four_channel_output_collection_0/v3_four_channel_placement_0/v3_channel_selector_late_promotion_2/element_input v3_four_channel_bias_reference_distribution_0/v3_four_channel_phase_distribution_0/v3_four_channel_output_collection_0/v3_four_channel_placement_0/v3_channel_selector_late_promotion_2/v3_channel_input_bias_late_promotion_0/a_4254_14978# VSUBS sky130_fd_pr__nfet_01v8 ad=1.9575 pd=15.24 as=0 ps=0 w=0.84 l=0.6
X708 v3_four_channel_bias_reference_distribution_0/v3_four_channel_phase_distribution_0/v3_four_channel_output_collection_0/v3_four_channel_placement_0/v3_channel_selector_late_promotion_2/v3_channel_input_bias_late_promotion_0/a_4678_15422# v3_four_channel_bias_reference_distribution_0/v3_four_channel_phase_distribution_0/v3_four_channel_output_collection_0/v3_four_channel_placement_0/v3_channel_selector_late_promotion_2/v3_selector_route_pilot_0/group1_lo_n v3_four_channel_bias_reference_distribution_0/v3_four_channel_phase_distribution_0/v3_four_channel_output_collection_0/combined_p_internal VSUBS sky130_fd_pr__nfet_01v8 ad=0.6206 pd=6.02 as=0 ps=0 w=0.65 l=0.15
X709 v3_four_channel_bias_reference_distribution_0/v3_four_channel_phase_distribution_0/v3_four_channel_output_collection_0/combined_n_internal v3_four_channel_bias_reference_distribution_0/v3_four_channel_phase_distribution_0/v3_four_channel_output_collection_0/v3_four_channel_placement_0/v3_channel_selector_late_promotion_2/v3_selector_route_pilot_0/group2_lo_n v3_four_channel_bias_reference_distribution_0/v3_four_channel_phase_distribution_0/v3_four_channel_output_collection_0/v3_four_channel_placement_0/v3_channel_selector_late_promotion_2/v3_channel_input_bias_late_promotion_0/a_4254_18978# VSUBS sky130_fd_pr__nfet_01v8 ad=0 pd=0 as=0 ps=0 w=0.65 l=0.15
X710 v3_four_channel_bias_reference_distribution_0/v3_four_channel_phase_distribution_0/v3_four_channel_output_collection_0/combined_p_internal v3_four_channel_bias_reference_distribution_0/v3_four_channel_phase_distribution_0/v3_four_channel_output_collection_0/v3_four_channel_placement_0/v3_channel_selector_late_promotion_2/v3_selector_route_pilot_0/group3_lo_n v3_four_channel_bias_reference_distribution_0/v3_four_channel_phase_distribution_0/v3_four_channel_output_collection_0/v3_four_channel_placement_0/v3_channel_selector_late_promotion_2/v3_channel_input_bias_late_promotion_0/a_5646_10978# VSUBS sky130_fd_pr__nfet_01v8 ad=0 pd=0 as=0.6206 ps=6.02 w=0.65 l=0.15
X711 v3_four_channel_bias_reference_distribution_0/v3_four_channel_phase_distribution_0/v3_four_channel_output_collection_0/combined_p_internal v3_four_channel_bias_reference_distribution_0/v3_four_channel_phase_distribution_0/v3_four_channel_output_collection_0/v3_four_channel_placement_0/v3_channel_selector_late_promotion_2/v3_selector_route_pilot_0/group1_lo_n v3_four_channel_bias_reference_distribution_0/v3_four_channel_phase_distribution_0/v3_four_channel_output_collection_0/v3_four_channel_placement_0/v3_channel_selector_late_promotion_2/v3_channel_input_bias_late_promotion_0/a_7038_14978# VSUBS sky130_fd_pr__nfet_01v8 ad=0 pd=0 as=0.6206 ps=6.02 w=0.65 l=0.15
X712 v3_four_channel_bias_reference_distribution_0/v3_four_channel_phase_distribution_0/v3_four_channel_output_collection_0/v3_four_channel_placement_0/v3_channel_selector_late_promotion_2/v3_channel_input_bias_late_promotion_0/a_7462_19422# v3_four_channel_bias_reference_distribution_0/v3_four_channel_phase_distribution_0/v3_four_channel_output_collection_0/v3_four_channel_placement_0/v3_channel_selector_late_promotion_2/v3_selector_route_pilot_0/group2_lo_n v3_four_channel_bias_reference_distribution_0/v3_four_channel_phase_distribution_0/v3_four_channel_output_collection_0/combined_p_internal VSUBS sky130_fd_pr__nfet_01v8 ad=0.6206 pd=6.02 as=0 ps=0 w=0.65 l=0.15
X713 v3_four_channel_bias_reference_distribution_0/v3_four_channel_phase_distribution_0/v3_four_channel_output_collection_0/v3_four_channel_placement_0/v3_channel_selector_late_promotion_2/v3_channel_input_bias_late_promotion_0/a_4678_7422# v3_four_channel_bias_reference_distribution_0/v3_four_channel_phase_distribution_0/v3_four_channel_output_collection_0/v3_four_channel_placement_0/v3_channel_selector_late_promotion_2/v3_selector_route_pilot_0/group3_lo_p v3_four_channel_bias_reference_distribution_0/v3_four_channel_phase_distribution_0/v3_four_channel_output_collection_0/combined_p_internal VSUBS sky130_fd_pr__nfet_01v8 ad=0.6206 pd=6.02 as=0 ps=0 w=0.65 l=0.15
X714 v3_four_channel_bias_reference_distribution_0/v3_four_channel_phase_distribution_0/v3_four_channel_output_collection_0/v3_four_channel_placement_0/v3_channel_selector_late_promotion_2/v3_channel_input_bias_late_promotion_0/a_6070_11422# v3_four_channel_bias_reference_distribution_0/v3_four_channel_phase_distribution_0/v3_four_channel_output_collection_0/v3_four_channel_placement_0/v3_channel_selector_late_promotion_2/v3_selector_route_pilot_0/group3_lo_p v3_four_channel_bias_reference_distribution_0/v3_four_channel_phase_distribution_0/v3_four_channel_output_collection_0/combined_p_internal VSUBS sky130_fd_pr__nfet_01v8 ad=0.6206 pd=6.02 as=0 ps=0 w=0.65 l=0.15
X715 v3_four_channel_bias_reference_distribution_0/v3_four_channel_phase_distribution_0/v3_four_channel_output_collection_0/v3_four_channel_placement_0/v3_channel_selector_late_promotion_2/v3_channel_input_bias_late_promotion_0/a_7216_10978# v3_tail_bias_support_block_0/vbias VSUBS VSUBS sky130_fd_pr__nfet_01v8 ad=0 pd=0 as=0 ps=0 w=5.07 l=1
X716 v3_four_channel_bias_reference_distribution_0/v3_four_channel_phase_distribution_0/v3_four_channel_output_collection_0/v3_four_channel_placement_0/v3_channel_selector_late_promotion_2/v3_channel_input_bias_late_promotion_0/a_7216_14978# v3_vcm_support_block_0/ref v3_four_channel_bias_reference_distribution_0/v3_four_channel_phase_distribution_0/v3_four_channel_output_collection_0/v3_four_channel_placement_0/v3_channel_selector_late_promotion_2/v3_channel_input_bias_late_promotion_0/a_7038_14978# VSUBS sky130_fd_pr__nfet_01v8 ad=0 pd=0 as=0 ps=0 w=0.84 l=0.6
X717 v3_four_channel_bias_reference_distribution_0/v3_four_channel_phase_distribution_0/v3_four_channel_output_collection_0/v3_four_channel_placement_0/v3_channel_selector_late_promotion_2/v3_channel_input_bias_late_promotion_0/a_4678_19422# v3_vcm_support_block_0/ref v3_four_channel_bias_reference_distribution_0/v3_four_channel_phase_distribution_0/v3_four_channel_output_collection_0/v3_four_channel_placement_0/v3_channel_selector_late_promotion_2/v3_channel_input_bias_late_promotion_0/a_4382_17688# VSUBS sky130_fd_pr__nfet_01v8 ad=0 pd=0 as=0 ps=0 w=0.84 l=0.6
X718 v3_four_channel_bias_reference_distribution_0/v3_four_channel_phase_distribution_0/v3_four_channel_output_collection_0/v3_four_channel_placement_0/v3_channel_selector_late_promotion_2/v3_channel_input_bias_late_promotion_0/a_4678_19422# v3_four_channel_bias_reference_distribution_0/v3_four_channel_phase_distribution_0/v3_four_channel_output_collection_0/v3_four_channel_placement_0/v3_channel_selector_late_promotion_2/v3_selector_route_pilot_0/group2_lo_p v3_four_channel_bias_reference_distribution_0/v3_four_channel_phase_distribution_0/v3_four_channel_output_collection_0/combined_n_internal VSUBS sky130_fd_pr__nfet_01v8 ad=0 pd=0 as=0 ps=0 w=0.65 l=0.15
X719 v3_four_channel_bias_reference_distribution_0/v3_four_channel_phase_distribution_0/v3_four_channel_output_collection_0/combined_n_internal v3_four_channel_bias_reference_distribution_0/v3_four_channel_phase_distribution_0/v3_four_channel_output_collection_0/v3_four_channel_placement_0/v3_channel_selector_late_promotion_2/v3_selector_route_pilot_0/group0_lo_n v3_four_channel_bias_reference_distribution_0/v3_four_channel_phase_distribution_0/v3_four_channel_output_collection_0/v3_four_channel_placement_0/v3_channel_selector_late_promotion_2/v3_channel_input_bias_late_promotion_0/a_5646_14978# VSUBS sky130_fd_pr__nfet_01v8 ad=0 pd=0 as=0 ps=0 w=0.65 l=0.15
X720 v3_four_channel_bias_reference_distribution_0/v3_four_channel_phase_distribution_0/v3_four_channel_output_collection_0/combined_n_internal v3_four_channel_bias_reference_distribution_0/v3_four_channel_phase_distribution_0/v3_four_channel_output_collection_0/v3_four_channel_placement_0/v3_channel_selector_late_promotion_2/v3_selector_route_pilot_0/group2_lo_n v3_four_channel_bias_reference_distribution_0/v3_four_channel_phase_distribution_0/v3_four_channel_output_collection_0/v3_four_channel_placement_0/v3_channel_selector_late_promotion_2/v3_channel_input_bias_late_promotion_0/a_7038_18978# VSUBS sky130_fd_pr__nfet_01v8 ad=0 pd=0 as=0 ps=0 w=0.65 l=0.15
X721 v3_four_channel_bias_reference_distribution_0/v3_four_channel_phase_distribution_0/v3_four_channel_output_collection_0/v3_four_channel_placement_0/v3_channel_selector_late_promotion_2/v3_channel_input_bias_late_promotion_0/a_7462_7422# v3_four_channel_bias_reference_distribution_0/v3_four_channel_phase_distribution_0/v3_four_channel_output_collection_0/v3_four_channel_placement_0/v3_channel_selector_late_promotion_2/v3_selector_route_pilot_0/group3_lo_p v3_four_channel_bias_reference_distribution_0/v3_four_channel_phase_distribution_0/v3_four_channel_output_collection_0/combined_p_internal VSUBS sky130_fd_pr__nfet_01v8 ad=0.6206 pd=6.02 as=0 ps=0 w=0.65 l=0.15
X722 VSUBS v3_tail_bias_support_block_0/vbias v3_four_channel_bias_reference_distribution_0/v3_four_channel_phase_distribution_0/v3_four_channel_output_collection_0/v3_four_channel_placement_0/v3_channel_selector_late_promotion_2/v3_channel_input_bias_late_promotion_0/a_7166_21688# VSUBS sky130_fd_pr__nfet_01v8 ad=0 pd=0 as=0 ps=0 w=5.07 l=1
X723 v3_four_channel_bias_reference_distribution_0/v3_four_channel_phase_distribution_0/v3_four_channel_output_collection_0/v3_four_channel_placement_0/v3_channel_selector_late_promotion_2/v3_channel_input_bias_late_promotion_0/a_6070_15422# v3_vcm_support_block_0/ref v3_four_channel_bias_reference_distribution_0/v3_four_channel_phase_distribution_0/v3_four_channel_output_collection_0/v3_four_channel_placement_0/v3_channel_selector_late_promotion_2/v3_channel_input_bias_late_promotion_0/a_5774_13688# VSUBS sky130_fd_pr__nfet_01v8 ad=0 pd=0 as=0 ps=0 w=0.84 l=0.6
X724 v3_four_channel_bias_reference_distribution_0/v3_four_channel_phase_distribution_0/v3_four_channel_output_collection_0/combined_p_internal v3_four_channel_bias_reference_distribution_0/v3_four_channel_phase_distribution_0/v3_four_channel_output_collection_0/v3_four_channel_placement_0/v3_channel_selector_late_promotion_2/v3_selector_route_pilot_0/group2_lo_n v3_four_channel_bias_reference_distribution_0/v3_four_channel_phase_distribution_0/v3_four_channel_output_collection_0/v3_four_channel_placement_0/v3_channel_selector_late_promotion_2/v3_channel_input_bias_late_promotion_0/a_4254_10978# VSUBS sky130_fd_pr__nfet_01v8 ad=0 pd=0 as=0.6206 ps=6.02 w=0.65 l=0.15
X725 v3_four_channel_bias_reference_distribution_0/v3_four_channel_phase_distribution_0/v3_four_channel_output_collection_0/v3_four_channel_placement_0/v3_channel_selector_late_promotion_2/v3_channel_input_bias_late_promotion_0/a_6070_15422# v3_four_channel_bias_reference_distribution_0/v3_four_channel_phase_distribution_0/v3_four_channel_output_collection_0/v3_four_channel_placement_0/v3_channel_selector_late_promotion_2/v3_selector_route_pilot_0/group0_lo_p v3_four_channel_bias_reference_distribution_0/v3_four_channel_phase_distribution_0/v3_four_channel_output_collection_0/combined_n_internal VSUBS sky130_fd_pr__nfet_01v8 ad=0 pd=0 as=0 ps=0 w=0.65 l=0.15
X726 v3_four_channel_bias_reference_distribution_0/v3_four_channel_phase_distribution_0/v3_four_channel_output_collection_0/v3_four_channel_placement_0/v3_channel_selector_late_promotion_2/v3_channel_input_bias_late_promotion_0/a_5824_6978# v3_vcm_support_block_0/ref v3_four_channel_bias_reference_distribution_0/v3_four_channel_phase_distribution_0/v3_four_channel_output_collection_0/v3_four_channel_placement_0/v3_channel_selector_late_promotion_2/v3_channel_input_bias_late_promotion_0/a_5646_6978# VSUBS sky130_fd_pr__nfet_01v8 ad=0 pd=0 as=0.6206 ps=6.02 w=0.84 l=0.6
X727 v3_four_channel_bias_reference_distribution_0/v3_four_channel_phase_distribution_0/v3_four_channel_output_collection_0/v3_four_channel_placement_0/v3_channel_selector_late_promotion_2/v3_channel_input_bias_late_promotion_0/a_5774_17688# v3_four_channel_bias_reference_distribution_0/v3_four_channel_phase_distribution_0/v3_four_channel_output_collection_0/v3_four_channel_placement_0/v3_channel_selector_late_promotion_2/element_input v3_four_channel_bias_reference_distribution_0/v3_four_channel_phase_distribution_0/v3_four_channel_output_collection_0/v3_four_channel_placement_0/v3_channel_selector_late_promotion_2/v3_channel_input_bias_late_promotion_0/a_5646_18978# VSUBS sky130_fd_pr__nfet_01v8 ad=0 pd=0 as=0 ps=0 w=0.84 l=0.6
X728 v3_four_channel_bias_reference_distribution_0/v3_four_channel_phase_distribution_0/v3_four_channel_output_collection_0/combined_p_internal v3_four_channel_bias_reference_distribution_0/v3_four_channel_phase_distribution_0/v3_four_channel_output_collection_0/v3_four_channel_placement_0/v3_channel_selector_late_promotion_2/v3_selector_route_pilot_0/group3_lo_p v3_four_channel_bias_reference_distribution_0/v3_four_channel_phase_distribution_0/v3_four_channel_output_collection_0/v3_four_channel_placement_0/v3_channel_selector_late_promotion_2/v3_channel_input_bias_late_promotion_0/a_5646_22978# VSUBS sky130_fd_pr__nfet_01v8 ad=0 pd=0 as=0 ps=0 w=0.65 l=0.15
X729 v3_four_channel_bias_reference_distribution_0/v3_four_channel_phase_distribution_0/v3_four_channel_output_collection_0/v3_four_channel_placement_0/v3_channel_selector_late_promotion_2/v3_channel_input_bias_late_promotion_0/a_5824_6978# v3_tail_bias_support_block_0/vbias VSUBS VSUBS sky130_fd_pr__nfet_01v8 ad=0 pd=0 as=0 ps=0 w=5.07 l=1
X730 v3_four_channel_bias_reference_distribution_0/v3_four_channel_phase_distribution_0/v3_four_channel_output_collection_0/v3_four_channel_placement_0/v3_channel_selector_late_promotion_2/v3_channel_input_bias_late_promotion_0/a_4432_10978# v3_vcm_support_block_0/ref v3_four_channel_bias_reference_distribution_0/v3_four_channel_phase_distribution_0/v3_four_channel_output_collection_0/v3_four_channel_placement_0/v3_channel_selector_late_promotion_2/v3_channel_input_bias_late_promotion_0/a_4254_10978# VSUBS sky130_fd_pr__nfet_01v8 ad=1.9575 pd=15.24 as=0 ps=0 w=0.84 l=0.6
X731 v3_four_channel_bias_reference_distribution_0/v3_four_channel_phase_distribution_0/v3_four_channel_output_collection_0/v3_four_channel_placement_0/v3_channel_selector_late_promotion_2/v3_channel_input_bias_late_promotion_0/a_4678_11422# v3_four_channel_bias_reference_distribution_0/v3_four_channel_phase_distribution_0/v3_four_channel_output_collection_0/v3_four_channel_placement_0/v3_channel_selector_late_promotion_2/v3_selector_route_pilot_0/group2_lo_p v3_four_channel_bias_reference_distribution_0/v3_four_channel_phase_distribution_0/v3_four_channel_output_collection_0/combined_p_internal VSUBS sky130_fd_pr__nfet_01v8 ad=0.6206 pd=6.02 as=0 ps=0 w=0.65 l=0.15
X732 v3_four_channel_bias_reference_distribution_0/v3_four_channel_phase_distribution_0/v3_four_channel_output_collection_0/v3_four_channel_placement_0/v3_channel_selector_late_promotion_2/v3_channel_input_bias_late_promotion_0/a_6070_23422# v3_four_channel_bias_reference_distribution_0/v3_four_channel_phase_distribution_0/v3_four_channel_output_collection_0/v3_four_channel_placement_0/v3_channel_selector_late_promotion_2/v3_selector_route_pilot_0/group3_lo_n v3_four_channel_bias_reference_distribution_0/v3_four_channel_phase_distribution_0/v3_four_channel_output_collection_0/combined_p_internal VSUBS sky130_fd_pr__nfet_01v8 ad=0.6206 pd=6.02 as=0 ps=0 w=0.65 l=0.15
X733 v3_four_channel_bias_reference_distribution_0/v3_four_channel_phase_distribution_0/v3_four_channel_output_collection_0/combined_n_internal v3_four_channel_bias_reference_distribution_0/v3_four_channel_phase_distribution_0/v3_four_channel_output_collection_0/v3_four_channel_placement_0/v3_channel_selector_late_promotion_2/v3_selector_route_pilot_0/group1_lo_n v3_four_channel_bias_reference_distribution_0/v3_four_channel_phase_distribution_0/v3_four_channel_output_collection_0/v3_four_channel_placement_0/v3_channel_selector_late_promotion_2/v3_channel_input_bias_late_promotion_0/a_4254_14978# VSUBS sky130_fd_pr__nfet_01v8 ad=0 pd=0 as=0 ps=0 w=0.65 l=0.15
X734 v3_four_channel_bias_reference_distribution_0/v3_four_channel_phase_distribution_0/v3_four_channel_output_collection_0/combined_p_internal v3_four_channel_bias_reference_distribution_0/v3_four_channel_phase_distribution_0/v3_four_channel_output_collection_0/v3_four_channel_placement_0/v3_channel_selector_late_promotion_2/v3_selector_route_pilot_0/group2_lo_n v3_four_channel_bias_reference_distribution_0/v3_four_channel_phase_distribution_0/v3_four_channel_output_collection_0/v3_four_channel_placement_0/v3_channel_selector_late_promotion_2/v3_channel_input_bias_late_promotion_0/a_7038_10978# VSUBS sky130_fd_pr__nfet_01v8 ad=0 pd=0 as=0.6206 ps=6.02 w=0.65 l=0.15
X735 v3_four_channel_bias_reference_distribution_0/v3_four_channel_phase_distribution_0/v3_four_channel_output_collection_0/v3_four_channel_placement_0/v3_channel_selector_late_promotion_2/v3_channel_input_bias_late_promotion_0/a_7462_15422# v3_four_channel_bias_reference_distribution_0/v3_four_channel_phase_distribution_0/v3_four_channel_output_collection_0/v3_four_channel_placement_0/v3_channel_selector_late_promotion_2/v3_selector_route_pilot_0/group1_lo_p v3_four_channel_bias_reference_distribution_0/v3_four_channel_phase_distribution_0/v3_four_channel_output_collection_0/combined_p_internal VSUBS sky130_fd_pr__nfet_01v8 ad=0.6206 pd=6.02 as=0 ps=0 w=0.65 l=0.15
X736 VSUBS VSUBS VSUBS VSUBS sky130_fd_pr__nfet_01v8 ad=0 pd=0 as=0 ps=0 w=5.07 l=1
X737 v3_four_channel_bias_reference_distribution_0/v3_four_channel_phase_distribution_0/v3_four_channel_output_collection_0/v3_four_channel_placement_0/v3_channel_selector_late_promotion_2/v3_channel_input_bias_late_promotion_0/a_7216_6978# v3_tail_bias_support_block_0/vbias VSUBS VSUBS sky130_fd_pr__nfet_01v8 ad=1.9575 pd=15.24 as=0 ps=0 w=5.07 l=1
X738 v3_four_channel_bias_reference_distribution_0/v3_four_channel_phase_distribution_0/v3_four_channel_output_collection_0/v3_four_channel_placement_0/v3_channel_selector_late_promotion_2/v3_channel_input_bias_late_promotion_0/a_7216_10978# v3_vcm_support_block_0/ref v3_four_channel_bias_reference_distribution_0/v3_four_channel_phase_distribution_0/v3_four_channel_output_collection_0/v3_four_channel_placement_0/v3_channel_selector_late_promotion_2/v3_channel_input_bias_late_promotion_0/a_7038_10978# VSUBS sky130_fd_pr__nfet_01v8 ad=0 pd=0 as=0 ps=0 w=0.84 l=0.6
X739 v3_four_channel_bias_reference_distribution_0/v3_four_channel_phase_distribution_0/v3_four_channel_output_collection_0/v3_four_channel_placement_0/v3_channel_selector_late_promotion_2/v3_channel_input_bias_late_promotion_0/a_4678_15422# v3_vcm_support_block_0/ref v3_four_channel_bias_reference_distribution_0/v3_four_channel_phase_distribution_0/v3_four_channel_output_collection_0/v3_four_channel_placement_0/v3_channel_selector_late_promotion_2/v3_channel_input_bias_late_promotion_0/a_4382_13688# VSUBS sky130_fd_pr__nfet_01v8 ad=0 pd=0 as=0 ps=0 w=0.84 l=0.6
X740 v3_four_channel_bias_reference_distribution_0/v3_four_channel_phase_distribution_0/v3_four_channel_output_collection_0/v3_four_channel_placement_0/v3_channel_selector_late_promotion_2/v3_channel_input_bias_late_promotion_0/a_4678_15422# v3_four_channel_bias_reference_distribution_0/v3_four_channel_phase_distribution_0/v3_four_channel_output_collection_0/v3_four_channel_placement_0/v3_channel_selector_late_promotion_2/v3_selector_route_pilot_0/group1_lo_p v3_four_channel_bias_reference_distribution_0/v3_four_channel_phase_distribution_0/v3_four_channel_output_collection_0/combined_n_internal VSUBS sky130_fd_pr__nfet_01v8 ad=0 pd=0 as=0 ps=0 w=0.65 l=0.15
X741 v3_four_channel_bias_reference_distribution_0/v3_four_channel_phase_distribution_0/v3_four_channel_output_collection_0/combined_p_internal v3_four_channel_bias_reference_distribution_0/v3_four_channel_phase_distribution_0/v3_four_channel_output_collection_0/v3_four_channel_placement_0/v3_channel_selector_late_promotion_2/v3_selector_route_pilot_0/group3_lo_p v3_four_channel_bias_reference_distribution_0/v3_four_channel_phase_distribution_0/v3_four_channel_output_collection_0/v3_four_channel_placement_0/v3_channel_selector_late_promotion_2/v3_channel_input_bias_late_promotion_0/a_4254_22978# VSUBS sky130_fd_pr__nfet_01v8 ad=0 pd=0 as=0.6206 ps=6.02 w=0.65 l=0.15
X742 v3_four_channel_bias_reference_distribution_0/v3_four_channel_phase_distribution_0/v3_four_channel_output_collection_0/v3_four_channel_placement_0/v3_channel_selector_late_promotion_2/v3_channel_input_bias_late_promotion_0/a_7462_19422# v3_vcm_support_block_0/ref v3_four_channel_bias_reference_distribution_0/v3_four_channel_phase_distribution_0/v3_four_channel_output_collection_0/v3_four_channel_placement_0/v3_channel_selector_late_promotion_2/v3_channel_input_bias_late_promotion_0/a_7166_17688# VSUBS sky130_fd_pr__nfet_01v8 ad=0 pd=0 as=0 ps=0 w=0.84 l=0.6
X743 v3_four_channel_bias_reference_distribution_0/v3_four_channel_phase_distribution_0/v3_four_channel_output_collection_0/combined_n_internal v3_four_channel_bias_reference_distribution_0/v3_four_channel_phase_distribution_0/v3_four_channel_output_collection_0/v3_four_channel_placement_0/v3_channel_selector_late_promotion_2/v3_selector_route_pilot_0/group3_lo_p v3_four_channel_bias_reference_distribution_0/v3_four_channel_phase_distribution_0/v3_four_channel_output_collection_0/v3_four_channel_placement_0/v3_channel_selector_late_promotion_2/v3_channel_input_bias_late_promotion_0/a_5646_10978# VSUBS sky130_fd_pr__nfet_01v8 ad=0 pd=0 as=0 ps=0 w=0.65 l=0.15
X744 v3_four_channel_bias_reference_distribution_0/v3_four_channel_phase_distribution_0/v3_four_channel_output_collection_0/combined_n_internal v3_four_channel_bias_reference_distribution_0/v3_four_channel_phase_distribution_0/v3_four_channel_output_collection_0/v3_four_channel_placement_0/v3_channel_selector_late_promotion_2/v3_selector_route_pilot_0/group1_lo_p v3_four_channel_bias_reference_distribution_0/v3_four_channel_phase_distribution_0/v3_four_channel_output_collection_0/v3_four_channel_placement_0/v3_channel_selector_late_promotion_2/v3_channel_input_bias_late_promotion_0/a_7038_14978# VSUBS sky130_fd_pr__nfet_01v8 ad=0 pd=0 as=0 ps=0 w=0.65 l=0.15
X745 v3_four_channel_bias_reference_distribution_0/v3_four_channel_phase_distribution_0/v3_four_channel_output_collection_0/v3_four_channel_placement_0/v3_channel_selector_late_promotion_2/v3_channel_input_bias_late_promotion_0/a_7462_19422# v3_four_channel_bias_reference_distribution_0/v3_four_channel_phase_distribution_0/v3_four_channel_output_collection_0/v3_four_channel_placement_0/v3_channel_selector_late_promotion_2/v3_selector_route_pilot_0/group2_lo_p v3_four_channel_bias_reference_distribution_0/v3_four_channel_phase_distribution_0/v3_four_channel_output_collection_0/combined_n_internal VSUBS sky130_fd_pr__nfet_01v8 ad=0 pd=0 as=0 ps=0 w=0.65 l=0.15
X746 v3_four_channel_bias_reference_distribution_0/v3_four_channel_phase_distribution_0/v3_four_channel_output_collection_0/v3_four_channel_placement_0/v3_channel_selector_late_promotion_2/v3_channel_input_bias_late_promotion_0/a_4678_7422# v3_four_channel_bias_reference_distribution_0/v3_four_channel_phase_distribution_0/v3_four_channel_output_collection_0/v3_four_channel_placement_0/v3_channel_selector_late_promotion_2/element_input v3_four_channel_bias_reference_distribution_0/v3_four_channel_phase_distribution_0/v3_four_channel_output_collection_0/v3_four_channel_placement_0/v3_channel_selector_late_promotion_2/v3_channel_input_bias_late_promotion_0/a_4432_6978# VSUBS sky130_fd_pr__nfet_01v8 ad=0 pd=0 as=1.9575 ps=15.24 w=0.84 l=0.6
X747 v3_four_channel_bias_reference_distribution_0/v3_four_channel_phase_distribution_0/v3_four_channel_output_collection_0/combined_p_internal v3_four_channel_bias_reference_distribution_0/v3_four_channel_phase_distribution_0/v3_four_channel_output_collection_0/v3_four_channel_placement_0/v3_channel_selector_late_promotion_2/v3_selector_route_pilot_0/group3_lo_n v3_four_channel_bias_reference_distribution_0/v3_four_channel_phase_distribution_0/v3_four_channel_output_collection_0/v3_four_channel_placement_0/v3_channel_selector_late_promotion_2/v3_channel_input_bias_late_promotion_0/a_5646_6978# VSUBS sky130_fd_pr__nfet_01v8 ad=0 pd=0 as=0 ps=0 w=0.65 l=0.15
X748 v3_four_channel_bias_reference_distribution_0/v3_four_channel_phase_distribution_0/v3_four_channel_output_collection_0/v3_four_channel_placement_0/v3_channel_selector_late_promotion_2/v3_channel_input_bias_late_promotion_0/a_4678_7422# v3_four_channel_bias_reference_distribution_0/v3_four_channel_phase_distribution_0/v3_four_channel_output_collection_0/v3_four_channel_placement_0/v3_channel_selector_late_promotion_2/v3_selector_route_pilot_0/group3_lo_n v3_four_channel_bias_reference_distribution_0/v3_four_channel_phase_distribution_0/v3_four_channel_output_collection_0/combined_n_internal VSUBS sky130_fd_pr__nfet_01v8 ad=0 pd=0 as=0 ps=0 w=0.65 l=0.15
X749 v3_four_channel_bias_reference_distribution_0/v3_four_channel_phase_distribution_0/v3_four_channel_output_collection_0/v3_four_channel_placement_0/v3_channel_selector_late_promotion_2/v3_channel_input_bias_late_promotion_0/a_6070_11422# v3_four_channel_bias_reference_distribution_0/v3_four_channel_phase_distribution_0/v3_four_channel_output_collection_0/v3_four_channel_placement_0/v3_channel_selector_late_promotion_2/element_input v3_four_channel_bias_reference_distribution_0/v3_four_channel_phase_distribution_0/v3_four_channel_output_collection_0/v3_four_channel_placement_0/v3_channel_selector_late_promotion_2/v3_channel_input_bias_late_promotion_0/a_5824_10978# VSUBS sky130_fd_pr__nfet_01v8 ad=0 pd=0 as=0 ps=0 w=0.84 l=0.6
X750 v3_four_channel_bias_reference_distribution_0/v3_four_channel_phase_distribution_0/v3_four_channel_output_collection_0/v3_four_channel_placement_0/v3_channel_selector_late_promotion_2/v3_channel_input_bias_late_promotion_0/a_6070_11422# v3_four_channel_bias_reference_distribution_0/v3_four_channel_phase_distribution_0/v3_four_channel_output_collection_0/v3_four_channel_placement_0/v3_channel_selector_late_promotion_2/v3_selector_route_pilot_0/group3_lo_n v3_four_channel_bias_reference_distribution_0/v3_four_channel_phase_distribution_0/v3_four_channel_output_collection_0/combined_n_internal VSUBS sky130_fd_pr__nfet_01v8 ad=0 pd=0 as=0 ps=0 w=0.65 l=0.15
X751 v3_four_channel_bias_reference_distribution_0/v3_four_channel_phase_distribution_0/v3_four_channel_output_collection_0/v3_four_channel_placement_0/v3_channel_selector_late_promotion_2/v3_channel_input_bias_late_promotion_0/a_4382_21688# v3_four_channel_bias_reference_distribution_0/v3_four_channel_phase_distribution_0/v3_four_channel_output_collection_0/v3_four_channel_placement_0/v3_channel_selector_late_promotion_2/element_input v3_four_channel_bias_reference_distribution_0/v3_four_channel_phase_distribution_0/v3_four_channel_output_collection_0/v3_four_channel_placement_0/v3_channel_selector_late_promotion_2/v3_channel_input_bias_late_promotion_0/a_4254_22978# VSUBS sky130_fd_pr__nfet_01v8 ad=0 pd=0 as=0 ps=0 w=0.84 l=0.6
X752 v3_four_channel_bias_reference_distribution_0/v3_four_channel_phase_distribution_0/v3_four_channel_output_collection_0/v3_four_channel_placement_0/v3_channel_selector_late_promotion_2/v3_channel_input_bias_late_promotion_0/a_4678_23422# v3_four_channel_bias_reference_distribution_0/v3_four_channel_phase_distribution_0/v3_four_channel_output_collection_0/v3_four_channel_placement_0/v3_channel_selector_late_promotion_2/v3_selector_route_pilot_0/group3_lo_n v3_four_channel_bias_reference_distribution_0/v3_four_channel_phase_distribution_0/v3_four_channel_output_collection_0/combined_p_internal VSUBS sky130_fd_pr__nfet_01v8 ad=0 pd=0 as=0 ps=0 w=0.65 l=0.15
X753 v3_four_channel_bias_reference_distribution_0/v3_four_channel_phase_distribution_0/v3_four_channel_output_collection_0/combined_p_internal v3_four_channel_bias_reference_distribution_0/v3_four_channel_phase_distribution_0/v3_four_channel_output_collection_0/v3_four_channel_placement_0/v3_channel_selector_late_promotion_2/v3_selector_route_pilot_0/group3_lo_n v3_four_channel_bias_reference_distribution_0/v3_four_channel_phase_distribution_0/v3_four_channel_output_collection_0/v3_four_channel_placement_0/v3_channel_selector_late_promotion_2/v3_channel_input_bias_late_promotion_0/a_4254_6978# VSUBS sky130_fd_pr__nfet_01v8 ad=0 pd=0 as=0 ps=0 w=0.65 l=0.15
X754 v3_four_channel_bias_reference_distribution_0/v3_four_channel_phase_distribution_0/v3_four_channel_output_collection_0/v3_four_channel_placement_0/v3_channel_selector_late_promotion_2/v3_channel_input_bias_late_promotion_0/a_5774_13688# v3_four_channel_bias_reference_distribution_0/v3_four_channel_phase_distribution_0/v3_four_channel_output_collection_0/v3_four_channel_placement_0/v3_channel_selector_late_promotion_2/element_input v3_four_channel_bias_reference_distribution_0/v3_four_channel_phase_distribution_0/v3_four_channel_output_collection_0/v3_four_channel_placement_0/v3_channel_selector_late_promotion_2/v3_channel_input_bias_late_promotion_0/a_5646_14978# VSUBS sky130_fd_pr__nfet_01v8 ad=0 pd=0 as=0 ps=0 w=0.84 l=0.6
X755 v3_four_channel_bias_reference_distribution_0/v3_four_channel_phase_distribution_0/v3_four_channel_output_collection_0/combined_p_internal v3_four_channel_bias_reference_distribution_0/v3_four_channel_phase_distribution_0/v3_four_channel_output_collection_0/v3_four_channel_placement_0/v3_channel_selector_late_promotion_2/v3_selector_route_pilot_0/group3_lo_p v3_four_channel_bias_reference_distribution_0/v3_four_channel_phase_distribution_0/v3_four_channel_output_collection_0/v3_four_channel_placement_0/v3_channel_selector_late_promotion_2/v3_channel_input_bias_late_promotion_0/a_7038_22978# VSUBS sky130_fd_pr__nfet_01v8 ad=0 pd=0 as=0 ps=0 w=0.65 l=0.15
X756 v3_four_channel_bias_reference_distribution_0/v3_four_channel_phase_distribution_0/v3_four_channel_output_collection_0/v3_four_channel_placement_0/v3_channel_selector_late_promotion_2/v3_channel_input_bias_late_promotion_0/a_7462_7422# v3_four_channel_bias_reference_distribution_0/v3_four_channel_phase_distribution_0/v3_four_channel_output_collection_0/v3_four_channel_placement_0/v3_channel_selector_late_promotion_2/element_input v3_four_channel_bias_reference_distribution_0/v3_four_channel_phase_distribution_0/v3_four_channel_output_collection_0/v3_four_channel_placement_0/v3_channel_selector_late_promotion_2/v3_channel_input_bias_late_promotion_0/a_7216_6978# VSUBS sky130_fd_pr__nfet_01v8 ad=0 pd=0 as=0 ps=0 w=0.84 l=0.6
X757 v3_four_channel_bias_reference_distribution_0/v3_four_channel_phase_distribution_0/v3_four_channel_output_collection_0/v3_four_channel_placement_0/v3_channel_selector_late_promotion_2/v3_channel_input_bias_late_promotion_0/a_4432_10978# v3_tail_bias_support_block_0/vbias VSUBS VSUBS sky130_fd_pr__nfet_01v8 ad=0 pd=0 as=0 ps=0 w=5.07 l=1
X758 v3_four_channel_bias_reference_distribution_0/v3_four_channel_phase_distribution_0/v3_four_channel_output_collection_0/v3_four_channel_placement_0/v3_channel_selector_late_promotion_2/v3_channel_input_bias_late_promotion_0/a_7462_7422# v3_four_channel_bias_reference_distribution_0/v3_four_channel_phase_distribution_0/v3_four_channel_output_collection_0/v3_four_channel_placement_0/v3_channel_selector_late_promotion_2/v3_selector_route_pilot_0/group3_lo_n v3_four_channel_bias_reference_distribution_0/v3_four_channel_phase_distribution_0/v3_four_channel_output_collection_0/combined_n_internal VSUBS sky130_fd_pr__nfet_01v8 ad=0 pd=0 as=0 ps=0 w=0.65 l=0.15
X759 VSUBS v3_tail_bias_support_block_0/vbias v3_four_channel_bias_reference_distribution_0/v3_four_channel_phase_distribution_0/v3_four_channel_output_collection_0/v3_four_channel_placement_0/v3_channel_selector_late_promotion_2/v3_channel_input_bias_late_promotion_0/a_4382_17688# VSUBS sky130_fd_pr__nfet_01v8 ad=0 pd=0 as=0 ps=0 w=5.07 l=1
X760 v3_four_channel_bias_reference_distribution_0/v3_four_channel_phase_distribution_0/v3_four_channel_output_collection_0/combined_p_internal v3_four_channel_bias_reference_distribution_0/v3_four_channel_phase_distribution_0/v3_four_channel_output_collection_0/v3_four_channel_placement_0/v3_channel_selector_late_promotion_2/v3_selector_route_pilot_0/group3_lo_n v3_four_channel_bias_reference_distribution_0/v3_four_channel_phase_distribution_0/v3_four_channel_output_collection_0/v3_four_channel_placement_0/v3_channel_selector_late_promotion_2/v3_channel_input_bias_late_promotion_0/a_7038_6978# VSUBS sky130_fd_pr__nfet_01v8 ad=0 pd=0 as=0 ps=0 w=0.65 l=0.15
X761 v3_four_channel_bias_reference_distribution_0/v3_four_channel_phase_distribution_0/v3_four_channel_output_collection_0/combined_n_internal v3_four_channel_bias_reference_distribution_0/v3_four_channel_phase_distribution_0/v3_four_channel_output_collection_0/v3_four_channel_placement_0/v3_channel_selector_late_promotion_2/v3_selector_route_pilot_0/group2_lo_p v3_four_channel_bias_reference_distribution_0/v3_four_channel_phase_distribution_0/v3_four_channel_output_collection_0/v3_four_channel_placement_0/v3_channel_selector_late_promotion_2/v3_channel_input_bias_late_promotion_0/a_4254_10978# VSUBS sky130_fd_pr__nfet_01v8 ad=0 pd=0 as=0 ps=0 w=0.65 l=0.15
X762 v3_four_channel_bias_reference_distribution_0/v3_four_channel_phase_distribution_0/v3_four_channel_output_collection_0/v3_four_channel_placement_0/v3_channel_selector_late_promotion_2/v3_channel_input_bias_late_promotion_0/a_7462_11422# v3_four_channel_bias_reference_distribution_0/v3_four_channel_phase_distribution_0/v3_four_channel_output_collection_0/v3_four_channel_placement_0/v3_channel_selector_late_promotion_2/v3_selector_route_pilot_0/group2_lo_p v3_four_channel_bias_reference_distribution_0/v3_four_channel_phase_distribution_0/v3_four_channel_output_collection_0/combined_p_internal VSUBS sky130_fd_pr__nfet_01v8 ad=0 pd=0 as=0 ps=0 w=0.65 l=0.15
X763 v3_four_channel_bias_reference_distribution_0/v3_four_channel_phase_distribution_0/v3_four_channel_output_collection_0/v3_four_channel_placement_0/v3_channel_selector_late_promotion_2/v3_channel_input_bias_late_promotion_0/a_7166_21688# v3_four_channel_bias_reference_distribution_0/v3_four_channel_phase_distribution_0/v3_four_channel_output_collection_0/v3_four_channel_placement_0/v3_channel_selector_late_promotion_2/element_input v3_four_channel_bias_reference_distribution_0/v3_four_channel_phase_distribution_0/v3_four_channel_output_collection_0/v3_four_channel_placement_0/v3_channel_selector_late_promotion_2/v3_channel_input_bias_late_promotion_0/a_7038_22978# VSUBS sky130_fd_pr__nfet_01v8 ad=0 pd=0 as=0 ps=0 w=0.84 l=0.6
X764 v3_four_channel_bias_reference_distribution_0/v3_four_channel_phase_distribution_0/v3_four_channel_output_collection_0/combined_n_internal v3_four_channel_bias_reference_distribution_0/v3_four_channel_phase_distribution_0/v3_four_channel_output_collection_0/v3_four_channel_placement_0/v3_channel_selector_late_promotion_2/v3_selector_route_pilot_0/group3_lo_n v3_four_channel_bias_reference_distribution_0/v3_four_channel_phase_distribution_0/v3_four_channel_output_collection_0/v3_four_channel_placement_0/v3_channel_selector_late_promotion_2/v3_channel_input_bias_late_promotion_0/a_5646_22978# VSUBS sky130_fd_pr__nfet_01v8 ad=0 pd=0 as=0 ps=0 w=0.65 l=0.15
X765 v3_four_channel_bias_reference_distribution_0/v3_four_channel_phase_distribution_0/v3_four_channel_output_collection_0/v3_four_channel_placement_0/v3_channel_selector_late_promotion_2/v3_channel_input_bias_late_promotion_0/a_4678_11422# v3_four_channel_bias_reference_distribution_0/v3_four_channel_phase_distribution_0/v3_four_channel_output_collection_0/v3_four_channel_placement_0/v3_channel_selector_late_promotion_2/element_input v3_four_channel_bias_reference_distribution_0/v3_four_channel_phase_distribution_0/v3_four_channel_output_collection_0/v3_four_channel_placement_0/v3_channel_selector_late_promotion_2/v3_channel_input_bias_late_promotion_0/a_4432_10978# VSUBS sky130_fd_pr__nfet_01v8 ad=0 pd=0 as=0 ps=0 w=0.84 l=0.6
X766 v3_four_channel_bias_reference_distribution_0/v3_four_channel_phase_distribution_0/v3_four_channel_output_collection_0/v3_four_channel_placement_0/v3_channel_selector_late_promotion_2/v3_channel_input_bias_late_promotion_0/a_6070_23422# v3_vcm_support_block_0/ref v3_four_channel_bias_reference_distribution_0/v3_four_channel_phase_distribution_0/v3_four_channel_output_collection_0/v3_four_channel_placement_0/v3_channel_selector_late_promotion_2/v3_channel_input_bias_late_promotion_0/a_5774_21688# VSUBS sky130_fd_pr__nfet_01v8 ad=0 pd=0 as=0 ps=0 w=0.84 l=0.6
X767 v3_four_channel_bias_reference_distribution_0/v3_four_channel_phase_distribution_0/v3_four_channel_output_collection_0/v3_four_channel_placement_0/v3_channel_selector_late_promotion_2/v3_channel_input_bias_late_promotion_0/a_6070_23422# v3_four_channel_bias_reference_distribution_0/v3_four_channel_phase_distribution_0/v3_four_channel_output_collection_0/v3_four_channel_placement_0/v3_channel_selector_late_promotion_2/v3_selector_route_pilot_0/group3_lo_p v3_four_channel_bias_reference_distribution_0/v3_four_channel_phase_distribution_0/v3_four_channel_output_collection_0/combined_n_internal VSUBS sky130_fd_pr__nfet_01v8 ad=0 pd=0 as=0 ps=0 w=0.65 l=0.15
X768 v3_four_channel_bias_reference_distribution_0/v3_four_channel_phase_distribution_0/v3_four_channel_output_collection_0/v3_four_channel_placement_0/v3_channel_selector_late_promotion_2/v3_channel_input_bias_late_promotion_0/a_4678_11422# v3_four_channel_bias_reference_distribution_0/v3_four_channel_phase_distribution_0/v3_four_channel_output_collection_0/v3_four_channel_placement_0/v3_channel_selector_late_promotion_2/v3_selector_route_pilot_0/group2_lo_n v3_four_channel_bias_reference_distribution_0/v3_four_channel_phase_distribution_0/v3_four_channel_output_collection_0/combined_n_internal VSUBS sky130_fd_pr__nfet_01v8 ad=0 pd=0 as=0 ps=0 w=0.65 l=0.15
X769 v3_four_channel_bias_reference_distribution_0/v3_four_channel_phase_distribution_0/v3_four_channel_output_collection_0/v3_four_channel_placement_0/v3_channel_selector_late_promotion_2/v3_channel_input_bias_late_promotion_0/a_7462_15422# v3_four_channel_bias_reference_distribution_0/v3_four_channel_phase_distribution_0/v3_four_channel_output_collection_0/v3_four_channel_placement_0/v3_channel_selector_late_promotion_2/element_input v3_four_channel_bias_reference_distribution_0/v3_four_channel_phase_distribution_0/v3_four_channel_output_collection_0/v3_four_channel_placement_0/v3_channel_selector_late_promotion_2/v3_channel_input_bias_late_promotion_0/a_7216_14978# VSUBS sky130_fd_pr__nfet_01v8 ad=0 pd=0 as=0 ps=0 w=0.84 l=0.6
X770 v3_four_channel_bias_reference_distribution_0/v3_four_channel_phase_distribution_0/v3_four_channel_output_collection_0/v3_four_channel_placement_0/v3_channel_selector_late_promotion_2/v3_channel_input_bias_late_promotion_0/a_6070_7422# v3_four_channel_bias_reference_distribution_0/v3_four_channel_phase_distribution_0/v3_four_channel_output_collection_0/v3_four_channel_placement_0/v3_channel_selector_late_promotion_2/v3_selector_route_pilot_0/group3_lo_p v3_four_channel_bias_reference_distribution_0/v3_four_channel_phase_distribution_0/v3_four_channel_output_collection_0/combined_p_internal VSUBS sky130_fd_pr__nfet_01v8 ad=0 pd=0 as=0 ps=0 w=0.65 l=0.15
X771 v3_four_channel_bias_reference_distribution_0/v3_four_channel_phase_distribution_0/v3_four_channel_output_collection_0/combined_n_internal v3_four_channel_bias_reference_distribution_0/v3_four_channel_phase_distribution_0/v3_four_channel_output_collection_0/v3_four_channel_placement_0/v3_channel_selector_late_promotion_2/v3_selector_route_pilot_0/group2_lo_p v3_four_channel_bias_reference_distribution_0/v3_four_channel_phase_distribution_0/v3_four_channel_output_collection_0/v3_four_channel_placement_0/v3_channel_selector_late_promotion_2/v3_channel_input_bias_late_promotion_0/a_7038_10978# VSUBS sky130_fd_pr__nfet_01v8 ad=0 pd=0 as=0 ps=0 w=0.65 l=0.15
X772 v3_four_channel_bias_reference_distribution_0/v3_four_channel_phase_distribution_0/v3_four_channel_output_collection_0/v3_four_channel_placement_0/v3_channel_selector_late_promotion_2/v3_channel_input_bias_late_promotion_0/a_7462_15422# v3_four_channel_bias_reference_distribution_0/v3_four_channel_phase_distribution_0/v3_four_channel_output_collection_0/v3_four_channel_placement_0/v3_channel_selector_late_promotion_2/v3_selector_route_pilot_0/group1_lo_n v3_four_channel_bias_reference_distribution_0/v3_four_channel_phase_distribution_0/v3_four_channel_output_collection_0/combined_n_internal VSUBS sky130_fd_pr__nfet_01v8 ad=0 pd=0 as=0 ps=0 w=0.65 l=0.15
X773 v3_four_channel_bias_reference_distribution_0/v3_four_channel_phase_distribution_0/v3_four_channel_output_collection_0/v3_four_channel_placement_0/v3_channel_selector_late_promotion_2/v3_channel_input_bias_late_promotion_0/a_4432_6978# v3_vcm_support_block_0/ref v3_four_channel_bias_reference_distribution_0/v3_four_channel_phase_distribution_0/v3_four_channel_output_collection_0/v3_four_channel_placement_0/v3_channel_selector_late_promotion_2/v3_channel_input_bias_late_promotion_0/a_4254_6978# VSUBS sky130_fd_pr__nfet_01v8 ad=0 pd=0 as=0 ps=0 w=0.84 l=0.6
X774 v3_four_channel_bias_reference_distribution_0/v3_four_channel_phase_distribution_0/v3_four_channel_output_collection_0/v3_four_channel_placement_0/v3_channel_selector_late_promotion_2/v3_channel_input_bias_late_promotion_0/a_5824_10978# v3_vcm_support_block_0/ref v3_four_channel_bias_reference_distribution_0/v3_four_channel_phase_distribution_0/v3_four_channel_output_collection_0/v3_four_channel_placement_0/v3_channel_selector_late_promotion_2/v3_channel_input_bias_late_promotion_0/a_5646_10978# VSUBS sky130_fd_pr__nfet_01v8 ad=0 pd=0 as=0 ps=0 w=0.84 l=0.6
X775 v3_four_channel_bias_reference_distribution_0/v3_four_channel_phase_distribution_0/v3_four_channel_output_collection_0/combined_n_internal v3_four_channel_bias_reference_distribution_0/v3_four_channel_phase_distribution_0/v3_four_channel_output_collection_0/v3_four_channel_placement_0/v3_channel_selector_late_promotion_2/v3_selector_route_pilot_0/group3_lo_n v3_four_channel_bias_reference_distribution_0/v3_four_channel_phase_distribution_0/v3_four_channel_output_collection_0/v3_four_channel_placement_0/v3_channel_selector_late_promotion_2/v3_channel_input_bias_late_promotion_0/a_4254_22978# VSUBS sky130_fd_pr__nfet_01v8 ad=0 pd=0 as=0 ps=0 w=0.65 l=0.15
X776 v3_four_channel_bias_reference_distribution_0/v3_four_channel_phase_distribution_0/v3_four_channel_output_collection_0/v3_four_channel_placement_0/v3_channel_selector_late_promotion_2/v3_channel_input_bias_late_promotion_0/a_7462_23422# v3_four_channel_bias_reference_distribution_0/v3_four_channel_phase_distribution_0/v3_four_channel_output_collection_0/v3_four_channel_placement_0/v3_channel_selector_late_promotion_2/v3_selector_route_pilot_0/group3_lo_n v3_four_channel_bias_reference_distribution_0/v3_four_channel_phase_distribution_0/v3_four_channel_output_collection_0/combined_p_internal VSUBS sky130_fd_pr__nfet_01v8 ad=0 pd=0 as=0 ps=0 w=0.65 l=0.15
X777 v3_four_channel_bias_reference_distribution_0/v3_four_channel_phase_distribution_0/v3_four_channel_output_collection_0/v3_four_channel_placement_0/v3_channel_selector_late_promotion_2/v3_channel_input_bias_late_promotion_0/a_4432_6978# v3_tail_bias_support_block_0/vbias VSUBS VSUBS sky130_fd_pr__nfet_01v8 ad=0 pd=0 as=0 ps=0 w=5.07 l=1
X778 v3_four_channel_bias_reference_distribution_0/v3_four_channel_phase_distribution_0/v3_four_channel_output_collection_0/v3_four_channel_placement_0/v3_channel_selector_late_promotion_2/v3_channel_input_bias_late_promotion_0/a_7216_6978# v3_vcm_support_block_0/ref v3_four_channel_bias_reference_distribution_0/v3_four_channel_phase_distribution_0/v3_four_channel_output_collection_0/v3_four_channel_placement_0/v3_channel_selector_late_promotion_2/v3_channel_input_bias_late_promotion_0/a_7038_6978# VSUBS sky130_fd_pr__nfet_01v8 ad=0 pd=0 as=0 ps=0 w=0.84 l=0.6
X779 v3_four_channel_bias_reference_distribution_0/v3_four_channel_phase_distribution_0/v3_four_channel_output_collection_0/combined_n_internal v3_four_channel_bias_reference_distribution_0/v3_four_channel_phase_distribution_0/v3_four_channel_output_collection_0/v3_four_channel_placement_0/v3_channel_selector_late_promotion_2/v3_selector_route_pilot_0/group3_lo_p v3_four_channel_bias_reference_distribution_0/v3_four_channel_phase_distribution_0/v3_four_channel_output_collection_0/v3_four_channel_placement_0/v3_channel_selector_late_promotion_2/v3_channel_input_bias_late_promotion_0/a_5646_6978# VSUBS sky130_fd_pr__nfet_01v8 ad=0 pd=0 as=0 ps=0 w=0.65 l=0.15
X780 VSUBS v3_tail_bias_support_block_0/vbias v3_four_channel_bias_reference_distribution_0/v3_four_channel_phase_distribution_0/v3_four_channel_output_collection_0/v3_four_channel_placement_0/v3_channel_selector_late_promotion_2/v3_channel_input_bias_late_promotion_0/a_4382_13688# VSUBS sky130_fd_pr__nfet_01v8 ad=0 pd=0 as=0 ps=0 w=5.07 l=1
X781 v3_four_channel_bias_reference_distribution_0/v3_four_channel_phase_distribution_0/v3_four_channel_output_collection_0/v3_four_channel_placement_0/v3_channel_selector_late_promotion_2/VPWR v3_four_channel_bias_reference_distribution_0/v3_four_channel_phase_distribution_0/v3_four_channel_output_collection_0/v3_four_channel_placement_0/v3_channel_selector_late_promotion_2/v3_selector_route_pilot_0/G1_MUX_POS/a_505_21# v3_four_channel_bias_reference_distribution_0/v3_four_channel_phase_distribution_0/v3_four_channel_output_collection_0/v3_four_channel_placement_0/v3_channel_selector_late_promotion_2/v3_selector_route_pilot_0/G1_MUX_POS/a_535_374# v3_four_channel_bias_reference_distribution_0/v3_four_channel_phase_distribution_0/v3_four_channel_output_collection_0/v3_four_channel_placement_0/v3_channel_selector_late_promotion_2/VPWR sky130_fd_pr__pfet_01v8_hvt ad=10.2594 pd=93.2 as=0.0882 ps=1.26 w=0.42 l=0.15
X782 v3_four_channel_bias_reference_distribution_0/v3_four_channel_phase_distribution_0/v3_four_channel_output_collection_0/v3_four_channel_placement_0/v3_channel_selector_late_promotion_2/v3_selector_route_pilot_0/G1_MUX_POS/a_505_21# v3_four_channel_bias_reference_distribution_0/v3_four_channel_phase_distribution_0/v3_four_channel_output_collection_0/v3_four_channel_placement_0/v3_channel_selector_late_promotion_2/group1_bit0 v3_four_channel_bias_reference_distribution_0/v3_four_channel_phase_distribution_0/v3_four_channel_output_collection_0/v3_four_channel_placement_0/v3_channel_selector_late_promotion_2/VPWR v3_four_channel_bias_reference_distribution_0/v3_four_channel_phase_distribution_0/v3_four_channel_output_collection_0/v3_four_channel_placement_0/v3_channel_selector_late_promotion_2/VPWR sky130_fd_pr__pfet_01v8_hvt ad=0.1176 pd=1.4 as=0 ps=0 w=0.42 l=0.15
X783 v3_four_channel_bias_reference_distribution_0/v3_four_channel_phase_distribution_0/v3_four_channel_output_collection_0/v3_four_channel_placement_0/v3_channel_selector_late_promotion_2/v3_selector_route_pilot_0/G1_MUX_POS/a_218_374# v3_four_channel_bias_reference_distribution_0/v3_four_channel_phase_distribution_0/v3_four_channel_output_collection_0/v3_four_channel_placement_0/v3_channel_selector_late_promotion_2/group1_bit0 v3_four_channel_bias_reference_distribution_0/v3_four_channel_phase_distribution_0/v3_four_channel_output_collection_0/v3_four_channel_placement_0/v3_channel_selector_late_promotion_2/VPWR v3_four_channel_bias_reference_distribution_0/v3_four_channel_phase_distribution_0/v3_four_channel_output_collection_0/v3_four_channel_placement_0/v3_channel_selector_late_promotion_2/VPWR sky130_fd_pr__pfet_01v8_hvt ad=0.1533 pd=1.57 as=0 ps=0 w=0.42 l=0.15
X784 VSUBS v3_four_channel_bias_reference_distribution_0/v3_four_channel_phase_distribution_0/v3_four_channel_output_collection_0/v3_four_channel_placement_0/v3_channel_selector_late_promotion_2/v3_selector_route_pilot_0/G1_MUX_POS/a_505_21# v3_four_channel_bias_reference_distribution_0/v3_four_channel_phase_distribution_0/v3_four_channel_output_collection_0/v3_four_channel_placement_0/v3_channel_selector_late_promotion_2/v3_selector_route_pilot_0/G1_MUX_POS/a_439_47# VSUBS sky130_fd_pr__nfet_01v8 ad=0 pd=0 as=0.1386 ps=1.5 w=0.42 l=0.15
X785 v3_four_channel_bias_reference_distribution_0/v3_four_channel_phase_distribution_0/v3_four_channel_output_collection_0/v3_four_channel_placement_0/v3_channel_selector_late_promotion_2/v3_selector_route_pilot_0/G1_MUX_POS/a_76_199# v3_four_channel_bias_reference_distribution_0/v3_four_channel_phase_distribution_0/phase_0 v3_four_channel_bias_reference_distribution_0/v3_four_channel_phase_distribution_0/v3_four_channel_output_collection_0/v3_four_channel_placement_0/v3_channel_selector_late_promotion_2/v3_selector_route_pilot_0/G1_MUX_POS/a_218_374# v3_four_channel_bias_reference_distribution_0/v3_four_channel_phase_distribution_0/v3_four_channel_output_collection_0/v3_four_channel_placement_0/v3_channel_selector_late_promotion_2/VPWR sky130_fd_pr__pfet_01v8_hvt ad=0.3864 pd=2.68 as=0 ps=0 w=0.42 l=0.15
X786 v3_four_channel_bias_reference_distribution_0/v3_four_channel_phase_distribution_0/v3_four_channel_output_collection_0/v3_four_channel_placement_0/v3_channel_selector_late_promotion_2/v3_selector_route_pilot_0/G1_MUX_POS/a_505_21# v3_four_channel_bias_reference_distribution_0/v3_four_channel_phase_distribution_0/v3_four_channel_output_collection_0/v3_four_channel_placement_0/v3_channel_selector_late_promotion_2/group1_bit0 VSUBS VSUBS sky130_fd_pr__nfet_01v8 ad=0.1092 pd=1.36 as=0 ps=0 w=0.42 l=0.15
X787 v3_four_channel_bias_reference_distribution_0/v3_four_channel_phase_distribution_0/v3_four_channel_output_collection_0/v3_four_channel_placement_0/v3_channel_selector_late_promotion_2/v3_selector_route_pilot_0/G1_MUX_POS/a_439_47# v3_four_channel_bias_reference_distribution_0/v3_four_channel_phase_distribution_0/phase_0 v3_four_channel_bias_reference_distribution_0/v3_four_channel_phase_distribution_0/v3_four_channel_output_collection_0/v3_four_channel_placement_0/v3_channel_selector_late_promotion_2/v3_selector_route_pilot_0/G1_MUX_POS/a_76_199# VSUBS sky130_fd_pr__nfet_01v8 ad=0 pd=0 as=0.1995 ps=1.79 w=0.42 l=0.15
X788 v3_four_channel_bias_reference_distribution_0/v3_four_channel_phase_distribution_0/v3_four_channel_output_collection_0/v3_four_channel_placement_0/v3_channel_selector_late_promotion_2/v3_selector_route_pilot_0/G1_MUX_POS/a_535_374# v3_four_channel_bias_reference_distribution_0/v3_four_channel_phase_distribution_0/phase_90 v3_four_channel_bias_reference_distribution_0/v3_four_channel_phase_distribution_0/v3_four_channel_output_collection_0/v3_four_channel_placement_0/v3_channel_selector_late_promotion_2/v3_selector_route_pilot_0/G1_MUX_POS/a_76_199# v3_four_channel_bias_reference_distribution_0/v3_four_channel_phase_distribution_0/v3_four_channel_output_collection_0/v3_four_channel_placement_0/v3_channel_selector_late_promotion_2/VPWR sky130_fd_pr__pfet_01v8_hvt ad=0 pd=0 as=0 ps=0 w=0.42 l=0.15
X789 v3_four_channel_bias_reference_distribution_0/v3_four_channel_phase_distribution_0/v3_four_channel_output_collection_0/v3_four_channel_placement_0/v3_channel_selector_late_promotion_2/v3_selector_route_pilot_0/G1_MUX_POS/a_76_199# v3_four_channel_bias_reference_distribution_0/v3_four_channel_phase_distribution_0/phase_90 v3_four_channel_bias_reference_distribution_0/v3_four_channel_phase_distribution_0/v3_four_channel_output_collection_0/v3_four_channel_placement_0/v3_channel_selector_late_promotion_2/v3_selector_route_pilot_0/G1_MUX_POS/a_218_47# VSUBS sky130_fd_pr__nfet_01v8 ad=0 pd=0 as=0.1386 ps=1.5 w=0.42 l=0.15
X790 v3_four_channel_bias_reference_distribution_0/v3_four_channel_phase_distribution_0/v3_four_channel_output_collection_0/v3_four_channel_placement_0/v3_channel_selector_late_promotion_2/v3_selector_route_pilot_0/G1_MUX_POS/a_218_47# v3_four_channel_bias_reference_distribution_0/v3_four_channel_phase_distribution_0/v3_four_channel_output_collection_0/v3_four_channel_placement_0/v3_channel_selector_late_promotion_2/group1_bit0 VSUBS VSUBS sky130_fd_pr__nfet_01v8 ad=0 pd=0 as=0 ps=0 w=0.42 l=0.15
X791 v3_four_channel_bias_reference_distribution_0/v3_four_channel_phase_distribution_0/v3_four_channel_output_collection_0/v3_four_channel_placement_0/v3_channel_selector_late_promotion_2/VPWR v3_four_channel_bias_reference_distribution_0/v3_four_channel_phase_distribution_0/v3_four_channel_output_collection_0/v3_four_channel_placement_0/v3_channel_selector_late_promotion_2/v3_selector_route_pilot_0/G1_MUX_POS/a_76_199# v3_four_channel_bias_reference_distribution_0/v3_four_channel_phase_distribution_0/v3_four_channel_output_collection_0/v3_four_channel_placement_0/v3_channel_selector_late_promotion_2/v3_selector_route_pilot_0/G1_MUX_POS/X v3_four_channel_bias_reference_distribution_0/v3_four_channel_phase_distribution_0/v3_four_channel_output_collection_0/v3_four_channel_placement_0/v3_channel_selector_late_promotion_2/VPWR sky130_fd_pr__pfet_01v8_hvt ad=0 pd=0 as=0.26 ps=2.52 w=1 l=0.15
X792 VSUBS v3_four_channel_bias_reference_distribution_0/v3_four_channel_phase_distribution_0/v3_four_channel_output_collection_0/v3_four_channel_placement_0/v3_channel_selector_late_promotion_2/v3_selector_route_pilot_0/G1_MUX_POS/a_76_199# v3_four_channel_bias_reference_distribution_0/v3_four_channel_phase_distribution_0/v3_four_channel_output_collection_0/v3_four_channel_placement_0/v3_channel_selector_late_promotion_2/v3_selector_route_pilot_0/G1_MUX_POS/X VSUBS sky130_fd_pr__nfet_01v8 ad=0 pd=0 as=0.169 ps=1.82 w=0.65 l=0.15
X793 v3_four_channel_bias_reference_distribution_0/v3_four_channel_phase_distribution_0/v3_four_channel_output_collection_0/v3_four_channel_placement_0/v3_channel_selector_late_promotion_2/VPWR v3_four_channel_bias_reference_distribution_0/v3_four_channel_phase_distribution_0/v3_four_channel_output_collection_0/v3_four_channel_placement_0/v3_channel_selector_late_promotion_2/v3_selector_route_pilot_0/G3_MUX_AXIS/a_505_21# v3_four_channel_bias_reference_distribution_0/v3_four_channel_phase_distribution_0/v3_four_channel_output_collection_0/v3_four_channel_placement_0/v3_channel_selector_late_promotion_2/v3_selector_route_pilot_0/G3_MUX_AXIS/a_535_374# v3_four_channel_bias_reference_distribution_0/v3_four_channel_phase_distribution_0/v3_four_channel_output_collection_0/v3_four_channel_placement_0/v3_channel_selector_late_promotion_2/VPWR sky130_fd_pr__pfet_01v8_hvt ad=0 pd=0 as=0.0882 ps=1.26 w=0.42 l=0.15
X794 v3_four_channel_bias_reference_distribution_0/v3_four_channel_phase_distribution_0/v3_four_channel_output_collection_0/v3_four_channel_placement_0/v3_channel_selector_late_promotion_2/v3_selector_route_pilot_0/G3_MUX_AXIS/a_505_21# v3_four_channel_bias_reference_distribution_0/v3_four_channel_phase_distribution_0/v3_four_channel_output_collection_0/v3_four_channel_placement_0/v3_channel_selector_late_promotion_2/group3_bit1 v3_four_channel_bias_reference_distribution_0/v3_four_channel_phase_distribution_0/v3_four_channel_output_collection_0/v3_four_channel_placement_0/v3_channel_selector_late_promotion_2/VPWR v3_four_channel_bias_reference_distribution_0/v3_four_channel_phase_distribution_0/v3_four_channel_output_collection_0/v3_four_channel_placement_0/v3_channel_selector_late_promotion_2/VPWR sky130_fd_pr__pfet_01v8_hvt ad=0.1176 pd=1.4 as=0 ps=0 w=0.42 l=0.15
X795 v3_four_channel_bias_reference_distribution_0/v3_four_channel_phase_distribution_0/v3_four_channel_output_collection_0/v3_four_channel_placement_0/v3_channel_selector_late_promotion_2/v3_selector_route_pilot_0/G3_MUX_AXIS/a_218_374# v3_four_channel_bias_reference_distribution_0/v3_four_channel_phase_distribution_0/v3_four_channel_output_collection_0/v3_four_channel_placement_0/v3_channel_selector_late_promotion_2/group3_bit1 v3_four_channel_bias_reference_distribution_0/v3_four_channel_phase_distribution_0/v3_four_channel_output_collection_0/v3_four_channel_placement_0/v3_channel_selector_late_promotion_2/VPWR v3_four_channel_bias_reference_distribution_0/v3_four_channel_phase_distribution_0/v3_four_channel_output_collection_0/v3_four_channel_placement_0/v3_channel_selector_late_promotion_2/VPWR sky130_fd_pr__pfet_01v8_hvt ad=0.1533 pd=1.57 as=0 ps=0 w=0.42 l=0.15
X796 VSUBS v3_four_channel_bias_reference_distribution_0/v3_four_channel_phase_distribution_0/v3_four_channel_output_collection_0/v3_four_channel_placement_0/v3_channel_selector_late_promotion_2/v3_selector_route_pilot_0/G3_MUX_AXIS/a_505_21# v3_four_channel_bias_reference_distribution_0/v3_four_channel_phase_distribution_0/v3_four_channel_output_collection_0/v3_four_channel_placement_0/v3_channel_selector_late_promotion_2/v3_selector_route_pilot_0/G3_MUX_AXIS/a_439_47# VSUBS sky130_fd_pr__nfet_01v8 ad=0 pd=0 as=0.1386 ps=1.5 w=0.42 l=0.15
X797 v3_four_channel_bias_reference_distribution_0/v3_four_channel_phase_distribution_0/v3_four_channel_output_collection_0/v3_four_channel_placement_0/v3_channel_selector_late_promotion_2/v3_selector_route_pilot_0/G3_MUX_AXIS/a_76_199# v3_four_channel_bias_reference_distribution_0/v3_four_channel_phase_distribution_0/v3_four_channel_output_collection_0/v3_four_channel_placement_0/v3_channel_selector_late_promotion_2/v3_selector_route_pilot_0/G3_MUX_POS/X v3_four_channel_bias_reference_distribution_0/v3_four_channel_phase_distribution_0/v3_four_channel_output_collection_0/v3_four_channel_placement_0/v3_channel_selector_late_promotion_2/v3_selector_route_pilot_0/G3_MUX_AXIS/a_218_374# v3_four_channel_bias_reference_distribution_0/v3_four_channel_phase_distribution_0/v3_four_channel_output_collection_0/v3_four_channel_placement_0/v3_channel_selector_late_promotion_2/VPWR sky130_fd_pr__pfet_01v8_hvt ad=0.3864 pd=2.68 as=0 ps=0 w=0.42 l=0.15
X798 v3_four_channel_bias_reference_distribution_0/v3_four_channel_phase_distribution_0/v3_four_channel_output_collection_0/v3_four_channel_placement_0/v3_channel_selector_late_promotion_2/v3_selector_route_pilot_0/G3_MUX_AXIS/a_505_21# v3_four_channel_bias_reference_distribution_0/v3_four_channel_phase_distribution_0/v3_four_channel_output_collection_0/v3_four_channel_placement_0/v3_channel_selector_late_promotion_2/group3_bit1 VSUBS VSUBS sky130_fd_pr__nfet_01v8 ad=0.1092 pd=1.36 as=0 ps=0 w=0.42 l=0.15
X799 v3_four_channel_bias_reference_distribution_0/v3_four_channel_phase_distribution_0/v3_four_channel_output_collection_0/v3_four_channel_placement_0/v3_channel_selector_late_promotion_2/v3_selector_route_pilot_0/G3_MUX_AXIS/a_439_47# v3_four_channel_bias_reference_distribution_0/v3_four_channel_phase_distribution_0/v3_four_channel_output_collection_0/v3_four_channel_placement_0/v3_channel_selector_late_promotion_2/v3_selector_route_pilot_0/G3_MUX_POS/X v3_four_channel_bias_reference_distribution_0/v3_four_channel_phase_distribution_0/v3_four_channel_output_collection_0/v3_four_channel_placement_0/v3_channel_selector_late_promotion_2/v3_selector_route_pilot_0/G3_MUX_AXIS/a_76_199# VSUBS sky130_fd_pr__nfet_01v8 ad=0 pd=0 as=0.1995 ps=1.79 w=0.42 l=0.15
X800 v3_four_channel_bias_reference_distribution_0/v3_four_channel_phase_distribution_0/v3_four_channel_output_collection_0/v3_four_channel_placement_0/v3_channel_selector_late_promotion_2/v3_selector_route_pilot_0/G3_MUX_AXIS/a_535_374# v3_four_channel_bias_reference_distribution_0/v3_four_channel_phase_distribution_0/v3_four_channel_output_collection_0/v3_four_channel_placement_0/v3_channel_selector_late_promotion_2/v3_selector_route_pilot_0/G3_MUX_NEG/X v3_four_channel_bias_reference_distribution_0/v3_four_channel_phase_distribution_0/v3_four_channel_output_collection_0/v3_four_channel_placement_0/v3_channel_selector_late_promotion_2/v3_selector_route_pilot_0/G3_MUX_AXIS/a_76_199# v3_four_channel_bias_reference_distribution_0/v3_four_channel_phase_distribution_0/v3_four_channel_output_collection_0/v3_four_channel_placement_0/v3_channel_selector_late_promotion_2/VPWR sky130_fd_pr__pfet_01v8_hvt ad=0 pd=0 as=0 ps=0 w=0.42 l=0.15
X801 v3_four_channel_bias_reference_distribution_0/v3_four_channel_phase_distribution_0/v3_four_channel_output_collection_0/v3_four_channel_placement_0/v3_channel_selector_late_promotion_2/v3_selector_route_pilot_0/G3_MUX_AXIS/a_76_199# v3_four_channel_bias_reference_distribution_0/v3_four_channel_phase_distribution_0/v3_four_channel_output_collection_0/v3_four_channel_placement_0/v3_channel_selector_late_promotion_2/v3_selector_route_pilot_0/G3_MUX_NEG/X v3_four_channel_bias_reference_distribution_0/v3_four_channel_phase_distribution_0/v3_four_channel_output_collection_0/v3_four_channel_placement_0/v3_channel_selector_late_promotion_2/v3_selector_route_pilot_0/G3_MUX_AXIS/a_218_47# VSUBS sky130_fd_pr__nfet_01v8 ad=0 pd=0 as=0.1386 ps=1.5 w=0.42 l=0.15
X802 v3_four_channel_bias_reference_distribution_0/v3_four_channel_phase_distribution_0/v3_four_channel_output_collection_0/v3_four_channel_placement_0/v3_channel_selector_late_promotion_2/v3_selector_route_pilot_0/G3_MUX_AXIS/a_218_47# v3_four_channel_bias_reference_distribution_0/v3_four_channel_phase_distribution_0/v3_four_channel_output_collection_0/v3_four_channel_placement_0/v3_channel_selector_late_promotion_2/group3_bit1 VSUBS VSUBS sky130_fd_pr__nfet_01v8 ad=0 pd=0 as=0 ps=0 w=0.42 l=0.15
X803 v3_four_channel_bias_reference_distribution_0/v3_four_channel_phase_distribution_0/v3_four_channel_output_collection_0/v3_four_channel_placement_0/v3_channel_selector_late_promotion_2/VPWR v3_four_channel_bias_reference_distribution_0/v3_four_channel_phase_distribution_0/v3_four_channel_output_collection_0/v3_four_channel_placement_0/v3_channel_selector_late_promotion_2/v3_selector_route_pilot_0/G3_MUX_AXIS/a_76_199# v3_four_channel_bias_reference_distribution_0/v3_four_channel_phase_distribution_0/v3_four_channel_output_collection_0/v3_four_channel_placement_0/v3_channel_selector_late_promotion_2/v3_selector_route_pilot_0/G3_MUX_AXIS/X v3_four_channel_bias_reference_distribution_0/v3_four_channel_phase_distribution_0/v3_four_channel_output_collection_0/v3_four_channel_placement_0/v3_channel_selector_late_promotion_2/VPWR sky130_fd_pr__pfet_01v8_hvt ad=0 pd=0 as=0.26 ps=2.52 w=1 l=0.15
X804 VSUBS v3_four_channel_bias_reference_distribution_0/v3_four_channel_phase_distribution_0/v3_four_channel_output_collection_0/v3_four_channel_placement_0/v3_channel_selector_late_promotion_2/v3_selector_route_pilot_0/G3_MUX_AXIS/a_76_199# v3_four_channel_bias_reference_distribution_0/v3_four_channel_phase_distribution_0/v3_four_channel_output_collection_0/v3_four_channel_placement_0/v3_channel_selector_late_promotion_2/v3_selector_route_pilot_0/G3_MUX_AXIS/X VSUBS sky130_fd_pr__nfet_01v8 ad=0 pd=0 as=0.169 ps=1.82 w=0.65 l=0.15
X805 v3_four_channel_bias_reference_distribution_0/v3_four_channel_phase_distribution_0/v3_four_channel_output_collection_0/v3_four_channel_placement_0/v3_channel_selector_late_promotion_2/VPWR v3_four_channel_bias_reference_distribution_0/v3_four_channel_phase_distribution_0/v3_four_channel_output_collection_0/v3_four_channel_placement_0/v3_channel_selector_late_promotion_2/channel_enable v3_four_channel_bias_reference_distribution_0/v3_four_channel_phase_distribution_0/v3_four_channel_output_collection_0/v3_four_channel_placement_0/v3_channel_selector_late_promotion_2/v3_selector_route_pilot_0/ENABLE_ANDNOT/a_207_413# v3_four_channel_bias_reference_distribution_0/v3_four_channel_phase_distribution_0/v3_four_channel_output_collection_0/v3_four_channel_placement_0/v3_channel_selector_late_promotion_2/VPWR sky130_fd_pr__pfet_01v8_hvt ad=0 pd=0 as=0.1218 ps=1.42 w=0.42 l=0.15
X806 v3_four_channel_bias_reference_distribution_0/v3_four_channel_phase_distribution_0/v3_four_channel_output_collection_0/v3_four_channel_placement_0/v3_channel_selector_late_promotion_2/v3_selector_route_pilot_0/G3_LO_P_AND/B v3_four_channel_bias_reference_distribution_0/v3_four_channel_phase_distribution_0/v3_four_channel_output_collection_0/v3_four_channel_placement_0/v3_channel_selector_late_promotion_2/v3_selector_route_pilot_0/ENABLE_ANDNOT/a_207_413# v3_four_channel_bias_reference_distribution_0/v3_four_channel_phase_distribution_0/v3_four_channel_output_collection_0/v3_four_channel_placement_0/v3_channel_selector_late_promotion_2/VPWR v3_four_channel_bias_reference_distribution_0/v3_four_channel_phase_distribution_0/v3_four_channel_output_collection_0/v3_four_channel_placement_0/v3_channel_selector_late_promotion_2/VPWR sky130_fd_pr__pfet_01v8_hvt ad=0.26 pd=2.52 as=0 ps=0 w=1 l=0.15
X807 v3_four_channel_bias_reference_distribution_0/v3_four_channel_phase_distribution_0/v3_four_channel_output_collection_0/v3_four_channel_placement_0/v3_channel_selector_late_promotion_2/v3_selector_route_pilot_0/ENABLE_ANDNOT/a_297_47# v3_four_channel_bias_reference_distribution_0/v3_four_channel_phase_distribution_0/v3_four_channel_output_collection_0/v3_four_channel_placement_0/v3_channel_selector_late_promotion_2/v3_selector_route_pilot_0/ENABLE_ANDNOT/a_27_413# v3_four_channel_bias_reference_distribution_0/v3_four_channel_phase_distribution_0/v3_four_channel_output_collection_0/v3_four_channel_placement_0/v3_channel_selector_late_promotion_2/v3_selector_route_pilot_0/ENABLE_ANDNOT/a_207_413# VSUBS sky130_fd_pr__nfet_01v8 ad=0.1008 pd=1.32 as=0.1092 ps=1.36 w=0.42 l=0.15
X808 v3_four_channel_bias_reference_distribution_0/v3_four_channel_phase_distribution_0/v3_four_channel_output_collection_0/v3_four_channel_placement_0/v3_channel_selector_late_promotion_2/v3_selector_route_pilot_0/G3_LO_P_AND/B v3_four_channel_bias_reference_distribution_0/v3_four_channel_phase_distribution_0/v3_four_channel_output_collection_0/v3_four_channel_placement_0/v3_channel_selector_late_promotion_2/v3_selector_route_pilot_0/ENABLE_ANDNOT/a_207_413# VSUBS VSUBS sky130_fd_pr__nfet_01v8 ad=0.169 pd=1.82 as=0 ps=0 w=0.65 l=0.15
X809 v3_four_channel_bias_reference_distribution_0/v3_four_channel_phase_distribution_0/v3_four_channel_output_collection_0/v3_four_channel_placement_0/v3_channel_selector_late_promotion_2/v3_selector_route_pilot_0/ENABLE_ANDNOT/a_207_413# v3_four_channel_bias_reference_distribution_0/v3_four_channel_phase_distribution_0/v3_four_channel_output_collection_0/v3_four_channel_placement_0/v3_channel_selector_late_promotion_2/v3_selector_route_pilot_0/ENABLE_ANDNOT/a_27_413# v3_four_channel_bias_reference_distribution_0/v3_four_channel_phase_distribution_0/v3_four_channel_output_collection_0/v3_four_channel_placement_0/v3_channel_selector_late_promotion_2/VPWR v3_four_channel_bias_reference_distribution_0/v3_four_channel_phase_distribution_0/v3_four_channel_output_collection_0/v3_four_channel_placement_0/v3_channel_selector_late_promotion_2/VPWR sky130_fd_pr__pfet_01v8_hvt ad=0 pd=0 as=0 ps=0 w=0.42 l=0.15
X810 v3_four_channel_bias_reference_distribution_0/v3_four_channel_phase_distribution_0/v3_four_channel_output_collection_0/v3_four_channel_placement_0/v3_channel_selector_late_promotion_2/VPWR v3_four_channel_bias_reference_distribution_0/v3_four_channel_phase_distribution_0/v3_four_channel_output_collection_0/v3_four_channel_placement_0/v3_channel_selector_late_promotion_2/mixers_blank v3_four_channel_bias_reference_distribution_0/v3_four_channel_phase_distribution_0/v3_four_channel_output_collection_0/v3_four_channel_placement_0/v3_channel_selector_late_promotion_2/v3_selector_route_pilot_0/ENABLE_ANDNOT/a_27_413# v3_four_channel_bias_reference_distribution_0/v3_four_channel_phase_distribution_0/v3_four_channel_output_collection_0/v3_four_channel_placement_0/v3_channel_selector_late_promotion_2/VPWR sky130_fd_pr__pfet_01v8_hvt ad=0 pd=0 as=0.1092 ps=1.36 w=0.42 l=0.15
X811 VSUBS v3_four_channel_bias_reference_distribution_0/v3_four_channel_phase_distribution_0/v3_four_channel_output_collection_0/v3_four_channel_placement_0/v3_channel_selector_late_promotion_2/channel_enable v3_four_channel_bias_reference_distribution_0/v3_four_channel_phase_distribution_0/v3_four_channel_output_collection_0/v3_four_channel_placement_0/v3_channel_selector_late_promotion_2/v3_selector_route_pilot_0/ENABLE_ANDNOT/a_297_47# VSUBS sky130_fd_pr__nfet_01v8 ad=0 pd=0 as=0 ps=0 w=0.42 l=0.15
X812 v3_four_channel_bias_reference_distribution_0/v3_four_channel_phase_distribution_0/v3_four_channel_output_collection_0/v3_four_channel_placement_0/v3_channel_selector_late_promotion_2/v3_selector_route_pilot_0/ENABLE_ANDNOT/a_27_413# v3_four_channel_bias_reference_distribution_0/v3_four_channel_phase_distribution_0/v3_four_channel_output_collection_0/v3_four_channel_placement_0/v3_channel_selector_late_promotion_2/mixers_blank VSUBS VSUBS sky130_fd_pr__nfet_01v8 ad=0.1092 pd=1.36 as=0 ps=0 w=0.42 l=0.15
X813 v3_four_channel_bias_reference_distribution_0/v3_four_channel_phase_distribution_0/v3_four_channel_output_collection_0/v3_four_channel_placement_0/v3_channel_selector_late_promotion_2/VPWR v3_four_channel_bias_reference_distribution_0/v3_four_channel_phase_distribution_0/v3_four_channel_output_collection_0/v3_four_channel_placement_0/v3_channel_selector_late_promotion_2/v3_selector_route_pilot_0/G1_MUX_NEG/a_505_21# v3_four_channel_bias_reference_distribution_0/v3_four_channel_phase_distribution_0/v3_four_channel_output_collection_0/v3_four_channel_placement_0/v3_channel_selector_late_promotion_2/v3_selector_route_pilot_0/G1_MUX_NEG/a_535_374# v3_four_channel_bias_reference_distribution_0/v3_four_channel_phase_distribution_0/v3_four_channel_output_collection_0/v3_four_channel_placement_0/v3_channel_selector_late_promotion_2/VPWR sky130_fd_pr__pfet_01v8_hvt ad=0 pd=0 as=0.0882 ps=1.26 w=0.42 l=0.15
X814 v3_four_channel_bias_reference_distribution_0/v3_four_channel_phase_distribution_0/v3_four_channel_output_collection_0/v3_four_channel_placement_0/v3_channel_selector_late_promotion_2/v3_selector_route_pilot_0/G1_MUX_NEG/a_505_21# v3_four_channel_bias_reference_distribution_0/v3_four_channel_phase_distribution_0/v3_four_channel_output_collection_0/v3_four_channel_placement_0/v3_channel_selector_late_promotion_2/group1_bit0 v3_four_channel_bias_reference_distribution_0/v3_four_channel_phase_distribution_0/v3_four_channel_output_collection_0/v3_four_channel_placement_0/v3_channel_selector_late_promotion_2/VPWR v3_four_channel_bias_reference_distribution_0/v3_four_channel_phase_distribution_0/v3_four_channel_output_collection_0/v3_four_channel_placement_0/v3_channel_selector_late_promotion_2/VPWR sky130_fd_pr__pfet_01v8_hvt ad=0.1176 pd=1.4 as=0 ps=0 w=0.42 l=0.15
X815 v3_four_channel_bias_reference_distribution_0/v3_four_channel_phase_distribution_0/v3_four_channel_output_collection_0/v3_four_channel_placement_0/v3_channel_selector_late_promotion_2/v3_selector_route_pilot_0/G1_MUX_NEG/a_218_374# v3_four_channel_bias_reference_distribution_0/v3_four_channel_phase_distribution_0/v3_four_channel_output_collection_0/v3_four_channel_placement_0/v3_channel_selector_late_promotion_2/group1_bit0 v3_four_channel_bias_reference_distribution_0/v3_four_channel_phase_distribution_0/v3_four_channel_output_collection_0/v3_four_channel_placement_0/v3_channel_selector_late_promotion_2/VPWR v3_four_channel_bias_reference_distribution_0/v3_four_channel_phase_distribution_0/v3_four_channel_output_collection_0/v3_four_channel_placement_0/v3_channel_selector_late_promotion_2/VPWR sky130_fd_pr__pfet_01v8_hvt ad=0.1533 pd=1.57 as=0 ps=0 w=0.42 l=0.15
X816 VSUBS v3_four_channel_bias_reference_distribution_0/v3_four_channel_phase_distribution_0/v3_four_channel_output_collection_0/v3_four_channel_placement_0/v3_channel_selector_late_promotion_2/v3_selector_route_pilot_0/G1_MUX_NEG/a_505_21# v3_four_channel_bias_reference_distribution_0/v3_four_channel_phase_distribution_0/v3_four_channel_output_collection_0/v3_four_channel_placement_0/v3_channel_selector_late_promotion_2/v3_selector_route_pilot_0/G1_MUX_NEG/a_439_47# VSUBS sky130_fd_pr__nfet_01v8 ad=0 pd=0 as=0.1386 ps=1.5 w=0.42 l=0.15
X817 v3_four_channel_bias_reference_distribution_0/v3_four_channel_phase_distribution_0/v3_four_channel_output_collection_0/v3_four_channel_placement_0/v3_channel_selector_late_promotion_2/v3_selector_route_pilot_0/G1_MUX_NEG/a_76_199# v3_four_channel_bias_reference_distribution_0/v3_four_channel_phase_distribution_0/phase_180 v3_four_channel_bias_reference_distribution_0/v3_four_channel_phase_distribution_0/v3_four_channel_output_collection_0/v3_four_channel_placement_0/v3_channel_selector_late_promotion_2/v3_selector_route_pilot_0/G1_MUX_NEG/a_218_374# v3_four_channel_bias_reference_distribution_0/v3_four_channel_phase_distribution_0/v3_four_channel_output_collection_0/v3_four_channel_placement_0/v3_channel_selector_late_promotion_2/VPWR sky130_fd_pr__pfet_01v8_hvt ad=0.3864 pd=2.68 as=0 ps=0 w=0.42 l=0.15
X818 v3_four_channel_bias_reference_distribution_0/v3_four_channel_phase_distribution_0/v3_four_channel_output_collection_0/v3_four_channel_placement_0/v3_channel_selector_late_promotion_2/v3_selector_route_pilot_0/G1_MUX_NEG/a_505_21# v3_four_channel_bias_reference_distribution_0/v3_four_channel_phase_distribution_0/v3_four_channel_output_collection_0/v3_four_channel_placement_0/v3_channel_selector_late_promotion_2/group1_bit0 VSUBS VSUBS sky130_fd_pr__nfet_01v8 ad=0.1092 pd=1.36 as=0 ps=0 w=0.42 l=0.15
X819 v3_four_channel_bias_reference_distribution_0/v3_four_channel_phase_distribution_0/v3_four_channel_output_collection_0/v3_four_channel_placement_0/v3_channel_selector_late_promotion_2/v3_selector_route_pilot_0/G1_MUX_NEG/a_439_47# v3_four_channel_bias_reference_distribution_0/v3_four_channel_phase_distribution_0/phase_180 v3_four_channel_bias_reference_distribution_0/v3_four_channel_phase_distribution_0/v3_four_channel_output_collection_0/v3_four_channel_placement_0/v3_channel_selector_late_promotion_2/v3_selector_route_pilot_0/G1_MUX_NEG/a_76_199# VSUBS sky130_fd_pr__nfet_01v8 ad=0 pd=0 as=0.1995 ps=1.79 w=0.42 l=0.15
X820 v3_four_channel_bias_reference_distribution_0/v3_four_channel_phase_distribution_0/v3_four_channel_output_collection_0/v3_four_channel_placement_0/v3_channel_selector_late_promotion_2/v3_selector_route_pilot_0/G1_MUX_NEG/a_535_374# v3_four_channel_bias_reference_distribution_0/v3_four_channel_phase_distribution_0/phase_270 v3_four_channel_bias_reference_distribution_0/v3_four_channel_phase_distribution_0/v3_four_channel_output_collection_0/v3_four_channel_placement_0/v3_channel_selector_late_promotion_2/v3_selector_route_pilot_0/G1_MUX_NEG/a_76_199# v3_four_channel_bias_reference_distribution_0/v3_four_channel_phase_distribution_0/v3_four_channel_output_collection_0/v3_four_channel_placement_0/v3_channel_selector_late_promotion_2/VPWR sky130_fd_pr__pfet_01v8_hvt ad=0 pd=0 as=0 ps=0 w=0.42 l=0.15
X821 v3_four_channel_bias_reference_distribution_0/v3_four_channel_phase_distribution_0/v3_four_channel_output_collection_0/v3_four_channel_placement_0/v3_channel_selector_late_promotion_2/v3_selector_route_pilot_0/G1_MUX_NEG/a_76_199# v3_four_channel_bias_reference_distribution_0/v3_four_channel_phase_distribution_0/phase_270 v3_four_channel_bias_reference_distribution_0/v3_four_channel_phase_distribution_0/v3_four_channel_output_collection_0/v3_four_channel_placement_0/v3_channel_selector_late_promotion_2/v3_selector_route_pilot_0/G1_MUX_NEG/a_218_47# VSUBS sky130_fd_pr__nfet_01v8 ad=0 pd=0 as=0.1386 ps=1.5 w=0.42 l=0.15
X822 v3_four_channel_bias_reference_distribution_0/v3_four_channel_phase_distribution_0/v3_four_channel_output_collection_0/v3_four_channel_placement_0/v3_channel_selector_late_promotion_2/v3_selector_route_pilot_0/G1_MUX_NEG/a_218_47# v3_four_channel_bias_reference_distribution_0/v3_four_channel_phase_distribution_0/v3_four_channel_output_collection_0/v3_four_channel_placement_0/v3_channel_selector_late_promotion_2/group1_bit0 VSUBS VSUBS sky130_fd_pr__nfet_01v8 ad=0 pd=0 as=0 ps=0 w=0.42 l=0.15
X823 v3_four_channel_bias_reference_distribution_0/v3_four_channel_phase_distribution_0/v3_four_channel_output_collection_0/v3_four_channel_placement_0/v3_channel_selector_late_promotion_2/VPWR v3_four_channel_bias_reference_distribution_0/v3_four_channel_phase_distribution_0/v3_four_channel_output_collection_0/v3_four_channel_placement_0/v3_channel_selector_late_promotion_2/v3_selector_route_pilot_0/G1_MUX_NEG/a_76_199# v3_four_channel_bias_reference_distribution_0/v3_four_channel_phase_distribution_0/v3_four_channel_output_collection_0/v3_four_channel_placement_0/v3_channel_selector_late_promotion_2/v3_selector_route_pilot_0/G1_MUX_NEG/X v3_four_channel_bias_reference_distribution_0/v3_four_channel_phase_distribution_0/v3_four_channel_output_collection_0/v3_four_channel_placement_0/v3_channel_selector_late_promotion_2/VPWR sky130_fd_pr__pfet_01v8_hvt ad=0 pd=0 as=0.26 ps=2.52 w=1 l=0.15
X824 VSUBS v3_four_channel_bias_reference_distribution_0/v3_four_channel_phase_distribution_0/v3_four_channel_output_collection_0/v3_four_channel_placement_0/v3_channel_selector_late_promotion_2/v3_selector_route_pilot_0/G1_MUX_NEG/a_76_199# v3_four_channel_bias_reference_distribution_0/v3_four_channel_phase_distribution_0/v3_four_channel_output_collection_0/v3_four_channel_placement_0/v3_channel_selector_late_promotion_2/v3_selector_route_pilot_0/G1_MUX_NEG/X VSUBS sky130_fd_pr__nfet_01v8 ad=0 pd=0 as=0.169 ps=1.82 w=0.65 l=0.15
X825 v3_four_channel_bias_reference_distribution_0/v3_four_channel_phase_distribution_0/v3_four_channel_output_collection_0/v3_four_channel_placement_0/v3_channel_selector_late_promotion_2/VPWR v3_four_channel_bias_reference_distribution_0/v3_four_channel_phase_distribution_0/v3_four_channel_output_collection_0/v3_four_channel_placement_0/v3_channel_selector_late_promotion_2/v3_selector_route_pilot_0/G3_LO_P_AND/B v3_four_channel_bias_reference_distribution_0/v3_four_channel_phase_distribution_0/v3_four_channel_output_collection_0/v3_four_channel_placement_0/v3_channel_selector_late_promotion_2/v3_selector_route_pilot_0/G1_LO_P_AND/a_59_75# v3_four_channel_bias_reference_distribution_0/v3_four_channel_phase_distribution_0/v3_four_channel_output_collection_0/v3_four_channel_placement_0/v3_channel_selector_late_promotion_2/VPWR sky130_fd_pr__pfet_01v8_hvt ad=0 pd=0 as=0.1134 ps=1.38 w=0.42 l=0.15
X826 v3_four_channel_bias_reference_distribution_0/v3_four_channel_phase_distribution_0/v3_four_channel_output_collection_0/v3_four_channel_placement_0/v3_channel_selector_late_promotion_2/v3_selector_route_pilot_0/group1_lo_p v3_four_channel_bias_reference_distribution_0/v3_four_channel_phase_distribution_0/v3_four_channel_output_collection_0/v3_four_channel_placement_0/v3_channel_selector_late_promotion_2/v3_selector_route_pilot_0/G1_LO_P_AND/a_59_75# v3_four_channel_bias_reference_distribution_0/v3_four_channel_phase_distribution_0/v3_four_channel_output_collection_0/v3_four_channel_placement_0/v3_channel_selector_late_promotion_2/VPWR v3_four_channel_bias_reference_distribution_0/v3_four_channel_phase_distribution_0/v3_four_channel_output_collection_0/v3_four_channel_placement_0/v3_channel_selector_late_promotion_2/VPWR sky130_fd_pr__pfet_01v8_hvt ad=0.475 pd=2.95 as=0 ps=0 w=1 l=0.15
X827 VSUBS v3_four_channel_bias_reference_distribution_0/v3_four_channel_phase_distribution_0/v3_four_channel_output_collection_0/v3_four_channel_placement_0/v3_channel_selector_late_promotion_2/v3_selector_route_pilot_0/G3_LO_P_AND/B v3_four_channel_bias_reference_distribution_0/v3_four_channel_phase_distribution_0/v3_four_channel_output_collection_0/v3_four_channel_placement_0/v3_channel_selector_late_promotion_2/v3_selector_route_pilot_0/G1_LO_P_AND/a_145_75# VSUBS sky130_fd_pr__nfet_01v8 ad=0 pd=0 as=0.1134 ps=1.38 w=0.42 l=0.15
X828 v3_four_channel_bias_reference_distribution_0/v3_four_channel_phase_distribution_0/v3_four_channel_output_collection_0/v3_four_channel_placement_0/v3_channel_selector_late_promotion_2/v3_selector_route_pilot_0/G1_LO_P_AND/a_59_75# v3_four_channel_bias_reference_distribution_0/v3_four_channel_phase_distribution_0/v3_four_channel_output_collection_0/v3_four_channel_placement_0/v3_channel_selector_late_promotion_2/v3_selector_route_pilot_0/G1_MUX_AXIS/X v3_four_channel_bias_reference_distribution_0/v3_four_channel_phase_distribution_0/v3_four_channel_output_collection_0/v3_four_channel_placement_0/v3_channel_selector_late_promotion_2/VPWR v3_four_channel_bias_reference_distribution_0/v3_four_channel_phase_distribution_0/v3_four_channel_output_collection_0/v3_four_channel_placement_0/v3_channel_selector_late_promotion_2/VPWR sky130_fd_pr__pfet_01v8_hvt ad=0 pd=0 as=0 ps=0 w=0.42 l=0.15
X829 v3_four_channel_bias_reference_distribution_0/v3_four_channel_phase_distribution_0/v3_four_channel_output_collection_0/v3_four_channel_placement_0/v3_channel_selector_late_promotion_2/v3_selector_route_pilot_0/group1_lo_p v3_four_channel_bias_reference_distribution_0/v3_four_channel_phase_distribution_0/v3_four_channel_output_collection_0/v3_four_channel_placement_0/v3_channel_selector_late_promotion_2/v3_selector_route_pilot_0/G1_LO_P_AND/a_59_75# VSUBS VSUBS sky130_fd_pr__nfet_01v8 ad=0.182 pd=1.86 as=0 ps=0 w=0.65 l=0.15
X830 v3_four_channel_bias_reference_distribution_0/v3_four_channel_phase_distribution_0/v3_four_channel_output_collection_0/v3_four_channel_placement_0/v3_channel_selector_late_promotion_2/v3_selector_route_pilot_0/G1_LO_P_AND/a_145_75# v3_four_channel_bias_reference_distribution_0/v3_four_channel_phase_distribution_0/v3_four_channel_output_collection_0/v3_four_channel_placement_0/v3_channel_selector_late_promotion_2/v3_selector_route_pilot_0/G1_MUX_AXIS/X v3_four_channel_bias_reference_distribution_0/v3_four_channel_phase_distribution_0/v3_four_channel_output_collection_0/v3_four_channel_placement_0/v3_channel_selector_late_promotion_2/v3_selector_route_pilot_0/G1_LO_P_AND/a_59_75# VSUBS sky130_fd_pr__nfet_01v8 ad=0 pd=0 as=0.1176 ps=1.4 w=0.42 l=0.15
X831 v3_four_channel_bias_reference_distribution_0/v3_four_channel_phase_distribution_0/v3_four_channel_output_collection_0/v3_four_channel_placement_0/v3_channel_selector_late_promotion_2/VPWR v3_four_channel_bias_reference_distribution_0/v3_four_channel_phase_distribution_0/v3_four_channel_output_collection_0/v3_four_channel_placement_0/v3_channel_selector_late_promotion_2/v3_selector_route_pilot_0/G0_MUX_POS/a_505_21# v3_four_channel_bias_reference_distribution_0/v3_four_channel_phase_distribution_0/v3_four_channel_output_collection_0/v3_four_channel_placement_0/v3_channel_selector_late_promotion_2/v3_selector_route_pilot_0/G0_MUX_POS/a_535_374# v3_four_channel_bias_reference_distribution_0/v3_four_channel_phase_distribution_0/v3_four_channel_output_collection_0/v3_four_channel_placement_0/v3_channel_selector_late_promotion_2/VPWR sky130_fd_pr__pfet_01v8_hvt ad=0 pd=0 as=0.0882 ps=1.26 w=0.42 l=0.15
X832 v3_four_channel_bias_reference_distribution_0/v3_four_channel_phase_distribution_0/v3_four_channel_output_collection_0/v3_four_channel_placement_0/v3_channel_selector_late_promotion_2/v3_selector_route_pilot_0/G0_MUX_POS/a_505_21# v3_four_channel_bias_reference_distribution_0/v3_four_channel_phase_distribution_0/v3_four_channel_output_collection_0/v3_four_channel_placement_0/v3_channel_selector_late_promotion_2/group0_bit0 v3_four_channel_bias_reference_distribution_0/v3_four_channel_phase_distribution_0/v3_four_channel_output_collection_0/v3_four_channel_placement_0/v3_channel_selector_late_promotion_2/VPWR v3_four_channel_bias_reference_distribution_0/v3_four_channel_phase_distribution_0/v3_four_channel_output_collection_0/v3_four_channel_placement_0/v3_channel_selector_late_promotion_2/VPWR sky130_fd_pr__pfet_01v8_hvt ad=0.1176 pd=1.4 as=0 ps=0 w=0.42 l=0.15
X833 v3_four_channel_bias_reference_distribution_0/v3_four_channel_phase_distribution_0/v3_four_channel_output_collection_0/v3_four_channel_placement_0/v3_channel_selector_late_promotion_2/v3_selector_route_pilot_0/G0_MUX_POS/a_218_374# v3_four_channel_bias_reference_distribution_0/v3_four_channel_phase_distribution_0/v3_four_channel_output_collection_0/v3_four_channel_placement_0/v3_channel_selector_late_promotion_2/group0_bit0 v3_four_channel_bias_reference_distribution_0/v3_four_channel_phase_distribution_0/v3_four_channel_output_collection_0/v3_four_channel_placement_0/v3_channel_selector_late_promotion_2/VPWR v3_four_channel_bias_reference_distribution_0/v3_four_channel_phase_distribution_0/v3_four_channel_output_collection_0/v3_four_channel_placement_0/v3_channel_selector_late_promotion_2/VPWR sky130_fd_pr__pfet_01v8_hvt ad=0.1533 pd=1.57 as=0 ps=0 w=0.42 l=0.15
X834 VSUBS v3_four_channel_bias_reference_distribution_0/v3_four_channel_phase_distribution_0/v3_four_channel_output_collection_0/v3_four_channel_placement_0/v3_channel_selector_late_promotion_2/v3_selector_route_pilot_0/G0_MUX_POS/a_505_21# v3_four_channel_bias_reference_distribution_0/v3_four_channel_phase_distribution_0/v3_four_channel_output_collection_0/v3_four_channel_placement_0/v3_channel_selector_late_promotion_2/v3_selector_route_pilot_0/G0_MUX_POS/a_439_47# VSUBS sky130_fd_pr__nfet_01v8 ad=0 pd=0 as=0.1386 ps=1.5 w=0.42 l=0.15
X835 v3_four_channel_bias_reference_distribution_0/v3_four_channel_phase_distribution_0/v3_four_channel_output_collection_0/v3_four_channel_placement_0/v3_channel_selector_late_promotion_2/v3_selector_route_pilot_0/G0_MUX_POS/a_76_199# v3_four_channel_bias_reference_distribution_0/v3_four_channel_phase_distribution_0/phase_0 v3_four_channel_bias_reference_distribution_0/v3_four_channel_phase_distribution_0/v3_four_channel_output_collection_0/v3_four_channel_placement_0/v3_channel_selector_late_promotion_2/v3_selector_route_pilot_0/G0_MUX_POS/a_218_374# v3_four_channel_bias_reference_distribution_0/v3_four_channel_phase_distribution_0/v3_four_channel_output_collection_0/v3_four_channel_placement_0/v3_channel_selector_late_promotion_2/VPWR sky130_fd_pr__pfet_01v8_hvt ad=0.3864 pd=2.68 as=0 ps=0 w=0.42 l=0.15
X836 v3_four_channel_bias_reference_distribution_0/v3_four_channel_phase_distribution_0/v3_four_channel_output_collection_0/v3_four_channel_placement_0/v3_channel_selector_late_promotion_2/v3_selector_route_pilot_0/G0_MUX_POS/a_505_21# v3_four_channel_bias_reference_distribution_0/v3_four_channel_phase_distribution_0/v3_four_channel_output_collection_0/v3_four_channel_placement_0/v3_channel_selector_late_promotion_2/group0_bit0 VSUBS VSUBS sky130_fd_pr__nfet_01v8 ad=0.1092 pd=1.36 as=0 ps=0 w=0.42 l=0.15
X837 v3_four_channel_bias_reference_distribution_0/v3_four_channel_phase_distribution_0/v3_four_channel_output_collection_0/v3_four_channel_placement_0/v3_channel_selector_late_promotion_2/v3_selector_route_pilot_0/G0_MUX_POS/a_439_47# v3_four_channel_bias_reference_distribution_0/v3_four_channel_phase_distribution_0/phase_0 v3_four_channel_bias_reference_distribution_0/v3_four_channel_phase_distribution_0/v3_four_channel_output_collection_0/v3_four_channel_placement_0/v3_channel_selector_late_promotion_2/v3_selector_route_pilot_0/G0_MUX_POS/a_76_199# VSUBS sky130_fd_pr__nfet_01v8 ad=0 pd=0 as=0.1995 ps=1.79 w=0.42 l=0.15
X838 v3_four_channel_bias_reference_distribution_0/v3_four_channel_phase_distribution_0/v3_four_channel_output_collection_0/v3_four_channel_placement_0/v3_channel_selector_late_promotion_2/v3_selector_route_pilot_0/G0_MUX_POS/a_535_374# v3_four_channel_bias_reference_distribution_0/v3_four_channel_phase_distribution_0/phase_90 v3_four_channel_bias_reference_distribution_0/v3_four_channel_phase_distribution_0/v3_four_channel_output_collection_0/v3_four_channel_placement_0/v3_channel_selector_late_promotion_2/v3_selector_route_pilot_0/G0_MUX_POS/a_76_199# v3_four_channel_bias_reference_distribution_0/v3_four_channel_phase_distribution_0/v3_four_channel_output_collection_0/v3_four_channel_placement_0/v3_channel_selector_late_promotion_2/VPWR sky130_fd_pr__pfet_01v8_hvt ad=0 pd=0 as=0 ps=0 w=0.42 l=0.15
X839 v3_four_channel_bias_reference_distribution_0/v3_four_channel_phase_distribution_0/v3_four_channel_output_collection_0/v3_four_channel_placement_0/v3_channel_selector_late_promotion_2/v3_selector_route_pilot_0/G0_MUX_POS/a_76_199# v3_four_channel_bias_reference_distribution_0/v3_four_channel_phase_distribution_0/phase_90 v3_four_channel_bias_reference_distribution_0/v3_four_channel_phase_distribution_0/v3_four_channel_output_collection_0/v3_four_channel_placement_0/v3_channel_selector_late_promotion_2/v3_selector_route_pilot_0/G0_MUX_POS/a_218_47# VSUBS sky130_fd_pr__nfet_01v8 ad=0 pd=0 as=0.1386 ps=1.5 w=0.42 l=0.15
X840 v3_four_channel_bias_reference_distribution_0/v3_four_channel_phase_distribution_0/v3_four_channel_output_collection_0/v3_four_channel_placement_0/v3_channel_selector_late_promotion_2/v3_selector_route_pilot_0/G0_MUX_POS/a_218_47# v3_four_channel_bias_reference_distribution_0/v3_four_channel_phase_distribution_0/v3_four_channel_output_collection_0/v3_four_channel_placement_0/v3_channel_selector_late_promotion_2/group0_bit0 VSUBS VSUBS sky130_fd_pr__nfet_01v8 ad=0 pd=0 as=0 ps=0 w=0.42 l=0.15
X841 v3_four_channel_bias_reference_distribution_0/v3_four_channel_phase_distribution_0/v3_four_channel_output_collection_0/v3_four_channel_placement_0/v3_channel_selector_late_promotion_2/VPWR v3_four_channel_bias_reference_distribution_0/v3_four_channel_phase_distribution_0/v3_four_channel_output_collection_0/v3_four_channel_placement_0/v3_channel_selector_late_promotion_2/v3_selector_route_pilot_0/G0_MUX_POS/a_76_199# v3_four_channel_bias_reference_distribution_0/v3_four_channel_phase_distribution_0/v3_four_channel_output_collection_0/v3_four_channel_placement_0/v3_channel_selector_late_promotion_2/v3_selector_route_pilot_0/G0_MUX_POS/X v3_four_channel_bias_reference_distribution_0/v3_four_channel_phase_distribution_0/v3_four_channel_output_collection_0/v3_four_channel_placement_0/v3_channel_selector_late_promotion_2/VPWR sky130_fd_pr__pfet_01v8_hvt ad=0 pd=0 as=0.26 ps=2.52 w=1 l=0.15
X842 VSUBS v3_four_channel_bias_reference_distribution_0/v3_four_channel_phase_distribution_0/v3_four_channel_output_collection_0/v3_four_channel_placement_0/v3_channel_selector_late_promotion_2/v3_selector_route_pilot_0/G0_MUX_POS/a_76_199# v3_four_channel_bias_reference_distribution_0/v3_four_channel_phase_distribution_0/v3_four_channel_output_collection_0/v3_four_channel_placement_0/v3_channel_selector_late_promotion_2/v3_selector_route_pilot_0/G0_MUX_POS/X VSUBS sky130_fd_pr__nfet_01v8 ad=0 pd=0 as=0.169 ps=1.82 w=0.65 l=0.15
X843 v3_four_channel_bias_reference_distribution_0/v3_four_channel_phase_distribution_0/v3_four_channel_output_collection_0/v3_four_channel_placement_0/v3_channel_selector_late_promotion_2/VPWR v3_four_channel_bias_reference_distribution_0/v3_four_channel_phase_distribution_0/v3_four_channel_output_collection_0/v3_four_channel_placement_0/v3_channel_selector_late_promotion_2/v3_selector_route_pilot_0/G0_MUX_NEG/a_505_21# v3_four_channel_bias_reference_distribution_0/v3_four_channel_phase_distribution_0/v3_four_channel_output_collection_0/v3_four_channel_placement_0/v3_channel_selector_late_promotion_2/v3_selector_route_pilot_0/G0_MUX_NEG/a_535_374# v3_four_channel_bias_reference_distribution_0/v3_four_channel_phase_distribution_0/v3_four_channel_output_collection_0/v3_four_channel_placement_0/v3_channel_selector_late_promotion_2/VPWR sky130_fd_pr__pfet_01v8_hvt ad=0 pd=0 as=0.0882 ps=1.26 w=0.42 l=0.15
X844 v3_four_channel_bias_reference_distribution_0/v3_four_channel_phase_distribution_0/v3_four_channel_output_collection_0/v3_four_channel_placement_0/v3_channel_selector_late_promotion_2/v3_selector_route_pilot_0/G0_MUX_NEG/a_505_21# v3_four_channel_bias_reference_distribution_0/v3_four_channel_phase_distribution_0/v3_four_channel_output_collection_0/v3_four_channel_placement_0/v3_channel_selector_late_promotion_2/group0_bit0 v3_four_channel_bias_reference_distribution_0/v3_four_channel_phase_distribution_0/v3_four_channel_output_collection_0/v3_four_channel_placement_0/v3_channel_selector_late_promotion_2/VPWR v3_four_channel_bias_reference_distribution_0/v3_four_channel_phase_distribution_0/v3_four_channel_output_collection_0/v3_four_channel_placement_0/v3_channel_selector_late_promotion_2/VPWR sky130_fd_pr__pfet_01v8_hvt ad=0.1176 pd=1.4 as=0 ps=0 w=0.42 l=0.15
X845 v3_four_channel_bias_reference_distribution_0/v3_four_channel_phase_distribution_0/v3_four_channel_output_collection_0/v3_four_channel_placement_0/v3_channel_selector_late_promotion_2/v3_selector_route_pilot_0/G0_MUX_NEG/a_218_374# v3_four_channel_bias_reference_distribution_0/v3_four_channel_phase_distribution_0/v3_four_channel_output_collection_0/v3_four_channel_placement_0/v3_channel_selector_late_promotion_2/group0_bit0 v3_four_channel_bias_reference_distribution_0/v3_four_channel_phase_distribution_0/v3_four_channel_output_collection_0/v3_four_channel_placement_0/v3_channel_selector_late_promotion_2/VPWR v3_four_channel_bias_reference_distribution_0/v3_four_channel_phase_distribution_0/v3_four_channel_output_collection_0/v3_four_channel_placement_0/v3_channel_selector_late_promotion_2/VPWR sky130_fd_pr__pfet_01v8_hvt ad=0.1533 pd=1.57 as=0 ps=0 w=0.42 l=0.15
X846 VSUBS v3_four_channel_bias_reference_distribution_0/v3_four_channel_phase_distribution_0/v3_four_channel_output_collection_0/v3_four_channel_placement_0/v3_channel_selector_late_promotion_2/v3_selector_route_pilot_0/G0_MUX_NEG/a_505_21# v3_four_channel_bias_reference_distribution_0/v3_four_channel_phase_distribution_0/v3_four_channel_output_collection_0/v3_four_channel_placement_0/v3_channel_selector_late_promotion_2/v3_selector_route_pilot_0/G0_MUX_NEG/a_439_47# VSUBS sky130_fd_pr__nfet_01v8 ad=0 pd=0 as=0.1386 ps=1.5 w=0.42 l=0.15
X847 v3_four_channel_bias_reference_distribution_0/v3_four_channel_phase_distribution_0/v3_four_channel_output_collection_0/v3_four_channel_placement_0/v3_channel_selector_late_promotion_2/v3_selector_route_pilot_0/G0_MUX_NEG/a_76_199# v3_four_channel_bias_reference_distribution_0/v3_four_channel_phase_distribution_0/phase_180 v3_four_channel_bias_reference_distribution_0/v3_four_channel_phase_distribution_0/v3_four_channel_output_collection_0/v3_four_channel_placement_0/v3_channel_selector_late_promotion_2/v3_selector_route_pilot_0/G0_MUX_NEG/a_218_374# v3_four_channel_bias_reference_distribution_0/v3_four_channel_phase_distribution_0/v3_four_channel_output_collection_0/v3_four_channel_placement_0/v3_channel_selector_late_promotion_2/VPWR sky130_fd_pr__pfet_01v8_hvt ad=0.3864 pd=2.68 as=0 ps=0 w=0.42 l=0.15
X848 v3_four_channel_bias_reference_distribution_0/v3_four_channel_phase_distribution_0/v3_four_channel_output_collection_0/v3_four_channel_placement_0/v3_channel_selector_late_promotion_2/v3_selector_route_pilot_0/G0_MUX_NEG/a_505_21# v3_four_channel_bias_reference_distribution_0/v3_four_channel_phase_distribution_0/v3_four_channel_output_collection_0/v3_four_channel_placement_0/v3_channel_selector_late_promotion_2/group0_bit0 VSUBS VSUBS sky130_fd_pr__nfet_01v8 ad=0.1092 pd=1.36 as=0 ps=0 w=0.42 l=0.15
X849 v3_four_channel_bias_reference_distribution_0/v3_four_channel_phase_distribution_0/v3_four_channel_output_collection_0/v3_four_channel_placement_0/v3_channel_selector_late_promotion_2/v3_selector_route_pilot_0/G0_MUX_NEG/a_439_47# v3_four_channel_bias_reference_distribution_0/v3_four_channel_phase_distribution_0/phase_180 v3_four_channel_bias_reference_distribution_0/v3_four_channel_phase_distribution_0/v3_four_channel_output_collection_0/v3_four_channel_placement_0/v3_channel_selector_late_promotion_2/v3_selector_route_pilot_0/G0_MUX_NEG/a_76_199# VSUBS sky130_fd_pr__nfet_01v8 ad=0 pd=0 as=0.1995 ps=1.79 w=0.42 l=0.15
X850 v3_four_channel_bias_reference_distribution_0/v3_four_channel_phase_distribution_0/v3_four_channel_output_collection_0/v3_four_channel_placement_0/v3_channel_selector_late_promotion_2/v3_selector_route_pilot_0/G0_MUX_NEG/a_535_374# v3_four_channel_bias_reference_distribution_0/v3_four_channel_phase_distribution_0/phase_270 v3_four_channel_bias_reference_distribution_0/v3_four_channel_phase_distribution_0/v3_four_channel_output_collection_0/v3_four_channel_placement_0/v3_channel_selector_late_promotion_2/v3_selector_route_pilot_0/G0_MUX_NEG/a_76_199# v3_four_channel_bias_reference_distribution_0/v3_four_channel_phase_distribution_0/v3_four_channel_output_collection_0/v3_four_channel_placement_0/v3_channel_selector_late_promotion_2/VPWR sky130_fd_pr__pfet_01v8_hvt ad=0 pd=0 as=0 ps=0 w=0.42 l=0.15
X851 v3_four_channel_bias_reference_distribution_0/v3_four_channel_phase_distribution_0/v3_four_channel_output_collection_0/v3_four_channel_placement_0/v3_channel_selector_late_promotion_2/v3_selector_route_pilot_0/G0_MUX_NEG/a_76_199# v3_four_channel_bias_reference_distribution_0/v3_four_channel_phase_distribution_0/phase_270 v3_four_channel_bias_reference_distribution_0/v3_four_channel_phase_distribution_0/v3_four_channel_output_collection_0/v3_four_channel_placement_0/v3_channel_selector_late_promotion_2/v3_selector_route_pilot_0/G0_MUX_NEG/a_218_47# VSUBS sky130_fd_pr__nfet_01v8 ad=0 pd=0 as=0.1386 ps=1.5 w=0.42 l=0.15
X852 v3_four_channel_bias_reference_distribution_0/v3_four_channel_phase_distribution_0/v3_four_channel_output_collection_0/v3_four_channel_placement_0/v3_channel_selector_late_promotion_2/v3_selector_route_pilot_0/G0_MUX_NEG/a_218_47# v3_four_channel_bias_reference_distribution_0/v3_four_channel_phase_distribution_0/v3_four_channel_output_collection_0/v3_four_channel_placement_0/v3_channel_selector_late_promotion_2/group0_bit0 VSUBS VSUBS sky130_fd_pr__nfet_01v8 ad=0 pd=0 as=0 ps=0 w=0.42 l=0.15
X853 v3_four_channel_bias_reference_distribution_0/v3_four_channel_phase_distribution_0/v3_four_channel_output_collection_0/v3_four_channel_placement_0/v3_channel_selector_late_promotion_2/VPWR v3_four_channel_bias_reference_distribution_0/v3_four_channel_phase_distribution_0/v3_four_channel_output_collection_0/v3_four_channel_placement_0/v3_channel_selector_late_promotion_2/v3_selector_route_pilot_0/G0_MUX_NEG/a_76_199# v3_four_channel_bias_reference_distribution_0/v3_four_channel_phase_distribution_0/v3_four_channel_output_collection_0/v3_four_channel_placement_0/v3_channel_selector_late_promotion_2/v3_selector_route_pilot_0/G0_MUX_NEG/X v3_four_channel_bias_reference_distribution_0/v3_four_channel_phase_distribution_0/v3_four_channel_output_collection_0/v3_four_channel_placement_0/v3_channel_selector_late_promotion_2/VPWR sky130_fd_pr__pfet_01v8_hvt ad=0 pd=0 as=0.26 ps=2.52 w=1 l=0.15
X854 VSUBS v3_four_channel_bias_reference_distribution_0/v3_four_channel_phase_distribution_0/v3_four_channel_output_collection_0/v3_four_channel_placement_0/v3_channel_selector_late_promotion_2/v3_selector_route_pilot_0/G0_MUX_NEG/a_76_199# v3_four_channel_bias_reference_distribution_0/v3_four_channel_phase_distribution_0/v3_four_channel_output_collection_0/v3_four_channel_placement_0/v3_channel_selector_late_promotion_2/v3_selector_route_pilot_0/G0_MUX_NEG/X VSUBS sky130_fd_pr__nfet_01v8 ad=0 pd=0 as=0.169 ps=1.82 w=0.65 l=0.15
X855 v3_four_channel_bias_reference_distribution_0/v3_four_channel_phase_distribution_0/v3_four_channel_output_collection_0/v3_four_channel_placement_0/v3_channel_selector_late_promotion_2/VPWR v3_four_channel_bias_reference_distribution_0/v3_four_channel_phase_distribution_0/v3_four_channel_output_collection_0/v3_four_channel_placement_0/v3_channel_selector_late_promotion_2/v3_selector_route_pilot_0/G2_MUX_AXIS/a_505_21# v3_four_channel_bias_reference_distribution_0/v3_four_channel_phase_distribution_0/v3_four_channel_output_collection_0/v3_four_channel_placement_0/v3_channel_selector_late_promotion_2/v3_selector_route_pilot_0/G2_MUX_AXIS/a_535_374# v3_four_channel_bias_reference_distribution_0/v3_four_channel_phase_distribution_0/v3_four_channel_output_collection_0/v3_four_channel_placement_0/v3_channel_selector_late_promotion_2/VPWR sky130_fd_pr__pfet_01v8_hvt ad=0 pd=0 as=0.0882 ps=1.26 w=0.42 l=0.15
X856 v3_four_channel_bias_reference_distribution_0/v3_four_channel_phase_distribution_0/v3_four_channel_output_collection_0/v3_four_channel_placement_0/v3_channel_selector_late_promotion_2/v3_selector_route_pilot_0/G2_MUX_AXIS/a_505_21# v3_four_channel_bias_reference_distribution_0/v3_four_channel_phase_distribution_0/v3_four_channel_output_collection_0/v3_four_channel_placement_0/v3_channel_selector_late_promotion_2/group2_bit1 v3_four_channel_bias_reference_distribution_0/v3_four_channel_phase_distribution_0/v3_four_channel_output_collection_0/v3_four_channel_placement_0/v3_channel_selector_late_promotion_2/VPWR v3_four_channel_bias_reference_distribution_0/v3_four_channel_phase_distribution_0/v3_four_channel_output_collection_0/v3_four_channel_placement_0/v3_channel_selector_late_promotion_2/VPWR sky130_fd_pr__pfet_01v8_hvt ad=0.1176 pd=1.4 as=0 ps=0 w=0.42 l=0.15
X857 v3_four_channel_bias_reference_distribution_0/v3_four_channel_phase_distribution_0/v3_four_channel_output_collection_0/v3_four_channel_placement_0/v3_channel_selector_late_promotion_2/v3_selector_route_pilot_0/G2_MUX_AXIS/a_218_374# v3_four_channel_bias_reference_distribution_0/v3_four_channel_phase_distribution_0/v3_four_channel_output_collection_0/v3_four_channel_placement_0/v3_channel_selector_late_promotion_2/group2_bit1 v3_four_channel_bias_reference_distribution_0/v3_four_channel_phase_distribution_0/v3_four_channel_output_collection_0/v3_four_channel_placement_0/v3_channel_selector_late_promotion_2/VPWR v3_four_channel_bias_reference_distribution_0/v3_four_channel_phase_distribution_0/v3_four_channel_output_collection_0/v3_four_channel_placement_0/v3_channel_selector_late_promotion_2/VPWR sky130_fd_pr__pfet_01v8_hvt ad=0.1533 pd=1.57 as=0 ps=0 w=0.42 l=0.15
X858 VSUBS v3_four_channel_bias_reference_distribution_0/v3_four_channel_phase_distribution_0/v3_four_channel_output_collection_0/v3_four_channel_placement_0/v3_channel_selector_late_promotion_2/v3_selector_route_pilot_0/G2_MUX_AXIS/a_505_21# v3_four_channel_bias_reference_distribution_0/v3_four_channel_phase_distribution_0/v3_four_channel_output_collection_0/v3_four_channel_placement_0/v3_channel_selector_late_promotion_2/v3_selector_route_pilot_0/G2_MUX_AXIS/a_439_47# VSUBS sky130_fd_pr__nfet_01v8 ad=0 pd=0 as=0.1386 ps=1.5 w=0.42 l=0.15
X859 v3_four_channel_bias_reference_distribution_0/v3_four_channel_phase_distribution_0/v3_four_channel_output_collection_0/v3_four_channel_placement_0/v3_channel_selector_late_promotion_2/v3_selector_route_pilot_0/G2_MUX_AXIS/a_76_199# v3_four_channel_bias_reference_distribution_0/v3_four_channel_phase_distribution_0/v3_four_channel_output_collection_0/v3_four_channel_placement_0/v3_channel_selector_late_promotion_2/v3_selector_route_pilot_0/G2_MUX_POS/X v3_four_channel_bias_reference_distribution_0/v3_four_channel_phase_distribution_0/v3_four_channel_output_collection_0/v3_four_channel_placement_0/v3_channel_selector_late_promotion_2/v3_selector_route_pilot_0/G2_MUX_AXIS/a_218_374# v3_four_channel_bias_reference_distribution_0/v3_four_channel_phase_distribution_0/v3_four_channel_output_collection_0/v3_four_channel_placement_0/v3_channel_selector_late_promotion_2/VPWR sky130_fd_pr__pfet_01v8_hvt ad=0.3864 pd=2.68 as=0 ps=0 w=0.42 l=0.15
X860 v3_four_channel_bias_reference_distribution_0/v3_four_channel_phase_distribution_0/v3_four_channel_output_collection_0/v3_four_channel_placement_0/v3_channel_selector_late_promotion_2/v3_selector_route_pilot_0/G2_MUX_AXIS/a_505_21# v3_four_channel_bias_reference_distribution_0/v3_four_channel_phase_distribution_0/v3_four_channel_output_collection_0/v3_four_channel_placement_0/v3_channel_selector_late_promotion_2/group2_bit1 VSUBS VSUBS sky130_fd_pr__nfet_01v8 ad=0.1092 pd=1.36 as=0 ps=0 w=0.42 l=0.15
X861 v3_four_channel_bias_reference_distribution_0/v3_four_channel_phase_distribution_0/v3_four_channel_output_collection_0/v3_four_channel_placement_0/v3_channel_selector_late_promotion_2/v3_selector_route_pilot_0/G2_MUX_AXIS/a_439_47# v3_four_channel_bias_reference_distribution_0/v3_four_channel_phase_distribution_0/v3_four_channel_output_collection_0/v3_four_channel_placement_0/v3_channel_selector_late_promotion_2/v3_selector_route_pilot_0/G2_MUX_POS/X v3_four_channel_bias_reference_distribution_0/v3_four_channel_phase_distribution_0/v3_four_channel_output_collection_0/v3_four_channel_placement_0/v3_channel_selector_late_promotion_2/v3_selector_route_pilot_0/G2_MUX_AXIS/a_76_199# VSUBS sky130_fd_pr__nfet_01v8 ad=0 pd=0 as=0.1995 ps=1.79 w=0.42 l=0.15
X862 v3_four_channel_bias_reference_distribution_0/v3_four_channel_phase_distribution_0/v3_four_channel_output_collection_0/v3_four_channel_placement_0/v3_channel_selector_late_promotion_2/v3_selector_route_pilot_0/G2_MUX_AXIS/a_535_374# v3_four_channel_bias_reference_distribution_0/v3_four_channel_phase_distribution_0/v3_four_channel_output_collection_0/v3_four_channel_placement_0/v3_channel_selector_late_promotion_2/v3_selector_route_pilot_0/G2_MUX_NEG/X v3_four_channel_bias_reference_distribution_0/v3_four_channel_phase_distribution_0/v3_four_channel_output_collection_0/v3_four_channel_placement_0/v3_channel_selector_late_promotion_2/v3_selector_route_pilot_0/G2_MUX_AXIS/a_76_199# v3_four_channel_bias_reference_distribution_0/v3_four_channel_phase_distribution_0/v3_four_channel_output_collection_0/v3_four_channel_placement_0/v3_channel_selector_late_promotion_2/VPWR sky130_fd_pr__pfet_01v8_hvt ad=0 pd=0 as=0 ps=0 w=0.42 l=0.15
X863 v3_four_channel_bias_reference_distribution_0/v3_four_channel_phase_distribution_0/v3_four_channel_output_collection_0/v3_four_channel_placement_0/v3_channel_selector_late_promotion_2/v3_selector_route_pilot_0/G2_MUX_AXIS/a_76_199# v3_four_channel_bias_reference_distribution_0/v3_four_channel_phase_distribution_0/v3_four_channel_output_collection_0/v3_four_channel_placement_0/v3_channel_selector_late_promotion_2/v3_selector_route_pilot_0/G2_MUX_NEG/X v3_four_channel_bias_reference_distribution_0/v3_four_channel_phase_distribution_0/v3_four_channel_output_collection_0/v3_four_channel_placement_0/v3_channel_selector_late_promotion_2/v3_selector_route_pilot_0/G2_MUX_AXIS/a_218_47# VSUBS sky130_fd_pr__nfet_01v8 ad=0 pd=0 as=0.1386 ps=1.5 w=0.42 l=0.15
X864 v3_four_channel_bias_reference_distribution_0/v3_four_channel_phase_distribution_0/v3_four_channel_output_collection_0/v3_four_channel_placement_0/v3_channel_selector_late_promotion_2/v3_selector_route_pilot_0/G2_MUX_AXIS/a_218_47# v3_four_channel_bias_reference_distribution_0/v3_four_channel_phase_distribution_0/v3_four_channel_output_collection_0/v3_four_channel_placement_0/v3_channel_selector_late_promotion_2/group2_bit1 VSUBS VSUBS sky130_fd_pr__nfet_01v8 ad=0 pd=0 as=0 ps=0 w=0.42 l=0.15
X865 v3_four_channel_bias_reference_distribution_0/v3_four_channel_phase_distribution_0/v3_four_channel_output_collection_0/v3_four_channel_placement_0/v3_channel_selector_late_promotion_2/VPWR v3_four_channel_bias_reference_distribution_0/v3_four_channel_phase_distribution_0/v3_four_channel_output_collection_0/v3_four_channel_placement_0/v3_channel_selector_late_promotion_2/v3_selector_route_pilot_0/G2_MUX_AXIS/a_76_199# v3_four_channel_bias_reference_distribution_0/v3_four_channel_phase_distribution_0/v3_four_channel_output_collection_0/v3_four_channel_placement_0/v3_channel_selector_late_promotion_2/v3_selector_route_pilot_0/G2_MUX_AXIS/X v3_four_channel_bias_reference_distribution_0/v3_four_channel_phase_distribution_0/v3_four_channel_output_collection_0/v3_four_channel_placement_0/v3_channel_selector_late_promotion_2/VPWR sky130_fd_pr__pfet_01v8_hvt ad=0 pd=0 as=0.26 ps=2.52 w=1 l=0.15
X866 VSUBS v3_four_channel_bias_reference_distribution_0/v3_four_channel_phase_distribution_0/v3_four_channel_output_collection_0/v3_four_channel_placement_0/v3_channel_selector_late_promotion_2/v3_selector_route_pilot_0/G2_MUX_AXIS/a_76_199# v3_four_channel_bias_reference_distribution_0/v3_four_channel_phase_distribution_0/v3_four_channel_output_collection_0/v3_four_channel_placement_0/v3_channel_selector_late_promotion_2/v3_selector_route_pilot_0/G2_MUX_AXIS/X VSUBS sky130_fd_pr__nfet_01v8 ad=0 pd=0 as=0.169 ps=1.82 w=0.65 l=0.15
X867 v3_four_channel_bias_reference_distribution_0/v3_four_channel_phase_distribution_0/v3_four_channel_output_collection_0/v3_four_channel_placement_0/v3_channel_selector_late_promotion_2/VPWR v3_four_channel_bias_reference_distribution_0/v3_four_channel_phase_distribution_0/v3_four_channel_output_collection_0/v3_four_channel_placement_0/v3_channel_selector_late_promotion_2/v3_selector_route_pilot_0/G3_MUX_POS/a_505_21# v3_four_channel_bias_reference_distribution_0/v3_four_channel_phase_distribution_0/v3_four_channel_output_collection_0/v3_four_channel_placement_0/v3_channel_selector_late_promotion_2/v3_selector_route_pilot_0/G3_MUX_POS/a_535_374# v3_four_channel_bias_reference_distribution_0/v3_four_channel_phase_distribution_0/v3_four_channel_output_collection_0/v3_four_channel_placement_0/v3_channel_selector_late_promotion_2/VPWR sky130_fd_pr__pfet_01v8_hvt ad=0 pd=0 as=0.0882 ps=1.26 w=0.42 l=0.15
X868 v3_four_channel_bias_reference_distribution_0/v3_four_channel_phase_distribution_0/v3_four_channel_output_collection_0/v3_four_channel_placement_0/v3_channel_selector_late_promotion_2/v3_selector_route_pilot_0/G3_MUX_POS/a_505_21# v3_four_channel_bias_reference_distribution_0/v3_four_channel_phase_distribution_0/v3_four_channel_output_collection_0/v3_four_channel_placement_0/v3_channel_selector_late_promotion_2/group3_bit0 v3_four_channel_bias_reference_distribution_0/v3_four_channel_phase_distribution_0/v3_four_channel_output_collection_0/v3_four_channel_placement_0/v3_channel_selector_late_promotion_2/VPWR v3_four_channel_bias_reference_distribution_0/v3_four_channel_phase_distribution_0/v3_four_channel_output_collection_0/v3_four_channel_placement_0/v3_channel_selector_late_promotion_2/VPWR sky130_fd_pr__pfet_01v8_hvt ad=0.1176 pd=1.4 as=0 ps=0 w=0.42 l=0.15
X869 v3_four_channel_bias_reference_distribution_0/v3_four_channel_phase_distribution_0/v3_four_channel_output_collection_0/v3_four_channel_placement_0/v3_channel_selector_late_promotion_2/v3_selector_route_pilot_0/G3_MUX_POS/a_218_374# v3_four_channel_bias_reference_distribution_0/v3_four_channel_phase_distribution_0/v3_four_channel_output_collection_0/v3_four_channel_placement_0/v3_channel_selector_late_promotion_2/group3_bit0 v3_four_channel_bias_reference_distribution_0/v3_four_channel_phase_distribution_0/v3_four_channel_output_collection_0/v3_four_channel_placement_0/v3_channel_selector_late_promotion_2/VPWR v3_four_channel_bias_reference_distribution_0/v3_four_channel_phase_distribution_0/v3_four_channel_output_collection_0/v3_four_channel_placement_0/v3_channel_selector_late_promotion_2/VPWR sky130_fd_pr__pfet_01v8_hvt ad=0.1533 pd=1.57 as=0 ps=0 w=0.42 l=0.15
X870 VSUBS v3_four_channel_bias_reference_distribution_0/v3_four_channel_phase_distribution_0/v3_four_channel_output_collection_0/v3_four_channel_placement_0/v3_channel_selector_late_promotion_2/v3_selector_route_pilot_0/G3_MUX_POS/a_505_21# v3_four_channel_bias_reference_distribution_0/v3_four_channel_phase_distribution_0/v3_four_channel_output_collection_0/v3_four_channel_placement_0/v3_channel_selector_late_promotion_2/v3_selector_route_pilot_0/G3_MUX_POS/a_439_47# VSUBS sky130_fd_pr__nfet_01v8 ad=0 pd=0 as=0.1386 ps=1.5 w=0.42 l=0.15
X871 v3_four_channel_bias_reference_distribution_0/v3_four_channel_phase_distribution_0/v3_four_channel_output_collection_0/v3_four_channel_placement_0/v3_channel_selector_late_promotion_2/v3_selector_route_pilot_0/G3_MUX_POS/a_76_199# v3_four_channel_bias_reference_distribution_0/v3_four_channel_phase_distribution_0/phase_0 v3_four_channel_bias_reference_distribution_0/v3_four_channel_phase_distribution_0/v3_four_channel_output_collection_0/v3_four_channel_placement_0/v3_channel_selector_late_promotion_2/v3_selector_route_pilot_0/G3_MUX_POS/a_218_374# v3_four_channel_bias_reference_distribution_0/v3_four_channel_phase_distribution_0/v3_four_channel_output_collection_0/v3_four_channel_placement_0/v3_channel_selector_late_promotion_2/VPWR sky130_fd_pr__pfet_01v8_hvt ad=0.3864 pd=2.68 as=0 ps=0 w=0.42 l=0.15
X872 v3_four_channel_bias_reference_distribution_0/v3_four_channel_phase_distribution_0/v3_four_channel_output_collection_0/v3_four_channel_placement_0/v3_channel_selector_late_promotion_2/v3_selector_route_pilot_0/G3_MUX_POS/a_505_21# v3_four_channel_bias_reference_distribution_0/v3_four_channel_phase_distribution_0/v3_four_channel_output_collection_0/v3_four_channel_placement_0/v3_channel_selector_late_promotion_2/group3_bit0 VSUBS VSUBS sky130_fd_pr__nfet_01v8 ad=0.1092 pd=1.36 as=0 ps=0 w=0.42 l=0.15
X873 v3_four_channel_bias_reference_distribution_0/v3_four_channel_phase_distribution_0/v3_four_channel_output_collection_0/v3_four_channel_placement_0/v3_channel_selector_late_promotion_2/v3_selector_route_pilot_0/G3_MUX_POS/a_439_47# v3_four_channel_bias_reference_distribution_0/v3_four_channel_phase_distribution_0/phase_0 v3_four_channel_bias_reference_distribution_0/v3_four_channel_phase_distribution_0/v3_four_channel_output_collection_0/v3_four_channel_placement_0/v3_channel_selector_late_promotion_2/v3_selector_route_pilot_0/G3_MUX_POS/a_76_199# VSUBS sky130_fd_pr__nfet_01v8 ad=0 pd=0 as=0.1995 ps=1.79 w=0.42 l=0.15
X874 v3_four_channel_bias_reference_distribution_0/v3_four_channel_phase_distribution_0/v3_four_channel_output_collection_0/v3_four_channel_placement_0/v3_channel_selector_late_promotion_2/v3_selector_route_pilot_0/G3_MUX_POS/a_535_374# v3_four_channel_bias_reference_distribution_0/v3_four_channel_phase_distribution_0/phase_90 v3_four_channel_bias_reference_distribution_0/v3_four_channel_phase_distribution_0/v3_four_channel_output_collection_0/v3_four_channel_placement_0/v3_channel_selector_late_promotion_2/v3_selector_route_pilot_0/G3_MUX_POS/a_76_199# v3_four_channel_bias_reference_distribution_0/v3_four_channel_phase_distribution_0/v3_four_channel_output_collection_0/v3_four_channel_placement_0/v3_channel_selector_late_promotion_2/VPWR sky130_fd_pr__pfet_01v8_hvt ad=0 pd=0 as=0 ps=0 w=0.42 l=0.15
X875 v3_four_channel_bias_reference_distribution_0/v3_four_channel_phase_distribution_0/v3_four_channel_output_collection_0/v3_four_channel_placement_0/v3_channel_selector_late_promotion_2/v3_selector_route_pilot_0/G3_MUX_POS/a_76_199# v3_four_channel_bias_reference_distribution_0/v3_four_channel_phase_distribution_0/phase_90 v3_four_channel_bias_reference_distribution_0/v3_four_channel_phase_distribution_0/v3_four_channel_output_collection_0/v3_four_channel_placement_0/v3_channel_selector_late_promotion_2/v3_selector_route_pilot_0/G3_MUX_POS/a_218_47# VSUBS sky130_fd_pr__nfet_01v8 ad=0 pd=0 as=0.1386 ps=1.5 w=0.42 l=0.15
X876 v3_four_channel_bias_reference_distribution_0/v3_four_channel_phase_distribution_0/v3_four_channel_output_collection_0/v3_four_channel_placement_0/v3_channel_selector_late_promotion_2/v3_selector_route_pilot_0/G3_MUX_POS/a_218_47# v3_four_channel_bias_reference_distribution_0/v3_four_channel_phase_distribution_0/v3_four_channel_output_collection_0/v3_four_channel_placement_0/v3_channel_selector_late_promotion_2/group3_bit0 VSUBS VSUBS sky130_fd_pr__nfet_01v8 ad=0 pd=0 as=0 ps=0 w=0.42 l=0.15
X877 v3_four_channel_bias_reference_distribution_0/v3_four_channel_phase_distribution_0/v3_four_channel_output_collection_0/v3_four_channel_placement_0/v3_channel_selector_late_promotion_2/VPWR v3_four_channel_bias_reference_distribution_0/v3_four_channel_phase_distribution_0/v3_four_channel_output_collection_0/v3_four_channel_placement_0/v3_channel_selector_late_promotion_2/v3_selector_route_pilot_0/G3_MUX_POS/a_76_199# v3_four_channel_bias_reference_distribution_0/v3_four_channel_phase_distribution_0/v3_four_channel_output_collection_0/v3_four_channel_placement_0/v3_channel_selector_late_promotion_2/v3_selector_route_pilot_0/G3_MUX_POS/X v3_four_channel_bias_reference_distribution_0/v3_four_channel_phase_distribution_0/v3_four_channel_output_collection_0/v3_four_channel_placement_0/v3_channel_selector_late_promotion_2/VPWR sky130_fd_pr__pfet_01v8_hvt ad=0 pd=0 as=0.26 ps=2.52 w=1 l=0.15
X878 VSUBS v3_four_channel_bias_reference_distribution_0/v3_four_channel_phase_distribution_0/v3_four_channel_output_collection_0/v3_four_channel_placement_0/v3_channel_selector_late_promotion_2/v3_selector_route_pilot_0/G3_MUX_POS/a_76_199# v3_four_channel_bias_reference_distribution_0/v3_four_channel_phase_distribution_0/v3_four_channel_output_collection_0/v3_four_channel_placement_0/v3_channel_selector_late_promotion_2/v3_selector_route_pilot_0/G3_MUX_POS/X VSUBS sky130_fd_pr__nfet_01v8 ad=0 pd=0 as=0.169 ps=1.82 w=0.65 l=0.15
X879 v3_four_channel_bias_reference_distribution_0/v3_four_channel_phase_distribution_0/v3_four_channel_output_collection_0/v3_four_channel_placement_0/v3_channel_selector_late_promotion_2/VPWR v3_four_channel_bias_reference_distribution_0/v3_four_channel_phase_distribution_0/v3_four_channel_output_collection_0/v3_four_channel_placement_0/v3_channel_selector_late_promotion_2/v3_selector_route_pilot_0/G3_MUX_NEG/a_505_21# v3_four_channel_bias_reference_distribution_0/v3_four_channel_phase_distribution_0/v3_four_channel_output_collection_0/v3_four_channel_placement_0/v3_channel_selector_late_promotion_2/v3_selector_route_pilot_0/G3_MUX_NEG/a_535_374# v3_four_channel_bias_reference_distribution_0/v3_four_channel_phase_distribution_0/v3_four_channel_output_collection_0/v3_four_channel_placement_0/v3_channel_selector_late_promotion_2/VPWR sky130_fd_pr__pfet_01v8_hvt ad=0 pd=0 as=0.0882 ps=1.26 w=0.42 l=0.15
X880 v3_four_channel_bias_reference_distribution_0/v3_four_channel_phase_distribution_0/v3_four_channel_output_collection_0/v3_four_channel_placement_0/v3_channel_selector_late_promotion_2/v3_selector_route_pilot_0/G3_MUX_NEG/a_505_21# v3_four_channel_bias_reference_distribution_0/v3_four_channel_phase_distribution_0/v3_four_channel_output_collection_0/v3_four_channel_placement_0/v3_channel_selector_late_promotion_2/group3_bit0 v3_four_channel_bias_reference_distribution_0/v3_four_channel_phase_distribution_0/v3_four_channel_output_collection_0/v3_four_channel_placement_0/v3_channel_selector_late_promotion_2/VPWR v3_four_channel_bias_reference_distribution_0/v3_four_channel_phase_distribution_0/v3_four_channel_output_collection_0/v3_four_channel_placement_0/v3_channel_selector_late_promotion_2/VPWR sky130_fd_pr__pfet_01v8_hvt ad=0.1176 pd=1.4 as=0 ps=0 w=0.42 l=0.15
X881 v3_four_channel_bias_reference_distribution_0/v3_four_channel_phase_distribution_0/v3_four_channel_output_collection_0/v3_four_channel_placement_0/v3_channel_selector_late_promotion_2/v3_selector_route_pilot_0/G3_MUX_NEG/a_218_374# v3_four_channel_bias_reference_distribution_0/v3_four_channel_phase_distribution_0/v3_four_channel_output_collection_0/v3_four_channel_placement_0/v3_channel_selector_late_promotion_2/group3_bit0 v3_four_channel_bias_reference_distribution_0/v3_four_channel_phase_distribution_0/v3_four_channel_output_collection_0/v3_four_channel_placement_0/v3_channel_selector_late_promotion_2/VPWR v3_four_channel_bias_reference_distribution_0/v3_four_channel_phase_distribution_0/v3_four_channel_output_collection_0/v3_four_channel_placement_0/v3_channel_selector_late_promotion_2/VPWR sky130_fd_pr__pfet_01v8_hvt ad=0.1533 pd=1.57 as=0 ps=0 w=0.42 l=0.15
X882 VSUBS v3_four_channel_bias_reference_distribution_0/v3_four_channel_phase_distribution_0/v3_four_channel_output_collection_0/v3_four_channel_placement_0/v3_channel_selector_late_promotion_2/v3_selector_route_pilot_0/G3_MUX_NEG/a_505_21# v3_four_channel_bias_reference_distribution_0/v3_four_channel_phase_distribution_0/v3_four_channel_output_collection_0/v3_four_channel_placement_0/v3_channel_selector_late_promotion_2/v3_selector_route_pilot_0/G3_MUX_NEG/a_439_47# VSUBS sky130_fd_pr__nfet_01v8 ad=0 pd=0 as=0.1386 ps=1.5 w=0.42 l=0.15
X883 v3_four_channel_bias_reference_distribution_0/v3_four_channel_phase_distribution_0/v3_four_channel_output_collection_0/v3_four_channel_placement_0/v3_channel_selector_late_promotion_2/v3_selector_route_pilot_0/G3_MUX_NEG/a_76_199# v3_four_channel_bias_reference_distribution_0/v3_four_channel_phase_distribution_0/phase_180 v3_four_channel_bias_reference_distribution_0/v3_four_channel_phase_distribution_0/v3_four_channel_output_collection_0/v3_four_channel_placement_0/v3_channel_selector_late_promotion_2/v3_selector_route_pilot_0/G3_MUX_NEG/a_218_374# v3_four_channel_bias_reference_distribution_0/v3_four_channel_phase_distribution_0/v3_four_channel_output_collection_0/v3_four_channel_placement_0/v3_channel_selector_late_promotion_2/VPWR sky130_fd_pr__pfet_01v8_hvt ad=0.3864 pd=2.68 as=0 ps=0 w=0.42 l=0.15
X884 v3_four_channel_bias_reference_distribution_0/v3_four_channel_phase_distribution_0/v3_four_channel_output_collection_0/v3_four_channel_placement_0/v3_channel_selector_late_promotion_2/v3_selector_route_pilot_0/G3_MUX_NEG/a_505_21# v3_four_channel_bias_reference_distribution_0/v3_four_channel_phase_distribution_0/v3_four_channel_output_collection_0/v3_four_channel_placement_0/v3_channel_selector_late_promotion_2/group3_bit0 VSUBS VSUBS sky130_fd_pr__nfet_01v8 ad=0.1092 pd=1.36 as=0 ps=0 w=0.42 l=0.15
X885 v3_four_channel_bias_reference_distribution_0/v3_four_channel_phase_distribution_0/v3_four_channel_output_collection_0/v3_four_channel_placement_0/v3_channel_selector_late_promotion_2/v3_selector_route_pilot_0/G3_MUX_NEG/a_439_47# v3_four_channel_bias_reference_distribution_0/v3_four_channel_phase_distribution_0/phase_180 v3_four_channel_bias_reference_distribution_0/v3_four_channel_phase_distribution_0/v3_four_channel_output_collection_0/v3_four_channel_placement_0/v3_channel_selector_late_promotion_2/v3_selector_route_pilot_0/G3_MUX_NEG/a_76_199# VSUBS sky130_fd_pr__nfet_01v8 ad=0 pd=0 as=0.1995 ps=1.79 w=0.42 l=0.15
X886 v3_four_channel_bias_reference_distribution_0/v3_four_channel_phase_distribution_0/v3_four_channel_output_collection_0/v3_four_channel_placement_0/v3_channel_selector_late_promotion_2/v3_selector_route_pilot_0/G3_MUX_NEG/a_535_374# v3_four_channel_bias_reference_distribution_0/v3_four_channel_phase_distribution_0/phase_270 v3_four_channel_bias_reference_distribution_0/v3_four_channel_phase_distribution_0/v3_four_channel_output_collection_0/v3_four_channel_placement_0/v3_channel_selector_late_promotion_2/v3_selector_route_pilot_0/G3_MUX_NEG/a_76_199# v3_four_channel_bias_reference_distribution_0/v3_four_channel_phase_distribution_0/v3_four_channel_output_collection_0/v3_four_channel_placement_0/v3_channel_selector_late_promotion_2/VPWR sky130_fd_pr__pfet_01v8_hvt ad=0 pd=0 as=0 ps=0 w=0.42 l=0.15
X887 v3_four_channel_bias_reference_distribution_0/v3_four_channel_phase_distribution_0/v3_four_channel_output_collection_0/v3_four_channel_placement_0/v3_channel_selector_late_promotion_2/v3_selector_route_pilot_0/G3_MUX_NEG/a_76_199# v3_four_channel_bias_reference_distribution_0/v3_four_channel_phase_distribution_0/phase_270 v3_four_channel_bias_reference_distribution_0/v3_four_channel_phase_distribution_0/v3_four_channel_output_collection_0/v3_four_channel_placement_0/v3_channel_selector_late_promotion_2/v3_selector_route_pilot_0/G3_MUX_NEG/a_218_47# VSUBS sky130_fd_pr__nfet_01v8 ad=0 pd=0 as=0.1386 ps=1.5 w=0.42 l=0.15
X888 v3_four_channel_bias_reference_distribution_0/v3_four_channel_phase_distribution_0/v3_four_channel_output_collection_0/v3_four_channel_placement_0/v3_channel_selector_late_promotion_2/v3_selector_route_pilot_0/G3_MUX_NEG/a_218_47# v3_four_channel_bias_reference_distribution_0/v3_four_channel_phase_distribution_0/v3_four_channel_output_collection_0/v3_four_channel_placement_0/v3_channel_selector_late_promotion_2/group3_bit0 VSUBS VSUBS sky130_fd_pr__nfet_01v8 ad=0 pd=0 as=0 ps=0 w=0.42 l=0.15
X889 v3_four_channel_bias_reference_distribution_0/v3_four_channel_phase_distribution_0/v3_four_channel_output_collection_0/v3_four_channel_placement_0/v3_channel_selector_late_promotion_2/VPWR v3_four_channel_bias_reference_distribution_0/v3_four_channel_phase_distribution_0/v3_four_channel_output_collection_0/v3_four_channel_placement_0/v3_channel_selector_late_promotion_2/v3_selector_route_pilot_0/G3_MUX_NEG/a_76_199# v3_four_channel_bias_reference_distribution_0/v3_four_channel_phase_distribution_0/v3_four_channel_output_collection_0/v3_four_channel_placement_0/v3_channel_selector_late_promotion_2/v3_selector_route_pilot_0/G3_MUX_NEG/X v3_four_channel_bias_reference_distribution_0/v3_four_channel_phase_distribution_0/v3_four_channel_output_collection_0/v3_four_channel_placement_0/v3_channel_selector_late_promotion_2/VPWR sky130_fd_pr__pfet_01v8_hvt ad=0 pd=0 as=0.26 ps=2.52 w=1 l=0.15
X890 VSUBS v3_four_channel_bias_reference_distribution_0/v3_four_channel_phase_distribution_0/v3_four_channel_output_collection_0/v3_four_channel_placement_0/v3_channel_selector_late_promotion_2/v3_selector_route_pilot_0/G3_MUX_NEG/a_76_199# v3_four_channel_bias_reference_distribution_0/v3_four_channel_phase_distribution_0/v3_four_channel_output_collection_0/v3_four_channel_placement_0/v3_channel_selector_late_promotion_2/v3_selector_route_pilot_0/G3_MUX_NEG/X VSUBS sky130_fd_pr__nfet_01v8 ad=0 pd=0 as=0.169 ps=1.82 w=0.65 l=0.15
X891 v3_four_channel_bias_reference_distribution_0/v3_four_channel_phase_distribution_0/v3_four_channel_output_collection_0/v3_four_channel_placement_0/v3_channel_selector_late_promotion_2/VPWR v3_four_channel_bias_reference_distribution_0/v3_four_channel_phase_distribution_0/v3_four_channel_output_collection_0/v3_four_channel_placement_0/v3_channel_selector_late_promotion_2/v3_selector_route_pilot_0/G3_LO_P_AND/B v3_four_channel_bias_reference_distribution_0/v3_four_channel_phase_distribution_0/v3_four_channel_output_collection_0/v3_four_channel_placement_0/v3_channel_selector_late_promotion_2/v3_selector_route_pilot_0/G0_LO_P_AND/a_59_75# v3_four_channel_bias_reference_distribution_0/v3_four_channel_phase_distribution_0/v3_four_channel_output_collection_0/v3_four_channel_placement_0/v3_channel_selector_late_promotion_2/VPWR sky130_fd_pr__pfet_01v8_hvt ad=0 pd=0 as=0.1134 ps=1.38 w=0.42 l=0.15
X892 v3_four_channel_bias_reference_distribution_0/v3_four_channel_phase_distribution_0/v3_four_channel_output_collection_0/v3_four_channel_placement_0/v3_channel_selector_late_promotion_2/v3_selector_route_pilot_0/group0_lo_p v3_four_channel_bias_reference_distribution_0/v3_four_channel_phase_distribution_0/v3_four_channel_output_collection_0/v3_four_channel_placement_0/v3_channel_selector_late_promotion_2/v3_selector_route_pilot_0/G0_LO_P_AND/a_59_75# v3_four_channel_bias_reference_distribution_0/v3_four_channel_phase_distribution_0/v3_four_channel_output_collection_0/v3_four_channel_placement_0/v3_channel_selector_late_promotion_2/VPWR v3_four_channel_bias_reference_distribution_0/v3_four_channel_phase_distribution_0/v3_four_channel_output_collection_0/v3_four_channel_placement_0/v3_channel_selector_late_promotion_2/VPWR sky130_fd_pr__pfet_01v8_hvt ad=0.475 pd=2.95 as=0 ps=0 w=1 l=0.15
X893 VSUBS v3_four_channel_bias_reference_distribution_0/v3_four_channel_phase_distribution_0/v3_four_channel_output_collection_0/v3_four_channel_placement_0/v3_channel_selector_late_promotion_2/v3_selector_route_pilot_0/G3_LO_P_AND/B v3_four_channel_bias_reference_distribution_0/v3_four_channel_phase_distribution_0/v3_four_channel_output_collection_0/v3_four_channel_placement_0/v3_channel_selector_late_promotion_2/v3_selector_route_pilot_0/G0_LO_P_AND/a_145_75# VSUBS sky130_fd_pr__nfet_01v8 ad=0 pd=0 as=0.1134 ps=1.38 w=0.42 l=0.15
X894 v3_four_channel_bias_reference_distribution_0/v3_four_channel_phase_distribution_0/v3_four_channel_output_collection_0/v3_four_channel_placement_0/v3_channel_selector_late_promotion_2/v3_selector_route_pilot_0/G0_LO_P_AND/a_59_75# v3_four_channel_bias_reference_distribution_0/v3_four_channel_phase_distribution_0/v3_four_channel_output_collection_0/v3_four_channel_placement_0/v3_channel_selector_late_promotion_2/v3_selector_route_pilot_0/G0_MUX_AXIS/X v3_four_channel_bias_reference_distribution_0/v3_four_channel_phase_distribution_0/v3_four_channel_output_collection_0/v3_four_channel_placement_0/v3_channel_selector_late_promotion_2/VPWR v3_four_channel_bias_reference_distribution_0/v3_four_channel_phase_distribution_0/v3_four_channel_output_collection_0/v3_four_channel_placement_0/v3_channel_selector_late_promotion_2/VPWR sky130_fd_pr__pfet_01v8_hvt ad=0 pd=0 as=0 ps=0 w=0.42 l=0.15
X895 v3_four_channel_bias_reference_distribution_0/v3_four_channel_phase_distribution_0/v3_four_channel_output_collection_0/v3_four_channel_placement_0/v3_channel_selector_late_promotion_2/v3_selector_route_pilot_0/group0_lo_p v3_four_channel_bias_reference_distribution_0/v3_four_channel_phase_distribution_0/v3_four_channel_output_collection_0/v3_four_channel_placement_0/v3_channel_selector_late_promotion_2/v3_selector_route_pilot_0/G0_LO_P_AND/a_59_75# VSUBS VSUBS sky130_fd_pr__nfet_01v8 ad=0.182 pd=1.86 as=0 ps=0 w=0.65 l=0.15
X896 v3_four_channel_bias_reference_distribution_0/v3_four_channel_phase_distribution_0/v3_four_channel_output_collection_0/v3_four_channel_placement_0/v3_channel_selector_late_promotion_2/v3_selector_route_pilot_0/G0_LO_P_AND/a_145_75# v3_four_channel_bias_reference_distribution_0/v3_four_channel_phase_distribution_0/v3_four_channel_output_collection_0/v3_four_channel_placement_0/v3_channel_selector_late_promotion_2/v3_selector_route_pilot_0/G0_MUX_AXIS/X v3_four_channel_bias_reference_distribution_0/v3_four_channel_phase_distribution_0/v3_four_channel_output_collection_0/v3_four_channel_placement_0/v3_channel_selector_late_promotion_2/v3_selector_route_pilot_0/G0_LO_P_AND/a_59_75# VSUBS sky130_fd_pr__nfet_01v8 ad=0 pd=0 as=0.1176 ps=1.4 w=0.42 l=0.15
X897 v3_four_channel_bias_reference_distribution_0/v3_four_channel_phase_distribution_0/v3_four_channel_output_collection_0/v3_four_channel_placement_0/v3_channel_selector_late_promotion_2/VPWR v3_four_channel_bias_reference_distribution_0/v3_four_channel_phase_distribution_0/v3_four_channel_output_collection_0/v3_four_channel_placement_0/v3_channel_selector_late_promotion_2/v3_selector_route_pilot_0/G3_LO_P_AND/B v3_four_channel_bias_reference_distribution_0/v3_four_channel_phase_distribution_0/v3_four_channel_output_collection_0/v3_four_channel_placement_0/v3_channel_selector_late_promotion_2/v3_selector_route_pilot_0/G3_LO_N_ANDNOT/a_207_413# v3_four_channel_bias_reference_distribution_0/v3_four_channel_phase_distribution_0/v3_four_channel_output_collection_0/v3_four_channel_placement_0/v3_channel_selector_late_promotion_2/VPWR sky130_fd_pr__pfet_01v8_hvt ad=0 pd=0 as=0.1218 ps=1.42 w=0.42 l=0.15
X898 v3_four_channel_bias_reference_distribution_0/v3_four_channel_phase_distribution_0/v3_four_channel_output_collection_0/v3_four_channel_placement_0/v3_channel_selector_late_promotion_2/v3_selector_route_pilot_0/group3_lo_n v3_four_channel_bias_reference_distribution_0/v3_four_channel_phase_distribution_0/v3_four_channel_output_collection_0/v3_four_channel_placement_0/v3_channel_selector_late_promotion_2/v3_selector_route_pilot_0/G3_LO_N_ANDNOT/a_207_413# v3_four_channel_bias_reference_distribution_0/v3_four_channel_phase_distribution_0/v3_four_channel_output_collection_0/v3_four_channel_placement_0/v3_channel_selector_late_promotion_2/VPWR v3_four_channel_bias_reference_distribution_0/v3_four_channel_phase_distribution_0/v3_four_channel_output_collection_0/v3_four_channel_placement_0/v3_channel_selector_late_promotion_2/VPWR sky130_fd_pr__pfet_01v8_hvt ad=0.26 pd=2.52 as=0 ps=0 w=1 l=0.15
X899 v3_four_channel_bias_reference_distribution_0/v3_four_channel_phase_distribution_0/v3_four_channel_output_collection_0/v3_four_channel_placement_0/v3_channel_selector_late_promotion_2/v3_selector_route_pilot_0/G3_LO_N_ANDNOT/a_297_47# v3_four_channel_bias_reference_distribution_0/v3_four_channel_phase_distribution_0/v3_four_channel_output_collection_0/v3_four_channel_placement_0/v3_channel_selector_late_promotion_2/v3_selector_route_pilot_0/G3_LO_N_ANDNOT/a_27_413# v3_four_channel_bias_reference_distribution_0/v3_four_channel_phase_distribution_0/v3_four_channel_output_collection_0/v3_four_channel_placement_0/v3_channel_selector_late_promotion_2/v3_selector_route_pilot_0/G3_LO_N_ANDNOT/a_207_413# VSUBS sky130_fd_pr__nfet_01v8 ad=0.1008 pd=1.32 as=0.1092 ps=1.36 w=0.42 l=0.15
X900 v3_four_channel_bias_reference_distribution_0/v3_four_channel_phase_distribution_0/v3_four_channel_output_collection_0/v3_four_channel_placement_0/v3_channel_selector_late_promotion_2/v3_selector_route_pilot_0/group3_lo_n v3_four_channel_bias_reference_distribution_0/v3_four_channel_phase_distribution_0/v3_four_channel_output_collection_0/v3_four_channel_placement_0/v3_channel_selector_late_promotion_2/v3_selector_route_pilot_0/G3_LO_N_ANDNOT/a_207_413# VSUBS VSUBS sky130_fd_pr__nfet_01v8 ad=0.169 pd=1.82 as=0 ps=0 w=0.65 l=0.15
X901 v3_four_channel_bias_reference_distribution_0/v3_four_channel_phase_distribution_0/v3_four_channel_output_collection_0/v3_four_channel_placement_0/v3_channel_selector_late_promotion_2/v3_selector_route_pilot_0/G3_LO_N_ANDNOT/a_207_413# v3_four_channel_bias_reference_distribution_0/v3_four_channel_phase_distribution_0/v3_four_channel_output_collection_0/v3_four_channel_placement_0/v3_channel_selector_late_promotion_2/v3_selector_route_pilot_0/G3_LO_N_ANDNOT/a_27_413# v3_four_channel_bias_reference_distribution_0/v3_four_channel_phase_distribution_0/v3_four_channel_output_collection_0/v3_four_channel_placement_0/v3_channel_selector_late_promotion_2/VPWR v3_four_channel_bias_reference_distribution_0/v3_four_channel_phase_distribution_0/v3_four_channel_output_collection_0/v3_four_channel_placement_0/v3_channel_selector_late_promotion_2/VPWR sky130_fd_pr__pfet_01v8_hvt ad=0 pd=0 as=0 ps=0 w=0.42 l=0.15
X902 v3_four_channel_bias_reference_distribution_0/v3_four_channel_phase_distribution_0/v3_four_channel_output_collection_0/v3_four_channel_placement_0/v3_channel_selector_late_promotion_2/VPWR v3_four_channel_bias_reference_distribution_0/v3_four_channel_phase_distribution_0/v3_four_channel_output_collection_0/v3_four_channel_placement_0/v3_channel_selector_late_promotion_2/v3_selector_route_pilot_0/G3_MUX_AXIS/X v3_four_channel_bias_reference_distribution_0/v3_four_channel_phase_distribution_0/v3_four_channel_output_collection_0/v3_four_channel_placement_0/v3_channel_selector_late_promotion_2/v3_selector_route_pilot_0/G3_LO_N_ANDNOT/a_27_413# v3_four_channel_bias_reference_distribution_0/v3_four_channel_phase_distribution_0/v3_four_channel_output_collection_0/v3_four_channel_placement_0/v3_channel_selector_late_promotion_2/VPWR sky130_fd_pr__pfet_01v8_hvt ad=0 pd=0 as=0.1092 ps=1.36 w=0.42 l=0.15
X903 VSUBS v3_four_channel_bias_reference_distribution_0/v3_four_channel_phase_distribution_0/v3_four_channel_output_collection_0/v3_four_channel_placement_0/v3_channel_selector_late_promotion_2/v3_selector_route_pilot_0/G3_LO_P_AND/B v3_four_channel_bias_reference_distribution_0/v3_four_channel_phase_distribution_0/v3_four_channel_output_collection_0/v3_four_channel_placement_0/v3_channel_selector_late_promotion_2/v3_selector_route_pilot_0/G3_LO_N_ANDNOT/a_297_47# VSUBS sky130_fd_pr__nfet_01v8 ad=0 pd=0 as=0 ps=0 w=0.42 l=0.15
X904 v3_four_channel_bias_reference_distribution_0/v3_four_channel_phase_distribution_0/v3_four_channel_output_collection_0/v3_four_channel_placement_0/v3_channel_selector_late_promotion_2/v3_selector_route_pilot_0/G3_LO_N_ANDNOT/a_27_413# v3_four_channel_bias_reference_distribution_0/v3_four_channel_phase_distribution_0/v3_four_channel_output_collection_0/v3_four_channel_placement_0/v3_channel_selector_late_promotion_2/v3_selector_route_pilot_0/G3_MUX_AXIS/X VSUBS VSUBS sky130_fd_pr__nfet_01v8 ad=0.1092 pd=1.36 as=0 ps=0 w=0.42 l=0.15
X905 v3_four_channel_bias_reference_distribution_0/v3_four_channel_phase_distribution_0/v3_four_channel_output_collection_0/v3_four_channel_placement_0/v3_channel_selector_late_promotion_2/VPWR v3_four_channel_bias_reference_distribution_0/v3_four_channel_phase_distribution_0/v3_four_channel_output_collection_0/v3_four_channel_placement_0/v3_channel_selector_late_promotion_2/v3_selector_route_pilot_0/G3_LO_P_AND/B v3_four_channel_bias_reference_distribution_0/v3_four_channel_phase_distribution_0/v3_four_channel_output_collection_0/v3_four_channel_placement_0/v3_channel_selector_late_promotion_2/v3_selector_route_pilot_0/G2_LO_N_ANDNOT/a_207_413# v3_four_channel_bias_reference_distribution_0/v3_four_channel_phase_distribution_0/v3_four_channel_output_collection_0/v3_four_channel_placement_0/v3_channel_selector_late_promotion_2/VPWR sky130_fd_pr__pfet_01v8_hvt ad=0 pd=0 as=0.1218 ps=1.42 w=0.42 l=0.15
X906 v3_four_channel_bias_reference_distribution_0/v3_four_channel_phase_distribution_0/v3_four_channel_output_collection_0/v3_four_channel_placement_0/v3_channel_selector_late_promotion_2/v3_selector_route_pilot_0/group2_lo_n v3_four_channel_bias_reference_distribution_0/v3_four_channel_phase_distribution_0/v3_four_channel_output_collection_0/v3_four_channel_placement_0/v3_channel_selector_late_promotion_2/v3_selector_route_pilot_0/G2_LO_N_ANDNOT/a_207_413# v3_four_channel_bias_reference_distribution_0/v3_four_channel_phase_distribution_0/v3_four_channel_output_collection_0/v3_four_channel_placement_0/v3_channel_selector_late_promotion_2/VPWR v3_four_channel_bias_reference_distribution_0/v3_four_channel_phase_distribution_0/v3_four_channel_output_collection_0/v3_four_channel_placement_0/v3_channel_selector_late_promotion_2/VPWR sky130_fd_pr__pfet_01v8_hvt ad=0.26 pd=2.52 as=0 ps=0 w=1 l=0.15
X907 v3_four_channel_bias_reference_distribution_0/v3_four_channel_phase_distribution_0/v3_four_channel_output_collection_0/v3_four_channel_placement_0/v3_channel_selector_late_promotion_2/v3_selector_route_pilot_0/G2_LO_N_ANDNOT/a_297_47# v3_four_channel_bias_reference_distribution_0/v3_four_channel_phase_distribution_0/v3_four_channel_output_collection_0/v3_four_channel_placement_0/v3_channel_selector_late_promotion_2/v3_selector_route_pilot_0/G2_LO_N_ANDNOT/a_27_413# v3_four_channel_bias_reference_distribution_0/v3_four_channel_phase_distribution_0/v3_four_channel_output_collection_0/v3_four_channel_placement_0/v3_channel_selector_late_promotion_2/v3_selector_route_pilot_0/G2_LO_N_ANDNOT/a_207_413# VSUBS sky130_fd_pr__nfet_01v8 ad=0.1008 pd=1.32 as=0.1092 ps=1.36 w=0.42 l=0.15
X908 v3_four_channel_bias_reference_distribution_0/v3_four_channel_phase_distribution_0/v3_four_channel_output_collection_0/v3_four_channel_placement_0/v3_channel_selector_late_promotion_2/v3_selector_route_pilot_0/group2_lo_n v3_four_channel_bias_reference_distribution_0/v3_four_channel_phase_distribution_0/v3_four_channel_output_collection_0/v3_four_channel_placement_0/v3_channel_selector_late_promotion_2/v3_selector_route_pilot_0/G2_LO_N_ANDNOT/a_207_413# VSUBS VSUBS sky130_fd_pr__nfet_01v8 ad=0.169 pd=1.82 as=0 ps=0 w=0.65 l=0.15
X909 v3_four_channel_bias_reference_distribution_0/v3_four_channel_phase_distribution_0/v3_four_channel_output_collection_0/v3_four_channel_placement_0/v3_channel_selector_late_promotion_2/v3_selector_route_pilot_0/G2_LO_N_ANDNOT/a_207_413# v3_four_channel_bias_reference_distribution_0/v3_four_channel_phase_distribution_0/v3_four_channel_output_collection_0/v3_four_channel_placement_0/v3_channel_selector_late_promotion_2/v3_selector_route_pilot_0/G2_LO_N_ANDNOT/a_27_413# v3_four_channel_bias_reference_distribution_0/v3_four_channel_phase_distribution_0/v3_four_channel_output_collection_0/v3_four_channel_placement_0/v3_channel_selector_late_promotion_2/VPWR v3_four_channel_bias_reference_distribution_0/v3_four_channel_phase_distribution_0/v3_four_channel_output_collection_0/v3_four_channel_placement_0/v3_channel_selector_late_promotion_2/VPWR sky130_fd_pr__pfet_01v8_hvt ad=0 pd=0 as=0 ps=0 w=0.42 l=0.15
X910 v3_four_channel_bias_reference_distribution_0/v3_four_channel_phase_distribution_0/v3_four_channel_output_collection_0/v3_four_channel_placement_0/v3_channel_selector_late_promotion_2/VPWR v3_four_channel_bias_reference_distribution_0/v3_four_channel_phase_distribution_0/v3_four_channel_output_collection_0/v3_four_channel_placement_0/v3_channel_selector_late_promotion_2/v3_selector_route_pilot_0/G2_MUX_AXIS/X v3_four_channel_bias_reference_distribution_0/v3_four_channel_phase_distribution_0/v3_four_channel_output_collection_0/v3_four_channel_placement_0/v3_channel_selector_late_promotion_2/v3_selector_route_pilot_0/G2_LO_N_ANDNOT/a_27_413# v3_four_channel_bias_reference_distribution_0/v3_four_channel_phase_distribution_0/v3_four_channel_output_collection_0/v3_four_channel_placement_0/v3_channel_selector_late_promotion_2/VPWR sky130_fd_pr__pfet_01v8_hvt ad=0 pd=0 as=0.1092 ps=1.36 w=0.42 l=0.15
X911 VSUBS v3_four_channel_bias_reference_distribution_0/v3_four_channel_phase_distribution_0/v3_four_channel_output_collection_0/v3_four_channel_placement_0/v3_channel_selector_late_promotion_2/v3_selector_route_pilot_0/G3_LO_P_AND/B v3_four_channel_bias_reference_distribution_0/v3_four_channel_phase_distribution_0/v3_four_channel_output_collection_0/v3_four_channel_placement_0/v3_channel_selector_late_promotion_2/v3_selector_route_pilot_0/G2_LO_N_ANDNOT/a_297_47# VSUBS sky130_fd_pr__nfet_01v8 ad=0 pd=0 as=0 ps=0 w=0.42 l=0.15
X912 v3_four_channel_bias_reference_distribution_0/v3_four_channel_phase_distribution_0/v3_four_channel_output_collection_0/v3_four_channel_placement_0/v3_channel_selector_late_promotion_2/v3_selector_route_pilot_0/G2_LO_N_ANDNOT/a_27_413# v3_four_channel_bias_reference_distribution_0/v3_four_channel_phase_distribution_0/v3_four_channel_output_collection_0/v3_four_channel_placement_0/v3_channel_selector_late_promotion_2/v3_selector_route_pilot_0/G2_MUX_AXIS/X VSUBS VSUBS sky130_fd_pr__nfet_01v8 ad=0.1092 pd=1.36 as=0 ps=0 w=0.42 l=0.15
X913 v3_four_channel_bias_reference_distribution_0/v3_four_channel_phase_distribution_0/v3_four_channel_output_collection_0/v3_four_channel_placement_0/v3_channel_selector_late_promotion_2/VPWR v3_four_channel_bias_reference_distribution_0/v3_four_channel_phase_distribution_0/v3_four_channel_output_collection_0/v3_four_channel_placement_0/v3_channel_selector_late_promotion_2/v3_selector_route_pilot_0/G3_LO_P_AND/B v3_four_channel_bias_reference_distribution_0/v3_four_channel_phase_distribution_0/v3_four_channel_output_collection_0/v3_four_channel_placement_0/v3_channel_selector_late_promotion_2/v3_selector_route_pilot_0/G0_LO_N_ANDNOT/a_207_413# v3_four_channel_bias_reference_distribution_0/v3_four_channel_phase_distribution_0/v3_four_channel_output_collection_0/v3_four_channel_placement_0/v3_channel_selector_late_promotion_2/VPWR sky130_fd_pr__pfet_01v8_hvt ad=0 pd=0 as=0.1218 ps=1.42 w=0.42 l=0.15
X914 v3_four_channel_bias_reference_distribution_0/v3_four_channel_phase_distribution_0/v3_four_channel_output_collection_0/v3_four_channel_placement_0/v3_channel_selector_late_promotion_2/v3_selector_route_pilot_0/group0_lo_n v3_four_channel_bias_reference_distribution_0/v3_four_channel_phase_distribution_0/v3_four_channel_output_collection_0/v3_four_channel_placement_0/v3_channel_selector_late_promotion_2/v3_selector_route_pilot_0/G0_LO_N_ANDNOT/a_207_413# v3_four_channel_bias_reference_distribution_0/v3_four_channel_phase_distribution_0/v3_four_channel_output_collection_0/v3_four_channel_placement_0/v3_channel_selector_late_promotion_2/VPWR v3_four_channel_bias_reference_distribution_0/v3_four_channel_phase_distribution_0/v3_four_channel_output_collection_0/v3_four_channel_placement_0/v3_channel_selector_late_promotion_2/VPWR sky130_fd_pr__pfet_01v8_hvt ad=0.26 pd=2.52 as=0 ps=0 w=1 l=0.15
X915 v3_four_channel_bias_reference_distribution_0/v3_four_channel_phase_distribution_0/v3_four_channel_output_collection_0/v3_four_channel_placement_0/v3_channel_selector_late_promotion_2/v3_selector_route_pilot_0/G0_LO_N_ANDNOT/a_297_47# v3_four_channel_bias_reference_distribution_0/v3_four_channel_phase_distribution_0/v3_four_channel_output_collection_0/v3_four_channel_placement_0/v3_channel_selector_late_promotion_2/v3_selector_route_pilot_0/G0_LO_N_ANDNOT/a_27_413# v3_four_channel_bias_reference_distribution_0/v3_four_channel_phase_distribution_0/v3_four_channel_output_collection_0/v3_four_channel_placement_0/v3_channel_selector_late_promotion_2/v3_selector_route_pilot_0/G0_LO_N_ANDNOT/a_207_413# VSUBS sky130_fd_pr__nfet_01v8 ad=0.1008 pd=1.32 as=0.1092 ps=1.36 w=0.42 l=0.15
X916 v3_four_channel_bias_reference_distribution_0/v3_four_channel_phase_distribution_0/v3_four_channel_output_collection_0/v3_four_channel_placement_0/v3_channel_selector_late_promotion_2/v3_selector_route_pilot_0/group0_lo_n v3_four_channel_bias_reference_distribution_0/v3_four_channel_phase_distribution_0/v3_four_channel_output_collection_0/v3_four_channel_placement_0/v3_channel_selector_late_promotion_2/v3_selector_route_pilot_0/G0_LO_N_ANDNOT/a_207_413# VSUBS VSUBS sky130_fd_pr__nfet_01v8 ad=0.169 pd=1.82 as=0 ps=0 w=0.65 l=0.15
X917 v3_four_channel_bias_reference_distribution_0/v3_four_channel_phase_distribution_0/v3_four_channel_output_collection_0/v3_four_channel_placement_0/v3_channel_selector_late_promotion_2/v3_selector_route_pilot_0/G0_LO_N_ANDNOT/a_207_413# v3_four_channel_bias_reference_distribution_0/v3_four_channel_phase_distribution_0/v3_four_channel_output_collection_0/v3_four_channel_placement_0/v3_channel_selector_late_promotion_2/v3_selector_route_pilot_0/G0_LO_N_ANDNOT/a_27_413# v3_four_channel_bias_reference_distribution_0/v3_four_channel_phase_distribution_0/v3_four_channel_output_collection_0/v3_four_channel_placement_0/v3_channel_selector_late_promotion_2/VPWR v3_four_channel_bias_reference_distribution_0/v3_four_channel_phase_distribution_0/v3_four_channel_output_collection_0/v3_four_channel_placement_0/v3_channel_selector_late_promotion_2/VPWR sky130_fd_pr__pfet_01v8_hvt ad=0 pd=0 as=0 ps=0 w=0.42 l=0.15
X918 v3_four_channel_bias_reference_distribution_0/v3_four_channel_phase_distribution_0/v3_four_channel_output_collection_0/v3_four_channel_placement_0/v3_channel_selector_late_promotion_2/VPWR v3_four_channel_bias_reference_distribution_0/v3_four_channel_phase_distribution_0/v3_four_channel_output_collection_0/v3_four_channel_placement_0/v3_channel_selector_late_promotion_2/v3_selector_route_pilot_0/G0_MUX_AXIS/X v3_four_channel_bias_reference_distribution_0/v3_four_channel_phase_distribution_0/v3_four_channel_output_collection_0/v3_four_channel_placement_0/v3_channel_selector_late_promotion_2/v3_selector_route_pilot_0/G0_LO_N_ANDNOT/a_27_413# v3_four_channel_bias_reference_distribution_0/v3_four_channel_phase_distribution_0/v3_four_channel_output_collection_0/v3_four_channel_placement_0/v3_channel_selector_late_promotion_2/VPWR sky130_fd_pr__pfet_01v8_hvt ad=0 pd=0 as=0.1092 ps=1.36 w=0.42 l=0.15
X919 VSUBS v3_four_channel_bias_reference_distribution_0/v3_four_channel_phase_distribution_0/v3_four_channel_output_collection_0/v3_four_channel_placement_0/v3_channel_selector_late_promotion_2/v3_selector_route_pilot_0/G3_LO_P_AND/B v3_four_channel_bias_reference_distribution_0/v3_four_channel_phase_distribution_0/v3_four_channel_output_collection_0/v3_four_channel_placement_0/v3_channel_selector_late_promotion_2/v3_selector_route_pilot_0/G0_LO_N_ANDNOT/a_297_47# VSUBS sky130_fd_pr__nfet_01v8 ad=0 pd=0 as=0 ps=0 w=0.42 l=0.15
X920 v3_four_channel_bias_reference_distribution_0/v3_four_channel_phase_distribution_0/v3_four_channel_output_collection_0/v3_four_channel_placement_0/v3_channel_selector_late_promotion_2/v3_selector_route_pilot_0/G0_LO_N_ANDNOT/a_27_413# v3_four_channel_bias_reference_distribution_0/v3_four_channel_phase_distribution_0/v3_four_channel_output_collection_0/v3_four_channel_placement_0/v3_channel_selector_late_promotion_2/v3_selector_route_pilot_0/G0_MUX_AXIS/X VSUBS VSUBS sky130_fd_pr__nfet_01v8 ad=0.1092 pd=1.36 as=0 ps=0 w=0.42 l=0.15
X921 v3_four_channel_bias_reference_distribution_0/v3_four_channel_phase_distribution_0/v3_four_channel_output_collection_0/v3_four_channel_placement_0/v3_channel_selector_late_promotion_2/VPWR v3_four_channel_bias_reference_distribution_0/v3_four_channel_phase_distribution_0/v3_four_channel_output_collection_0/v3_four_channel_placement_0/v3_channel_selector_late_promotion_2/v3_selector_route_pilot_0/G1_MUX_AXIS/a_505_21# v3_four_channel_bias_reference_distribution_0/v3_four_channel_phase_distribution_0/v3_four_channel_output_collection_0/v3_four_channel_placement_0/v3_channel_selector_late_promotion_2/v3_selector_route_pilot_0/G1_MUX_AXIS/a_535_374# v3_four_channel_bias_reference_distribution_0/v3_four_channel_phase_distribution_0/v3_four_channel_output_collection_0/v3_four_channel_placement_0/v3_channel_selector_late_promotion_2/VPWR sky130_fd_pr__pfet_01v8_hvt ad=0 pd=0 as=0.0882 ps=1.26 w=0.42 l=0.15
X922 v3_four_channel_bias_reference_distribution_0/v3_four_channel_phase_distribution_0/v3_four_channel_output_collection_0/v3_four_channel_placement_0/v3_channel_selector_late_promotion_2/v3_selector_route_pilot_0/G1_MUX_AXIS/a_505_21# v3_four_channel_bias_reference_distribution_0/v3_four_channel_phase_distribution_0/v3_four_channel_output_collection_0/v3_four_channel_placement_0/v3_channel_selector_late_promotion_2/group1_bit1 v3_four_channel_bias_reference_distribution_0/v3_four_channel_phase_distribution_0/v3_four_channel_output_collection_0/v3_four_channel_placement_0/v3_channel_selector_late_promotion_2/VPWR v3_four_channel_bias_reference_distribution_0/v3_four_channel_phase_distribution_0/v3_four_channel_output_collection_0/v3_four_channel_placement_0/v3_channel_selector_late_promotion_2/VPWR sky130_fd_pr__pfet_01v8_hvt ad=0.1176 pd=1.4 as=0 ps=0 w=0.42 l=0.15
X923 v3_four_channel_bias_reference_distribution_0/v3_four_channel_phase_distribution_0/v3_four_channel_output_collection_0/v3_four_channel_placement_0/v3_channel_selector_late_promotion_2/v3_selector_route_pilot_0/G1_MUX_AXIS/a_218_374# v3_four_channel_bias_reference_distribution_0/v3_four_channel_phase_distribution_0/v3_four_channel_output_collection_0/v3_four_channel_placement_0/v3_channel_selector_late_promotion_2/group1_bit1 v3_four_channel_bias_reference_distribution_0/v3_four_channel_phase_distribution_0/v3_four_channel_output_collection_0/v3_four_channel_placement_0/v3_channel_selector_late_promotion_2/VPWR v3_four_channel_bias_reference_distribution_0/v3_four_channel_phase_distribution_0/v3_four_channel_output_collection_0/v3_four_channel_placement_0/v3_channel_selector_late_promotion_2/VPWR sky130_fd_pr__pfet_01v8_hvt ad=0.1533 pd=1.57 as=0 ps=0 w=0.42 l=0.15
X924 VSUBS v3_four_channel_bias_reference_distribution_0/v3_four_channel_phase_distribution_0/v3_four_channel_output_collection_0/v3_four_channel_placement_0/v3_channel_selector_late_promotion_2/v3_selector_route_pilot_0/G1_MUX_AXIS/a_505_21# v3_four_channel_bias_reference_distribution_0/v3_four_channel_phase_distribution_0/v3_four_channel_output_collection_0/v3_four_channel_placement_0/v3_channel_selector_late_promotion_2/v3_selector_route_pilot_0/G1_MUX_AXIS/a_439_47# VSUBS sky130_fd_pr__nfet_01v8 ad=0 pd=0 as=0.1386 ps=1.5 w=0.42 l=0.15
X925 v3_four_channel_bias_reference_distribution_0/v3_four_channel_phase_distribution_0/v3_four_channel_output_collection_0/v3_four_channel_placement_0/v3_channel_selector_late_promotion_2/v3_selector_route_pilot_0/G1_MUX_AXIS/a_76_199# v3_four_channel_bias_reference_distribution_0/v3_four_channel_phase_distribution_0/v3_four_channel_output_collection_0/v3_four_channel_placement_0/v3_channel_selector_late_promotion_2/v3_selector_route_pilot_0/G1_MUX_POS/X v3_four_channel_bias_reference_distribution_0/v3_four_channel_phase_distribution_0/v3_four_channel_output_collection_0/v3_four_channel_placement_0/v3_channel_selector_late_promotion_2/v3_selector_route_pilot_0/G1_MUX_AXIS/a_218_374# v3_four_channel_bias_reference_distribution_0/v3_four_channel_phase_distribution_0/v3_four_channel_output_collection_0/v3_four_channel_placement_0/v3_channel_selector_late_promotion_2/VPWR sky130_fd_pr__pfet_01v8_hvt ad=0.3864 pd=2.68 as=0 ps=0 w=0.42 l=0.15
X926 v3_four_channel_bias_reference_distribution_0/v3_four_channel_phase_distribution_0/v3_four_channel_output_collection_0/v3_four_channel_placement_0/v3_channel_selector_late_promotion_2/v3_selector_route_pilot_0/G1_MUX_AXIS/a_505_21# v3_four_channel_bias_reference_distribution_0/v3_four_channel_phase_distribution_0/v3_four_channel_output_collection_0/v3_four_channel_placement_0/v3_channel_selector_late_promotion_2/group1_bit1 VSUBS VSUBS sky130_fd_pr__nfet_01v8 ad=0.1092 pd=1.36 as=0 ps=0 w=0.42 l=0.15
X927 v3_four_channel_bias_reference_distribution_0/v3_four_channel_phase_distribution_0/v3_four_channel_output_collection_0/v3_four_channel_placement_0/v3_channel_selector_late_promotion_2/v3_selector_route_pilot_0/G1_MUX_AXIS/a_439_47# v3_four_channel_bias_reference_distribution_0/v3_four_channel_phase_distribution_0/v3_four_channel_output_collection_0/v3_four_channel_placement_0/v3_channel_selector_late_promotion_2/v3_selector_route_pilot_0/G1_MUX_POS/X v3_four_channel_bias_reference_distribution_0/v3_four_channel_phase_distribution_0/v3_four_channel_output_collection_0/v3_four_channel_placement_0/v3_channel_selector_late_promotion_2/v3_selector_route_pilot_0/G1_MUX_AXIS/a_76_199# VSUBS sky130_fd_pr__nfet_01v8 ad=0 pd=0 as=0.1995 ps=1.79 w=0.42 l=0.15
X928 v3_four_channel_bias_reference_distribution_0/v3_four_channel_phase_distribution_0/v3_four_channel_output_collection_0/v3_four_channel_placement_0/v3_channel_selector_late_promotion_2/v3_selector_route_pilot_0/G1_MUX_AXIS/a_535_374# v3_four_channel_bias_reference_distribution_0/v3_four_channel_phase_distribution_0/v3_four_channel_output_collection_0/v3_four_channel_placement_0/v3_channel_selector_late_promotion_2/v3_selector_route_pilot_0/G1_MUX_NEG/X v3_four_channel_bias_reference_distribution_0/v3_four_channel_phase_distribution_0/v3_four_channel_output_collection_0/v3_four_channel_placement_0/v3_channel_selector_late_promotion_2/v3_selector_route_pilot_0/G1_MUX_AXIS/a_76_199# v3_four_channel_bias_reference_distribution_0/v3_four_channel_phase_distribution_0/v3_four_channel_output_collection_0/v3_four_channel_placement_0/v3_channel_selector_late_promotion_2/VPWR sky130_fd_pr__pfet_01v8_hvt ad=0 pd=0 as=0 ps=0 w=0.42 l=0.15
X929 v3_four_channel_bias_reference_distribution_0/v3_four_channel_phase_distribution_0/v3_four_channel_output_collection_0/v3_four_channel_placement_0/v3_channel_selector_late_promotion_2/v3_selector_route_pilot_0/G1_MUX_AXIS/a_76_199# v3_four_channel_bias_reference_distribution_0/v3_four_channel_phase_distribution_0/v3_four_channel_output_collection_0/v3_four_channel_placement_0/v3_channel_selector_late_promotion_2/v3_selector_route_pilot_0/G1_MUX_NEG/X v3_four_channel_bias_reference_distribution_0/v3_four_channel_phase_distribution_0/v3_four_channel_output_collection_0/v3_four_channel_placement_0/v3_channel_selector_late_promotion_2/v3_selector_route_pilot_0/G1_MUX_AXIS/a_218_47# VSUBS sky130_fd_pr__nfet_01v8 ad=0 pd=0 as=0.1386 ps=1.5 w=0.42 l=0.15
X930 v3_four_channel_bias_reference_distribution_0/v3_four_channel_phase_distribution_0/v3_four_channel_output_collection_0/v3_four_channel_placement_0/v3_channel_selector_late_promotion_2/v3_selector_route_pilot_0/G1_MUX_AXIS/a_218_47# v3_four_channel_bias_reference_distribution_0/v3_four_channel_phase_distribution_0/v3_four_channel_output_collection_0/v3_four_channel_placement_0/v3_channel_selector_late_promotion_2/group1_bit1 VSUBS VSUBS sky130_fd_pr__nfet_01v8 ad=0 pd=0 as=0 ps=0 w=0.42 l=0.15
X931 v3_four_channel_bias_reference_distribution_0/v3_four_channel_phase_distribution_0/v3_four_channel_output_collection_0/v3_four_channel_placement_0/v3_channel_selector_late_promotion_2/VPWR v3_four_channel_bias_reference_distribution_0/v3_four_channel_phase_distribution_0/v3_four_channel_output_collection_0/v3_four_channel_placement_0/v3_channel_selector_late_promotion_2/v3_selector_route_pilot_0/G1_MUX_AXIS/a_76_199# v3_four_channel_bias_reference_distribution_0/v3_four_channel_phase_distribution_0/v3_four_channel_output_collection_0/v3_four_channel_placement_0/v3_channel_selector_late_promotion_2/v3_selector_route_pilot_0/G1_MUX_AXIS/X v3_four_channel_bias_reference_distribution_0/v3_four_channel_phase_distribution_0/v3_four_channel_output_collection_0/v3_four_channel_placement_0/v3_channel_selector_late_promotion_2/VPWR sky130_fd_pr__pfet_01v8_hvt ad=0 pd=0 as=0.26 ps=2.52 w=1 l=0.15
X932 VSUBS v3_four_channel_bias_reference_distribution_0/v3_four_channel_phase_distribution_0/v3_four_channel_output_collection_0/v3_four_channel_placement_0/v3_channel_selector_late_promotion_2/v3_selector_route_pilot_0/G1_MUX_AXIS/a_76_199# v3_four_channel_bias_reference_distribution_0/v3_four_channel_phase_distribution_0/v3_four_channel_output_collection_0/v3_four_channel_placement_0/v3_channel_selector_late_promotion_2/v3_selector_route_pilot_0/G1_MUX_AXIS/X VSUBS sky130_fd_pr__nfet_01v8 ad=0 pd=0 as=0.169 ps=1.82 w=0.65 l=0.15
X933 v3_four_channel_bias_reference_distribution_0/v3_four_channel_phase_distribution_0/v3_four_channel_output_collection_0/v3_four_channel_placement_0/v3_channel_selector_late_promotion_2/VPWR v3_four_channel_bias_reference_distribution_0/v3_four_channel_phase_distribution_0/v3_four_channel_output_collection_0/v3_four_channel_placement_0/v3_channel_selector_late_promotion_2/v3_selector_route_pilot_0/G3_LO_P_AND/B v3_four_channel_bias_reference_distribution_0/v3_four_channel_phase_distribution_0/v3_four_channel_output_collection_0/v3_four_channel_placement_0/v3_channel_selector_late_promotion_2/v3_selector_route_pilot_0/G1_LO_N_ANDNOT/a_207_413# v3_four_channel_bias_reference_distribution_0/v3_four_channel_phase_distribution_0/v3_four_channel_output_collection_0/v3_four_channel_placement_0/v3_channel_selector_late_promotion_2/VPWR sky130_fd_pr__pfet_01v8_hvt ad=0 pd=0 as=0.1218 ps=1.42 w=0.42 l=0.15
X934 v3_four_channel_bias_reference_distribution_0/v3_four_channel_phase_distribution_0/v3_four_channel_output_collection_0/v3_four_channel_placement_0/v3_channel_selector_late_promotion_2/v3_selector_route_pilot_0/group1_lo_n v3_four_channel_bias_reference_distribution_0/v3_four_channel_phase_distribution_0/v3_four_channel_output_collection_0/v3_four_channel_placement_0/v3_channel_selector_late_promotion_2/v3_selector_route_pilot_0/G1_LO_N_ANDNOT/a_207_413# v3_four_channel_bias_reference_distribution_0/v3_four_channel_phase_distribution_0/v3_four_channel_output_collection_0/v3_four_channel_placement_0/v3_channel_selector_late_promotion_2/VPWR v3_four_channel_bias_reference_distribution_0/v3_four_channel_phase_distribution_0/v3_four_channel_output_collection_0/v3_four_channel_placement_0/v3_channel_selector_late_promotion_2/VPWR sky130_fd_pr__pfet_01v8_hvt ad=0.26 pd=2.52 as=0 ps=0 w=1 l=0.15
X935 v3_four_channel_bias_reference_distribution_0/v3_four_channel_phase_distribution_0/v3_four_channel_output_collection_0/v3_four_channel_placement_0/v3_channel_selector_late_promotion_2/v3_selector_route_pilot_0/G1_LO_N_ANDNOT/a_297_47# v3_four_channel_bias_reference_distribution_0/v3_four_channel_phase_distribution_0/v3_four_channel_output_collection_0/v3_four_channel_placement_0/v3_channel_selector_late_promotion_2/v3_selector_route_pilot_0/G1_LO_N_ANDNOT/a_27_413# v3_four_channel_bias_reference_distribution_0/v3_four_channel_phase_distribution_0/v3_four_channel_output_collection_0/v3_four_channel_placement_0/v3_channel_selector_late_promotion_2/v3_selector_route_pilot_0/G1_LO_N_ANDNOT/a_207_413# VSUBS sky130_fd_pr__nfet_01v8 ad=0.1008 pd=1.32 as=0.1092 ps=1.36 w=0.42 l=0.15
X936 v3_four_channel_bias_reference_distribution_0/v3_four_channel_phase_distribution_0/v3_four_channel_output_collection_0/v3_four_channel_placement_0/v3_channel_selector_late_promotion_2/v3_selector_route_pilot_0/group1_lo_n v3_four_channel_bias_reference_distribution_0/v3_four_channel_phase_distribution_0/v3_four_channel_output_collection_0/v3_four_channel_placement_0/v3_channel_selector_late_promotion_2/v3_selector_route_pilot_0/G1_LO_N_ANDNOT/a_207_413# VSUBS VSUBS sky130_fd_pr__nfet_01v8 ad=0.169 pd=1.82 as=0 ps=0 w=0.65 l=0.15
X937 v3_four_channel_bias_reference_distribution_0/v3_four_channel_phase_distribution_0/v3_four_channel_output_collection_0/v3_four_channel_placement_0/v3_channel_selector_late_promotion_2/v3_selector_route_pilot_0/G1_LO_N_ANDNOT/a_207_413# v3_four_channel_bias_reference_distribution_0/v3_four_channel_phase_distribution_0/v3_four_channel_output_collection_0/v3_four_channel_placement_0/v3_channel_selector_late_promotion_2/v3_selector_route_pilot_0/G1_LO_N_ANDNOT/a_27_413# v3_four_channel_bias_reference_distribution_0/v3_four_channel_phase_distribution_0/v3_four_channel_output_collection_0/v3_four_channel_placement_0/v3_channel_selector_late_promotion_2/VPWR v3_four_channel_bias_reference_distribution_0/v3_four_channel_phase_distribution_0/v3_four_channel_output_collection_0/v3_four_channel_placement_0/v3_channel_selector_late_promotion_2/VPWR sky130_fd_pr__pfet_01v8_hvt ad=0 pd=0 as=0 ps=0 w=0.42 l=0.15
X938 v3_four_channel_bias_reference_distribution_0/v3_four_channel_phase_distribution_0/v3_four_channel_output_collection_0/v3_four_channel_placement_0/v3_channel_selector_late_promotion_2/VPWR v3_four_channel_bias_reference_distribution_0/v3_four_channel_phase_distribution_0/v3_four_channel_output_collection_0/v3_four_channel_placement_0/v3_channel_selector_late_promotion_2/v3_selector_route_pilot_0/G1_MUX_AXIS/X v3_four_channel_bias_reference_distribution_0/v3_four_channel_phase_distribution_0/v3_four_channel_output_collection_0/v3_four_channel_placement_0/v3_channel_selector_late_promotion_2/v3_selector_route_pilot_0/G1_LO_N_ANDNOT/a_27_413# v3_four_channel_bias_reference_distribution_0/v3_four_channel_phase_distribution_0/v3_four_channel_output_collection_0/v3_four_channel_placement_0/v3_channel_selector_late_promotion_2/VPWR sky130_fd_pr__pfet_01v8_hvt ad=0 pd=0 as=0.1092 ps=1.36 w=0.42 l=0.15
X939 VSUBS v3_four_channel_bias_reference_distribution_0/v3_four_channel_phase_distribution_0/v3_four_channel_output_collection_0/v3_four_channel_placement_0/v3_channel_selector_late_promotion_2/v3_selector_route_pilot_0/G3_LO_P_AND/B v3_four_channel_bias_reference_distribution_0/v3_four_channel_phase_distribution_0/v3_four_channel_output_collection_0/v3_four_channel_placement_0/v3_channel_selector_late_promotion_2/v3_selector_route_pilot_0/G1_LO_N_ANDNOT/a_297_47# VSUBS sky130_fd_pr__nfet_01v8 ad=0 pd=0 as=0 ps=0 w=0.42 l=0.15
X940 v3_four_channel_bias_reference_distribution_0/v3_four_channel_phase_distribution_0/v3_four_channel_output_collection_0/v3_four_channel_placement_0/v3_channel_selector_late_promotion_2/v3_selector_route_pilot_0/G1_LO_N_ANDNOT/a_27_413# v3_four_channel_bias_reference_distribution_0/v3_four_channel_phase_distribution_0/v3_four_channel_output_collection_0/v3_four_channel_placement_0/v3_channel_selector_late_promotion_2/v3_selector_route_pilot_0/G1_MUX_AXIS/X VSUBS VSUBS sky130_fd_pr__nfet_01v8 ad=0.1092 pd=1.36 as=0 ps=0 w=0.42 l=0.15
X941 v3_four_channel_bias_reference_distribution_0/v3_four_channel_phase_distribution_0/v3_four_channel_output_collection_0/v3_four_channel_placement_0/v3_channel_selector_late_promotion_2/VPWR v3_four_channel_bias_reference_distribution_0/v3_four_channel_phase_distribution_0/v3_four_channel_output_collection_0/v3_four_channel_placement_0/v3_channel_selector_late_promotion_2/v3_selector_route_pilot_0/G3_LO_P_AND/B v3_four_channel_bias_reference_distribution_0/v3_four_channel_phase_distribution_0/v3_four_channel_output_collection_0/v3_four_channel_placement_0/v3_channel_selector_late_promotion_2/v3_selector_route_pilot_0/G3_LO_P_AND/a_59_75# v3_four_channel_bias_reference_distribution_0/v3_four_channel_phase_distribution_0/v3_four_channel_output_collection_0/v3_four_channel_placement_0/v3_channel_selector_late_promotion_2/VPWR sky130_fd_pr__pfet_01v8_hvt ad=0 pd=0 as=0.1134 ps=1.38 w=0.42 l=0.15
X942 v3_four_channel_bias_reference_distribution_0/v3_four_channel_phase_distribution_0/v3_four_channel_output_collection_0/v3_four_channel_placement_0/v3_channel_selector_late_promotion_2/v3_selector_route_pilot_0/group3_lo_p v3_four_channel_bias_reference_distribution_0/v3_four_channel_phase_distribution_0/v3_four_channel_output_collection_0/v3_four_channel_placement_0/v3_channel_selector_late_promotion_2/v3_selector_route_pilot_0/G3_LO_P_AND/a_59_75# v3_four_channel_bias_reference_distribution_0/v3_four_channel_phase_distribution_0/v3_four_channel_output_collection_0/v3_four_channel_placement_0/v3_channel_selector_late_promotion_2/VPWR v3_four_channel_bias_reference_distribution_0/v3_four_channel_phase_distribution_0/v3_four_channel_output_collection_0/v3_four_channel_placement_0/v3_channel_selector_late_promotion_2/VPWR sky130_fd_pr__pfet_01v8_hvt ad=0.475 pd=2.95 as=0 ps=0 w=1 l=0.15
X943 VSUBS v3_four_channel_bias_reference_distribution_0/v3_four_channel_phase_distribution_0/v3_four_channel_output_collection_0/v3_four_channel_placement_0/v3_channel_selector_late_promotion_2/v3_selector_route_pilot_0/G3_LO_P_AND/B v3_four_channel_bias_reference_distribution_0/v3_four_channel_phase_distribution_0/v3_four_channel_output_collection_0/v3_four_channel_placement_0/v3_channel_selector_late_promotion_2/v3_selector_route_pilot_0/G3_LO_P_AND/a_145_75# VSUBS sky130_fd_pr__nfet_01v8 ad=0 pd=0 as=0.1134 ps=1.38 w=0.42 l=0.15
X944 v3_four_channel_bias_reference_distribution_0/v3_four_channel_phase_distribution_0/v3_four_channel_output_collection_0/v3_four_channel_placement_0/v3_channel_selector_late_promotion_2/v3_selector_route_pilot_0/G3_LO_P_AND/a_59_75# v3_four_channel_bias_reference_distribution_0/v3_four_channel_phase_distribution_0/v3_four_channel_output_collection_0/v3_four_channel_placement_0/v3_channel_selector_late_promotion_2/v3_selector_route_pilot_0/G3_MUX_AXIS/X v3_four_channel_bias_reference_distribution_0/v3_four_channel_phase_distribution_0/v3_four_channel_output_collection_0/v3_four_channel_placement_0/v3_channel_selector_late_promotion_2/VPWR v3_four_channel_bias_reference_distribution_0/v3_four_channel_phase_distribution_0/v3_four_channel_output_collection_0/v3_four_channel_placement_0/v3_channel_selector_late_promotion_2/VPWR sky130_fd_pr__pfet_01v8_hvt ad=0 pd=0 as=0 ps=0 w=0.42 l=0.15
X945 v3_four_channel_bias_reference_distribution_0/v3_four_channel_phase_distribution_0/v3_four_channel_output_collection_0/v3_four_channel_placement_0/v3_channel_selector_late_promotion_2/v3_selector_route_pilot_0/group3_lo_p v3_four_channel_bias_reference_distribution_0/v3_four_channel_phase_distribution_0/v3_four_channel_output_collection_0/v3_four_channel_placement_0/v3_channel_selector_late_promotion_2/v3_selector_route_pilot_0/G3_LO_P_AND/a_59_75# VSUBS VSUBS sky130_fd_pr__nfet_01v8 ad=0.182 pd=1.86 as=0 ps=0 w=0.65 l=0.15
X946 v3_four_channel_bias_reference_distribution_0/v3_four_channel_phase_distribution_0/v3_four_channel_output_collection_0/v3_four_channel_placement_0/v3_channel_selector_late_promotion_2/v3_selector_route_pilot_0/G3_LO_P_AND/a_145_75# v3_four_channel_bias_reference_distribution_0/v3_four_channel_phase_distribution_0/v3_four_channel_output_collection_0/v3_four_channel_placement_0/v3_channel_selector_late_promotion_2/v3_selector_route_pilot_0/G3_MUX_AXIS/X v3_four_channel_bias_reference_distribution_0/v3_four_channel_phase_distribution_0/v3_four_channel_output_collection_0/v3_four_channel_placement_0/v3_channel_selector_late_promotion_2/v3_selector_route_pilot_0/G3_LO_P_AND/a_59_75# VSUBS sky130_fd_pr__nfet_01v8 ad=0 pd=0 as=0.1176 ps=1.4 w=0.42 l=0.15
X947 v3_four_channel_bias_reference_distribution_0/v3_four_channel_phase_distribution_0/v3_four_channel_output_collection_0/v3_four_channel_placement_0/v3_channel_selector_late_promotion_2/VPWR v3_four_channel_bias_reference_distribution_0/v3_four_channel_phase_distribution_0/v3_four_channel_output_collection_0/v3_four_channel_placement_0/v3_channel_selector_late_promotion_2/v3_selector_route_pilot_0/G2_MUX_POS/a_505_21# v3_four_channel_bias_reference_distribution_0/v3_four_channel_phase_distribution_0/v3_four_channel_output_collection_0/v3_four_channel_placement_0/v3_channel_selector_late_promotion_2/v3_selector_route_pilot_0/G2_MUX_POS/a_535_374# v3_four_channel_bias_reference_distribution_0/v3_four_channel_phase_distribution_0/v3_four_channel_output_collection_0/v3_four_channel_placement_0/v3_channel_selector_late_promotion_2/VPWR sky130_fd_pr__pfet_01v8_hvt ad=0 pd=0 as=0.0882 ps=1.26 w=0.42 l=0.15
X948 v3_four_channel_bias_reference_distribution_0/v3_four_channel_phase_distribution_0/v3_four_channel_output_collection_0/v3_four_channel_placement_0/v3_channel_selector_late_promotion_2/v3_selector_route_pilot_0/G2_MUX_POS/a_505_21# v3_four_channel_bias_reference_distribution_0/v3_four_channel_phase_distribution_0/v3_four_channel_output_collection_0/v3_four_channel_placement_0/v3_channel_selector_late_promotion_2/group2_bit0 v3_four_channel_bias_reference_distribution_0/v3_four_channel_phase_distribution_0/v3_four_channel_output_collection_0/v3_four_channel_placement_0/v3_channel_selector_late_promotion_2/VPWR v3_four_channel_bias_reference_distribution_0/v3_four_channel_phase_distribution_0/v3_four_channel_output_collection_0/v3_four_channel_placement_0/v3_channel_selector_late_promotion_2/VPWR sky130_fd_pr__pfet_01v8_hvt ad=0.1176 pd=1.4 as=0 ps=0 w=0.42 l=0.15
X949 v3_four_channel_bias_reference_distribution_0/v3_four_channel_phase_distribution_0/v3_four_channel_output_collection_0/v3_four_channel_placement_0/v3_channel_selector_late_promotion_2/v3_selector_route_pilot_0/G2_MUX_POS/a_218_374# v3_four_channel_bias_reference_distribution_0/v3_four_channel_phase_distribution_0/v3_four_channel_output_collection_0/v3_four_channel_placement_0/v3_channel_selector_late_promotion_2/group2_bit0 v3_four_channel_bias_reference_distribution_0/v3_four_channel_phase_distribution_0/v3_four_channel_output_collection_0/v3_four_channel_placement_0/v3_channel_selector_late_promotion_2/VPWR v3_four_channel_bias_reference_distribution_0/v3_four_channel_phase_distribution_0/v3_four_channel_output_collection_0/v3_four_channel_placement_0/v3_channel_selector_late_promotion_2/VPWR sky130_fd_pr__pfet_01v8_hvt ad=0.1533 pd=1.57 as=0 ps=0 w=0.42 l=0.15
X950 VSUBS v3_four_channel_bias_reference_distribution_0/v3_four_channel_phase_distribution_0/v3_four_channel_output_collection_0/v3_four_channel_placement_0/v3_channel_selector_late_promotion_2/v3_selector_route_pilot_0/G2_MUX_POS/a_505_21# v3_four_channel_bias_reference_distribution_0/v3_four_channel_phase_distribution_0/v3_four_channel_output_collection_0/v3_four_channel_placement_0/v3_channel_selector_late_promotion_2/v3_selector_route_pilot_0/G2_MUX_POS/a_439_47# VSUBS sky130_fd_pr__nfet_01v8 ad=0 pd=0 as=0.1386 ps=1.5 w=0.42 l=0.15
X951 v3_four_channel_bias_reference_distribution_0/v3_four_channel_phase_distribution_0/v3_four_channel_output_collection_0/v3_four_channel_placement_0/v3_channel_selector_late_promotion_2/v3_selector_route_pilot_0/G2_MUX_POS/a_76_199# v3_four_channel_bias_reference_distribution_0/v3_four_channel_phase_distribution_0/phase_0 v3_four_channel_bias_reference_distribution_0/v3_four_channel_phase_distribution_0/v3_four_channel_output_collection_0/v3_four_channel_placement_0/v3_channel_selector_late_promotion_2/v3_selector_route_pilot_0/G2_MUX_POS/a_218_374# v3_four_channel_bias_reference_distribution_0/v3_four_channel_phase_distribution_0/v3_four_channel_output_collection_0/v3_four_channel_placement_0/v3_channel_selector_late_promotion_2/VPWR sky130_fd_pr__pfet_01v8_hvt ad=0.3864 pd=2.68 as=0 ps=0 w=0.42 l=0.15
X952 v3_four_channel_bias_reference_distribution_0/v3_four_channel_phase_distribution_0/v3_four_channel_output_collection_0/v3_four_channel_placement_0/v3_channel_selector_late_promotion_2/v3_selector_route_pilot_0/G2_MUX_POS/a_505_21# v3_four_channel_bias_reference_distribution_0/v3_four_channel_phase_distribution_0/v3_four_channel_output_collection_0/v3_four_channel_placement_0/v3_channel_selector_late_promotion_2/group2_bit0 VSUBS VSUBS sky130_fd_pr__nfet_01v8 ad=0.1092 pd=1.36 as=0 ps=0 w=0.42 l=0.15
X953 v3_four_channel_bias_reference_distribution_0/v3_four_channel_phase_distribution_0/v3_four_channel_output_collection_0/v3_four_channel_placement_0/v3_channel_selector_late_promotion_2/v3_selector_route_pilot_0/G2_MUX_POS/a_439_47# v3_four_channel_bias_reference_distribution_0/v3_four_channel_phase_distribution_0/phase_0 v3_four_channel_bias_reference_distribution_0/v3_four_channel_phase_distribution_0/v3_four_channel_output_collection_0/v3_four_channel_placement_0/v3_channel_selector_late_promotion_2/v3_selector_route_pilot_0/G2_MUX_POS/a_76_199# VSUBS sky130_fd_pr__nfet_01v8 ad=0 pd=0 as=0.1995 ps=1.79 w=0.42 l=0.15
X954 v3_four_channel_bias_reference_distribution_0/v3_four_channel_phase_distribution_0/v3_four_channel_output_collection_0/v3_four_channel_placement_0/v3_channel_selector_late_promotion_2/v3_selector_route_pilot_0/G2_MUX_POS/a_535_374# v3_four_channel_bias_reference_distribution_0/v3_four_channel_phase_distribution_0/phase_90 v3_four_channel_bias_reference_distribution_0/v3_four_channel_phase_distribution_0/v3_four_channel_output_collection_0/v3_four_channel_placement_0/v3_channel_selector_late_promotion_2/v3_selector_route_pilot_0/G2_MUX_POS/a_76_199# v3_four_channel_bias_reference_distribution_0/v3_four_channel_phase_distribution_0/v3_four_channel_output_collection_0/v3_four_channel_placement_0/v3_channel_selector_late_promotion_2/VPWR sky130_fd_pr__pfet_01v8_hvt ad=0 pd=0 as=0 ps=0 w=0.42 l=0.15
X955 v3_four_channel_bias_reference_distribution_0/v3_four_channel_phase_distribution_0/v3_four_channel_output_collection_0/v3_four_channel_placement_0/v3_channel_selector_late_promotion_2/v3_selector_route_pilot_0/G2_MUX_POS/a_76_199# v3_four_channel_bias_reference_distribution_0/v3_four_channel_phase_distribution_0/phase_90 v3_four_channel_bias_reference_distribution_0/v3_four_channel_phase_distribution_0/v3_four_channel_output_collection_0/v3_four_channel_placement_0/v3_channel_selector_late_promotion_2/v3_selector_route_pilot_0/G2_MUX_POS/a_218_47# VSUBS sky130_fd_pr__nfet_01v8 ad=0 pd=0 as=0.1386 ps=1.5 w=0.42 l=0.15
X956 v3_four_channel_bias_reference_distribution_0/v3_four_channel_phase_distribution_0/v3_four_channel_output_collection_0/v3_four_channel_placement_0/v3_channel_selector_late_promotion_2/v3_selector_route_pilot_0/G2_MUX_POS/a_218_47# v3_four_channel_bias_reference_distribution_0/v3_four_channel_phase_distribution_0/v3_four_channel_output_collection_0/v3_four_channel_placement_0/v3_channel_selector_late_promotion_2/group2_bit0 VSUBS VSUBS sky130_fd_pr__nfet_01v8 ad=0 pd=0 as=0 ps=0 w=0.42 l=0.15
X957 v3_four_channel_bias_reference_distribution_0/v3_four_channel_phase_distribution_0/v3_four_channel_output_collection_0/v3_four_channel_placement_0/v3_channel_selector_late_promotion_2/VPWR v3_four_channel_bias_reference_distribution_0/v3_four_channel_phase_distribution_0/v3_four_channel_output_collection_0/v3_four_channel_placement_0/v3_channel_selector_late_promotion_2/v3_selector_route_pilot_0/G2_MUX_POS/a_76_199# v3_four_channel_bias_reference_distribution_0/v3_four_channel_phase_distribution_0/v3_four_channel_output_collection_0/v3_four_channel_placement_0/v3_channel_selector_late_promotion_2/v3_selector_route_pilot_0/G2_MUX_POS/X v3_four_channel_bias_reference_distribution_0/v3_four_channel_phase_distribution_0/v3_four_channel_output_collection_0/v3_four_channel_placement_0/v3_channel_selector_late_promotion_2/VPWR sky130_fd_pr__pfet_01v8_hvt ad=0 pd=0 as=0.26 ps=2.52 w=1 l=0.15
X958 VSUBS v3_four_channel_bias_reference_distribution_0/v3_four_channel_phase_distribution_0/v3_four_channel_output_collection_0/v3_four_channel_placement_0/v3_channel_selector_late_promotion_2/v3_selector_route_pilot_0/G2_MUX_POS/a_76_199# v3_four_channel_bias_reference_distribution_0/v3_four_channel_phase_distribution_0/v3_four_channel_output_collection_0/v3_four_channel_placement_0/v3_channel_selector_late_promotion_2/v3_selector_route_pilot_0/G2_MUX_POS/X VSUBS sky130_fd_pr__nfet_01v8 ad=0 pd=0 as=0.169 ps=1.82 w=0.65 l=0.15
X959 v3_four_channel_bias_reference_distribution_0/v3_four_channel_phase_distribution_0/v3_four_channel_output_collection_0/v3_four_channel_placement_0/v3_channel_selector_late_promotion_2/VPWR v3_four_channel_bias_reference_distribution_0/v3_four_channel_phase_distribution_0/v3_four_channel_output_collection_0/v3_four_channel_placement_0/v3_channel_selector_late_promotion_2/v3_selector_route_pilot_0/G2_MUX_NEG/a_505_21# v3_four_channel_bias_reference_distribution_0/v3_four_channel_phase_distribution_0/v3_four_channel_output_collection_0/v3_four_channel_placement_0/v3_channel_selector_late_promotion_2/v3_selector_route_pilot_0/G2_MUX_NEG/a_535_374# v3_four_channel_bias_reference_distribution_0/v3_four_channel_phase_distribution_0/v3_four_channel_output_collection_0/v3_four_channel_placement_0/v3_channel_selector_late_promotion_2/VPWR sky130_fd_pr__pfet_01v8_hvt ad=0 pd=0 as=0.0882 ps=1.26 w=0.42 l=0.15
X960 v3_four_channel_bias_reference_distribution_0/v3_four_channel_phase_distribution_0/v3_four_channel_output_collection_0/v3_four_channel_placement_0/v3_channel_selector_late_promotion_2/v3_selector_route_pilot_0/G2_MUX_NEG/a_505_21# v3_four_channel_bias_reference_distribution_0/v3_four_channel_phase_distribution_0/v3_four_channel_output_collection_0/v3_four_channel_placement_0/v3_channel_selector_late_promotion_2/group2_bit0 v3_four_channel_bias_reference_distribution_0/v3_four_channel_phase_distribution_0/v3_four_channel_output_collection_0/v3_four_channel_placement_0/v3_channel_selector_late_promotion_2/VPWR v3_four_channel_bias_reference_distribution_0/v3_four_channel_phase_distribution_0/v3_four_channel_output_collection_0/v3_four_channel_placement_0/v3_channel_selector_late_promotion_2/VPWR sky130_fd_pr__pfet_01v8_hvt ad=0.1176 pd=1.4 as=0 ps=0 w=0.42 l=0.15
X961 v3_four_channel_bias_reference_distribution_0/v3_four_channel_phase_distribution_0/v3_four_channel_output_collection_0/v3_four_channel_placement_0/v3_channel_selector_late_promotion_2/v3_selector_route_pilot_0/G2_MUX_NEG/a_218_374# v3_four_channel_bias_reference_distribution_0/v3_four_channel_phase_distribution_0/v3_four_channel_output_collection_0/v3_four_channel_placement_0/v3_channel_selector_late_promotion_2/group2_bit0 v3_four_channel_bias_reference_distribution_0/v3_four_channel_phase_distribution_0/v3_four_channel_output_collection_0/v3_four_channel_placement_0/v3_channel_selector_late_promotion_2/VPWR v3_four_channel_bias_reference_distribution_0/v3_four_channel_phase_distribution_0/v3_four_channel_output_collection_0/v3_four_channel_placement_0/v3_channel_selector_late_promotion_2/VPWR sky130_fd_pr__pfet_01v8_hvt ad=0.1533 pd=1.57 as=0 ps=0 w=0.42 l=0.15
X962 VSUBS v3_four_channel_bias_reference_distribution_0/v3_four_channel_phase_distribution_0/v3_four_channel_output_collection_0/v3_four_channel_placement_0/v3_channel_selector_late_promotion_2/v3_selector_route_pilot_0/G2_MUX_NEG/a_505_21# v3_four_channel_bias_reference_distribution_0/v3_four_channel_phase_distribution_0/v3_four_channel_output_collection_0/v3_four_channel_placement_0/v3_channel_selector_late_promotion_2/v3_selector_route_pilot_0/G2_MUX_NEG/a_439_47# VSUBS sky130_fd_pr__nfet_01v8 ad=0 pd=0 as=0.1386 ps=1.5 w=0.42 l=0.15
X963 v3_four_channel_bias_reference_distribution_0/v3_four_channel_phase_distribution_0/v3_four_channel_output_collection_0/v3_four_channel_placement_0/v3_channel_selector_late_promotion_2/v3_selector_route_pilot_0/G2_MUX_NEG/a_76_199# v3_four_channel_bias_reference_distribution_0/v3_four_channel_phase_distribution_0/phase_180 v3_four_channel_bias_reference_distribution_0/v3_four_channel_phase_distribution_0/v3_four_channel_output_collection_0/v3_four_channel_placement_0/v3_channel_selector_late_promotion_2/v3_selector_route_pilot_0/G2_MUX_NEG/a_218_374# v3_four_channel_bias_reference_distribution_0/v3_four_channel_phase_distribution_0/v3_four_channel_output_collection_0/v3_four_channel_placement_0/v3_channel_selector_late_promotion_2/VPWR sky130_fd_pr__pfet_01v8_hvt ad=0.3864 pd=2.68 as=0 ps=0 w=0.42 l=0.15
X964 v3_four_channel_bias_reference_distribution_0/v3_four_channel_phase_distribution_0/v3_four_channel_output_collection_0/v3_four_channel_placement_0/v3_channel_selector_late_promotion_2/v3_selector_route_pilot_0/G2_MUX_NEG/a_505_21# v3_four_channel_bias_reference_distribution_0/v3_four_channel_phase_distribution_0/v3_four_channel_output_collection_0/v3_four_channel_placement_0/v3_channel_selector_late_promotion_2/group2_bit0 VSUBS VSUBS sky130_fd_pr__nfet_01v8 ad=0.1092 pd=1.36 as=0 ps=0 w=0.42 l=0.15
X965 v3_four_channel_bias_reference_distribution_0/v3_four_channel_phase_distribution_0/v3_four_channel_output_collection_0/v3_four_channel_placement_0/v3_channel_selector_late_promotion_2/v3_selector_route_pilot_0/G2_MUX_NEG/a_439_47# v3_four_channel_bias_reference_distribution_0/v3_four_channel_phase_distribution_0/phase_180 v3_four_channel_bias_reference_distribution_0/v3_four_channel_phase_distribution_0/v3_four_channel_output_collection_0/v3_four_channel_placement_0/v3_channel_selector_late_promotion_2/v3_selector_route_pilot_0/G2_MUX_NEG/a_76_199# VSUBS sky130_fd_pr__nfet_01v8 ad=0 pd=0 as=0.1995 ps=1.79 w=0.42 l=0.15
X966 v3_four_channel_bias_reference_distribution_0/v3_four_channel_phase_distribution_0/v3_four_channel_output_collection_0/v3_four_channel_placement_0/v3_channel_selector_late_promotion_2/v3_selector_route_pilot_0/G2_MUX_NEG/a_535_374# v3_four_channel_bias_reference_distribution_0/v3_four_channel_phase_distribution_0/phase_270 v3_four_channel_bias_reference_distribution_0/v3_four_channel_phase_distribution_0/v3_four_channel_output_collection_0/v3_four_channel_placement_0/v3_channel_selector_late_promotion_2/v3_selector_route_pilot_0/G2_MUX_NEG/a_76_199# v3_four_channel_bias_reference_distribution_0/v3_four_channel_phase_distribution_0/v3_four_channel_output_collection_0/v3_four_channel_placement_0/v3_channel_selector_late_promotion_2/VPWR sky130_fd_pr__pfet_01v8_hvt ad=0 pd=0 as=0 ps=0 w=0.42 l=0.15
X967 v3_four_channel_bias_reference_distribution_0/v3_four_channel_phase_distribution_0/v3_four_channel_output_collection_0/v3_four_channel_placement_0/v3_channel_selector_late_promotion_2/v3_selector_route_pilot_0/G2_MUX_NEG/a_76_199# v3_four_channel_bias_reference_distribution_0/v3_four_channel_phase_distribution_0/phase_270 v3_four_channel_bias_reference_distribution_0/v3_four_channel_phase_distribution_0/v3_four_channel_output_collection_0/v3_four_channel_placement_0/v3_channel_selector_late_promotion_2/v3_selector_route_pilot_0/G2_MUX_NEG/a_218_47# VSUBS sky130_fd_pr__nfet_01v8 ad=0 pd=0 as=0.1386 ps=1.5 w=0.42 l=0.15
X968 v3_four_channel_bias_reference_distribution_0/v3_four_channel_phase_distribution_0/v3_four_channel_output_collection_0/v3_four_channel_placement_0/v3_channel_selector_late_promotion_2/v3_selector_route_pilot_0/G2_MUX_NEG/a_218_47# v3_four_channel_bias_reference_distribution_0/v3_four_channel_phase_distribution_0/v3_four_channel_output_collection_0/v3_four_channel_placement_0/v3_channel_selector_late_promotion_2/group2_bit0 VSUBS VSUBS sky130_fd_pr__nfet_01v8 ad=0 pd=0 as=0 ps=0 w=0.42 l=0.15
X969 v3_four_channel_bias_reference_distribution_0/v3_four_channel_phase_distribution_0/v3_four_channel_output_collection_0/v3_four_channel_placement_0/v3_channel_selector_late_promotion_2/VPWR v3_four_channel_bias_reference_distribution_0/v3_four_channel_phase_distribution_0/v3_four_channel_output_collection_0/v3_four_channel_placement_0/v3_channel_selector_late_promotion_2/v3_selector_route_pilot_0/G2_MUX_NEG/a_76_199# v3_four_channel_bias_reference_distribution_0/v3_four_channel_phase_distribution_0/v3_four_channel_output_collection_0/v3_four_channel_placement_0/v3_channel_selector_late_promotion_2/v3_selector_route_pilot_0/G2_MUX_NEG/X v3_four_channel_bias_reference_distribution_0/v3_four_channel_phase_distribution_0/v3_four_channel_output_collection_0/v3_four_channel_placement_0/v3_channel_selector_late_promotion_2/VPWR sky130_fd_pr__pfet_01v8_hvt ad=0 pd=0 as=0.26 ps=2.52 w=1 l=0.15
X970 VSUBS v3_four_channel_bias_reference_distribution_0/v3_four_channel_phase_distribution_0/v3_four_channel_output_collection_0/v3_four_channel_placement_0/v3_channel_selector_late_promotion_2/v3_selector_route_pilot_0/G2_MUX_NEG/a_76_199# v3_four_channel_bias_reference_distribution_0/v3_four_channel_phase_distribution_0/v3_four_channel_output_collection_0/v3_four_channel_placement_0/v3_channel_selector_late_promotion_2/v3_selector_route_pilot_0/G2_MUX_NEG/X VSUBS sky130_fd_pr__nfet_01v8 ad=0 pd=0 as=0.169 ps=1.82 w=0.65 l=0.15
X971 v3_four_channel_bias_reference_distribution_0/v3_four_channel_phase_distribution_0/v3_four_channel_output_collection_0/v3_four_channel_placement_0/v3_channel_selector_late_promotion_2/VPWR v3_four_channel_bias_reference_distribution_0/v3_four_channel_phase_distribution_0/v3_four_channel_output_collection_0/v3_four_channel_placement_0/v3_channel_selector_late_promotion_2/v3_selector_route_pilot_0/G0_MUX_AXIS/a_505_21# v3_four_channel_bias_reference_distribution_0/v3_four_channel_phase_distribution_0/v3_four_channel_output_collection_0/v3_four_channel_placement_0/v3_channel_selector_late_promotion_2/v3_selector_route_pilot_0/G0_MUX_AXIS/a_535_374# v3_four_channel_bias_reference_distribution_0/v3_four_channel_phase_distribution_0/v3_four_channel_output_collection_0/v3_four_channel_placement_0/v3_channel_selector_late_promotion_2/VPWR sky130_fd_pr__pfet_01v8_hvt ad=0 pd=0 as=0.0882 ps=1.26 w=0.42 l=0.15
X972 v3_four_channel_bias_reference_distribution_0/v3_four_channel_phase_distribution_0/v3_four_channel_output_collection_0/v3_four_channel_placement_0/v3_channel_selector_late_promotion_2/v3_selector_route_pilot_0/G0_MUX_AXIS/a_505_21# v3_four_channel_bias_reference_distribution_0/v3_four_channel_phase_distribution_0/v3_four_channel_output_collection_0/v3_four_channel_placement_0/v3_channel_selector_late_promotion_2/group0_bit1 v3_four_channel_bias_reference_distribution_0/v3_four_channel_phase_distribution_0/v3_four_channel_output_collection_0/v3_four_channel_placement_0/v3_channel_selector_late_promotion_2/VPWR v3_four_channel_bias_reference_distribution_0/v3_four_channel_phase_distribution_0/v3_four_channel_output_collection_0/v3_four_channel_placement_0/v3_channel_selector_late_promotion_2/VPWR sky130_fd_pr__pfet_01v8_hvt ad=0.1176 pd=1.4 as=0 ps=0 w=0.42 l=0.15
X973 v3_four_channel_bias_reference_distribution_0/v3_four_channel_phase_distribution_0/v3_four_channel_output_collection_0/v3_four_channel_placement_0/v3_channel_selector_late_promotion_2/v3_selector_route_pilot_0/G0_MUX_AXIS/a_218_374# v3_four_channel_bias_reference_distribution_0/v3_four_channel_phase_distribution_0/v3_four_channel_output_collection_0/v3_four_channel_placement_0/v3_channel_selector_late_promotion_2/group0_bit1 v3_four_channel_bias_reference_distribution_0/v3_four_channel_phase_distribution_0/v3_four_channel_output_collection_0/v3_four_channel_placement_0/v3_channel_selector_late_promotion_2/VPWR v3_four_channel_bias_reference_distribution_0/v3_four_channel_phase_distribution_0/v3_four_channel_output_collection_0/v3_four_channel_placement_0/v3_channel_selector_late_promotion_2/VPWR sky130_fd_pr__pfet_01v8_hvt ad=0.1533 pd=1.57 as=0 ps=0 w=0.42 l=0.15
X974 VSUBS v3_four_channel_bias_reference_distribution_0/v3_four_channel_phase_distribution_0/v3_four_channel_output_collection_0/v3_four_channel_placement_0/v3_channel_selector_late_promotion_2/v3_selector_route_pilot_0/G0_MUX_AXIS/a_505_21# v3_four_channel_bias_reference_distribution_0/v3_four_channel_phase_distribution_0/v3_four_channel_output_collection_0/v3_four_channel_placement_0/v3_channel_selector_late_promotion_2/v3_selector_route_pilot_0/G0_MUX_AXIS/a_439_47# VSUBS sky130_fd_pr__nfet_01v8 ad=0 pd=0 as=0.1386 ps=1.5 w=0.42 l=0.15
X975 v3_four_channel_bias_reference_distribution_0/v3_four_channel_phase_distribution_0/v3_four_channel_output_collection_0/v3_four_channel_placement_0/v3_channel_selector_late_promotion_2/v3_selector_route_pilot_0/G0_MUX_AXIS/a_76_199# v3_four_channel_bias_reference_distribution_0/v3_four_channel_phase_distribution_0/v3_four_channel_output_collection_0/v3_four_channel_placement_0/v3_channel_selector_late_promotion_2/v3_selector_route_pilot_0/G0_MUX_POS/X v3_four_channel_bias_reference_distribution_0/v3_four_channel_phase_distribution_0/v3_four_channel_output_collection_0/v3_four_channel_placement_0/v3_channel_selector_late_promotion_2/v3_selector_route_pilot_0/G0_MUX_AXIS/a_218_374# v3_four_channel_bias_reference_distribution_0/v3_four_channel_phase_distribution_0/v3_four_channel_output_collection_0/v3_four_channel_placement_0/v3_channel_selector_late_promotion_2/VPWR sky130_fd_pr__pfet_01v8_hvt ad=0.3864 pd=2.68 as=0 ps=0 w=0.42 l=0.15
X976 v3_four_channel_bias_reference_distribution_0/v3_four_channel_phase_distribution_0/v3_four_channel_output_collection_0/v3_four_channel_placement_0/v3_channel_selector_late_promotion_2/v3_selector_route_pilot_0/G0_MUX_AXIS/a_505_21# v3_four_channel_bias_reference_distribution_0/v3_four_channel_phase_distribution_0/v3_four_channel_output_collection_0/v3_four_channel_placement_0/v3_channel_selector_late_promotion_2/group0_bit1 VSUBS VSUBS sky130_fd_pr__nfet_01v8 ad=0.1092 pd=1.36 as=0 ps=0 w=0.42 l=0.15
X977 v3_four_channel_bias_reference_distribution_0/v3_four_channel_phase_distribution_0/v3_four_channel_output_collection_0/v3_four_channel_placement_0/v3_channel_selector_late_promotion_2/v3_selector_route_pilot_0/G0_MUX_AXIS/a_439_47# v3_four_channel_bias_reference_distribution_0/v3_four_channel_phase_distribution_0/v3_four_channel_output_collection_0/v3_four_channel_placement_0/v3_channel_selector_late_promotion_2/v3_selector_route_pilot_0/G0_MUX_POS/X v3_four_channel_bias_reference_distribution_0/v3_four_channel_phase_distribution_0/v3_four_channel_output_collection_0/v3_four_channel_placement_0/v3_channel_selector_late_promotion_2/v3_selector_route_pilot_0/G0_MUX_AXIS/a_76_199# VSUBS sky130_fd_pr__nfet_01v8 ad=0 pd=0 as=0.1995 ps=1.79 w=0.42 l=0.15
X978 v3_four_channel_bias_reference_distribution_0/v3_four_channel_phase_distribution_0/v3_four_channel_output_collection_0/v3_four_channel_placement_0/v3_channel_selector_late_promotion_2/v3_selector_route_pilot_0/G0_MUX_AXIS/a_535_374# v3_four_channel_bias_reference_distribution_0/v3_four_channel_phase_distribution_0/v3_four_channel_output_collection_0/v3_four_channel_placement_0/v3_channel_selector_late_promotion_2/v3_selector_route_pilot_0/G0_MUX_NEG/X v3_four_channel_bias_reference_distribution_0/v3_four_channel_phase_distribution_0/v3_four_channel_output_collection_0/v3_four_channel_placement_0/v3_channel_selector_late_promotion_2/v3_selector_route_pilot_0/G0_MUX_AXIS/a_76_199# v3_four_channel_bias_reference_distribution_0/v3_four_channel_phase_distribution_0/v3_four_channel_output_collection_0/v3_four_channel_placement_0/v3_channel_selector_late_promotion_2/VPWR sky130_fd_pr__pfet_01v8_hvt ad=0 pd=0 as=0 ps=0 w=0.42 l=0.15
X979 v3_four_channel_bias_reference_distribution_0/v3_four_channel_phase_distribution_0/v3_four_channel_output_collection_0/v3_four_channel_placement_0/v3_channel_selector_late_promotion_2/v3_selector_route_pilot_0/G0_MUX_AXIS/a_76_199# v3_four_channel_bias_reference_distribution_0/v3_four_channel_phase_distribution_0/v3_four_channel_output_collection_0/v3_four_channel_placement_0/v3_channel_selector_late_promotion_2/v3_selector_route_pilot_0/G0_MUX_NEG/X v3_four_channel_bias_reference_distribution_0/v3_four_channel_phase_distribution_0/v3_four_channel_output_collection_0/v3_four_channel_placement_0/v3_channel_selector_late_promotion_2/v3_selector_route_pilot_0/G0_MUX_AXIS/a_218_47# VSUBS sky130_fd_pr__nfet_01v8 ad=0 pd=0 as=0.1386 ps=1.5 w=0.42 l=0.15
X980 v3_four_channel_bias_reference_distribution_0/v3_four_channel_phase_distribution_0/v3_four_channel_output_collection_0/v3_four_channel_placement_0/v3_channel_selector_late_promotion_2/v3_selector_route_pilot_0/G0_MUX_AXIS/a_218_47# v3_four_channel_bias_reference_distribution_0/v3_four_channel_phase_distribution_0/v3_four_channel_output_collection_0/v3_four_channel_placement_0/v3_channel_selector_late_promotion_2/group0_bit1 VSUBS VSUBS sky130_fd_pr__nfet_01v8 ad=0 pd=0 as=0 ps=0 w=0.42 l=0.15
X981 v3_four_channel_bias_reference_distribution_0/v3_four_channel_phase_distribution_0/v3_four_channel_output_collection_0/v3_four_channel_placement_0/v3_channel_selector_late_promotion_2/VPWR v3_four_channel_bias_reference_distribution_0/v3_four_channel_phase_distribution_0/v3_four_channel_output_collection_0/v3_four_channel_placement_0/v3_channel_selector_late_promotion_2/v3_selector_route_pilot_0/G0_MUX_AXIS/a_76_199# v3_four_channel_bias_reference_distribution_0/v3_four_channel_phase_distribution_0/v3_four_channel_output_collection_0/v3_four_channel_placement_0/v3_channel_selector_late_promotion_2/v3_selector_route_pilot_0/G0_MUX_AXIS/X v3_four_channel_bias_reference_distribution_0/v3_four_channel_phase_distribution_0/v3_four_channel_output_collection_0/v3_four_channel_placement_0/v3_channel_selector_late_promotion_2/VPWR sky130_fd_pr__pfet_01v8_hvt ad=0 pd=0 as=0.26 ps=2.52 w=1 l=0.15
X982 VSUBS v3_four_channel_bias_reference_distribution_0/v3_four_channel_phase_distribution_0/v3_four_channel_output_collection_0/v3_four_channel_placement_0/v3_channel_selector_late_promotion_2/v3_selector_route_pilot_0/G0_MUX_AXIS/a_76_199# v3_four_channel_bias_reference_distribution_0/v3_four_channel_phase_distribution_0/v3_four_channel_output_collection_0/v3_four_channel_placement_0/v3_channel_selector_late_promotion_2/v3_selector_route_pilot_0/G0_MUX_AXIS/X VSUBS sky130_fd_pr__nfet_01v8 ad=0 pd=0 as=0.169 ps=1.82 w=0.65 l=0.15
X983 v3_four_channel_bias_reference_distribution_0/v3_four_channel_phase_distribution_0/v3_four_channel_output_collection_0/v3_four_channel_placement_0/v3_channel_selector_late_promotion_2/VPWR v3_four_channel_bias_reference_distribution_0/v3_four_channel_phase_distribution_0/v3_four_channel_output_collection_0/v3_four_channel_placement_0/v3_channel_selector_late_promotion_2/v3_selector_route_pilot_0/G3_LO_P_AND/B v3_four_channel_bias_reference_distribution_0/v3_four_channel_phase_distribution_0/v3_four_channel_output_collection_0/v3_four_channel_placement_0/v3_channel_selector_late_promotion_2/v3_selector_route_pilot_0/G2_LO_P_AND/a_59_75# v3_four_channel_bias_reference_distribution_0/v3_four_channel_phase_distribution_0/v3_four_channel_output_collection_0/v3_four_channel_placement_0/v3_channel_selector_late_promotion_2/VPWR sky130_fd_pr__pfet_01v8_hvt ad=0 pd=0 as=0.1134 ps=1.38 w=0.42 l=0.15
X984 v3_four_channel_bias_reference_distribution_0/v3_four_channel_phase_distribution_0/v3_four_channel_output_collection_0/v3_four_channel_placement_0/v3_channel_selector_late_promotion_2/v3_selector_route_pilot_0/group2_lo_p v3_four_channel_bias_reference_distribution_0/v3_four_channel_phase_distribution_0/v3_four_channel_output_collection_0/v3_four_channel_placement_0/v3_channel_selector_late_promotion_2/v3_selector_route_pilot_0/G2_LO_P_AND/a_59_75# v3_four_channel_bias_reference_distribution_0/v3_four_channel_phase_distribution_0/v3_four_channel_output_collection_0/v3_four_channel_placement_0/v3_channel_selector_late_promotion_2/VPWR v3_four_channel_bias_reference_distribution_0/v3_four_channel_phase_distribution_0/v3_four_channel_output_collection_0/v3_four_channel_placement_0/v3_channel_selector_late_promotion_2/VPWR sky130_fd_pr__pfet_01v8_hvt ad=0.475 pd=2.95 as=0 ps=0 w=1 l=0.15
X985 VSUBS v3_four_channel_bias_reference_distribution_0/v3_four_channel_phase_distribution_0/v3_four_channel_output_collection_0/v3_four_channel_placement_0/v3_channel_selector_late_promotion_2/v3_selector_route_pilot_0/G3_LO_P_AND/B v3_four_channel_bias_reference_distribution_0/v3_four_channel_phase_distribution_0/v3_four_channel_output_collection_0/v3_four_channel_placement_0/v3_channel_selector_late_promotion_2/v3_selector_route_pilot_0/G2_LO_P_AND/a_145_75# VSUBS sky130_fd_pr__nfet_01v8 ad=0 pd=0 as=0.1134 ps=1.38 w=0.42 l=0.15
X986 v3_four_channel_bias_reference_distribution_0/v3_four_channel_phase_distribution_0/v3_four_channel_output_collection_0/v3_four_channel_placement_0/v3_channel_selector_late_promotion_2/v3_selector_route_pilot_0/G2_LO_P_AND/a_59_75# v3_four_channel_bias_reference_distribution_0/v3_four_channel_phase_distribution_0/v3_four_channel_output_collection_0/v3_four_channel_placement_0/v3_channel_selector_late_promotion_2/v3_selector_route_pilot_0/G2_MUX_AXIS/X v3_four_channel_bias_reference_distribution_0/v3_four_channel_phase_distribution_0/v3_four_channel_output_collection_0/v3_four_channel_placement_0/v3_channel_selector_late_promotion_2/VPWR v3_four_channel_bias_reference_distribution_0/v3_four_channel_phase_distribution_0/v3_four_channel_output_collection_0/v3_four_channel_placement_0/v3_channel_selector_late_promotion_2/VPWR sky130_fd_pr__pfet_01v8_hvt ad=0 pd=0 as=0 ps=0 w=0.42 l=0.15
X987 v3_four_channel_bias_reference_distribution_0/v3_four_channel_phase_distribution_0/v3_four_channel_output_collection_0/v3_four_channel_placement_0/v3_channel_selector_late_promotion_2/v3_selector_route_pilot_0/group2_lo_p v3_four_channel_bias_reference_distribution_0/v3_four_channel_phase_distribution_0/v3_four_channel_output_collection_0/v3_four_channel_placement_0/v3_channel_selector_late_promotion_2/v3_selector_route_pilot_0/G2_LO_P_AND/a_59_75# VSUBS VSUBS sky130_fd_pr__nfet_01v8 ad=0.182 pd=1.86 as=0 ps=0 w=0.65 l=0.15
X988 v3_four_channel_bias_reference_distribution_0/v3_four_channel_phase_distribution_0/v3_four_channel_output_collection_0/v3_four_channel_placement_0/v3_channel_selector_late_promotion_2/v3_selector_route_pilot_0/G2_LO_P_AND/a_145_75# v3_four_channel_bias_reference_distribution_0/v3_four_channel_phase_distribution_0/v3_four_channel_output_collection_0/v3_four_channel_placement_0/v3_channel_selector_late_promotion_2/v3_selector_route_pilot_0/G2_MUX_AXIS/X v3_four_channel_bias_reference_distribution_0/v3_four_channel_phase_distribution_0/v3_four_channel_output_collection_0/v3_four_channel_placement_0/v3_channel_selector_late_promotion_2/v3_selector_route_pilot_0/G2_LO_P_AND/a_59_75# VSUBS sky130_fd_pr__nfet_01v8 ad=0 pd=0 as=0.1176 ps=1.4 w=0.42 l=0.15
X989 v3_four_channel_bias_reference_distribution_0/v3_four_channel_phase_distribution_0/v3_four_channel_output_collection_0/v3_four_channel_placement_0/v3_channel_selector_late_promotion_3/v3_channel_input_bias_late_promotion_0/a_4678_23422# v3_four_channel_bias_reference_distribution_0/v3_four_channel_phase_distribution_0/v3_four_channel_output_collection_0/v3_four_channel_placement_0/v3_channel_selector_late_promotion_3/v3_selector_route_pilot_0/group3_lo_p v3_four_channel_bias_reference_distribution_0/v3_four_channel_phase_distribution_0/v3_four_channel_output_collection_0/combined_n_internal VSUBS sky130_fd_pr__nfet_01v8 ad=0.6206 pd=6.02 as=0 ps=0 w=0.65 l=0.15
X990 v3_four_channel_bias_reference_distribution_0/v3_four_channel_phase_distribution_0/v3_four_channel_output_collection_0/combined_n_internal v3_four_channel_bias_reference_distribution_0/v3_four_channel_phase_distribution_0/v3_four_channel_output_collection_0/v3_four_channel_placement_0/v3_channel_selector_late_promotion_3/v3_selector_route_pilot_0/group3_lo_p v3_four_channel_bias_reference_distribution_0/v3_four_channel_phase_distribution_0/v3_four_channel_output_collection_0/v3_four_channel_placement_0/v3_channel_selector_late_promotion_3/v3_channel_input_bias_late_promotion_0/a_4254_6978# VSUBS sky130_fd_pr__nfet_01v8 ad=0 pd=0 as=0.6206 ps=6.02 w=0.65 l=0.15
X991 v3_four_channel_bias_reference_distribution_0/v3_four_channel_phase_distribution_0/v3_four_channel_output_collection_0/v3_four_channel_placement_0/v3_channel_selector_late_promotion_3/v3_channel_input_bias_late_promotion_0/a_4678_23422# v3_vcm_support_block_0/ref v3_four_channel_bias_reference_distribution_0/v3_four_channel_phase_distribution_0/v3_four_channel_output_collection_0/v3_four_channel_placement_0/v3_channel_selector_late_promotion_3/v3_channel_input_bias_late_promotion_0/a_4382_21688# VSUBS sky130_fd_pr__nfet_01v8 ad=0 pd=0 as=1.9575 ps=15.24 w=0.84 l=0.6
X992 v3_four_channel_bias_reference_distribution_0/v3_four_channel_phase_distribution_0/v3_four_channel_output_collection_0/combined_n_internal v3_four_channel_bias_reference_distribution_0/v3_four_channel_phase_distribution_0/v3_four_channel_output_collection_0/v3_four_channel_placement_0/v3_channel_selector_late_promotion_3/v3_selector_route_pilot_0/group3_lo_n v3_four_channel_bias_reference_distribution_0/v3_four_channel_phase_distribution_0/v3_four_channel_output_collection_0/v3_four_channel_placement_0/v3_channel_selector_late_promotion_3/v3_channel_input_bias_late_promotion_0/a_7038_22978# VSUBS sky130_fd_pr__nfet_01v8 ad=0 pd=0 as=0.6206 ps=6.02 w=0.65 l=0.15
X993 v3_four_channel_bias_reference_distribution_0/v3_four_channel_phase_distribution_0/v3_four_channel_output_collection_0/combined_n_internal v3_four_channel_bias_reference_distribution_0/v3_four_channel_phase_distribution_0/v3_four_channel_output_collection_0/v3_four_channel_placement_0/v3_channel_selector_late_promotion_3/v3_selector_route_pilot_0/group3_lo_p v3_four_channel_bias_reference_distribution_0/v3_four_channel_phase_distribution_0/v3_four_channel_output_collection_0/v3_four_channel_placement_0/v3_channel_selector_late_promotion_3/v3_channel_input_bias_late_promotion_0/a_7038_6978# VSUBS sky130_fd_pr__nfet_01v8 ad=0 pd=0 as=0.6206 ps=6.02 w=0.65 l=0.15
X994 v3_four_channel_bias_reference_distribution_0/v3_four_channel_phase_distribution_0/v3_four_channel_output_collection_0/v3_four_channel_placement_0/v3_channel_selector_late_promotion_3/v3_channel_input_bias_late_promotion_0/a_7462_11422# v3_four_channel_bias_reference_distribution_0/v3_four_channel_phase_distribution_0/v3_four_channel_output_collection_0/v3_four_channel_placement_0/v3_channel_selector_late_promotion_3/element_input v3_four_channel_bias_reference_distribution_0/v3_four_channel_phase_distribution_0/v3_four_channel_output_collection_0/v3_four_channel_placement_0/v3_channel_selector_late_promotion_3/v3_channel_input_bias_late_promotion_0/a_7216_10978# VSUBS sky130_fd_pr__nfet_01v8 ad=0.6206 pd=6.02 as=1.9575 ps=15.24 w=0.84 l=0.6
X995 v3_four_channel_bias_reference_distribution_0/v3_four_channel_phase_distribution_0/v3_four_channel_output_collection_0/v3_four_channel_placement_0/v3_channel_selector_late_promotion_3/v3_channel_input_bias_late_promotion_0/a_7462_11422# v3_four_channel_bias_reference_distribution_0/v3_four_channel_phase_distribution_0/v3_four_channel_output_collection_0/v3_four_channel_placement_0/v3_channel_selector_late_promotion_3/v3_selector_route_pilot_0/group2_lo_n v3_four_channel_bias_reference_distribution_0/v3_four_channel_phase_distribution_0/v3_four_channel_output_collection_0/combined_n_internal VSUBS sky130_fd_pr__nfet_01v8 ad=0 pd=0 as=0 ps=0 w=0.65 l=0.15
X996 v3_four_channel_bias_reference_distribution_0/v3_four_channel_phase_distribution_0/v3_four_channel_output_collection_0/v3_four_channel_placement_0/v3_channel_selector_late_promotion_3/v3_channel_input_bias_late_promotion_0/a_5774_21688# v3_four_channel_bias_reference_distribution_0/v3_four_channel_phase_distribution_0/v3_four_channel_output_collection_0/v3_four_channel_placement_0/v3_channel_selector_late_promotion_3/element_input v3_four_channel_bias_reference_distribution_0/v3_four_channel_phase_distribution_0/v3_four_channel_output_collection_0/v3_four_channel_placement_0/v3_channel_selector_late_promotion_3/v3_channel_input_bias_late_promotion_0/a_5646_22978# VSUBS sky130_fd_pr__nfet_01v8 ad=1.9575 pd=15.24 as=0.6206 ps=6.02 w=0.84 l=0.6
X997 VSUBS v3_tail_bias_support_block_0/vbias v3_four_channel_bias_reference_distribution_0/v3_four_channel_phase_distribution_0/v3_four_channel_output_collection_0/v3_four_channel_placement_0/v3_channel_selector_late_promotion_3/v3_channel_input_bias_late_promotion_0/a_5774_17688# VSUBS sky130_fd_pr__nfet_01v8 ad=0 pd=0 as=1.9575 ps=15.24 w=5.07 l=1
X998 v3_four_channel_bias_reference_distribution_0/v3_four_channel_phase_distribution_0/v3_four_channel_output_collection_0/v3_four_channel_placement_0/v3_channel_selector_late_promotion_3/v3_channel_input_bias_late_promotion_0/a_6070_7422# v3_four_channel_bias_reference_distribution_0/v3_four_channel_phase_distribution_0/v3_four_channel_output_collection_0/v3_four_channel_placement_0/v3_channel_selector_late_promotion_3/element_input v3_four_channel_bias_reference_distribution_0/v3_four_channel_phase_distribution_0/v3_four_channel_output_collection_0/v3_four_channel_placement_0/v3_channel_selector_late_promotion_3/v3_channel_input_bias_late_promotion_0/a_5824_6978# VSUBS sky130_fd_pr__nfet_01v8 ad=0.6206 pd=6.02 as=1.9575 ps=15.24 w=0.84 l=0.6
X999 v3_four_channel_bias_reference_distribution_0/v3_four_channel_phase_distribution_0/v3_four_channel_output_collection_0/v3_four_channel_placement_0/v3_channel_selector_late_promotion_3/v3_channel_input_bias_late_promotion_0/a_6070_7422# v3_four_channel_bias_reference_distribution_0/v3_four_channel_phase_distribution_0/v3_four_channel_output_collection_0/v3_four_channel_placement_0/v3_channel_selector_late_promotion_3/v3_selector_route_pilot_0/group3_lo_n v3_four_channel_bias_reference_distribution_0/v3_four_channel_phase_distribution_0/v3_four_channel_output_collection_0/combined_n_internal VSUBS sky130_fd_pr__nfet_01v8 ad=0 pd=0 as=0 ps=0 w=0.65 l=0.15
X1000 v3_vcm_support_block_0/ref v3_four_channel_bias_reference_distribution_0/v3_four_channel_phase_distribution_0/v3_four_channel_output_collection_0/v3_four_channel_placement_0/v3_channel_selector_late_promotion_3/element_input VSUBS sky130_fd_pr__res_xhigh_po_0p35 l=17.36
X1001 v3_four_channel_bias_reference_distribution_0/v3_four_channel_phase_distribution_0/v3_four_channel_output_collection_0/v3_four_channel_placement_0/v3_channel_selector_late_promotion_3/v3_channel_input_bias_late_promotion_0/a_7462_23422# v3_vcm_support_block_0/ref v3_four_channel_bias_reference_distribution_0/v3_four_channel_phase_distribution_0/v3_four_channel_output_collection_0/v3_four_channel_placement_0/v3_channel_selector_late_promotion_3/v3_channel_input_bias_late_promotion_0/a_7166_21688# VSUBS sky130_fd_pr__nfet_01v8 ad=0.6206 pd=6.02 as=1.9575 ps=15.24 w=0.84 l=0.6
X1002 v3_four_channel_bias_reference_distribution_0/v3_four_channel_phase_distribution_0/v3_four_channel_output_collection_0/v3_four_channel_placement_0/v3_channel_selector_late_promotion_3/v3_channel_input_bias_late_promotion_0/a_7462_23422# v3_four_channel_bias_reference_distribution_0/v3_four_channel_phase_distribution_0/v3_four_channel_output_collection_0/v3_four_channel_placement_0/v3_channel_selector_late_promotion_3/v3_selector_route_pilot_0/group3_lo_p v3_four_channel_bias_reference_distribution_0/v3_four_channel_phase_distribution_0/v3_four_channel_output_collection_0/combined_n_internal VSUBS sky130_fd_pr__nfet_01v8 ad=0 pd=0 as=0 ps=0 w=0.65 l=0.15
X1003 VSUBS v3_tail_bias_support_block_0/vbias v3_four_channel_bias_reference_distribution_0/v3_four_channel_phase_distribution_0/v3_four_channel_output_collection_0/v3_four_channel_placement_0/v3_channel_selector_late_promotion_3/v3_channel_input_bias_late_promotion_0/a_4382_21688# VSUBS sky130_fd_pr__nfet_01v8 ad=0 pd=0 as=0 ps=0 w=5.07 l=1
X1004 VSUBS v3_tail_bias_support_block_0/vbias v3_four_channel_bias_reference_distribution_0/v3_four_channel_phase_distribution_0/v3_four_channel_output_collection_0/v3_four_channel_placement_0/v3_channel_selector_late_promotion_3/v3_channel_input_bias_late_promotion_0/a_5774_13688# VSUBS sky130_fd_pr__nfet_01v8 ad=0 pd=0 as=1.9575 ps=15.24 w=5.07 l=1
X1005 VSUBS v3_tail_bias_support_block_0/vbias v3_four_channel_bias_reference_distribution_0/v3_four_channel_phase_distribution_0/v3_four_channel_output_collection_0/v3_four_channel_placement_0/v3_channel_selector_late_promotion_3/v3_channel_input_bias_late_promotion_0/a_7166_17688# VSUBS sky130_fd_pr__nfet_01v8 ad=0 pd=0 as=1.9575 ps=15.24 w=5.07 l=1
X1006 VSUBS VSUBS VSUBS VSUBS sky130_fd_pr__nfet_01v8 ad=0 pd=0 as=0 ps=0 w=0.65 l=0.15
X1007 v3_four_channel_bias_reference_distribution_0/v3_four_channel_phase_distribution_0/v3_four_channel_output_collection_0/combined_p_internal v3_four_channel_bias_reference_distribution_0/v3_four_channel_phase_distribution_0/v3_four_channel_output_collection_0/v3_four_channel_placement_0/v3_channel_selector_late_promotion_3/v3_selector_route_pilot_0/group3_lo_p v3_four_channel_bias_reference_distribution_0/v3_four_channel_phase_distribution_0/v3_four_channel_output_collection_0/v3_four_channel_placement_0/v3_channel_selector_late_promotion_3/v3_channel_input_bias_late_promotion_0/a_5646_18978# VSUBS sky130_fd_pr__nfet_01v8 ad=0 pd=0 as=0.6206 ps=6.02 w=0.65 l=0.15
X1008 VSUBS VSUBS VSUBS VSUBS sky130_fd_pr__nfet_01v8 ad=0 pd=0 as=0 ps=0 w=0.65 l=0.15
X1009 v3_four_channel_bias_reference_distribution_0/v3_four_channel_phase_distribution_0/v3_four_channel_output_collection_0/v3_four_channel_placement_0/v3_channel_selector_late_promotion_3/v3_channel_input_bias_late_promotion_0/a_6070_19422# v3_four_channel_bias_reference_distribution_0/v3_four_channel_phase_distribution_0/v3_four_channel_output_collection_0/v3_four_channel_placement_0/v3_channel_selector_late_promotion_3/v3_selector_route_pilot_0/group3_lo_n v3_four_channel_bias_reference_distribution_0/v3_four_channel_phase_distribution_0/v3_four_channel_output_collection_0/combined_p_internal VSUBS sky130_fd_pr__nfet_01v8 ad=0.6206 pd=6.02 as=0 ps=0 w=0.65 l=0.15
X1010 VSUBS VSUBS VSUBS VSUBS sky130_fd_pr__nfet_01v8 ad=0 pd=0 as=0 ps=0 w=0.65 l=0.15
X1011 v3_four_channel_bias_reference_distribution_0/v3_four_channel_phase_distribution_0/v3_four_channel_output_collection_0/combined_p_internal v3_four_channel_bias_reference_distribution_0/v3_four_channel_phase_distribution_0/v3_four_channel_output_collection_0/v3_four_channel_placement_0/v3_channel_selector_late_promotion_3/v3_selector_route_pilot_0/group2_lo_p v3_four_channel_bias_reference_distribution_0/v3_four_channel_phase_distribution_0/v3_four_channel_output_collection_0/v3_four_channel_placement_0/v3_channel_selector_late_promotion_3/v3_channel_input_bias_late_promotion_0/a_4254_18978# VSUBS sky130_fd_pr__nfet_01v8 ad=0 pd=0 as=0.6206 ps=6.02 w=0.65 l=0.15
X1012 v3_four_channel_bias_reference_distribution_0/v3_four_channel_phase_distribution_0/v3_four_channel_output_collection_0/v3_four_channel_placement_0/v3_channel_selector_late_promotion_3/v3_channel_input_bias_late_promotion_0/a_7216_14978# v3_tail_bias_support_block_0/vbias VSUBS VSUBS sky130_fd_pr__nfet_01v8 ad=1.9575 pd=15.24 as=0 ps=0 w=5.07 l=1
X1013 VSUBS VSUBS VSUBS VSUBS sky130_fd_pr__nfet_01v8 ad=0 pd=0 as=0 ps=0 w=0.65 l=0.15
X1014 VSUBS VSUBS VSUBS VSUBS sky130_fd_pr__nfet_01v8 ad=0 pd=0 as=0 ps=0 w=0.65 l=0.15
X1015 v3_four_channel_bias_reference_distribution_0/v3_four_channel_phase_distribution_0/v3_four_channel_output_collection_0/v3_four_channel_placement_0/v3_channel_selector_late_promotion_3/v3_channel_input_bias_late_promotion_0/a_4382_17688# v3_four_channel_bias_reference_distribution_0/v3_four_channel_phase_distribution_0/v3_four_channel_output_collection_0/v3_four_channel_placement_0/v3_channel_selector_late_promotion_3/element_input v3_four_channel_bias_reference_distribution_0/v3_four_channel_phase_distribution_0/v3_four_channel_output_collection_0/v3_four_channel_placement_0/v3_channel_selector_late_promotion_3/v3_channel_input_bias_late_promotion_0/a_4254_18978# VSUBS sky130_fd_pr__nfet_01v8 ad=1.9575 pd=15.24 as=0 ps=0 w=0.84 l=0.6
X1016 v3_four_channel_bias_reference_distribution_0/v3_four_channel_phase_distribution_0/v3_four_channel_output_collection_0/v3_four_channel_placement_0/v3_channel_selector_late_promotion_3/v3_channel_input_bias_late_promotion_0/a_4678_19422# v3_four_channel_bias_reference_distribution_0/v3_four_channel_phase_distribution_0/v3_four_channel_output_collection_0/v3_four_channel_placement_0/v3_channel_selector_late_promotion_3/v3_selector_route_pilot_0/group2_lo_n v3_four_channel_bias_reference_distribution_0/v3_four_channel_phase_distribution_0/v3_four_channel_output_collection_0/combined_p_internal VSUBS sky130_fd_pr__nfet_01v8 ad=0.6206 pd=6.02 as=0 ps=0 w=0.65 l=0.15
X1017 v3_four_channel_bias_reference_distribution_0/v3_four_channel_phase_distribution_0/v3_four_channel_output_collection_0/combined_p_internal v3_four_channel_bias_reference_distribution_0/v3_four_channel_phase_distribution_0/v3_four_channel_output_collection_0/v3_four_channel_placement_0/v3_channel_selector_late_promotion_3/v3_selector_route_pilot_0/group0_lo_p v3_four_channel_bias_reference_distribution_0/v3_four_channel_phase_distribution_0/v3_four_channel_output_collection_0/v3_four_channel_placement_0/v3_channel_selector_late_promotion_3/v3_channel_input_bias_late_promotion_0/a_5646_14978# VSUBS sky130_fd_pr__nfet_01v8 ad=0 pd=0 as=0.6206 ps=6.02 w=0.65 l=0.15
X1018 v3_four_channel_bias_reference_distribution_0/v3_four_channel_phase_distribution_0/v3_four_channel_output_collection_0/combined_p_internal v3_four_channel_bias_reference_distribution_0/v3_four_channel_phase_distribution_0/v3_four_channel_output_collection_0/v3_four_channel_placement_0/v3_channel_selector_late_promotion_3/v3_selector_route_pilot_0/group2_lo_p v3_four_channel_bias_reference_distribution_0/v3_four_channel_phase_distribution_0/v3_four_channel_output_collection_0/v3_four_channel_placement_0/v3_channel_selector_late_promotion_3/v3_channel_input_bias_late_promotion_0/a_7038_18978# VSUBS sky130_fd_pr__nfet_01v8 ad=0 pd=0 as=0.6206 ps=6.02 w=0.65 l=0.15
X1019 VSUBS VSUBS VSUBS VSUBS sky130_fd_pr__nfet_01v8 ad=0 pd=0 as=0 ps=0 w=5.07 l=1
X1020 v3_four_channel_bias_reference_distribution_0/v3_four_channel_phase_distribution_0/v3_four_channel_output_collection_0/v3_four_channel_placement_0/v3_channel_selector_late_promotion_3/v3_channel_input_bias_late_promotion_0/a_6070_15422# v3_four_channel_bias_reference_distribution_0/v3_four_channel_phase_distribution_0/v3_four_channel_output_collection_0/v3_four_channel_placement_0/v3_channel_selector_late_promotion_3/v3_selector_route_pilot_0/group0_lo_n v3_four_channel_bias_reference_distribution_0/v3_four_channel_phase_distribution_0/v3_four_channel_output_collection_0/combined_p_internal VSUBS sky130_fd_pr__nfet_01v8 ad=0.6206 pd=6.02 as=0 ps=0 w=0.65 l=0.15
X1021 v3_four_channel_bias_reference_distribution_0/v3_four_channel_phase_distribution_0/v3_four_channel_output_collection_0/v3_four_channel_placement_0/v3_channel_selector_late_promotion_3/v3_channel_input_bias_late_promotion_0/a_7166_17688# v3_four_channel_bias_reference_distribution_0/v3_four_channel_phase_distribution_0/v3_four_channel_output_collection_0/v3_four_channel_placement_0/v3_channel_selector_late_promotion_3/element_input v3_four_channel_bias_reference_distribution_0/v3_four_channel_phase_distribution_0/v3_four_channel_output_collection_0/v3_four_channel_placement_0/v3_channel_selector_late_promotion_3/v3_channel_input_bias_late_promotion_0/a_7038_18978# VSUBS sky130_fd_pr__nfet_01v8 ad=0 pd=0 as=0 ps=0 w=0.84 l=0.6
X1022 v3_four_channel_bias_reference_distribution_0/v3_four_channel_phase_distribution_0/v3_four_channel_output_collection_0/combined_n_internal v3_four_channel_bias_reference_distribution_0/v3_four_channel_phase_distribution_0/v3_four_channel_output_collection_0/v3_four_channel_placement_0/v3_channel_selector_late_promotion_3/v3_selector_route_pilot_0/group3_lo_n v3_four_channel_bias_reference_distribution_0/v3_four_channel_phase_distribution_0/v3_four_channel_output_collection_0/v3_four_channel_placement_0/v3_channel_selector_late_promotion_3/v3_channel_input_bias_late_promotion_0/a_5646_18978# VSUBS sky130_fd_pr__nfet_01v8 ad=0 pd=0 as=0 ps=0 w=0.65 l=0.15
X1023 VSUBS v3_tail_bias_support_block_0/vbias v3_four_channel_bias_reference_distribution_0/v3_four_channel_phase_distribution_0/v3_four_channel_output_collection_0/v3_four_channel_placement_0/v3_channel_selector_late_promotion_3/v3_channel_input_bias_late_promotion_0/a_5774_21688# VSUBS sky130_fd_pr__nfet_01v8 ad=0 pd=0 as=0 ps=0 w=5.07 l=1
X1024 v3_four_channel_bias_reference_distribution_0/v3_four_channel_phase_distribution_0/v3_four_channel_output_collection_0/v3_four_channel_placement_0/v3_channel_selector_late_promotion_3/v3_channel_input_bias_late_promotion_0/a_6070_19422# v3_vcm_support_block_0/ref v3_four_channel_bias_reference_distribution_0/v3_four_channel_phase_distribution_0/v3_four_channel_output_collection_0/v3_four_channel_placement_0/v3_channel_selector_late_promotion_3/v3_channel_input_bias_late_promotion_0/a_5774_17688# VSUBS sky130_fd_pr__nfet_01v8 ad=0 pd=0 as=0 ps=0 w=0.84 l=0.6
X1025 VSUBS VSUBS VSUBS VSUBS sky130_fd_pr__nfet_01v8 ad=0 pd=0 as=0 ps=0 w=5.07 l=1
X1026 v3_four_channel_bias_reference_distribution_0/v3_four_channel_phase_distribution_0/v3_four_channel_output_collection_0/combined_p_internal v3_four_channel_bias_reference_distribution_0/v3_four_channel_phase_distribution_0/v3_four_channel_output_collection_0/v3_four_channel_placement_0/v3_channel_selector_late_promotion_3/v3_selector_route_pilot_0/group1_lo_p v3_four_channel_bias_reference_distribution_0/v3_four_channel_phase_distribution_0/v3_four_channel_output_collection_0/v3_four_channel_placement_0/v3_channel_selector_late_promotion_3/v3_channel_input_bias_late_promotion_0/a_4254_14978# VSUBS sky130_fd_pr__nfet_01v8 ad=0 pd=0 as=0.6206 ps=6.02 w=0.65 l=0.15
X1027 v3_four_channel_bias_reference_distribution_0/v3_four_channel_phase_distribution_0/v3_four_channel_output_collection_0/v3_four_channel_placement_0/v3_channel_selector_late_promotion_3/v3_channel_input_bias_late_promotion_0/a_6070_19422# v3_four_channel_bias_reference_distribution_0/v3_four_channel_phase_distribution_0/v3_four_channel_output_collection_0/v3_four_channel_placement_0/v3_channel_selector_late_promotion_3/v3_selector_route_pilot_0/group3_lo_p v3_four_channel_bias_reference_distribution_0/v3_four_channel_phase_distribution_0/v3_four_channel_output_collection_0/combined_n_internal VSUBS sky130_fd_pr__nfet_01v8 ad=0 pd=0 as=0 ps=0 w=0.65 l=0.15
X1028 VSUBS VSUBS VSUBS VSUBS sky130_fd_pr__nfet_01v8 ad=0 pd=0 as=0 ps=0 w=0.65 l=0.15
X1029 v3_four_channel_bias_reference_distribution_0/v3_four_channel_phase_distribution_0/v3_four_channel_output_collection_0/v3_four_channel_placement_0/v3_channel_selector_late_promotion_3/v3_channel_input_bias_late_promotion_0/a_5824_10978# v3_tail_bias_support_block_0/vbias VSUBS VSUBS sky130_fd_pr__nfet_01v8 ad=1.9575 pd=15.24 as=0 ps=0 w=5.07 l=1
X1030 v3_four_channel_bias_reference_distribution_0/v3_four_channel_phase_distribution_0/v3_four_channel_output_collection_0/v3_four_channel_placement_0/v3_channel_selector_late_promotion_3/v3_channel_input_bias_late_promotion_0/a_4382_13688# v3_four_channel_bias_reference_distribution_0/v3_four_channel_phase_distribution_0/v3_four_channel_output_collection_0/v3_four_channel_placement_0/v3_channel_selector_late_promotion_3/element_input v3_four_channel_bias_reference_distribution_0/v3_four_channel_phase_distribution_0/v3_four_channel_output_collection_0/v3_four_channel_placement_0/v3_channel_selector_late_promotion_3/v3_channel_input_bias_late_promotion_0/a_4254_14978# VSUBS sky130_fd_pr__nfet_01v8 ad=1.9575 pd=15.24 as=0 ps=0 w=0.84 l=0.6
X1031 v3_four_channel_bias_reference_distribution_0/v3_four_channel_phase_distribution_0/v3_four_channel_output_collection_0/v3_four_channel_placement_0/v3_channel_selector_late_promotion_3/v3_channel_input_bias_late_promotion_0/a_4678_15422# v3_four_channel_bias_reference_distribution_0/v3_four_channel_phase_distribution_0/v3_four_channel_output_collection_0/v3_four_channel_placement_0/v3_channel_selector_late_promotion_3/v3_selector_route_pilot_0/group1_lo_n v3_four_channel_bias_reference_distribution_0/v3_four_channel_phase_distribution_0/v3_four_channel_output_collection_0/combined_p_internal VSUBS sky130_fd_pr__nfet_01v8 ad=0.6206 pd=6.02 as=0 ps=0 w=0.65 l=0.15
X1032 v3_four_channel_bias_reference_distribution_0/v3_four_channel_phase_distribution_0/v3_four_channel_output_collection_0/combined_n_internal v3_four_channel_bias_reference_distribution_0/v3_four_channel_phase_distribution_0/v3_four_channel_output_collection_0/v3_four_channel_placement_0/v3_channel_selector_late_promotion_3/v3_selector_route_pilot_0/group2_lo_n v3_four_channel_bias_reference_distribution_0/v3_four_channel_phase_distribution_0/v3_four_channel_output_collection_0/v3_four_channel_placement_0/v3_channel_selector_late_promotion_3/v3_channel_input_bias_late_promotion_0/a_4254_18978# VSUBS sky130_fd_pr__nfet_01v8 ad=0 pd=0 as=0 ps=0 w=0.65 l=0.15
X1033 v3_four_channel_bias_reference_distribution_0/v3_four_channel_phase_distribution_0/v3_four_channel_output_collection_0/combined_p_internal v3_four_channel_bias_reference_distribution_0/v3_four_channel_phase_distribution_0/v3_four_channel_output_collection_0/v3_four_channel_placement_0/v3_channel_selector_late_promotion_3/v3_selector_route_pilot_0/group3_lo_n v3_four_channel_bias_reference_distribution_0/v3_four_channel_phase_distribution_0/v3_four_channel_output_collection_0/v3_four_channel_placement_0/v3_channel_selector_late_promotion_3/v3_channel_input_bias_late_promotion_0/a_5646_10978# VSUBS sky130_fd_pr__nfet_01v8 ad=0 pd=0 as=0.6206 ps=6.02 w=0.65 l=0.15
X1034 v3_four_channel_bias_reference_distribution_0/v3_four_channel_phase_distribution_0/v3_four_channel_output_collection_0/combined_p_internal v3_four_channel_bias_reference_distribution_0/v3_four_channel_phase_distribution_0/v3_four_channel_output_collection_0/v3_four_channel_placement_0/v3_channel_selector_late_promotion_3/v3_selector_route_pilot_0/group1_lo_n v3_four_channel_bias_reference_distribution_0/v3_four_channel_phase_distribution_0/v3_four_channel_output_collection_0/v3_four_channel_placement_0/v3_channel_selector_late_promotion_3/v3_channel_input_bias_late_promotion_0/a_7038_14978# VSUBS sky130_fd_pr__nfet_01v8 ad=0 pd=0 as=0.6206 ps=6.02 w=0.65 l=0.15
X1035 v3_four_channel_bias_reference_distribution_0/v3_four_channel_phase_distribution_0/v3_four_channel_output_collection_0/v3_four_channel_placement_0/v3_channel_selector_late_promotion_3/v3_channel_input_bias_late_promotion_0/a_7462_19422# v3_four_channel_bias_reference_distribution_0/v3_four_channel_phase_distribution_0/v3_four_channel_output_collection_0/v3_four_channel_placement_0/v3_channel_selector_late_promotion_3/v3_selector_route_pilot_0/group2_lo_n v3_four_channel_bias_reference_distribution_0/v3_four_channel_phase_distribution_0/v3_four_channel_output_collection_0/combined_p_internal VSUBS sky130_fd_pr__nfet_01v8 ad=0.6206 pd=6.02 as=0 ps=0 w=0.65 l=0.15
X1036 v3_four_channel_bias_reference_distribution_0/v3_four_channel_phase_distribution_0/v3_four_channel_output_collection_0/v3_four_channel_placement_0/v3_channel_selector_late_promotion_3/v3_channel_input_bias_late_promotion_0/a_4678_7422# v3_four_channel_bias_reference_distribution_0/v3_four_channel_phase_distribution_0/v3_four_channel_output_collection_0/v3_four_channel_placement_0/v3_channel_selector_late_promotion_3/v3_selector_route_pilot_0/group3_lo_p v3_four_channel_bias_reference_distribution_0/v3_four_channel_phase_distribution_0/v3_four_channel_output_collection_0/combined_p_internal VSUBS sky130_fd_pr__nfet_01v8 ad=0.6206 pd=6.02 as=0 ps=0 w=0.65 l=0.15
X1037 v3_four_channel_bias_reference_distribution_0/v3_four_channel_phase_distribution_0/v3_four_channel_output_collection_0/v3_four_channel_placement_0/v3_channel_selector_late_promotion_3/v3_channel_input_bias_late_promotion_0/a_6070_11422# v3_four_channel_bias_reference_distribution_0/v3_four_channel_phase_distribution_0/v3_four_channel_output_collection_0/v3_four_channel_placement_0/v3_channel_selector_late_promotion_3/v3_selector_route_pilot_0/group3_lo_p v3_four_channel_bias_reference_distribution_0/v3_four_channel_phase_distribution_0/v3_four_channel_output_collection_0/combined_p_internal VSUBS sky130_fd_pr__nfet_01v8 ad=0.6206 pd=6.02 as=0 ps=0 w=0.65 l=0.15
X1038 v3_four_channel_bias_reference_distribution_0/v3_four_channel_phase_distribution_0/v3_four_channel_output_collection_0/v3_four_channel_placement_0/v3_channel_selector_late_promotion_3/v3_channel_input_bias_late_promotion_0/a_7216_10978# v3_tail_bias_support_block_0/vbias VSUBS VSUBS sky130_fd_pr__nfet_01v8 ad=0 pd=0 as=0 ps=0 w=5.07 l=1
X1039 v3_four_channel_bias_reference_distribution_0/v3_four_channel_phase_distribution_0/v3_four_channel_output_collection_0/v3_four_channel_placement_0/v3_channel_selector_late_promotion_3/v3_channel_input_bias_late_promotion_0/a_7216_14978# v3_vcm_support_block_0/ref v3_four_channel_bias_reference_distribution_0/v3_four_channel_phase_distribution_0/v3_four_channel_output_collection_0/v3_four_channel_placement_0/v3_channel_selector_late_promotion_3/v3_channel_input_bias_late_promotion_0/a_7038_14978# VSUBS sky130_fd_pr__nfet_01v8 ad=0 pd=0 as=0 ps=0 w=0.84 l=0.6
X1040 v3_four_channel_bias_reference_distribution_0/v3_four_channel_phase_distribution_0/v3_four_channel_output_collection_0/v3_four_channel_placement_0/v3_channel_selector_late_promotion_3/v3_channel_input_bias_late_promotion_0/a_4678_19422# v3_vcm_support_block_0/ref v3_four_channel_bias_reference_distribution_0/v3_four_channel_phase_distribution_0/v3_four_channel_output_collection_0/v3_four_channel_placement_0/v3_channel_selector_late_promotion_3/v3_channel_input_bias_late_promotion_0/a_4382_17688# VSUBS sky130_fd_pr__nfet_01v8 ad=0 pd=0 as=0 ps=0 w=0.84 l=0.6
X1041 v3_four_channel_bias_reference_distribution_0/v3_four_channel_phase_distribution_0/v3_four_channel_output_collection_0/v3_four_channel_placement_0/v3_channel_selector_late_promotion_3/v3_channel_input_bias_late_promotion_0/a_4678_19422# v3_four_channel_bias_reference_distribution_0/v3_four_channel_phase_distribution_0/v3_four_channel_output_collection_0/v3_four_channel_placement_0/v3_channel_selector_late_promotion_3/v3_selector_route_pilot_0/group2_lo_p v3_four_channel_bias_reference_distribution_0/v3_four_channel_phase_distribution_0/v3_four_channel_output_collection_0/combined_n_internal VSUBS sky130_fd_pr__nfet_01v8 ad=0 pd=0 as=0 ps=0 w=0.65 l=0.15
X1042 v3_four_channel_bias_reference_distribution_0/v3_four_channel_phase_distribution_0/v3_four_channel_output_collection_0/combined_n_internal v3_four_channel_bias_reference_distribution_0/v3_four_channel_phase_distribution_0/v3_four_channel_output_collection_0/v3_four_channel_placement_0/v3_channel_selector_late_promotion_3/v3_selector_route_pilot_0/group0_lo_n v3_four_channel_bias_reference_distribution_0/v3_four_channel_phase_distribution_0/v3_four_channel_output_collection_0/v3_four_channel_placement_0/v3_channel_selector_late_promotion_3/v3_channel_input_bias_late_promotion_0/a_5646_14978# VSUBS sky130_fd_pr__nfet_01v8 ad=0 pd=0 as=0 ps=0 w=0.65 l=0.15
X1043 v3_four_channel_bias_reference_distribution_0/v3_four_channel_phase_distribution_0/v3_four_channel_output_collection_0/combined_n_internal v3_four_channel_bias_reference_distribution_0/v3_four_channel_phase_distribution_0/v3_four_channel_output_collection_0/v3_four_channel_placement_0/v3_channel_selector_late_promotion_3/v3_selector_route_pilot_0/group2_lo_n v3_four_channel_bias_reference_distribution_0/v3_four_channel_phase_distribution_0/v3_four_channel_output_collection_0/v3_four_channel_placement_0/v3_channel_selector_late_promotion_3/v3_channel_input_bias_late_promotion_0/a_7038_18978# VSUBS sky130_fd_pr__nfet_01v8 ad=0 pd=0 as=0 ps=0 w=0.65 l=0.15
X1044 v3_four_channel_bias_reference_distribution_0/v3_four_channel_phase_distribution_0/v3_four_channel_output_collection_0/v3_four_channel_placement_0/v3_channel_selector_late_promotion_3/v3_channel_input_bias_late_promotion_0/a_7462_7422# v3_four_channel_bias_reference_distribution_0/v3_four_channel_phase_distribution_0/v3_four_channel_output_collection_0/v3_four_channel_placement_0/v3_channel_selector_late_promotion_3/v3_selector_route_pilot_0/group3_lo_p v3_four_channel_bias_reference_distribution_0/v3_four_channel_phase_distribution_0/v3_four_channel_output_collection_0/combined_p_internal VSUBS sky130_fd_pr__nfet_01v8 ad=0.6206 pd=6.02 as=0 ps=0 w=0.65 l=0.15
X1045 VSUBS v3_tail_bias_support_block_0/vbias v3_four_channel_bias_reference_distribution_0/v3_four_channel_phase_distribution_0/v3_four_channel_output_collection_0/v3_four_channel_placement_0/v3_channel_selector_late_promotion_3/v3_channel_input_bias_late_promotion_0/a_7166_21688# VSUBS sky130_fd_pr__nfet_01v8 ad=0 pd=0 as=0 ps=0 w=5.07 l=1
X1046 v3_four_channel_bias_reference_distribution_0/v3_four_channel_phase_distribution_0/v3_four_channel_output_collection_0/v3_four_channel_placement_0/v3_channel_selector_late_promotion_3/v3_channel_input_bias_late_promotion_0/a_6070_15422# v3_vcm_support_block_0/ref v3_four_channel_bias_reference_distribution_0/v3_four_channel_phase_distribution_0/v3_four_channel_output_collection_0/v3_four_channel_placement_0/v3_channel_selector_late_promotion_3/v3_channel_input_bias_late_promotion_0/a_5774_13688# VSUBS sky130_fd_pr__nfet_01v8 ad=0 pd=0 as=0 ps=0 w=0.84 l=0.6
X1047 v3_four_channel_bias_reference_distribution_0/v3_four_channel_phase_distribution_0/v3_four_channel_output_collection_0/combined_p_internal v3_four_channel_bias_reference_distribution_0/v3_four_channel_phase_distribution_0/v3_four_channel_output_collection_0/v3_four_channel_placement_0/v3_channel_selector_late_promotion_3/v3_selector_route_pilot_0/group2_lo_n v3_four_channel_bias_reference_distribution_0/v3_four_channel_phase_distribution_0/v3_four_channel_output_collection_0/v3_four_channel_placement_0/v3_channel_selector_late_promotion_3/v3_channel_input_bias_late_promotion_0/a_4254_10978# VSUBS sky130_fd_pr__nfet_01v8 ad=0 pd=0 as=0.6206 ps=6.02 w=0.65 l=0.15
X1048 v3_four_channel_bias_reference_distribution_0/v3_four_channel_phase_distribution_0/v3_four_channel_output_collection_0/v3_four_channel_placement_0/v3_channel_selector_late_promotion_3/v3_channel_input_bias_late_promotion_0/a_6070_15422# v3_four_channel_bias_reference_distribution_0/v3_four_channel_phase_distribution_0/v3_four_channel_output_collection_0/v3_four_channel_placement_0/v3_channel_selector_late_promotion_3/v3_selector_route_pilot_0/group0_lo_p v3_four_channel_bias_reference_distribution_0/v3_four_channel_phase_distribution_0/v3_four_channel_output_collection_0/combined_n_internal VSUBS sky130_fd_pr__nfet_01v8 ad=0 pd=0 as=0 ps=0 w=0.65 l=0.15
X1049 v3_four_channel_bias_reference_distribution_0/v3_four_channel_phase_distribution_0/v3_four_channel_output_collection_0/v3_four_channel_placement_0/v3_channel_selector_late_promotion_3/v3_channel_input_bias_late_promotion_0/a_5824_6978# v3_vcm_support_block_0/ref v3_four_channel_bias_reference_distribution_0/v3_four_channel_phase_distribution_0/v3_four_channel_output_collection_0/v3_four_channel_placement_0/v3_channel_selector_late_promotion_3/v3_channel_input_bias_late_promotion_0/a_5646_6978# VSUBS sky130_fd_pr__nfet_01v8 ad=0 pd=0 as=0.6206 ps=6.02 w=0.84 l=0.6
X1050 v3_four_channel_bias_reference_distribution_0/v3_four_channel_phase_distribution_0/v3_four_channel_output_collection_0/v3_four_channel_placement_0/v3_channel_selector_late_promotion_3/v3_channel_input_bias_late_promotion_0/a_5774_17688# v3_four_channel_bias_reference_distribution_0/v3_four_channel_phase_distribution_0/v3_four_channel_output_collection_0/v3_four_channel_placement_0/v3_channel_selector_late_promotion_3/element_input v3_four_channel_bias_reference_distribution_0/v3_four_channel_phase_distribution_0/v3_four_channel_output_collection_0/v3_four_channel_placement_0/v3_channel_selector_late_promotion_3/v3_channel_input_bias_late_promotion_0/a_5646_18978# VSUBS sky130_fd_pr__nfet_01v8 ad=0 pd=0 as=0 ps=0 w=0.84 l=0.6
X1051 v3_four_channel_bias_reference_distribution_0/v3_four_channel_phase_distribution_0/v3_four_channel_output_collection_0/combined_p_internal v3_four_channel_bias_reference_distribution_0/v3_four_channel_phase_distribution_0/v3_four_channel_output_collection_0/v3_four_channel_placement_0/v3_channel_selector_late_promotion_3/v3_selector_route_pilot_0/group3_lo_p v3_four_channel_bias_reference_distribution_0/v3_four_channel_phase_distribution_0/v3_four_channel_output_collection_0/v3_four_channel_placement_0/v3_channel_selector_late_promotion_3/v3_channel_input_bias_late_promotion_0/a_5646_22978# VSUBS sky130_fd_pr__nfet_01v8 ad=0 pd=0 as=0 ps=0 w=0.65 l=0.15
X1052 v3_four_channel_bias_reference_distribution_0/v3_four_channel_phase_distribution_0/v3_four_channel_output_collection_0/v3_four_channel_placement_0/v3_channel_selector_late_promotion_3/v3_channel_input_bias_late_promotion_0/a_5824_6978# v3_tail_bias_support_block_0/vbias VSUBS VSUBS sky130_fd_pr__nfet_01v8 ad=0 pd=0 as=0 ps=0 w=5.07 l=1
X1053 v3_four_channel_bias_reference_distribution_0/v3_four_channel_phase_distribution_0/v3_four_channel_output_collection_0/v3_four_channel_placement_0/v3_channel_selector_late_promotion_3/v3_channel_input_bias_late_promotion_0/a_4432_10978# v3_vcm_support_block_0/ref v3_four_channel_bias_reference_distribution_0/v3_four_channel_phase_distribution_0/v3_four_channel_output_collection_0/v3_four_channel_placement_0/v3_channel_selector_late_promotion_3/v3_channel_input_bias_late_promotion_0/a_4254_10978# VSUBS sky130_fd_pr__nfet_01v8 ad=1.9575 pd=15.24 as=0 ps=0 w=0.84 l=0.6
X1054 v3_four_channel_bias_reference_distribution_0/v3_four_channel_phase_distribution_0/v3_four_channel_output_collection_0/v3_four_channel_placement_0/v3_channel_selector_late_promotion_3/v3_channel_input_bias_late_promotion_0/a_4678_11422# v3_four_channel_bias_reference_distribution_0/v3_four_channel_phase_distribution_0/v3_four_channel_output_collection_0/v3_four_channel_placement_0/v3_channel_selector_late_promotion_3/v3_selector_route_pilot_0/group2_lo_p v3_four_channel_bias_reference_distribution_0/v3_four_channel_phase_distribution_0/v3_four_channel_output_collection_0/combined_p_internal VSUBS sky130_fd_pr__nfet_01v8 ad=0.6206 pd=6.02 as=0 ps=0 w=0.65 l=0.15
X1055 v3_four_channel_bias_reference_distribution_0/v3_four_channel_phase_distribution_0/v3_four_channel_output_collection_0/v3_four_channel_placement_0/v3_channel_selector_late_promotion_3/v3_channel_input_bias_late_promotion_0/a_6070_23422# v3_four_channel_bias_reference_distribution_0/v3_four_channel_phase_distribution_0/v3_four_channel_output_collection_0/v3_four_channel_placement_0/v3_channel_selector_late_promotion_3/v3_selector_route_pilot_0/group3_lo_n v3_four_channel_bias_reference_distribution_0/v3_four_channel_phase_distribution_0/v3_four_channel_output_collection_0/combined_p_internal VSUBS sky130_fd_pr__nfet_01v8 ad=0.6206 pd=6.02 as=0 ps=0 w=0.65 l=0.15
X1056 v3_four_channel_bias_reference_distribution_0/v3_four_channel_phase_distribution_0/v3_four_channel_output_collection_0/combined_n_internal v3_four_channel_bias_reference_distribution_0/v3_four_channel_phase_distribution_0/v3_four_channel_output_collection_0/v3_four_channel_placement_0/v3_channel_selector_late_promotion_3/v3_selector_route_pilot_0/group1_lo_n v3_four_channel_bias_reference_distribution_0/v3_four_channel_phase_distribution_0/v3_four_channel_output_collection_0/v3_four_channel_placement_0/v3_channel_selector_late_promotion_3/v3_channel_input_bias_late_promotion_0/a_4254_14978# VSUBS sky130_fd_pr__nfet_01v8 ad=0 pd=0 as=0 ps=0 w=0.65 l=0.15
X1057 v3_four_channel_bias_reference_distribution_0/v3_four_channel_phase_distribution_0/v3_four_channel_output_collection_0/combined_p_internal v3_four_channel_bias_reference_distribution_0/v3_four_channel_phase_distribution_0/v3_four_channel_output_collection_0/v3_four_channel_placement_0/v3_channel_selector_late_promotion_3/v3_selector_route_pilot_0/group2_lo_n v3_four_channel_bias_reference_distribution_0/v3_four_channel_phase_distribution_0/v3_four_channel_output_collection_0/v3_four_channel_placement_0/v3_channel_selector_late_promotion_3/v3_channel_input_bias_late_promotion_0/a_7038_10978# VSUBS sky130_fd_pr__nfet_01v8 ad=0 pd=0 as=0.6206 ps=6.02 w=0.65 l=0.15
X1058 v3_four_channel_bias_reference_distribution_0/v3_four_channel_phase_distribution_0/v3_four_channel_output_collection_0/v3_four_channel_placement_0/v3_channel_selector_late_promotion_3/v3_channel_input_bias_late_promotion_0/a_7462_15422# v3_four_channel_bias_reference_distribution_0/v3_four_channel_phase_distribution_0/v3_four_channel_output_collection_0/v3_four_channel_placement_0/v3_channel_selector_late_promotion_3/v3_selector_route_pilot_0/group1_lo_p v3_four_channel_bias_reference_distribution_0/v3_four_channel_phase_distribution_0/v3_four_channel_output_collection_0/combined_p_internal VSUBS sky130_fd_pr__nfet_01v8 ad=0.6206 pd=6.02 as=0 ps=0 w=0.65 l=0.15
X1059 VSUBS VSUBS VSUBS VSUBS sky130_fd_pr__nfet_01v8 ad=0 pd=0 as=0 ps=0 w=5.07 l=1
X1060 v3_four_channel_bias_reference_distribution_0/v3_four_channel_phase_distribution_0/v3_four_channel_output_collection_0/v3_four_channel_placement_0/v3_channel_selector_late_promotion_3/v3_channel_input_bias_late_promotion_0/a_7216_6978# v3_tail_bias_support_block_0/vbias VSUBS VSUBS sky130_fd_pr__nfet_01v8 ad=1.9575 pd=15.24 as=0 ps=0 w=5.07 l=1
X1061 v3_four_channel_bias_reference_distribution_0/v3_four_channel_phase_distribution_0/v3_four_channel_output_collection_0/v3_four_channel_placement_0/v3_channel_selector_late_promotion_3/v3_channel_input_bias_late_promotion_0/a_7216_10978# v3_vcm_support_block_0/ref v3_four_channel_bias_reference_distribution_0/v3_four_channel_phase_distribution_0/v3_four_channel_output_collection_0/v3_four_channel_placement_0/v3_channel_selector_late_promotion_3/v3_channel_input_bias_late_promotion_0/a_7038_10978# VSUBS sky130_fd_pr__nfet_01v8 ad=0 pd=0 as=0 ps=0 w=0.84 l=0.6
X1062 v3_four_channel_bias_reference_distribution_0/v3_four_channel_phase_distribution_0/v3_four_channel_output_collection_0/v3_four_channel_placement_0/v3_channel_selector_late_promotion_3/v3_channel_input_bias_late_promotion_0/a_4678_15422# v3_vcm_support_block_0/ref v3_four_channel_bias_reference_distribution_0/v3_four_channel_phase_distribution_0/v3_four_channel_output_collection_0/v3_four_channel_placement_0/v3_channel_selector_late_promotion_3/v3_channel_input_bias_late_promotion_0/a_4382_13688# VSUBS sky130_fd_pr__nfet_01v8 ad=0 pd=0 as=0 ps=0 w=0.84 l=0.6
X1063 v3_four_channel_bias_reference_distribution_0/v3_four_channel_phase_distribution_0/v3_four_channel_output_collection_0/v3_four_channel_placement_0/v3_channel_selector_late_promotion_3/v3_channel_input_bias_late_promotion_0/a_4678_15422# v3_four_channel_bias_reference_distribution_0/v3_four_channel_phase_distribution_0/v3_four_channel_output_collection_0/v3_four_channel_placement_0/v3_channel_selector_late_promotion_3/v3_selector_route_pilot_0/group1_lo_p v3_four_channel_bias_reference_distribution_0/v3_four_channel_phase_distribution_0/v3_four_channel_output_collection_0/combined_n_internal VSUBS sky130_fd_pr__nfet_01v8 ad=0 pd=0 as=0 ps=0 w=0.65 l=0.15
X1064 v3_four_channel_bias_reference_distribution_0/v3_four_channel_phase_distribution_0/v3_four_channel_output_collection_0/combined_p_internal v3_four_channel_bias_reference_distribution_0/v3_four_channel_phase_distribution_0/v3_four_channel_output_collection_0/v3_four_channel_placement_0/v3_channel_selector_late_promotion_3/v3_selector_route_pilot_0/group3_lo_p v3_four_channel_bias_reference_distribution_0/v3_four_channel_phase_distribution_0/v3_four_channel_output_collection_0/v3_four_channel_placement_0/v3_channel_selector_late_promotion_3/v3_channel_input_bias_late_promotion_0/a_4254_22978# VSUBS sky130_fd_pr__nfet_01v8 ad=0 pd=0 as=0.6206 ps=6.02 w=0.65 l=0.15
X1065 v3_four_channel_bias_reference_distribution_0/v3_four_channel_phase_distribution_0/v3_four_channel_output_collection_0/v3_four_channel_placement_0/v3_channel_selector_late_promotion_3/v3_channel_input_bias_late_promotion_0/a_7462_19422# v3_vcm_support_block_0/ref v3_four_channel_bias_reference_distribution_0/v3_four_channel_phase_distribution_0/v3_four_channel_output_collection_0/v3_four_channel_placement_0/v3_channel_selector_late_promotion_3/v3_channel_input_bias_late_promotion_0/a_7166_17688# VSUBS sky130_fd_pr__nfet_01v8 ad=0 pd=0 as=0 ps=0 w=0.84 l=0.6
X1066 v3_four_channel_bias_reference_distribution_0/v3_four_channel_phase_distribution_0/v3_four_channel_output_collection_0/combined_n_internal v3_four_channel_bias_reference_distribution_0/v3_four_channel_phase_distribution_0/v3_four_channel_output_collection_0/v3_four_channel_placement_0/v3_channel_selector_late_promotion_3/v3_selector_route_pilot_0/group3_lo_p v3_four_channel_bias_reference_distribution_0/v3_four_channel_phase_distribution_0/v3_four_channel_output_collection_0/v3_four_channel_placement_0/v3_channel_selector_late_promotion_3/v3_channel_input_bias_late_promotion_0/a_5646_10978# VSUBS sky130_fd_pr__nfet_01v8 ad=0 pd=0 as=0 ps=0 w=0.65 l=0.15
X1067 v3_four_channel_bias_reference_distribution_0/v3_four_channel_phase_distribution_0/v3_four_channel_output_collection_0/combined_n_internal v3_four_channel_bias_reference_distribution_0/v3_four_channel_phase_distribution_0/v3_four_channel_output_collection_0/v3_four_channel_placement_0/v3_channel_selector_late_promotion_3/v3_selector_route_pilot_0/group1_lo_p v3_four_channel_bias_reference_distribution_0/v3_four_channel_phase_distribution_0/v3_four_channel_output_collection_0/v3_four_channel_placement_0/v3_channel_selector_late_promotion_3/v3_channel_input_bias_late_promotion_0/a_7038_14978# VSUBS sky130_fd_pr__nfet_01v8 ad=0 pd=0 as=0 ps=0 w=0.65 l=0.15
X1068 v3_four_channel_bias_reference_distribution_0/v3_four_channel_phase_distribution_0/v3_four_channel_output_collection_0/v3_four_channel_placement_0/v3_channel_selector_late_promotion_3/v3_channel_input_bias_late_promotion_0/a_7462_19422# v3_four_channel_bias_reference_distribution_0/v3_four_channel_phase_distribution_0/v3_four_channel_output_collection_0/v3_four_channel_placement_0/v3_channel_selector_late_promotion_3/v3_selector_route_pilot_0/group2_lo_p v3_four_channel_bias_reference_distribution_0/v3_four_channel_phase_distribution_0/v3_four_channel_output_collection_0/combined_n_internal VSUBS sky130_fd_pr__nfet_01v8 ad=0 pd=0 as=0 ps=0 w=0.65 l=0.15
X1069 v3_four_channel_bias_reference_distribution_0/v3_four_channel_phase_distribution_0/v3_four_channel_output_collection_0/v3_four_channel_placement_0/v3_channel_selector_late_promotion_3/v3_channel_input_bias_late_promotion_0/a_4678_7422# v3_four_channel_bias_reference_distribution_0/v3_four_channel_phase_distribution_0/v3_four_channel_output_collection_0/v3_four_channel_placement_0/v3_channel_selector_late_promotion_3/element_input v3_four_channel_bias_reference_distribution_0/v3_four_channel_phase_distribution_0/v3_four_channel_output_collection_0/v3_four_channel_placement_0/v3_channel_selector_late_promotion_3/v3_channel_input_bias_late_promotion_0/a_4432_6978# VSUBS sky130_fd_pr__nfet_01v8 ad=0 pd=0 as=1.9575 ps=15.24 w=0.84 l=0.6
X1070 v3_four_channel_bias_reference_distribution_0/v3_four_channel_phase_distribution_0/v3_four_channel_output_collection_0/combined_p_internal v3_four_channel_bias_reference_distribution_0/v3_four_channel_phase_distribution_0/v3_four_channel_output_collection_0/v3_four_channel_placement_0/v3_channel_selector_late_promotion_3/v3_selector_route_pilot_0/group3_lo_n v3_four_channel_bias_reference_distribution_0/v3_four_channel_phase_distribution_0/v3_four_channel_output_collection_0/v3_four_channel_placement_0/v3_channel_selector_late_promotion_3/v3_channel_input_bias_late_promotion_0/a_5646_6978# VSUBS sky130_fd_pr__nfet_01v8 ad=0 pd=0 as=0 ps=0 w=0.65 l=0.15
X1071 v3_four_channel_bias_reference_distribution_0/v3_four_channel_phase_distribution_0/v3_four_channel_output_collection_0/v3_four_channel_placement_0/v3_channel_selector_late_promotion_3/v3_channel_input_bias_late_promotion_0/a_4678_7422# v3_four_channel_bias_reference_distribution_0/v3_four_channel_phase_distribution_0/v3_four_channel_output_collection_0/v3_four_channel_placement_0/v3_channel_selector_late_promotion_3/v3_selector_route_pilot_0/group3_lo_n v3_four_channel_bias_reference_distribution_0/v3_four_channel_phase_distribution_0/v3_four_channel_output_collection_0/combined_n_internal VSUBS sky130_fd_pr__nfet_01v8 ad=0 pd=0 as=0 ps=0 w=0.65 l=0.15
X1072 v3_four_channel_bias_reference_distribution_0/v3_four_channel_phase_distribution_0/v3_four_channel_output_collection_0/v3_four_channel_placement_0/v3_channel_selector_late_promotion_3/v3_channel_input_bias_late_promotion_0/a_6070_11422# v3_four_channel_bias_reference_distribution_0/v3_four_channel_phase_distribution_0/v3_four_channel_output_collection_0/v3_four_channel_placement_0/v3_channel_selector_late_promotion_3/element_input v3_four_channel_bias_reference_distribution_0/v3_four_channel_phase_distribution_0/v3_four_channel_output_collection_0/v3_four_channel_placement_0/v3_channel_selector_late_promotion_3/v3_channel_input_bias_late_promotion_0/a_5824_10978# VSUBS sky130_fd_pr__nfet_01v8 ad=0 pd=0 as=0 ps=0 w=0.84 l=0.6
X1073 v3_four_channel_bias_reference_distribution_0/v3_four_channel_phase_distribution_0/v3_four_channel_output_collection_0/v3_four_channel_placement_0/v3_channel_selector_late_promotion_3/v3_channel_input_bias_late_promotion_0/a_6070_11422# v3_four_channel_bias_reference_distribution_0/v3_four_channel_phase_distribution_0/v3_four_channel_output_collection_0/v3_four_channel_placement_0/v3_channel_selector_late_promotion_3/v3_selector_route_pilot_0/group3_lo_n v3_four_channel_bias_reference_distribution_0/v3_four_channel_phase_distribution_0/v3_four_channel_output_collection_0/combined_n_internal VSUBS sky130_fd_pr__nfet_01v8 ad=0 pd=0 as=0 ps=0 w=0.65 l=0.15
X1074 v3_four_channel_bias_reference_distribution_0/v3_four_channel_phase_distribution_0/v3_four_channel_output_collection_0/v3_four_channel_placement_0/v3_channel_selector_late_promotion_3/v3_channel_input_bias_late_promotion_0/a_4382_21688# v3_four_channel_bias_reference_distribution_0/v3_four_channel_phase_distribution_0/v3_four_channel_output_collection_0/v3_four_channel_placement_0/v3_channel_selector_late_promotion_3/element_input v3_four_channel_bias_reference_distribution_0/v3_four_channel_phase_distribution_0/v3_four_channel_output_collection_0/v3_four_channel_placement_0/v3_channel_selector_late_promotion_3/v3_channel_input_bias_late_promotion_0/a_4254_22978# VSUBS sky130_fd_pr__nfet_01v8 ad=0 pd=0 as=0 ps=0 w=0.84 l=0.6
X1075 v3_four_channel_bias_reference_distribution_0/v3_four_channel_phase_distribution_0/v3_four_channel_output_collection_0/v3_four_channel_placement_0/v3_channel_selector_late_promotion_3/v3_channel_input_bias_late_promotion_0/a_4678_23422# v3_four_channel_bias_reference_distribution_0/v3_four_channel_phase_distribution_0/v3_four_channel_output_collection_0/v3_four_channel_placement_0/v3_channel_selector_late_promotion_3/v3_selector_route_pilot_0/group3_lo_n v3_four_channel_bias_reference_distribution_0/v3_four_channel_phase_distribution_0/v3_four_channel_output_collection_0/combined_p_internal VSUBS sky130_fd_pr__nfet_01v8 ad=0 pd=0 as=0 ps=0 w=0.65 l=0.15
X1076 v3_four_channel_bias_reference_distribution_0/v3_four_channel_phase_distribution_0/v3_four_channel_output_collection_0/combined_p_internal v3_four_channel_bias_reference_distribution_0/v3_four_channel_phase_distribution_0/v3_four_channel_output_collection_0/v3_four_channel_placement_0/v3_channel_selector_late_promotion_3/v3_selector_route_pilot_0/group3_lo_n v3_four_channel_bias_reference_distribution_0/v3_four_channel_phase_distribution_0/v3_four_channel_output_collection_0/v3_four_channel_placement_0/v3_channel_selector_late_promotion_3/v3_channel_input_bias_late_promotion_0/a_4254_6978# VSUBS sky130_fd_pr__nfet_01v8 ad=0 pd=0 as=0 ps=0 w=0.65 l=0.15
X1077 v3_four_channel_bias_reference_distribution_0/v3_four_channel_phase_distribution_0/v3_four_channel_output_collection_0/v3_four_channel_placement_0/v3_channel_selector_late_promotion_3/v3_channel_input_bias_late_promotion_0/a_5774_13688# v3_four_channel_bias_reference_distribution_0/v3_four_channel_phase_distribution_0/v3_four_channel_output_collection_0/v3_four_channel_placement_0/v3_channel_selector_late_promotion_3/element_input v3_four_channel_bias_reference_distribution_0/v3_four_channel_phase_distribution_0/v3_four_channel_output_collection_0/v3_four_channel_placement_0/v3_channel_selector_late_promotion_3/v3_channel_input_bias_late_promotion_0/a_5646_14978# VSUBS sky130_fd_pr__nfet_01v8 ad=0 pd=0 as=0 ps=0 w=0.84 l=0.6
X1078 v3_four_channel_bias_reference_distribution_0/v3_four_channel_phase_distribution_0/v3_four_channel_output_collection_0/combined_p_internal v3_four_channel_bias_reference_distribution_0/v3_four_channel_phase_distribution_0/v3_four_channel_output_collection_0/v3_four_channel_placement_0/v3_channel_selector_late_promotion_3/v3_selector_route_pilot_0/group3_lo_p v3_four_channel_bias_reference_distribution_0/v3_four_channel_phase_distribution_0/v3_four_channel_output_collection_0/v3_four_channel_placement_0/v3_channel_selector_late_promotion_3/v3_channel_input_bias_late_promotion_0/a_7038_22978# VSUBS sky130_fd_pr__nfet_01v8 ad=0 pd=0 as=0 ps=0 w=0.65 l=0.15
X1079 v3_four_channel_bias_reference_distribution_0/v3_four_channel_phase_distribution_0/v3_four_channel_output_collection_0/v3_four_channel_placement_0/v3_channel_selector_late_promotion_3/v3_channel_input_bias_late_promotion_0/a_7462_7422# v3_four_channel_bias_reference_distribution_0/v3_four_channel_phase_distribution_0/v3_four_channel_output_collection_0/v3_four_channel_placement_0/v3_channel_selector_late_promotion_3/element_input v3_four_channel_bias_reference_distribution_0/v3_four_channel_phase_distribution_0/v3_four_channel_output_collection_0/v3_four_channel_placement_0/v3_channel_selector_late_promotion_3/v3_channel_input_bias_late_promotion_0/a_7216_6978# VSUBS sky130_fd_pr__nfet_01v8 ad=0 pd=0 as=0 ps=0 w=0.84 l=0.6
X1080 v3_four_channel_bias_reference_distribution_0/v3_four_channel_phase_distribution_0/v3_four_channel_output_collection_0/v3_four_channel_placement_0/v3_channel_selector_late_promotion_3/v3_channel_input_bias_late_promotion_0/a_4432_10978# v3_tail_bias_support_block_0/vbias VSUBS VSUBS sky130_fd_pr__nfet_01v8 ad=0 pd=0 as=0 ps=0 w=5.07 l=1
X1081 v3_four_channel_bias_reference_distribution_0/v3_four_channel_phase_distribution_0/v3_four_channel_output_collection_0/v3_four_channel_placement_0/v3_channel_selector_late_promotion_3/v3_channel_input_bias_late_promotion_0/a_7462_7422# v3_four_channel_bias_reference_distribution_0/v3_four_channel_phase_distribution_0/v3_four_channel_output_collection_0/v3_four_channel_placement_0/v3_channel_selector_late_promotion_3/v3_selector_route_pilot_0/group3_lo_n v3_four_channel_bias_reference_distribution_0/v3_four_channel_phase_distribution_0/v3_four_channel_output_collection_0/combined_n_internal VSUBS sky130_fd_pr__nfet_01v8 ad=0 pd=0 as=0 ps=0 w=0.65 l=0.15
X1082 VSUBS v3_tail_bias_support_block_0/vbias v3_four_channel_bias_reference_distribution_0/v3_four_channel_phase_distribution_0/v3_four_channel_output_collection_0/v3_four_channel_placement_0/v3_channel_selector_late_promotion_3/v3_channel_input_bias_late_promotion_0/a_4382_17688# VSUBS sky130_fd_pr__nfet_01v8 ad=0 pd=0 as=0 ps=0 w=5.07 l=1
X1083 v3_four_channel_bias_reference_distribution_0/v3_four_channel_phase_distribution_0/v3_four_channel_output_collection_0/combined_p_internal v3_four_channel_bias_reference_distribution_0/v3_four_channel_phase_distribution_0/v3_four_channel_output_collection_0/v3_four_channel_placement_0/v3_channel_selector_late_promotion_3/v3_selector_route_pilot_0/group3_lo_n v3_four_channel_bias_reference_distribution_0/v3_four_channel_phase_distribution_0/v3_four_channel_output_collection_0/v3_four_channel_placement_0/v3_channel_selector_late_promotion_3/v3_channel_input_bias_late_promotion_0/a_7038_6978# VSUBS sky130_fd_pr__nfet_01v8 ad=0 pd=0 as=0 ps=0 w=0.65 l=0.15
X1084 v3_four_channel_bias_reference_distribution_0/v3_four_channel_phase_distribution_0/v3_four_channel_output_collection_0/combined_n_internal v3_four_channel_bias_reference_distribution_0/v3_four_channel_phase_distribution_0/v3_four_channel_output_collection_0/v3_four_channel_placement_0/v3_channel_selector_late_promotion_3/v3_selector_route_pilot_0/group2_lo_p v3_four_channel_bias_reference_distribution_0/v3_four_channel_phase_distribution_0/v3_four_channel_output_collection_0/v3_four_channel_placement_0/v3_channel_selector_late_promotion_3/v3_channel_input_bias_late_promotion_0/a_4254_10978# VSUBS sky130_fd_pr__nfet_01v8 ad=0 pd=0 as=0 ps=0 w=0.65 l=0.15
X1085 v3_four_channel_bias_reference_distribution_0/v3_four_channel_phase_distribution_0/v3_four_channel_output_collection_0/v3_four_channel_placement_0/v3_channel_selector_late_promotion_3/v3_channel_input_bias_late_promotion_0/a_7462_11422# v3_four_channel_bias_reference_distribution_0/v3_four_channel_phase_distribution_0/v3_four_channel_output_collection_0/v3_four_channel_placement_0/v3_channel_selector_late_promotion_3/v3_selector_route_pilot_0/group2_lo_p v3_four_channel_bias_reference_distribution_0/v3_four_channel_phase_distribution_0/v3_four_channel_output_collection_0/combined_p_internal VSUBS sky130_fd_pr__nfet_01v8 ad=0 pd=0 as=0 ps=0 w=0.65 l=0.15
X1086 v3_four_channel_bias_reference_distribution_0/v3_four_channel_phase_distribution_0/v3_four_channel_output_collection_0/v3_four_channel_placement_0/v3_channel_selector_late_promotion_3/v3_channel_input_bias_late_promotion_0/a_7166_21688# v3_four_channel_bias_reference_distribution_0/v3_four_channel_phase_distribution_0/v3_four_channel_output_collection_0/v3_four_channel_placement_0/v3_channel_selector_late_promotion_3/element_input v3_four_channel_bias_reference_distribution_0/v3_four_channel_phase_distribution_0/v3_four_channel_output_collection_0/v3_four_channel_placement_0/v3_channel_selector_late_promotion_3/v3_channel_input_bias_late_promotion_0/a_7038_22978# VSUBS sky130_fd_pr__nfet_01v8 ad=0 pd=0 as=0 ps=0 w=0.84 l=0.6
X1087 v3_four_channel_bias_reference_distribution_0/v3_four_channel_phase_distribution_0/v3_four_channel_output_collection_0/combined_n_internal v3_four_channel_bias_reference_distribution_0/v3_four_channel_phase_distribution_0/v3_four_channel_output_collection_0/v3_four_channel_placement_0/v3_channel_selector_late_promotion_3/v3_selector_route_pilot_0/group3_lo_n v3_four_channel_bias_reference_distribution_0/v3_four_channel_phase_distribution_0/v3_four_channel_output_collection_0/v3_four_channel_placement_0/v3_channel_selector_late_promotion_3/v3_channel_input_bias_late_promotion_0/a_5646_22978# VSUBS sky130_fd_pr__nfet_01v8 ad=0 pd=0 as=0 ps=0 w=0.65 l=0.15
X1088 v3_four_channel_bias_reference_distribution_0/v3_four_channel_phase_distribution_0/v3_four_channel_output_collection_0/v3_four_channel_placement_0/v3_channel_selector_late_promotion_3/v3_channel_input_bias_late_promotion_0/a_4678_11422# v3_four_channel_bias_reference_distribution_0/v3_four_channel_phase_distribution_0/v3_four_channel_output_collection_0/v3_four_channel_placement_0/v3_channel_selector_late_promotion_3/element_input v3_four_channel_bias_reference_distribution_0/v3_four_channel_phase_distribution_0/v3_four_channel_output_collection_0/v3_four_channel_placement_0/v3_channel_selector_late_promotion_3/v3_channel_input_bias_late_promotion_0/a_4432_10978# VSUBS sky130_fd_pr__nfet_01v8 ad=0 pd=0 as=0 ps=0 w=0.84 l=0.6
X1089 v3_four_channel_bias_reference_distribution_0/v3_four_channel_phase_distribution_0/v3_four_channel_output_collection_0/v3_four_channel_placement_0/v3_channel_selector_late_promotion_3/v3_channel_input_bias_late_promotion_0/a_6070_23422# v3_vcm_support_block_0/ref v3_four_channel_bias_reference_distribution_0/v3_four_channel_phase_distribution_0/v3_four_channel_output_collection_0/v3_four_channel_placement_0/v3_channel_selector_late_promotion_3/v3_channel_input_bias_late_promotion_0/a_5774_21688# VSUBS sky130_fd_pr__nfet_01v8 ad=0 pd=0 as=0 ps=0 w=0.84 l=0.6
X1090 v3_four_channel_bias_reference_distribution_0/v3_four_channel_phase_distribution_0/v3_four_channel_output_collection_0/v3_four_channel_placement_0/v3_channel_selector_late_promotion_3/v3_channel_input_bias_late_promotion_0/a_6070_23422# v3_four_channel_bias_reference_distribution_0/v3_four_channel_phase_distribution_0/v3_four_channel_output_collection_0/v3_four_channel_placement_0/v3_channel_selector_late_promotion_3/v3_selector_route_pilot_0/group3_lo_p v3_four_channel_bias_reference_distribution_0/v3_four_channel_phase_distribution_0/v3_four_channel_output_collection_0/combined_n_internal VSUBS sky130_fd_pr__nfet_01v8 ad=0 pd=0 as=0 ps=0 w=0.65 l=0.15
X1091 v3_four_channel_bias_reference_distribution_0/v3_four_channel_phase_distribution_0/v3_four_channel_output_collection_0/v3_four_channel_placement_0/v3_channel_selector_late_promotion_3/v3_channel_input_bias_late_promotion_0/a_4678_11422# v3_four_channel_bias_reference_distribution_0/v3_four_channel_phase_distribution_0/v3_four_channel_output_collection_0/v3_four_channel_placement_0/v3_channel_selector_late_promotion_3/v3_selector_route_pilot_0/group2_lo_n v3_four_channel_bias_reference_distribution_0/v3_four_channel_phase_distribution_0/v3_four_channel_output_collection_0/combined_n_internal VSUBS sky130_fd_pr__nfet_01v8 ad=0 pd=0 as=0 ps=0 w=0.65 l=0.15
X1092 v3_four_channel_bias_reference_distribution_0/v3_four_channel_phase_distribution_0/v3_four_channel_output_collection_0/v3_four_channel_placement_0/v3_channel_selector_late_promotion_3/v3_channel_input_bias_late_promotion_0/a_7462_15422# v3_four_channel_bias_reference_distribution_0/v3_four_channel_phase_distribution_0/v3_four_channel_output_collection_0/v3_four_channel_placement_0/v3_channel_selector_late_promotion_3/element_input v3_four_channel_bias_reference_distribution_0/v3_four_channel_phase_distribution_0/v3_four_channel_output_collection_0/v3_four_channel_placement_0/v3_channel_selector_late_promotion_3/v3_channel_input_bias_late_promotion_0/a_7216_14978# VSUBS sky130_fd_pr__nfet_01v8 ad=0 pd=0 as=0 ps=0 w=0.84 l=0.6
X1093 v3_four_channel_bias_reference_distribution_0/v3_four_channel_phase_distribution_0/v3_four_channel_output_collection_0/v3_four_channel_placement_0/v3_channel_selector_late_promotion_3/v3_channel_input_bias_late_promotion_0/a_6070_7422# v3_four_channel_bias_reference_distribution_0/v3_four_channel_phase_distribution_0/v3_four_channel_output_collection_0/v3_four_channel_placement_0/v3_channel_selector_late_promotion_3/v3_selector_route_pilot_0/group3_lo_p v3_four_channel_bias_reference_distribution_0/v3_four_channel_phase_distribution_0/v3_four_channel_output_collection_0/combined_p_internal VSUBS sky130_fd_pr__nfet_01v8 ad=0 pd=0 as=0 ps=0 w=0.65 l=0.15
X1094 v3_four_channel_bias_reference_distribution_0/v3_four_channel_phase_distribution_0/v3_four_channel_output_collection_0/combined_n_internal v3_four_channel_bias_reference_distribution_0/v3_four_channel_phase_distribution_0/v3_four_channel_output_collection_0/v3_four_channel_placement_0/v3_channel_selector_late_promotion_3/v3_selector_route_pilot_0/group2_lo_p v3_four_channel_bias_reference_distribution_0/v3_four_channel_phase_distribution_0/v3_four_channel_output_collection_0/v3_four_channel_placement_0/v3_channel_selector_late_promotion_3/v3_channel_input_bias_late_promotion_0/a_7038_10978# VSUBS sky130_fd_pr__nfet_01v8 ad=0 pd=0 as=0 ps=0 w=0.65 l=0.15
X1095 v3_four_channel_bias_reference_distribution_0/v3_four_channel_phase_distribution_0/v3_four_channel_output_collection_0/v3_four_channel_placement_0/v3_channel_selector_late_promotion_3/v3_channel_input_bias_late_promotion_0/a_7462_15422# v3_four_channel_bias_reference_distribution_0/v3_four_channel_phase_distribution_0/v3_four_channel_output_collection_0/v3_four_channel_placement_0/v3_channel_selector_late_promotion_3/v3_selector_route_pilot_0/group1_lo_n v3_four_channel_bias_reference_distribution_0/v3_four_channel_phase_distribution_0/v3_four_channel_output_collection_0/combined_n_internal VSUBS sky130_fd_pr__nfet_01v8 ad=0 pd=0 as=0 ps=0 w=0.65 l=0.15
X1096 v3_four_channel_bias_reference_distribution_0/v3_four_channel_phase_distribution_0/v3_four_channel_output_collection_0/v3_four_channel_placement_0/v3_channel_selector_late_promotion_3/v3_channel_input_bias_late_promotion_0/a_4432_6978# v3_vcm_support_block_0/ref v3_four_channel_bias_reference_distribution_0/v3_four_channel_phase_distribution_0/v3_four_channel_output_collection_0/v3_four_channel_placement_0/v3_channel_selector_late_promotion_3/v3_channel_input_bias_late_promotion_0/a_4254_6978# VSUBS sky130_fd_pr__nfet_01v8 ad=0 pd=0 as=0 ps=0 w=0.84 l=0.6
X1097 v3_four_channel_bias_reference_distribution_0/v3_four_channel_phase_distribution_0/v3_four_channel_output_collection_0/v3_four_channel_placement_0/v3_channel_selector_late_promotion_3/v3_channel_input_bias_late_promotion_0/a_5824_10978# v3_vcm_support_block_0/ref v3_four_channel_bias_reference_distribution_0/v3_four_channel_phase_distribution_0/v3_four_channel_output_collection_0/v3_four_channel_placement_0/v3_channel_selector_late_promotion_3/v3_channel_input_bias_late_promotion_0/a_5646_10978# VSUBS sky130_fd_pr__nfet_01v8 ad=0 pd=0 as=0 ps=0 w=0.84 l=0.6
X1098 v3_four_channel_bias_reference_distribution_0/v3_four_channel_phase_distribution_0/v3_four_channel_output_collection_0/combined_n_internal v3_four_channel_bias_reference_distribution_0/v3_four_channel_phase_distribution_0/v3_four_channel_output_collection_0/v3_four_channel_placement_0/v3_channel_selector_late_promotion_3/v3_selector_route_pilot_0/group3_lo_n v3_four_channel_bias_reference_distribution_0/v3_four_channel_phase_distribution_0/v3_four_channel_output_collection_0/v3_four_channel_placement_0/v3_channel_selector_late_promotion_3/v3_channel_input_bias_late_promotion_0/a_4254_22978# VSUBS sky130_fd_pr__nfet_01v8 ad=0 pd=0 as=0 ps=0 w=0.65 l=0.15
X1099 v3_four_channel_bias_reference_distribution_0/v3_four_channel_phase_distribution_0/v3_four_channel_output_collection_0/v3_four_channel_placement_0/v3_channel_selector_late_promotion_3/v3_channel_input_bias_late_promotion_0/a_7462_23422# v3_four_channel_bias_reference_distribution_0/v3_four_channel_phase_distribution_0/v3_four_channel_output_collection_0/v3_four_channel_placement_0/v3_channel_selector_late_promotion_3/v3_selector_route_pilot_0/group3_lo_n v3_four_channel_bias_reference_distribution_0/v3_four_channel_phase_distribution_0/v3_four_channel_output_collection_0/combined_p_internal VSUBS sky130_fd_pr__nfet_01v8 ad=0 pd=0 as=0 ps=0 w=0.65 l=0.15
X1100 v3_four_channel_bias_reference_distribution_0/v3_four_channel_phase_distribution_0/v3_four_channel_output_collection_0/v3_four_channel_placement_0/v3_channel_selector_late_promotion_3/v3_channel_input_bias_late_promotion_0/a_4432_6978# v3_tail_bias_support_block_0/vbias VSUBS VSUBS sky130_fd_pr__nfet_01v8 ad=0 pd=0 as=0 ps=0 w=5.07 l=1
X1101 v3_four_channel_bias_reference_distribution_0/v3_four_channel_phase_distribution_0/v3_four_channel_output_collection_0/v3_four_channel_placement_0/v3_channel_selector_late_promotion_3/v3_channel_input_bias_late_promotion_0/a_7216_6978# v3_vcm_support_block_0/ref v3_four_channel_bias_reference_distribution_0/v3_four_channel_phase_distribution_0/v3_four_channel_output_collection_0/v3_four_channel_placement_0/v3_channel_selector_late_promotion_3/v3_channel_input_bias_late_promotion_0/a_7038_6978# VSUBS sky130_fd_pr__nfet_01v8 ad=0 pd=0 as=0 ps=0 w=0.84 l=0.6
X1102 v3_four_channel_bias_reference_distribution_0/v3_four_channel_phase_distribution_0/v3_four_channel_output_collection_0/combined_n_internal v3_four_channel_bias_reference_distribution_0/v3_four_channel_phase_distribution_0/v3_four_channel_output_collection_0/v3_four_channel_placement_0/v3_channel_selector_late_promotion_3/v3_selector_route_pilot_0/group3_lo_p v3_four_channel_bias_reference_distribution_0/v3_four_channel_phase_distribution_0/v3_four_channel_output_collection_0/v3_four_channel_placement_0/v3_channel_selector_late_promotion_3/v3_channel_input_bias_late_promotion_0/a_5646_6978# VSUBS sky130_fd_pr__nfet_01v8 ad=0 pd=0 as=0 ps=0 w=0.65 l=0.15
X1103 VSUBS v3_tail_bias_support_block_0/vbias v3_four_channel_bias_reference_distribution_0/v3_four_channel_phase_distribution_0/v3_four_channel_output_collection_0/v3_four_channel_placement_0/v3_channel_selector_late_promotion_3/v3_channel_input_bias_late_promotion_0/a_4382_13688# VSUBS sky130_fd_pr__nfet_01v8 ad=0 pd=0 as=0 ps=0 w=5.07 l=1
X1104 v3_four_channel_bias_reference_distribution_0/v3_four_channel_phase_distribution_0/v3_four_channel_output_collection_0/v3_four_channel_placement_0/v3_channel_selector_late_promotion_3/VPWR v3_four_channel_bias_reference_distribution_0/v3_four_channel_phase_distribution_0/v3_four_channel_output_collection_0/v3_four_channel_placement_0/v3_channel_selector_late_promotion_3/v3_selector_route_pilot_0/G1_MUX_POS/a_505_21# v3_four_channel_bias_reference_distribution_0/v3_four_channel_phase_distribution_0/v3_four_channel_output_collection_0/v3_four_channel_placement_0/v3_channel_selector_late_promotion_3/v3_selector_route_pilot_0/G1_MUX_POS/a_535_374# v3_four_channel_bias_reference_distribution_0/v3_four_channel_phase_distribution_0/v3_four_channel_output_collection_0/v3_four_channel_placement_0/v3_channel_selector_late_promotion_3/VPWR sky130_fd_pr__pfet_01v8_hvt ad=10.2594 pd=93.2 as=0.0882 ps=1.26 w=0.42 l=0.15
X1105 v3_four_channel_bias_reference_distribution_0/v3_four_channel_phase_distribution_0/v3_four_channel_output_collection_0/v3_four_channel_placement_0/v3_channel_selector_late_promotion_3/v3_selector_route_pilot_0/G1_MUX_POS/a_505_21# v3_four_channel_bias_reference_distribution_0/v3_four_channel_phase_distribution_0/v3_four_channel_output_collection_0/v3_four_channel_placement_0/v3_channel_selector_late_promotion_3/group1_bit0 v3_four_channel_bias_reference_distribution_0/v3_four_channel_phase_distribution_0/v3_four_channel_output_collection_0/v3_four_channel_placement_0/v3_channel_selector_late_promotion_3/VPWR v3_four_channel_bias_reference_distribution_0/v3_four_channel_phase_distribution_0/v3_four_channel_output_collection_0/v3_four_channel_placement_0/v3_channel_selector_late_promotion_3/VPWR sky130_fd_pr__pfet_01v8_hvt ad=0.1176 pd=1.4 as=0 ps=0 w=0.42 l=0.15
X1106 v3_four_channel_bias_reference_distribution_0/v3_four_channel_phase_distribution_0/v3_four_channel_output_collection_0/v3_four_channel_placement_0/v3_channel_selector_late_promotion_3/v3_selector_route_pilot_0/G1_MUX_POS/a_218_374# v3_four_channel_bias_reference_distribution_0/v3_four_channel_phase_distribution_0/v3_four_channel_output_collection_0/v3_four_channel_placement_0/v3_channel_selector_late_promotion_3/group1_bit0 v3_four_channel_bias_reference_distribution_0/v3_four_channel_phase_distribution_0/v3_four_channel_output_collection_0/v3_four_channel_placement_0/v3_channel_selector_late_promotion_3/VPWR v3_four_channel_bias_reference_distribution_0/v3_four_channel_phase_distribution_0/v3_four_channel_output_collection_0/v3_four_channel_placement_0/v3_channel_selector_late_promotion_3/VPWR sky130_fd_pr__pfet_01v8_hvt ad=0.1533 pd=1.57 as=0 ps=0 w=0.42 l=0.15
X1107 VSUBS v3_four_channel_bias_reference_distribution_0/v3_four_channel_phase_distribution_0/v3_four_channel_output_collection_0/v3_four_channel_placement_0/v3_channel_selector_late_promotion_3/v3_selector_route_pilot_0/G1_MUX_POS/a_505_21# v3_four_channel_bias_reference_distribution_0/v3_four_channel_phase_distribution_0/v3_four_channel_output_collection_0/v3_four_channel_placement_0/v3_channel_selector_late_promotion_3/v3_selector_route_pilot_0/G1_MUX_POS/a_439_47# VSUBS sky130_fd_pr__nfet_01v8 ad=0 pd=0 as=0.1386 ps=1.5 w=0.42 l=0.15
X1108 v3_four_channel_bias_reference_distribution_0/v3_four_channel_phase_distribution_0/v3_four_channel_output_collection_0/v3_four_channel_placement_0/v3_channel_selector_late_promotion_3/v3_selector_route_pilot_0/G1_MUX_POS/a_76_199# v3_four_channel_bias_reference_distribution_0/v3_four_channel_phase_distribution_0/phase_0 v3_four_channel_bias_reference_distribution_0/v3_four_channel_phase_distribution_0/v3_four_channel_output_collection_0/v3_four_channel_placement_0/v3_channel_selector_late_promotion_3/v3_selector_route_pilot_0/G1_MUX_POS/a_218_374# v3_four_channel_bias_reference_distribution_0/v3_four_channel_phase_distribution_0/v3_four_channel_output_collection_0/v3_four_channel_placement_0/v3_channel_selector_late_promotion_3/VPWR sky130_fd_pr__pfet_01v8_hvt ad=0.3864 pd=2.68 as=0 ps=0 w=0.42 l=0.15
X1109 v3_four_channel_bias_reference_distribution_0/v3_four_channel_phase_distribution_0/v3_four_channel_output_collection_0/v3_four_channel_placement_0/v3_channel_selector_late_promotion_3/v3_selector_route_pilot_0/G1_MUX_POS/a_505_21# v3_four_channel_bias_reference_distribution_0/v3_four_channel_phase_distribution_0/v3_four_channel_output_collection_0/v3_four_channel_placement_0/v3_channel_selector_late_promotion_3/group1_bit0 VSUBS VSUBS sky130_fd_pr__nfet_01v8 ad=0.1092 pd=1.36 as=0 ps=0 w=0.42 l=0.15
X1110 v3_four_channel_bias_reference_distribution_0/v3_four_channel_phase_distribution_0/v3_four_channel_output_collection_0/v3_four_channel_placement_0/v3_channel_selector_late_promotion_3/v3_selector_route_pilot_0/G1_MUX_POS/a_439_47# v3_four_channel_bias_reference_distribution_0/v3_four_channel_phase_distribution_0/phase_0 v3_four_channel_bias_reference_distribution_0/v3_four_channel_phase_distribution_0/v3_four_channel_output_collection_0/v3_four_channel_placement_0/v3_channel_selector_late_promotion_3/v3_selector_route_pilot_0/G1_MUX_POS/a_76_199# VSUBS sky130_fd_pr__nfet_01v8 ad=0 pd=0 as=0.1995 ps=1.79 w=0.42 l=0.15
X1111 v3_four_channel_bias_reference_distribution_0/v3_four_channel_phase_distribution_0/v3_four_channel_output_collection_0/v3_four_channel_placement_0/v3_channel_selector_late_promotion_3/v3_selector_route_pilot_0/G1_MUX_POS/a_535_374# v3_four_channel_bias_reference_distribution_0/v3_four_channel_phase_distribution_0/phase_90 v3_four_channel_bias_reference_distribution_0/v3_four_channel_phase_distribution_0/v3_four_channel_output_collection_0/v3_four_channel_placement_0/v3_channel_selector_late_promotion_3/v3_selector_route_pilot_0/G1_MUX_POS/a_76_199# v3_four_channel_bias_reference_distribution_0/v3_four_channel_phase_distribution_0/v3_four_channel_output_collection_0/v3_four_channel_placement_0/v3_channel_selector_late_promotion_3/VPWR sky130_fd_pr__pfet_01v8_hvt ad=0 pd=0 as=0 ps=0 w=0.42 l=0.15
X1112 v3_four_channel_bias_reference_distribution_0/v3_four_channel_phase_distribution_0/v3_four_channel_output_collection_0/v3_four_channel_placement_0/v3_channel_selector_late_promotion_3/v3_selector_route_pilot_0/G1_MUX_POS/a_76_199# v3_four_channel_bias_reference_distribution_0/v3_four_channel_phase_distribution_0/phase_90 v3_four_channel_bias_reference_distribution_0/v3_four_channel_phase_distribution_0/v3_four_channel_output_collection_0/v3_four_channel_placement_0/v3_channel_selector_late_promotion_3/v3_selector_route_pilot_0/G1_MUX_POS/a_218_47# VSUBS sky130_fd_pr__nfet_01v8 ad=0 pd=0 as=0.1386 ps=1.5 w=0.42 l=0.15
X1113 v3_four_channel_bias_reference_distribution_0/v3_four_channel_phase_distribution_0/v3_four_channel_output_collection_0/v3_four_channel_placement_0/v3_channel_selector_late_promotion_3/v3_selector_route_pilot_0/G1_MUX_POS/a_218_47# v3_four_channel_bias_reference_distribution_0/v3_four_channel_phase_distribution_0/v3_four_channel_output_collection_0/v3_four_channel_placement_0/v3_channel_selector_late_promotion_3/group1_bit0 VSUBS VSUBS sky130_fd_pr__nfet_01v8 ad=0 pd=0 as=0 ps=0 w=0.42 l=0.15
X1114 v3_four_channel_bias_reference_distribution_0/v3_four_channel_phase_distribution_0/v3_four_channel_output_collection_0/v3_four_channel_placement_0/v3_channel_selector_late_promotion_3/VPWR v3_four_channel_bias_reference_distribution_0/v3_four_channel_phase_distribution_0/v3_four_channel_output_collection_0/v3_four_channel_placement_0/v3_channel_selector_late_promotion_3/v3_selector_route_pilot_0/G1_MUX_POS/a_76_199# v3_four_channel_bias_reference_distribution_0/v3_four_channel_phase_distribution_0/v3_four_channel_output_collection_0/v3_four_channel_placement_0/v3_channel_selector_late_promotion_3/v3_selector_route_pilot_0/G1_MUX_POS/X v3_four_channel_bias_reference_distribution_0/v3_four_channel_phase_distribution_0/v3_four_channel_output_collection_0/v3_four_channel_placement_0/v3_channel_selector_late_promotion_3/VPWR sky130_fd_pr__pfet_01v8_hvt ad=0 pd=0 as=0.26 ps=2.52 w=1 l=0.15
X1115 VSUBS v3_four_channel_bias_reference_distribution_0/v3_four_channel_phase_distribution_0/v3_four_channel_output_collection_0/v3_four_channel_placement_0/v3_channel_selector_late_promotion_3/v3_selector_route_pilot_0/G1_MUX_POS/a_76_199# v3_four_channel_bias_reference_distribution_0/v3_four_channel_phase_distribution_0/v3_four_channel_output_collection_0/v3_four_channel_placement_0/v3_channel_selector_late_promotion_3/v3_selector_route_pilot_0/G1_MUX_POS/X VSUBS sky130_fd_pr__nfet_01v8 ad=0 pd=0 as=0.169 ps=1.82 w=0.65 l=0.15
X1116 v3_four_channel_bias_reference_distribution_0/v3_four_channel_phase_distribution_0/v3_four_channel_output_collection_0/v3_four_channel_placement_0/v3_channel_selector_late_promotion_3/VPWR v3_four_channel_bias_reference_distribution_0/v3_four_channel_phase_distribution_0/v3_four_channel_output_collection_0/v3_four_channel_placement_0/v3_channel_selector_late_promotion_3/v3_selector_route_pilot_0/G3_MUX_AXIS/a_505_21# v3_four_channel_bias_reference_distribution_0/v3_four_channel_phase_distribution_0/v3_four_channel_output_collection_0/v3_four_channel_placement_0/v3_channel_selector_late_promotion_3/v3_selector_route_pilot_0/G3_MUX_AXIS/a_535_374# v3_four_channel_bias_reference_distribution_0/v3_four_channel_phase_distribution_0/v3_four_channel_output_collection_0/v3_four_channel_placement_0/v3_channel_selector_late_promotion_3/VPWR sky130_fd_pr__pfet_01v8_hvt ad=0 pd=0 as=0.0882 ps=1.26 w=0.42 l=0.15
X1117 v3_four_channel_bias_reference_distribution_0/v3_four_channel_phase_distribution_0/v3_four_channel_output_collection_0/v3_four_channel_placement_0/v3_channel_selector_late_promotion_3/v3_selector_route_pilot_0/G3_MUX_AXIS/a_505_21# v3_four_channel_bias_reference_distribution_0/v3_four_channel_phase_distribution_0/v3_four_channel_output_collection_0/v3_four_channel_placement_0/v3_channel_selector_late_promotion_3/group3_bit1 v3_four_channel_bias_reference_distribution_0/v3_four_channel_phase_distribution_0/v3_four_channel_output_collection_0/v3_four_channel_placement_0/v3_channel_selector_late_promotion_3/VPWR v3_four_channel_bias_reference_distribution_0/v3_four_channel_phase_distribution_0/v3_four_channel_output_collection_0/v3_four_channel_placement_0/v3_channel_selector_late_promotion_3/VPWR sky130_fd_pr__pfet_01v8_hvt ad=0.1176 pd=1.4 as=0 ps=0 w=0.42 l=0.15
X1118 v3_four_channel_bias_reference_distribution_0/v3_four_channel_phase_distribution_0/v3_four_channel_output_collection_0/v3_four_channel_placement_0/v3_channel_selector_late_promotion_3/v3_selector_route_pilot_0/G3_MUX_AXIS/a_218_374# v3_four_channel_bias_reference_distribution_0/v3_four_channel_phase_distribution_0/v3_four_channel_output_collection_0/v3_four_channel_placement_0/v3_channel_selector_late_promotion_3/group3_bit1 v3_four_channel_bias_reference_distribution_0/v3_four_channel_phase_distribution_0/v3_four_channel_output_collection_0/v3_four_channel_placement_0/v3_channel_selector_late_promotion_3/VPWR v3_four_channel_bias_reference_distribution_0/v3_four_channel_phase_distribution_0/v3_four_channel_output_collection_0/v3_four_channel_placement_0/v3_channel_selector_late_promotion_3/VPWR sky130_fd_pr__pfet_01v8_hvt ad=0.1533 pd=1.57 as=0 ps=0 w=0.42 l=0.15
X1119 VSUBS v3_four_channel_bias_reference_distribution_0/v3_four_channel_phase_distribution_0/v3_four_channel_output_collection_0/v3_four_channel_placement_0/v3_channel_selector_late_promotion_3/v3_selector_route_pilot_0/G3_MUX_AXIS/a_505_21# v3_four_channel_bias_reference_distribution_0/v3_four_channel_phase_distribution_0/v3_four_channel_output_collection_0/v3_four_channel_placement_0/v3_channel_selector_late_promotion_3/v3_selector_route_pilot_0/G3_MUX_AXIS/a_439_47# VSUBS sky130_fd_pr__nfet_01v8 ad=0 pd=0 as=0.1386 ps=1.5 w=0.42 l=0.15
X1120 v3_four_channel_bias_reference_distribution_0/v3_four_channel_phase_distribution_0/v3_four_channel_output_collection_0/v3_four_channel_placement_0/v3_channel_selector_late_promotion_3/v3_selector_route_pilot_0/G3_MUX_AXIS/a_76_199# v3_four_channel_bias_reference_distribution_0/v3_four_channel_phase_distribution_0/v3_four_channel_output_collection_0/v3_four_channel_placement_0/v3_channel_selector_late_promotion_3/v3_selector_route_pilot_0/G3_MUX_POS/X v3_four_channel_bias_reference_distribution_0/v3_four_channel_phase_distribution_0/v3_four_channel_output_collection_0/v3_four_channel_placement_0/v3_channel_selector_late_promotion_3/v3_selector_route_pilot_0/G3_MUX_AXIS/a_218_374# v3_four_channel_bias_reference_distribution_0/v3_four_channel_phase_distribution_0/v3_four_channel_output_collection_0/v3_four_channel_placement_0/v3_channel_selector_late_promotion_3/VPWR sky130_fd_pr__pfet_01v8_hvt ad=0.3864 pd=2.68 as=0 ps=0 w=0.42 l=0.15
X1121 v3_four_channel_bias_reference_distribution_0/v3_four_channel_phase_distribution_0/v3_four_channel_output_collection_0/v3_four_channel_placement_0/v3_channel_selector_late_promotion_3/v3_selector_route_pilot_0/G3_MUX_AXIS/a_505_21# v3_four_channel_bias_reference_distribution_0/v3_four_channel_phase_distribution_0/v3_four_channel_output_collection_0/v3_four_channel_placement_0/v3_channel_selector_late_promotion_3/group3_bit1 VSUBS VSUBS sky130_fd_pr__nfet_01v8 ad=0.1092 pd=1.36 as=0 ps=0 w=0.42 l=0.15
X1122 v3_four_channel_bias_reference_distribution_0/v3_four_channel_phase_distribution_0/v3_four_channel_output_collection_0/v3_four_channel_placement_0/v3_channel_selector_late_promotion_3/v3_selector_route_pilot_0/G3_MUX_AXIS/a_439_47# v3_four_channel_bias_reference_distribution_0/v3_four_channel_phase_distribution_0/v3_four_channel_output_collection_0/v3_four_channel_placement_0/v3_channel_selector_late_promotion_3/v3_selector_route_pilot_0/G3_MUX_POS/X v3_four_channel_bias_reference_distribution_0/v3_four_channel_phase_distribution_0/v3_four_channel_output_collection_0/v3_four_channel_placement_0/v3_channel_selector_late_promotion_3/v3_selector_route_pilot_0/G3_MUX_AXIS/a_76_199# VSUBS sky130_fd_pr__nfet_01v8 ad=0 pd=0 as=0.1995 ps=1.79 w=0.42 l=0.15
X1123 v3_four_channel_bias_reference_distribution_0/v3_four_channel_phase_distribution_0/v3_four_channel_output_collection_0/v3_four_channel_placement_0/v3_channel_selector_late_promotion_3/v3_selector_route_pilot_0/G3_MUX_AXIS/a_535_374# v3_four_channel_bias_reference_distribution_0/v3_four_channel_phase_distribution_0/v3_four_channel_output_collection_0/v3_four_channel_placement_0/v3_channel_selector_late_promotion_3/v3_selector_route_pilot_0/G3_MUX_NEG/X v3_four_channel_bias_reference_distribution_0/v3_four_channel_phase_distribution_0/v3_four_channel_output_collection_0/v3_four_channel_placement_0/v3_channel_selector_late_promotion_3/v3_selector_route_pilot_0/G3_MUX_AXIS/a_76_199# v3_four_channel_bias_reference_distribution_0/v3_four_channel_phase_distribution_0/v3_four_channel_output_collection_0/v3_four_channel_placement_0/v3_channel_selector_late_promotion_3/VPWR sky130_fd_pr__pfet_01v8_hvt ad=0 pd=0 as=0 ps=0 w=0.42 l=0.15
X1124 v3_four_channel_bias_reference_distribution_0/v3_four_channel_phase_distribution_0/v3_four_channel_output_collection_0/v3_four_channel_placement_0/v3_channel_selector_late_promotion_3/v3_selector_route_pilot_0/G3_MUX_AXIS/a_76_199# v3_four_channel_bias_reference_distribution_0/v3_four_channel_phase_distribution_0/v3_four_channel_output_collection_0/v3_four_channel_placement_0/v3_channel_selector_late_promotion_3/v3_selector_route_pilot_0/G3_MUX_NEG/X v3_four_channel_bias_reference_distribution_0/v3_four_channel_phase_distribution_0/v3_four_channel_output_collection_0/v3_four_channel_placement_0/v3_channel_selector_late_promotion_3/v3_selector_route_pilot_0/G3_MUX_AXIS/a_218_47# VSUBS sky130_fd_pr__nfet_01v8 ad=0 pd=0 as=0.1386 ps=1.5 w=0.42 l=0.15
X1125 v3_four_channel_bias_reference_distribution_0/v3_four_channel_phase_distribution_0/v3_four_channel_output_collection_0/v3_four_channel_placement_0/v3_channel_selector_late_promotion_3/v3_selector_route_pilot_0/G3_MUX_AXIS/a_218_47# v3_four_channel_bias_reference_distribution_0/v3_four_channel_phase_distribution_0/v3_four_channel_output_collection_0/v3_four_channel_placement_0/v3_channel_selector_late_promotion_3/group3_bit1 VSUBS VSUBS sky130_fd_pr__nfet_01v8 ad=0 pd=0 as=0 ps=0 w=0.42 l=0.15
X1126 v3_four_channel_bias_reference_distribution_0/v3_four_channel_phase_distribution_0/v3_four_channel_output_collection_0/v3_four_channel_placement_0/v3_channel_selector_late_promotion_3/VPWR v3_four_channel_bias_reference_distribution_0/v3_four_channel_phase_distribution_0/v3_four_channel_output_collection_0/v3_four_channel_placement_0/v3_channel_selector_late_promotion_3/v3_selector_route_pilot_0/G3_MUX_AXIS/a_76_199# v3_four_channel_bias_reference_distribution_0/v3_four_channel_phase_distribution_0/v3_four_channel_output_collection_0/v3_four_channel_placement_0/v3_channel_selector_late_promotion_3/v3_selector_route_pilot_0/G3_MUX_AXIS/X v3_four_channel_bias_reference_distribution_0/v3_four_channel_phase_distribution_0/v3_four_channel_output_collection_0/v3_four_channel_placement_0/v3_channel_selector_late_promotion_3/VPWR sky130_fd_pr__pfet_01v8_hvt ad=0 pd=0 as=0.26 ps=2.52 w=1 l=0.15
X1127 VSUBS v3_four_channel_bias_reference_distribution_0/v3_four_channel_phase_distribution_0/v3_four_channel_output_collection_0/v3_four_channel_placement_0/v3_channel_selector_late_promotion_3/v3_selector_route_pilot_0/G3_MUX_AXIS/a_76_199# v3_four_channel_bias_reference_distribution_0/v3_four_channel_phase_distribution_0/v3_four_channel_output_collection_0/v3_four_channel_placement_0/v3_channel_selector_late_promotion_3/v3_selector_route_pilot_0/G3_MUX_AXIS/X VSUBS sky130_fd_pr__nfet_01v8 ad=0 pd=0 as=0.169 ps=1.82 w=0.65 l=0.15
X1128 v3_four_channel_bias_reference_distribution_0/v3_four_channel_phase_distribution_0/v3_four_channel_output_collection_0/v3_four_channel_placement_0/v3_channel_selector_late_promotion_3/VPWR v3_four_channel_bias_reference_distribution_0/v3_four_channel_phase_distribution_0/v3_four_channel_output_collection_0/v3_four_channel_placement_0/v3_channel_selector_late_promotion_3/channel_enable v3_four_channel_bias_reference_distribution_0/v3_four_channel_phase_distribution_0/v3_four_channel_output_collection_0/v3_four_channel_placement_0/v3_channel_selector_late_promotion_3/v3_selector_route_pilot_0/ENABLE_ANDNOT/a_207_413# v3_four_channel_bias_reference_distribution_0/v3_four_channel_phase_distribution_0/v3_four_channel_output_collection_0/v3_four_channel_placement_0/v3_channel_selector_late_promotion_3/VPWR sky130_fd_pr__pfet_01v8_hvt ad=0 pd=0 as=0.1218 ps=1.42 w=0.42 l=0.15
X1129 v3_four_channel_bias_reference_distribution_0/v3_four_channel_phase_distribution_0/v3_four_channel_output_collection_0/v3_four_channel_placement_0/v3_channel_selector_late_promotion_3/v3_selector_route_pilot_0/G3_LO_P_AND/B v3_four_channel_bias_reference_distribution_0/v3_four_channel_phase_distribution_0/v3_four_channel_output_collection_0/v3_four_channel_placement_0/v3_channel_selector_late_promotion_3/v3_selector_route_pilot_0/ENABLE_ANDNOT/a_207_413# v3_four_channel_bias_reference_distribution_0/v3_four_channel_phase_distribution_0/v3_four_channel_output_collection_0/v3_four_channel_placement_0/v3_channel_selector_late_promotion_3/VPWR v3_four_channel_bias_reference_distribution_0/v3_four_channel_phase_distribution_0/v3_four_channel_output_collection_0/v3_four_channel_placement_0/v3_channel_selector_late_promotion_3/VPWR sky130_fd_pr__pfet_01v8_hvt ad=0.26 pd=2.52 as=0 ps=0 w=1 l=0.15
X1130 v3_four_channel_bias_reference_distribution_0/v3_four_channel_phase_distribution_0/v3_four_channel_output_collection_0/v3_four_channel_placement_0/v3_channel_selector_late_promotion_3/v3_selector_route_pilot_0/ENABLE_ANDNOT/a_297_47# v3_four_channel_bias_reference_distribution_0/v3_four_channel_phase_distribution_0/v3_four_channel_output_collection_0/v3_four_channel_placement_0/v3_channel_selector_late_promotion_3/v3_selector_route_pilot_0/ENABLE_ANDNOT/a_27_413# v3_four_channel_bias_reference_distribution_0/v3_four_channel_phase_distribution_0/v3_four_channel_output_collection_0/v3_four_channel_placement_0/v3_channel_selector_late_promotion_3/v3_selector_route_pilot_0/ENABLE_ANDNOT/a_207_413# VSUBS sky130_fd_pr__nfet_01v8 ad=0.1008 pd=1.32 as=0.1092 ps=1.36 w=0.42 l=0.15
X1131 v3_four_channel_bias_reference_distribution_0/v3_four_channel_phase_distribution_0/v3_four_channel_output_collection_0/v3_four_channel_placement_0/v3_channel_selector_late_promotion_3/v3_selector_route_pilot_0/G3_LO_P_AND/B v3_four_channel_bias_reference_distribution_0/v3_four_channel_phase_distribution_0/v3_four_channel_output_collection_0/v3_four_channel_placement_0/v3_channel_selector_late_promotion_3/v3_selector_route_pilot_0/ENABLE_ANDNOT/a_207_413# VSUBS VSUBS sky130_fd_pr__nfet_01v8 ad=0.169 pd=1.82 as=0 ps=0 w=0.65 l=0.15
X1132 v3_four_channel_bias_reference_distribution_0/v3_four_channel_phase_distribution_0/v3_four_channel_output_collection_0/v3_four_channel_placement_0/v3_channel_selector_late_promotion_3/v3_selector_route_pilot_0/ENABLE_ANDNOT/a_207_413# v3_four_channel_bias_reference_distribution_0/v3_four_channel_phase_distribution_0/v3_four_channel_output_collection_0/v3_four_channel_placement_0/v3_channel_selector_late_promotion_3/v3_selector_route_pilot_0/ENABLE_ANDNOT/a_27_413# v3_four_channel_bias_reference_distribution_0/v3_four_channel_phase_distribution_0/v3_four_channel_output_collection_0/v3_four_channel_placement_0/v3_channel_selector_late_promotion_3/VPWR v3_four_channel_bias_reference_distribution_0/v3_four_channel_phase_distribution_0/v3_four_channel_output_collection_0/v3_four_channel_placement_0/v3_channel_selector_late_promotion_3/VPWR sky130_fd_pr__pfet_01v8_hvt ad=0 pd=0 as=0 ps=0 w=0.42 l=0.15
X1133 v3_four_channel_bias_reference_distribution_0/v3_four_channel_phase_distribution_0/v3_four_channel_output_collection_0/v3_four_channel_placement_0/v3_channel_selector_late_promotion_3/VPWR v3_four_channel_bias_reference_distribution_0/v3_four_channel_phase_distribution_0/v3_four_channel_output_collection_0/v3_four_channel_placement_0/v3_channel_selector_late_promotion_3/mixers_blank v3_four_channel_bias_reference_distribution_0/v3_four_channel_phase_distribution_0/v3_four_channel_output_collection_0/v3_four_channel_placement_0/v3_channel_selector_late_promotion_3/v3_selector_route_pilot_0/ENABLE_ANDNOT/a_27_413# v3_four_channel_bias_reference_distribution_0/v3_four_channel_phase_distribution_0/v3_four_channel_output_collection_0/v3_four_channel_placement_0/v3_channel_selector_late_promotion_3/VPWR sky130_fd_pr__pfet_01v8_hvt ad=0 pd=0 as=0.1092 ps=1.36 w=0.42 l=0.15
X1134 VSUBS v3_four_channel_bias_reference_distribution_0/v3_four_channel_phase_distribution_0/v3_four_channel_output_collection_0/v3_four_channel_placement_0/v3_channel_selector_late_promotion_3/channel_enable v3_four_channel_bias_reference_distribution_0/v3_four_channel_phase_distribution_0/v3_four_channel_output_collection_0/v3_four_channel_placement_0/v3_channel_selector_late_promotion_3/v3_selector_route_pilot_0/ENABLE_ANDNOT/a_297_47# VSUBS sky130_fd_pr__nfet_01v8 ad=0 pd=0 as=0 ps=0 w=0.42 l=0.15
X1135 v3_four_channel_bias_reference_distribution_0/v3_four_channel_phase_distribution_0/v3_four_channel_output_collection_0/v3_four_channel_placement_0/v3_channel_selector_late_promotion_3/v3_selector_route_pilot_0/ENABLE_ANDNOT/a_27_413# v3_four_channel_bias_reference_distribution_0/v3_four_channel_phase_distribution_0/v3_four_channel_output_collection_0/v3_four_channel_placement_0/v3_channel_selector_late_promotion_3/mixers_blank VSUBS VSUBS sky130_fd_pr__nfet_01v8 ad=0.1092 pd=1.36 as=0 ps=0 w=0.42 l=0.15
X1136 v3_four_channel_bias_reference_distribution_0/v3_four_channel_phase_distribution_0/v3_four_channel_output_collection_0/v3_four_channel_placement_0/v3_channel_selector_late_promotion_3/VPWR v3_four_channel_bias_reference_distribution_0/v3_four_channel_phase_distribution_0/v3_four_channel_output_collection_0/v3_four_channel_placement_0/v3_channel_selector_late_promotion_3/v3_selector_route_pilot_0/G1_MUX_NEG/a_505_21# v3_four_channel_bias_reference_distribution_0/v3_four_channel_phase_distribution_0/v3_four_channel_output_collection_0/v3_four_channel_placement_0/v3_channel_selector_late_promotion_3/v3_selector_route_pilot_0/G1_MUX_NEG/a_535_374# v3_four_channel_bias_reference_distribution_0/v3_four_channel_phase_distribution_0/v3_four_channel_output_collection_0/v3_four_channel_placement_0/v3_channel_selector_late_promotion_3/VPWR sky130_fd_pr__pfet_01v8_hvt ad=0 pd=0 as=0.0882 ps=1.26 w=0.42 l=0.15
X1137 v3_four_channel_bias_reference_distribution_0/v3_four_channel_phase_distribution_0/v3_four_channel_output_collection_0/v3_four_channel_placement_0/v3_channel_selector_late_promotion_3/v3_selector_route_pilot_0/G1_MUX_NEG/a_505_21# v3_four_channel_bias_reference_distribution_0/v3_four_channel_phase_distribution_0/v3_four_channel_output_collection_0/v3_four_channel_placement_0/v3_channel_selector_late_promotion_3/group1_bit0 v3_four_channel_bias_reference_distribution_0/v3_four_channel_phase_distribution_0/v3_four_channel_output_collection_0/v3_four_channel_placement_0/v3_channel_selector_late_promotion_3/VPWR v3_four_channel_bias_reference_distribution_0/v3_four_channel_phase_distribution_0/v3_four_channel_output_collection_0/v3_four_channel_placement_0/v3_channel_selector_late_promotion_3/VPWR sky130_fd_pr__pfet_01v8_hvt ad=0.1176 pd=1.4 as=0 ps=0 w=0.42 l=0.15
X1138 v3_four_channel_bias_reference_distribution_0/v3_four_channel_phase_distribution_0/v3_four_channel_output_collection_0/v3_four_channel_placement_0/v3_channel_selector_late_promotion_3/v3_selector_route_pilot_0/G1_MUX_NEG/a_218_374# v3_four_channel_bias_reference_distribution_0/v3_four_channel_phase_distribution_0/v3_four_channel_output_collection_0/v3_four_channel_placement_0/v3_channel_selector_late_promotion_3/group1_bit0 v3_four_channel_bias_reference_distribution_0/v3_four_channel_phase_distribution_0/v3_four_channel_output_collection_0/v3_four_channel_placement_0/v3_channel_selector_late_promotion_3/VPWR v3_four_channel_bias_reference_distribution_0/v3_four_channel_phase_distribution_0/v3_four_channel_output_collection_0/v3_four_channel_placement_0/v3_channel_selector_late_promotion_3/VPWR sky130_fd_pr__pfet_01v8_hvt ad=0.1533 pd=1.57 as=0 ps=0 w=0.42 l=0.15
X1139 VSUBS v3_four_channel_bias_reference_distribution_0/v3_four_channel_phase_distribution_0/v3_four_channel_output_collection_0/v3_four_channel_placement_0/v3_channel_selector_late_promotion_3/v3_selector_route_pilot_0/G1_MUX_NEG/a_505_21# v3_four_channel_bias_reference_distribution_0/v3_four_channel_phase_distribution_0/v3_four_channel_output_collection_0/v3_four_channel_placement_0/v3_channel_selector_late_promotion_3/v3_selector_route_pilot_0/G1_MUX_NEG/a_439_47# VSUBS sky130_fd_pr__nfet_01v8 ad=0 pd=0 as=0.1386 ps=1.5 w=0.42 l=0.15
X1140 v3_four_channel_bias_reference_distribution_0/v3_four_channel_phase_distribution_0/v3_four_channel_output_collection_0/v3_four_channel_placement_0/v3_channel_selector_late_promotion_3/v3_selector_route_pilot_0/G1_MUX_NEG/a_76_199# v3_four_channel_bias_reference_distribution_0/v3_four_channel_phase_distribution_0/phase_180 v3_four_channel_bias_reference_distribution_0/v3_four_channel_phase_distribution_0/v3_four_channel_output_collection_0/v3_four_channel_placement_0/v3_channel_selector_late_promotion_3/v3_selector_route_pilot_0/G1_MUX_NEG/a_218_374# v3_four_channel_bias_reference_distribution_0/v3_four_channel_phase_distribution_0/v3_four_channel_output_collection_0/v3_four_channel_placement_0/v3_channel_selector_late_promotion_3/VPWR sky130_fd_pr__pfet_01v8_hvt ad=0.3864 pd=2.68 as=0 ps=0 w=0.42 l=0.15
X1141 v3_four_channel_bias_reference_distribution_0/v3_four_channel_phase_distribution_0/v3_four_channel_output_collection_0/v3_four_channel_placement_0/v3_channel_selector_late_promotion_3/v3_selector_route_pilot_0/G1_MUX_NEG/a_505_21# v3_four_channel_bias_reference_distribution_0/v3_four_channel_phase_distribution_0/v3_four_channel_output_collection_0/v3_four_channel_placement_0/v3_channel_selector_late_promotion_3/group1_bit0 VSUBS VSUBS sky130_fd_pr__nfet_01v8 ad=0.1092 pd=1.36 as=0 ps=0 w=0.42 l=0.15
X1142 v3_four_channel_bias_reference_distribution_0/v3_four_channel_phase_distribution_0/v3_four_channel_output_collection_0/v3_four_channel_placement_0/v3_channel_selector_late_promotion_3/v3_selector_route_pilot_0/G1_MUX_NEG/a_439_47# v3_four_channel_bias_reference_distribution_0/v3_four_channel_phase_distribution_0/phase_180 v3_four_channel_bias_reference_distribution_0/v3_four_channel_phase_distribution_0/v3_four_channel_output_collection_0/v3_four_channel_placement_0/v3_channel_selector_late_promotion_3/v3_selector_route_pilot_0/G1_MUX_NEG/a_76_199# VSUBS sky130_fd_pr__nfet_01v8 ad=0 pd=0 as=0.1995 ps=1.79 w=0.42 l=0.15
X1143 v3_four_channel_bias_reference_distribution_0/v3_four_channel_phase_distribution_0/v3_four_channel_output_collection_0/v3_four_channel_placement_0/v3_channel_selector_late_promotion_3/v3_selector_route_pilot_0/G1_MUX_NEG/a_535_374# v3_four_channel_bias_reference_distribution_0/v3_four_channel_phase_distribution_0/phase_270 v3_four_channel_bias_reference_distribution_0/v3_four_channel_phase_distribution_0/v3_four_channel_output_collection_0/v3_four_channel_placement_0/v3_channel_selector_late_promotion_3/v3_selector_route_pilot_0/G1_MUX_NEG/a_76_199# v3_four_channel_bias_reference_distribution_0/v3_four_channel_phase_distribution_0/v3_four_channel_output_collection_0/v3_four_channel_placement_0/v3_channel_selector_late_promotion_3/VPWR sky130_fd_pr__pfet_01v8_hvt ad=0 pd=0 as=0 ps=0 w=0.42 l=0.15
X1144 v3_four_channel_bias_reference_distribution_0/v3_four_channel_phase_distribution_0/v3_four_channel_output_collection_0/v3_four_channel_placement_0/v3_channel_selector_late_promotion_3/v3_selector_route_pilot_0/G1_MUX_NEG/a_76_199# v3_four_channel_bias_reference_distribution_0/v3_four_channel_phase_distribution_0/phase_270 v3_four_channel_bias_reference_distribution_0/v3_four_channel_phase_distribution_0/v3_four_channel_output_collection_0/v3_four_channel_placement_0/v3_channel_selector_late_promotion_3/v3_selector_route_pilot_0/G1_MUX_NEG/a_218_47# VSUBS sky130_fd_pr__nfet_01v8 ad=0 pd=0 as=0.1386 ps=1.5 w=0.42 l=0.15
X1145 v3_four_channel_bias_reference_distribution_0/v3_four_channel_phase_distribution_0/v3_four_channel_output_collection_0/v3_four_channel_placement_0/v3_channel_selector_late_promotion_3/v3_selector_route_pilot_0/G1_MUX_NEG/a_218_47# v3_four_channel_bias_reference_distribution_0/v3_four_channel_phase_distribution_0/v3_four_channel_output_collection_0/v3_four_channel_placement_0/v3_channel_selector_late_promotion_3/group1_bit0 VSUBS VSUBS sky130_fd_pr__nfet_01v8 ad=0 pd=0 as=0 ps=0 w=0.42 l=0.15
X1146 v3_four_channel_bias_reference_distribution_0/v3_four_channel_phase_distribution_0/v3_four_channel_output_collection_0/v3_four_channel_placement_0/v3_channel_selector_late_promotion_3/VPWR v3_four_channel_bias_reference_distribution_0/v3_four_channel_phase_distribution_0/v3_four_channel_output_collection_0/v3_four_channel_placement_0/v3_channel_selector_late_promotion_3/v3_selector_route_pilot_0/G1_MUX_NEG/a_76_199# v3_four_channel_bias_reference_distribution_0/v3_four_channel_phase_distribution_0/v3_four_channel_output_collection_0/v3_four_channel_placement_0/v3_channel_selector_late_promotion_3/v3_selector_route_pilot_0/G1_MUX_NEG/X v3_four_channel_bias_reference_distribution_0/v3_four_channel_phase_distribution_0/v3_four_channel_output_collection_0/v3_four_channel_placement_0/v3_channel_selector_late_promotion_3/VPWR sky130_fd_pr__pfet_01v8_hvt ad=0 pd=0 as=0.26 ps=2.52 w=1 l=0.15
X1147 VSUBS v3_four_channel_bias_reference_distribution_0/v3_four_channel_phase_distribution_0/v3_four_channel_output_collection_0/v3_four_channel_placement_0/v3_channel_selector_late_promotion_3/v3_selector_route_pilot_0/G1_MUX_NEG/a_76_199# v3_four_channel_bias_reference_distribution_0/v3_four_channel_phase_distribution_0/v3_four_channel_output_collection_0/v3_four_channel_placement_0/v3_channel_selector_late_promotion_3/v3_selector_route_pilot_0/G1_MUX_NEG/X VSUBS sky130_fd_pr__nfet_01v8 ad=0 pd=0 as=0.169 ps=1.82 w=0.65 l=0.15
X1148 v3_four_channel_bias_reference_distribution_0/v3_four_channel_phase_distribution_0/v3_four_channel_output_collection_0/v3_four_channel_placement_0/v3_channel_selector_late_promotion_3/VPWR v3_four_channel_bias_reference_distribution_0/v3_four_channel_phase_distribution_0/v3_four_channel_output_collection_0/v3_four_channel_placement_0/v3_channel_selector_late_promotion_3/v3_selector_route_pilot_0/G3_LO_P_AND/B v3_four_channel_bias_reference_distribution_0/v3_four_channel_phase_distribution_0/v3_four_channel_output_collection_0/v3_four_channel_placement_0/v3_channel_selector_late_promotion_3/v3_selector_route_pilot_0/G1_LO_P_AND/a_59_75# v3_four_channel_bias_reference_distribution_0/v3_four_channel_phase_distribution_0/v3_four_channel_output_collection_0/v3_four_channel_placement_0/v3_channel_selector_late_promotion_3/VPWR sky130_fd_pr__pfet_01v8_hvt ad=0 pd=0 as=0.1134 ps=1.38 w=0.42 l=0.15
X1149 v3_four_channel_bias_reference_distribution_0/v3_four_channel_phase_distribution_0/v3_four_channel_output_collection_0/v3_four_channel_placement_0/v3_channel_selector_late_promotion_3/v3_selector_route_pilot_0/group1_lo_p v3_four_channel_bias_reference_distribution_0/v3_four_channel_phase_distribution_0/v3_four_channel_output_collection_0/v3_four_channel_placement_0/v3_channel_selector_late_promotion_3/v3_selector_route_pilot_0/G1_LO_P_AND/a_59_75# v3_four_channel_bias_reference_distribution_0/v3_four_channel_phase_distribution_0/v3_four_channel_output_collection_0/v3_four_channel_placement_0/v3_channel_selector_late_promotion_3/VPWR v3_four_channel_bias_reference_distribution_0/v3_four_channel_phase_distribution_0/v3_four_channel_output_collection_0/v3_four_channel_placement_0/v3_channel_selector_late_promotion_3/VPWR sky130_fd_pr__pfet_01v8_hvt ad=0.475 pd=2.95 as=0 ps=0 w=1 l=0.15
X1150 VSUBS v3_four_channel_bias_reference_distribution_0/v3_four_channel_phase_distribution_0/v3_four_channel_output_collection_0/v3_four_channel_placement_0/v3_channel_selector_late_promotion_3/v3_selector_route_pilot_0/G3_LO_P_AND/B v3_four_channel_bias_reference_distribution_0/v3_four_channel_phase_distribution_0/v3_four_channel_output_collection_0/v3_four_channel_placement_0/v3_channel_selector_late_promotion_3/v3_selector_route_pilot_0/G1_LO_P_AND/a_145_75# VSUBS sky130_fd_pr__nfet_01v8 ad=0 pd=0 as=0.1134 ps=1.38 w=0.42 l=0.15
X1151 v3_four_channel_bias_reference_distribution_0/v3_four_channel_phase_distribution_0/v3_four_channel_output_collection_0/v3_four_channel_placement_0/v3_channel_selector_late_promotion_3/v3_selector_route_pilot_0/G1_LO_P_AND/a_59_75# v3_four_channel_bias_reference_distribution_0/v3_four_channel_phase_distribution_0/v3_four_channel_output_collection_0/v3_four_channel_placement_0/v3_channel_selector_late_promotion_3/v3_selector_route_pilot_0/G1_MUX_AXIS/X v3_four_channel_bias_reference_distribution_0/v3_four_channel_phase_distribution_0/v3_four_channel_output_collection_0/v3_four_channel_placement_0/v3_channel_selector_late_promotion_3/VPWR v3_four_channel_bias_reference_distribution_0/v3_four_channel_phase_distribution_0/v3_four_channel_output_collection_0/v3_four_channel_placement_0/v3_channel_selector_late_promotion_3/VPWR sky130_fd_pr__pfet_01v8_hvt ad=0 pd=0 as=0 ps=0 w=0.42 l=0.15
X1152 v3_four_channel_bias_reference_distribution_0/v3_four_channel_phase_distribution_0/v3_four_channel_output_collection_0/v3_four_channel_placement_0/v3_channel_selector_late_promotion_3/v3_selector_route_pilot_0/group1_lo_p v3_four_channel_bias_reference_distribution_0/v3_four_channel_phase_distribution_0/v3_four_channel_output_collection_0/v3_four_channel_placement_0/v3_channel_selector_late_promotion_3/v3_selector_route_pilot_0/G1_LO_P_AND/a_59_75# VSUBS VSUBS sky130_fd_pr__nfet_01v8 ad=0.182 pd=1.86 as=0 ps=0 w=0.65 l=0.15
X1153 v3_four_channel_bias_reference_distribution_0/v3_four_channel_phase_distribution_0/v3_four_channel_output_collection_0/v3_four_channel_placement_0/v3_channel_selector_late_promotion_3/v3_selector_route_pilot_0/G1_LO_P_AND/a_145_75# v3_four_channel_bias_reference_distribution_0/v3_four_channel_phase_distribution_0/v3_four_channel_output_collection_0/v3_four_channel_placement_0/v3_channel_selector_late_promotion_3/v3_selector_route_pilot_0/G1_MUX_AXIS/X v3_four_channel_bias_reference_distribution_0/v3_four_channel_phase_distribution_0/v3_four_channel_output_collection_0/v3_four_channel_placement_0/v3_channel_selector_late_promotion_3/v3_selector_route_pilot_0/G1_LO_P_AND/a_59_75# VSUBS sky130_fd_pr__nfet_01v8 ad=0 pd=0 as=0.1176 ps=1.4 w=0.42 l=0.15
X1154 v3_four_channel_bias_reference_distribution_0/v3_four_channel_phase_distribution_0/v3_four_channel_output_collection_0/v3_four_channel_placement_0/v3_channel_selector_late_promotion_3/VPWR v3_four_channel_bias_reference_distribution_0/v3_four_channel_phase_distribution_0/v3_four_channel_output_collection_0/v3_four_channel_placement_0/v3_channel_selector_late_promotion_3/v3_selector_route_pilot_0/G0_MUX_POS/a_505_21# v3_four_channel_bias_reference_distribution_0/v3_four_channel_phase_distribution_0/v3_four_channel_output_collection_0/v3_four_channel_placement_0/v3_channel_selector_late_promotion_3/v3_selector_route_pilot_0/G0_MUX_POS/a_535_374# v3_four_channel_bias_reference_distribution_0/v3_four_channel_phase_distribution_0/v3_four_channel_output_collection_0/v3_four_channel_placement_0/v3_channel_selector_late_promotion_3/VPWR sky130_fd_pr__pfet_01v8_hvt ad=0 pd=0 as=0.0882 ps=1.26 w=0.42 l=0.15
X1155 v3_four_channel_bias_reference_distribution_0/v3_four_channel_phase_distribution_0/v3_four_channel_output_collection_0/v3_four_channel_placement_0/v3_channel_selector_late_promotion_3/v3_selector_route_pilot_0/G0_MUX_POS/a_505_21# v3_four_channel_bias_reference_distribution_0/v3_four_channel_phase_distribution_0/v3_four_channel_output_collection_0/v3_four_channel_placement_0/v3_channel_selector_late_promotion_3/group0_bit0 v3_four_channel_bias_reference_distribution_0/v3_four_channel_phase_distribution_0/v3_four_channel_output_collection_0/v3_four_channel_placement_0/v3_channel_selector_late_promotion_3/VPWR v3_four_channel_bias_reference_distribution_0/v3_four_channel_phase_distribution_0/v3_four_channel_output_collection_0/v3_four_channel_placement_0/v3_channel_selector_late_promotion_3/VPWR sky130_fd_pr__pfet_01v8_hvt ad=0.1176 pd=1.4 as=0 ps=0 w=0.42 l=0.15
X1156 v3_four_channel_bias_reference_distribution_0/v3_four_channel_phase_distribution_0/v3_four_channel_output_collection_0/v3_four_channel_placement_0/v3_channel_selector_late_promotion_3/v3_selector_route_pilot_0/G0_MUX_POS/a_218_374# v3_four_channel_bias_reference_distribution_0/v3_four_channel_phase_distribution_0/v3_four_channel_output_collection_0/v3_four_channel_placement_0/v3_channel_selector_late_promotion_3/group0_bit0 v3_four_channel_bias_reference_distribution_0/v3_four_channel_phase_distribution_0/v3_four_channel_output_collection_0/v3_four_channel_placement_0/v3_channel_selector_late_promotion_3/VPWR v3_four_channel_bias_reference_distribution_0/v3_four_channel_phase_distribution_0/v3_four_channel_output_collection_0/v3_four_channel_placement_0/v3_channel_selector_late_promotion_3/VPWR sky130_fd_pr__pfet_01v8_hvt ad=0.1533 pd=1.57 as=0 ps=0 w=0.42 l=0.15
X1157 VSUBS v3_four_channel_bias_reference_distribution_0/v3_four_channel_phase_distribution_0/v3_four_channel_output_collection_0/v3_four_channel_placement_0/v3_channel_selector_late_promotion_3/v3_selector_route_pilot_0/G0_MUX_POS/a_505_21# v3_four_channel_bias_reference_distribution_0/v3_four_channel_phase_distribution_0/v3_four_channel_output_collection_0/v3_four_channel_placement_0/v3_channel_selector_late_promotion_3/v3_selector_route_pilot_0/G0_MUX_POS/a_439_47# VSUBS sky130_fd_pr__nfet_01v8 ad=0 pd=0 as=0.1386 ps=1.5 w=0.42 l=0.15
X1158 v3_four_channel_bias_reference_distribution_0/v3_four_channel_phase_distribution_0/v3_four_channel_output_collection_0/v3_four_channel_placement_0/v3_channel_selector_late_promotion_3/v3_selector_route_pilot_0/G0_MUX_POS/a_76_199# v3_four_channel_bias_reference_distribution_0/v3_four_channel_phase_distribution_0/phase_0 v3_four_channel_bias_reference_distribution_0/v3_four_channel_phase_distribution_0/v3_four_channel_output_collection_0/v3_four_channel_placement_0/v3_channel_selector_late_promotion_3/v3_selector_route_pilot_0/G0_MUX_POS/a_218_374# v3_four_channel_bias_reference_distribution_0/v3_four_channel_phase_distribution_0/v3_four_channel_output_collection_0/v3_four_channel_placement_0/v3_channel_selector_late_promotion_3/VPWR sky130_fd_pr__pfet_01v8_hvt ad=0.3864 pd=2.68 as=0 ps=0 w=0.42 l=0.15
X1159 v3_four_channel_bias_reference_distribution_0/v3_four_channel_phase_distribution_0/v3_four_channel_output_collection_0/v3_four_channel_placement_0/v3_channel_selector_late_promotion_3/v3_selector_route_pilot_0/G0_MUX_POS/a_505_21# v3_four_channel_bias_reference_distribution_0/v3_four_channel_phase_distribution_0/v3_four_channel_output_collection_0/v3_four_channel_placement_0/v3_channel_selector_late_promotion_3/group0_bit0 VSUBS VSUBS sky130_fd_pr__nfet_01v8 ad=0.1092 pd=1.36 as=0 ps=0 w=0.42 l=0.15
X1160 v3_four_channel_bias_reference_distribution_0/v3_four_channel_phase_distribution_0/v3_four_channel_output_collection_0/v3_four_channel_placement_0/v3_channel_selector_late_promotion_3/v3_selector_route_pilot_0/G0_MUX_POS/a_439_47# v3_four_channel_bias_reference_distribution_0/v3_four_channel_phase_distribution_0/phase_0 v3_four_channel_bias_reference_distribution_0/v3_four_channel_phase_distribution_0/v3_four_channel_output_collection_0/v3_four_channel_placement_0/v3_channel_selector_late_promotion_3/v3_selector_route_pilot_0/G0_MUX_POS/a_76_199# VSUBS sky130_fd_pr__nfet_01v8 ad=0 pd=0 as=0.1995 ps=1.79 w=0.42 l=0.15
X1161 v3_four_channel_bias_reference_distribution_0/v3_four_channel_phase_distribution_0/v3_four_channel_output_collection_0/v3_four_channel_placement_0/v3_channel_selector_late_promotion_3/v3_selector_route_pilot_0/G0_MUX_POS/a_535_374# v3_four_channel_bias_reference_distribution_0/v3_four_channel_phase_distribution_0/phase_90 v3_four_channel_bias_reference_distribution_0/v3_four_channel_phase_distribution_0/v3_four_channel_output_collection_0/v3_four_channel_placement_0/v3_channel_selector_late_promotion_3/v3_selector_route_pilot_0/G0_MUX_POS/a_76_199# v3_four_channel_bias_reference_distribution_0/v3_four_channel_phase_distribution_0/v3_four_channel_output_collection_0/v3_four_channel_placement_0/v3_channel_selector_late_promotion_3/VPWR sky130_fd_pr__pfet_01v8_hvt ad=0 pd=0 as=0 ps=0 w=0.42 l=0.15
X1162 v3_four_channel_bias_reference_distribution_0/v3_four_channel_phase_distribution_0/v3_four_channel_output_collection_0/v3_four_channel_placement_0/v3_channel_selector_late_promotion_3/v3_selector_route_pilot_0/G0_MUX_POS/a_76_199# v3_four_channel_bias_reference_distribution_0/v3_four_channel_phase_distribution_0/phase_90 v3_four_channel_bias_reference_distribution_0/v3_four_channel_phase_distribution_0/v3_four_channel_output_collection_0/v3_four_channel_placement_0/v3_channel_selector_late_promotion_3/v3_selector_route_pilot_0/G0_MUX_POS/a_218_47# VSUBS sky130_fd_pr__nfet_01v8 ad=0 pd=0 as=0.1386 ps=1.5 w=0.42 l=0.15
X1163 v3_four_channel_bias_reference_distribution_0/v3_four_channel_phase_distribution_0/v3_four_channel_output_collection_0/v3_four_channel_placement_0/v3_channel_selector_late_promotion_3/v3_selector_route_pilot_0/G0_MUX_POS/a_218_47# v3_four_channel_bias_reference_distribution_0/v3_four_channel_phase_distribution_0/v3_four_channel_output_collection_0/v3_four_channel_placement_0/v3_channel_selector_late_promotion_3/group0_bit0 VSUBS VSUBS sky130_fd_pr__nfet_01v8 ad=0 pd=0 as=0 ps=0 w=0.42 l=0.15
X1164 v3_four_channel_bias_reference_distribution_0/v3_four_channel_phase_distribution_0/v3_four_channel_output_collection_0/v3_four_channel_placement_0/v3_channel_selector_late_promotion_3/VPWR v3_four_channel_bias_reference_distribution_0/v3_four_channel_phase_distribution_0/v3_four_channel_output_collection_0/v3_four_channel_placement_0/v3_channel_selector_late_promotion_3/v3_selector_route_pilot_0/G0_MUX_POS/a_76_199# v3_four_channel_bias_reference_distribution_0/v3_four_channel_phase_distribution_0/v3_four_channel_output_collection_0/v3_four_channel_placement_0/v3_channel_selector_late_promotion_3/v3_selector_route_pilot_0/G0_MUX_POS/X v3_four_channel_bias_reference_distribution_0/v3_four_channel_phase_distribution_0/v3_four_channel_output_collection_0/v3_four_channel_placement_0/v3_channel_selector_late_promotion_3/VPWR sky130_fd_pr__pfet_01v8_hvt ad=0 pd=0 as=0.26 ps=2.52 w=1 l=0.15
X1165 VSUBS v3_four_channel_bias_reference_distribution_0/v3_four_channel_phase_distribution_0/v3_four_channel_output_collection_0/v3_four_channel_placement_0/v3_channel_selector_late_promotion_3/v3_selector_route_pilot_0/G0_MUX_POS/a_76_199# v3_four_channel_bias_reference_distribution_0/v3_four_channel_phase_distribution_0/v3_four_channel_output_collection_0/v3_four_channel_placement_0/v3_channel_selector_late_promotion_3/v3_selector_route_pilot_0/G0_MUX_POS/X VSUBS sky130_fd_pr__nfet_01v8 ad=0 pd=0 as=0.169 ps=1.82 w=0.65 l=0.15
X1166 v3_four_channel_bias_reference_distribution_0/v3_four_channel_phase_distribution_0/v3_four_channel_output_collection_0/v3_four_channel_placement_0/v3_channel_selector_late_promotion_3/VPWR v3_four_channel_bias_reference_distribution_0/v3_four_channel_phase_distribution_0/v3_four_channel_output_collection_0/v3_four_channel_placement_0/v3_channel_selector_late_promotion_3/v3_selector_route_pilot_0/G0_MUX_NEG/a_505_21# v3_four_channel_bias_reference_distribution_0/v3_four_channel_phase_distribution_0/v3_four_channel_output_collection_0/v3_four_channel_placement_0/v3_channel_selector_late_promotion_3/v3_selector_route_pilot_0/G0_MUX_NEG/a_535_374# v3_four_channel_bias_reference_distribution_0/v3_four_channel_phase_distribution_0/v3_four_channel_output_collection_0/v3_four_channel_placement_0/v3_channel_selector_late_promotion_3/VPWR sky130_fd_pr__pfet_01v8_hvt ad=0 pd=0 as=0.0882 ps=1.26 w=0.42 l=0.15
X1167 v3_four_channel_bias_reference_distribution_0/v3_four_channel_phase_distribution_0/v3_four_channel_output_collection_0/v3_four_channel_placement_0/v3_channel_selector_late_promotion_3/v3_selector_route_pilot_0/G0_MUX_NEG/a_505_21# v3_four_channel_bias_reference_distribution_0/v3_four_channel_phase_distribution_0/v3_four_channel_output_collection_0/v3_four_channel_placement_0/v3_channel_selector_late_promotion_3/group0_bit0 v3_four_channel_bias_reference_distribution_0/v3_four_channel_phase_distribution_0/v3_four_channel_output_collection_0/v3_four_channel_placement_0/v3_channel_selector_late_promotion_3/VPWR v3_four_channel_bias_reference_distribution_0/v3_four_channel_phase_distribution_0/v3_four_channel_output_collection_0/v3_four_channel_placement_0/v3_channel_selector_late_promotion_3/VPWR sky130_fd_pr__pfet_01v8_hvt ad=0.1176 pd=1.4 as=0 ps=0 w=0.42 l=0.15
X1168 v3_four_channel_bias_reference_distribution_0/v3_four_channel_phase_distribution_0/v3_four_channel_output_collection_0/v3_four_channel_placement_0/v3_channel_selector_late_promotion_3/v3_selector_route_pilot_0/G0_MUX_NEG/a_218_374# v3_four_channel_bias_reference_distribution_0/v3_four_channel_phase_distribution_0/v3_four_channel_output_collection_0/v3_four_channel_placement_0/v3_channel_selector_late_promotion_3/group0_bit0 v3_four_channel_bias_reference_distribution_0/v3_four_channel_phase_distribution_0/v3_four_channel_output_collection_0/v3_four_channel_placement_0/v3_channel_selector_late_promotion_3/VPWR v3_four_channel_bias_reference_distribution_0/v3_four_channel_phase_distribution_0/v3_four_channel_output_collection_0/v3_four_channel_placement_0/v3_channel_selector_late_promotion_3/VPWR sky130_fd_pr__pfet_01v8_hvt ad=0.1533 pd=1.57 as=0 ps=0 w=0.42 l=0.15
X1169 VSUBS v3_four_channel_bias_reference_distribution_0/v3_four_channel_phase_distribution_0/v3_four_channel_output_collection_0/v3_four_channel_placement_0/v3_channel_selector_late_promotion_3/v3_selector_route_pilot_0/G0_MUX_NEG/a_505_21# v3_four_channel_bias_reference_distribution_0/v3_four_channel_phase_distribution_0/v3_four_channel_output_collection_0/v3_four_channel_placement_0/v3_channel_selector_late_promotion_3/v3_selector_route_pilot_0/G0_MUX_NEG/a_439_47# VSUBS sky130_fd_pr__nfet_01v8 ad=0 pd=0 as=0.1386 ps=1.5 w=0.42 l=0.15
X1170 v3_four_channel_bias_reference_distribution_0/v3_four_channel_phase_distribution_0/v3_four_channel_output_collection_0/v3_four_channel_placement_0/v3_channel_selector_late_promotion_3/v3_selector_route_pilot_0/G0_MUX_NEG/a_76_199# v3_four_channel_bias_reference_distribution_0/v3_four_channel_phase_distribution_0/phase_180 v3_four_channel_bias_reference_distribution_0/v3_four_channel_phase_distribution_0/v3_four_channel_output_collection_0/v3_four_channel_placement_0/v3_channel_selector_late_promotion_3/v3_selector_route_pilot_0/G0_MUX_NEG/a_218_374# v3_four_channel_bias_reference_distribution_0/v3_four_channel_phase_distribution_0/v3_four_channel_output_collection_0/v3_four_channel_placement_0/v3_channel_selector_late_promotion_3/VPWR sky130_fd_pr__pfet_01v8_hvt ad=0.3864 pd=2.68 as=0 ps=0 w=0.42 l=0.15
X1171 v3_four_channel_bias_reference_distribution_0/v3_four_channel_phase_distribution_0/v3_four_channel_output_collection_0/v3_four_channel_placement_0/v3_channel_selector_late_promotion_3/v3_selector_route_pilot_0/G0_MUX_NEG/a_505_21# v3_four_channel_bias_reference_distribution_0/v3_four_channel_phase_distribution_0/v3_four_channel_output_collection_0/v3_four_channel_placement_0/v3_channel_selector_late_promotion_3/group0_bit0 VSUBS VSUBS sky130_fd_pr__nfet_01v8 ad=0.1092 pd=1.36 as=0 ps=0 w=0.42 l=0.15
X1172 v3_four_channel_bias_reference_distribution_0/v3_four_channel_phase_distribution_0/v3_four_channel_output_collection_0/v3_four_channel_placement_0/v3_channel_selector_late_promotion_3/v3_selector_route_pilot_0/G0_MUX_NEG/a_439_47# v3_four_channel_bias_reference_distribution_0/v3_four_channel_phase_distribution_0/phase_180 v3_four_channel_bias_reference_distribution_0/v3_four_channel_phase_distribution_0/v3_four_channel_output_collection_0/v3_four_channel_placement_0/v3_channel_selector_late_promotion_3/v3_selector_route_pilot_0/G0_MUX_NEG/a_76_199# VSUBS sky130_fd_pr__nfet_01v8 ad=0 pd=0 as=0.1995 ps=1.79 w=0.42 l=0.15
X1173 v3_four_channel_bias_reference_distribution_0/v3_four_channel_phase_distribution_0/v3_four_channel_output_collection_0/v3_four_channel_placement_0/v3_channel_selector_late_promotion_3/v3_selector_route_pilot_0/G0_MUX_NEG/a_535_374# v3_four_channel_bias_reference_distribution_0/v3_four_channel_phase_distribution_0/phase_270 v3_four_channel_bias_reference_distribution_0/v3_four_channel_phase_distribution_0/v3_four_channel_output_collection_0/v3_four_channel_placement_0/v3_channel_selector_late_promotion_3/v3_selector_route_pilot_0/G0_MUX_NEG/a_76_199# v3_four_channel_bias_reference_distribution_0/v3_four_channel_phase_distribution_0/v3_four_channel_output_collection_0/v3_four_channel_placement_0/v3_channel_selector_late_promotion_3/VPWR sky130_fd_pr__pfet_01v8_hvt ad=0 pd=0 as=0 ps=0 w=0.42 l=0.15
X1174 v3_four_channel_bias_reference_distribution_0/v3_four_channel_phase_distribution_0/v3_four_channel_output_collection_0/v3_four_channel_placement_0/v3_channel_selector_late_promotion_3/v3_selector_route_pilot_0/G0_MUX_NEG/a_76_199# v3_four_channel_bias_reference_distribution_0/v3_four_channel_phase_distribution_0/phase_270 v3_four_channel_bias_reference_distribution_0/v3_four_channel_phase_distribution_0/v3_four_channel_output_collection_0/v3_four_channel_placement_0/v3_channel_selector_late_promotion_3/v3_selector_route_pilot_0/G0_MUX_NEG/a_218_47# VSUBS sky130_fd_pr__nfet_01v8 ad=0 pd=0 as=0.1386 ps=1.5 w=0.42 l=0.15
X1175 v3_four_channel_bias_reference_distribution_0/v3_four_channel_phase_distribution_0/v3_four_channel_output_collection_0/v3_four_channel_placement_0/v3_channel_selector_late_promotion_3/v3_selector_route_pilot_0/G0_MUX_NEG/a_218_47# v3_four_channel_bias_reference_distribution_0/v3_four_channel_phase_distribution_0/v3_four_channel_output_collection_0/v3_four_channel_placement_0/v3_channel_selector_late_promotion_3/group0_bit0 VSUBS VSUBS sky130_fd_pr__nfet_01v8 ad=0 pd=0 as=0 ps=0 w=0.42 l=0.15
X1176 v3_four_channel_bias_reference_distribution_0/v3_four_channel_phase_distribution_0/v3_four_channel_output_collection_0/v3_four_channel_placement_0/v3_channel_selector_late_promotion_3/VPWR v3_four_channel_bias_reference_distribution_0/v3_four_channel_phase_distribution_0/v3_four_channel_output_collection_0/v3_four_channel_placement_0/v3_channel_selector_late_promotion_3/v3_selector_route_pilot_0/G0_MUX_NEG/a_76_199# v3_four_channel_bias_reference_distribution_0/v3_four_channel_phase_distribution_0/v3_four_channel_output_collection_0/v3_four_channel_placement_0/v3_channel_selector_late_promotion_3/v3_selector_route_pilot_0/G0_MUX_NEG/X v3_four_channel_bias_reference_distribution_0/v3_four_channel_phase_distribution_0/v3_four_channel_output_collection_0/v3_four_channel_placement_0/v3_channel_selector_late_promotion_3/VPWR sky130_fd_pr__pfet_01v8_hvt ad=0 pd=0 as=0.26 ps=2.52 w=1 l=0.15
X1177 VSUBS v3_four_channel_bias_reference_distribution_0/v3_four_channel_phase_distribution_0/v3_four_channel_output_collection_0/v3_four_channel_placement_0/v3_channel_selector_late_promotion_3/v3_selector_route_pilot_0/G0_MUX_NEG/a_76_199# v3_four_channel_bias_reference_distribution_0/v3_four_channel_phase_distribution_0/v3_four_channel_output_collection_0/v3_four_channel_placement_0/v3_channel_selector_late_promotion_3/v3_selector_route_pilot_0/G0_MUX_NEG/X VSUBS sky130_fd_pr__nfet_01v8 ad=0 pd=0 as=0.169 ps=1.82 w=0.65 l=0.15
X1178 v3_four_channel_bias_reference_distribution_0/v3_four_channel_phase_distribution_0/v3_four_channel_output_collection_0/v3_four_channel_placement_0/v3_channel_selector_late_promotion_3/VPWR v3_four_channel_bias_reference_distribution_0/v3_four_channel_phase_distribution_0/v3_four_channel_output_collection_0/v3_four_channel_placement_0/v3_channel_selector_late_promotion_3/v3_selector_route_pilot_0/G2_MUX_AXIS/a_505_21# v3_four_channel_bias_reference_distribution_0/v3_four_channel_phase_distribution_0/v3_four_channel_output_collection_0/v3_four_channel_placement_0/v3_channel_selector_late_promotion_3/v3_selector_route_pilot_0/G2_MUX_AXIS/a_535_374# v3_four_channel_bias_reference_distribution_0/v3_four_channel_phase_distribution_0/v3_four_channel_output_collection_0/v3_four_channel_placement_0/v3_channel_selector_late_promotion_3/VPWR sky130_fd_pr__pfet_01v8_hvt ad=0 pd=0 as=0.0882 ps=1.26 w=0.42 l=0.15
X1179 v3_four_channel_bias_reference_distribution_0/v3_four_channel_phase_distribution_0/v3_four_channel_output_collection_0/v3_four_channel_placement_0/v3_channel_selector_late_promotion_3/v3_selector_route_pilot_0/G2_MUX_AXIS/a_505_21# v3_four_channel_bias_reference_distribution_0/v3_four_channel_phase_distribution_0/v3_four_channel_output_collection_0/v3_four_channel_placement_0/v3_channel_selector_late_promotion_3/group2_bit1 v3_four_channel_bias_reference_distribution_0/v3_four_channel_phase_distribution_0/v3_four_channel_output_collection_0/v3_four_channel_placement_0/v3_channel_selector_late_promotion_3/VPWR v3_four_channel_bias_reference_distribution_0/v3_four_channel_phase_distribution_0/v3_four_channel_output_collection_0/v3_four_channel_placement_0/v3_channel_selector_late_promotion_3/VPWR sky130_fd_pr__pfet_01v8_hvt ad=0.1176 pd=1.4 as=0 ps=0 w=0.42 l=0.15
X1180 v3_four_channel_bias_reference_distribution_0/v3_four_channel_phase_distribution_0/v3_four_channel_output_collection_0/v3_four_channel_placement_0/v3_channel_selector_late_promotion_3/v3_selector_route_pilot_0/G2_MUX_AXIS/a_218_374# v3_four_channel_bias_reference_distribution_0/v3_four_channel_phase_distribution_0/v3_four_channel_output_collection_0/v3_four_channel_placement_0/v3_channel_selector_late_promotion_3/group2_bit1 v3_four_channel_bias_reference_distribution_0/v3_four_channel_phase_distribution_0/v3_four_channel_output_collection_0/v3_four_channel_placement_0/v3_channel_selector_late_promotion_3/VPWR v3_four_channel_bias_reference_distribution_0/v3_four_channel_phase_distribution_0/v3_four_channel_output_collection_0/v3_four_channel_placement_0/v3_channel_selector_late_promotion_3/VPWR sky130_fd_pr__pfet_01v8_hvt ad=0.1533 pd=1.57 as=0 ps=0 w=0.42 l=0.15
X1181 VSUBS v3_four_channel_bias_reference_distribution_0/v3_four_channel_phase_distribution_0/v3_four_channel_output_collection_0/v3_four_channel_placement_0/v3_channel_selector_late_promotion_3/v3_selector_route_pilot_0/G2_MUX_AXIS/a_505_21# v3_four_channel_bias_reference_distribution_0/v3_four_channel_phase_distribution_0/v3_four_channel_output_collection_0/v3_four_channel_placement_0/v3_channel_selector_late_promotion_3/v3_selector_route_pilot_0/G2_MUX_AXIS/a_439_47# VSUBS sky130_fd_pr__nfet_01v8 ad=0 pd=0 as=0.1386 ps=1.5 w=0.42 l=0.15
X1182 v3_four_channel_bias_reference_distribution_0/v3_four_channel_phase_distribution_0/v3_four_channel_output_collection_0/v3_four_channel_placement_0/v3_channel_selector_late_promotion_3/v3_selector_route_pilot_0/G2_MUX_AXIS/a_76_199# v3_four_channel_bias_reference_distribution_0/v3_four_channel_phase_distribution_0/v3_four_channel_output_collection_0/v3_four_channel_placement_0/v3_channel_selector_late_promotion_3/v3_selector_route_pilot_0/G2_MUX_POS/X v3_four_channel_bias_reference_distribution_0/v3_four_channel_phase_distribution_0/v3_four_channel_output_collection_0/v3_four_channel_placement_0/v3_channel_selector_late_promotion_3/v3_selector_route_pilot_0/G2_MUX_AXIS/a_218_374# v3_four_channel_bias_reference_distribution_0/v3_four_channel_phase_distribution_0/v3_four_channel_output_collection_0/v3_four_channel_placement_0/v3_channel_selector_late_promotion_3/VPWR sky130_fd_pr__pfet_01v8_hvt ad=0.3864 pd=2.68 as=0 ps=0 w=0.42 l=0.15
X1183 v3_four_channel_bias_reference_distribution_0/v3_four_channel_phase_distribution_0/v3_four_channel_output_collection_0/v3_four_channel_placement_0/v3_channel_selector_late_promotion_3/v3_selector_route_pilot_0/G2_MUX_AXIS/a_505_21# v3_four_channel_bias_reference_distribution_0/v3_four_channel_phase_distribution_0/v3_four_channel_output_collection_0/v3_four_channel_placement_0/v3_channel_selector_late_promotion_3/group2_bit1 VSUBS VSUBS sky130_fd_pr__nfet_01v8 ad=0.1092 pd=1.36 as=0 ps=0 w=0.42 l=0.15
X1184 v3_four_channel_bias_reference_distribution_0/v3_four_channel_phase_distribution_0/v3_four_channel_output_collection_0/v3_four_channel_placement_0/v3_channel_selector_late_promotion_3/v3_selector_route_pilot_0/G2_MUX_AXIS/a_439_47# v3_four_channel_bias_reference_distribution_0/v3_four_channel_phase_distribution_0/v3_four_channel_output_collection_0/v3_four_channel_placement_0/v3_channel_selector_late_promotion_3/v3_selector_route_pilot_0/G2_MUX_POS/X v3_four_channel_bias_reference_distribution_0/v3_four_channel_phase_distribution_0/v3_four_channel_output_collection_0/v3_four_channel_placement_0/v3_channel_selector_late_promotion_3/v3_selector_route_pilot_0/G2_MUX_AXIS/a_76_199# VSUBS sky130_fd_pr__nfet_01v8 ad=0 pd=0 as=0.1995 ps=1.79 w=0.42 l=0.15
X1185 v3_four_channel_bias_reference_distribution_0/v3_four_channel_phase_distribution_0/v3_four_channel_output_collection_0/v3_four_channel_placement_0/v3_channel_selector_late_promotion_3/v3_selector_route_pilot_0/G2_MUX_AXIS/a_535_374# v3_four_channel_bias_reference_distribution_0/v3_four_channel_phase_distribution_0/v3_four_channel_output_collection_0/v3_four_channel_placement_0/v3_channel_selector_late_promotion_3/v3_selector_route_pilot_0/G2_MUX_NEG/X v3_four_channel_bias_reference_distribution_0/v3_four_channel_phase_distribution_0/v3_four_channel_output_collection_0/v3_four_channel_placement_0/v3_channel_selector_late_promotion_3/v3_selector_route_pilot_0/G2_MUX_AXIS/a_76_199# v3_four_channel_bias_reference_distribution_0/v3_four_channel_phase_distribution_0/v3_four_channel_output_collection_0/v3_four_channel_placement_0/v3_channel_selector_late_promotion_3/VPWR sky130_fd_pr__pfet_01v8_hvt ad=0 pd=0 as=0 ps=0 w=0.42 l=0.15
X1186 v3_four_channel_bias_reference_distribution_0/v3_four_channel_phase_distribution_0/v3_four_channel_output_collection_0/v3_four_channel_placement_0/v3_channel_selector_late_promotion_3/v3_selector_route_pilot_0/G2_MUX_AXIS/a_76_199# v3_four_channel_bias_reference_distribution_0/v3_four_channel_phase_distribution_0/v3_four_channel_output_collection_0/v3_four_channel_placement_0/v3_channel_selector_late_promotion_3/v3_selector_route_pilot_0/G2_MUX_NEG/X v3_four_channel_bias_reference_distribution_0/v3_four_channel_phase_distribution_0/v3_four_channel_output_collection_0/v3_four_channel_placement_0/v3_channel_selector_late_promotion_3/v3_selector_route_pilot_0/G2_MUX_AXIS/a_218_47# VSUBS sky130_fd_pr__nfet_01v8 ad=0 pd=0 as=0.1386 ps=1.5 w=0.42 l=0.15
X1187 v3_four_channel_bias_reference_distribution_0/v3_four_channel_phase_distribution_0/v3_four_channel_output_collection_0/v3_four_channel_placement_0/v3_channel_selector_late_promotion_3/v3_selector_route_pilot_0/G2_MUX_AXIS/a_218_47# v3_four_channel_bias_reference_distribution_0/v3_four_channel_phase_distribution_0/v3_four_channel_output_collection_0/v3_four_channel_placement_0/v3_channel_selector_late_promotion_3/group2_bit1 VSUBS VSUBS sky130_fd_pr__nfet_01v8 ad=0 pd=0 as=0 ps=0 w=0.42 l=0.15
X1188 v3_four_channel_bias_reference_distribution_0/v3_four_channel_phase_distribution_0/v3_four_channel_output_collection_0/v3_four_channel_placement_0/v3_channel_selector_late_promotion_3/VPWR v3_four_channel_bias_reference_distribution_0/v3_four_channel_phase_distribution_0/v3_four_channel_output_collection_0/v3_four_channel_placement_0/v3_channel_selector_late_promotion_3/v3_selector_route_pilot_0/G2_MUX_AXIS/a_76_199# v3_four_channel_bias_reference_distribution_0/v3_four_channel_phase_distribution_0/v3_four_channel_output_collection_0/v3_four_channel_placement_0/v3_channel_selector_late_promotion_3/v3_selector_route_pilot_0/G2_MUX_AXIS/X v3_four_channel_bias_reference_distribution_0/v3_four_channel_phase_distribution_0/v3_four_channel_output_collection_0/v3_four_channel_placement_0/v3_channel_selector_late_promotion_3/VPWR sky130_fd_pr__pfet_01v8_hvt ad=0 pd=0 as=0.26 ps=2.52 w=1 l=0.15
X1189 VSUBS v3_four_channel_bias_reference_distribution_0/v3_four_channel_phase_distribution_0/v3_four_channel_output_collection_0/v3_four_channel_placement_0/v3_channel_selector_late_promotion_3/v3_selector_route_pilot_0/G2_MUX_AXIS/a_76_199# v3_four_channel_bias_reference_distribution_0/v3_four_channel_phase_distribution_0/v3_four_channel_output_collection_0/v3_four_channel_placement_0/v3_channel_selector_late_promotion_3/v3_selector_route_pilot_0/G2_MUX_AXIS/X VSUBS sky130_fd_pr__nfet_01v8 ad=0 pd=0 as=0.169 ps=1.82 w=0.65 l=0.15
X1190 v3_four_channel_bias_reference_distribution_0/v3_four_channel_phase_distribution_0/v3_four_channel_output_collection_0/v3_four_channel_placement_0/v3_channel_selector_late_promotion_3/VPWR v3_four_channel_bias_reference_distribution_0/v3_four_channel_phase_distribution_0/v3_four_channel_output_collection_0/v3_four_channel_placement_0/v3_channel_selector_late_promotion_3/v3_selector_route_pilot_0/G3_MUX_POS/a_505_21# v3_four_channel_bias_reference_distribution_0/v3_four_channel_phase_distribution_0/v3_four_channel_output_collection_0/v3_four_channel_placement_0/v3_channel_selector_late_promotion_3/v3_selector_route_pilot_0/G3_MUX_POS/a_535_374# v3_four_channel_bias_reference_distribution_0/v3_four_channel_phase_distribution_0/v3_four_channel_output_collection_0/v3_four_channel_placement_0/v3_channel_selector_late_promotion_3/VPWR sky130_fd_pr__pfet_01v8_hvt ad=0 pd=0 as=0.0882 ps=1.26 w=0.42 l=0.15
X1191 v3_four_channel_bias_reference_distribution_0/v3_four_channel_phase_distribution_0/v3_four_channel_output_collection_0/v3_four_channel_placement_0/v3_channel_selector_late_promotion_3/v3_selector_route_pilot_0/G3_MUX_POS/a_505_21# v3_four_channel_bias_reference_distribution_0/v3_four_channel_phase_distribution_0/v3_four_channel_output_collection_0/v3_four_channel_placement_0/v3_channel_selector_late_promotion_3/group3_bit0 v3_four_channel_bias_reference_distribution_0/v3_four_channel_phase_distribution_0/v3_four_channel_output_collection_0/v3_four_channel_placement_0/v3_channel_selector_late_promotion_3/VPWR v3_four_channel_bias_reference_distribution_0/v3_four_channel_phase_distribution_0/v3_four_channel_output_collection_0/v3_four_channel_placement_0/v3_channel_selector_late_promotion_3/VPWR sky130_fd_pr__pfet_01v8_hvt ad=0.1176 pd=1.4 as=0 ps=0 w=0.42 l=0.15
X1192 v3_four_channel_bias_reference_distribution_0/v3_four_channel_phase_distribution_0/v3_four_channel_output_collection_0/v3_four_channel_placement_0/v3_channel_selector_late_promotion_3/v3_selector_route_pilot_0/G3_MUX_POS/a_218_374# v3_four_channel_bias_reference_distribution_0/v3_four_channel_phase_distribution_0/v3_four_channel_output_collection_0/v3_four_channel_placement_0/v3_channel_selector_late_promotion_3/group3_bit0 v3_four_channel_bias_reference_distribution_0/v3_four_channel_phase_distribution_0/v3_four_channel_output_collection_0/v3_four_channel_placement_0/v3_channel_selector_late_promotion_3/VPWR v3_four_channel_bias_reference_distribution_0/v3_four_channel_phase_distribution_0/v3_four_channel_output_collection_0/v3_four_channel_placement_0/v3_channel_selector_late_promotion_3/VPWR sky130_fd_pr__pfet_01v8_hvt ad=0.1533 pd=1.57 as=0 ps=0 w=0.42 l=0.15
X1193 VSUBS v3_four_channel_bias_reference_distribution_0/v3_four_channel_phase_distribution_0/v3_four_channel_output_collection_0/v3_four_channel_placement_0/v3_channel_selector_late_promotion_3/v3_selector_route_pilot_0/G3_MUX_POS/a_505_21# v3_four_channel_bias_reference_distribution_0/v3_four_channel_phase_distribution_0/v3_four_channel_output_collection_0/v3_four_channel_placement_0/v3_channel_selector_late_promotion_3/v3_selector_route_pilot_0/G3_MUX_POS/a_439_47# VSUBS sky130_fd_pr__nfet_01v8 ad=0 pd=0 as=0.1386 ps=1.5 w=0.42 l=0.15
X1194 v3_four_channel_bias_reference_distribution_0/v3_four_channel_phase_distribution_0/v3_four_channel_output_collection_0/v3_four_channel_placement_0/v3_channel_selector_late_promotion_3/v3_selector_route_pilot_0/G3_MUX_POS/a_76_199# v3_four_channel_bias_reference_distribution_0/v3_four_channel_phase_distribution_0/phase_0 v3_four_channel_bias_reference_distribution_0/v3_four_channel_phase_distribution_0/v3_four_channel_output_collection_0/v3_four_channel_placement_0/v3_channel_selector_late_promotion_3/v3_selector_route_pilot_0/G3_MUX_POS/a_218_374# v3_four_channel_bias_reference_distribution_0/v3_four_channel_phase_distribution_0/v3_four_channel_output_collection_0/v3_four_channel_placement_0/v3_channel_selector_late_promotion_3/VPWR sky130_fd_pr__pfet_01v8_hvt ad=0.3864 pd=2.68 as=0 ps=0 w=0.42 l=0.15
X1195 v3_four_channel_bias_reference_distribution_0/v3_four_channel_phase_distribution_0/v3_four_channel_output_collection_0/v3_four_channel_placement_0/v3_channel_selector_late_promotion_3/v3_selector_route_pilot_0/G3_MUX_POS/a_505_21# v3_four_channel_bias_reference_distribution_0/v3_four_channel_phase_distribution_0/v3_four_channel_output_collection_0/v3_four_channel_placement_0/v3_channel_selector_late_promotion_3/group3_bit0 VSUBS VSUBS sky130_fd_pr__nfet_01v8 ad=0.1092 pd=1.36 as=0 ps=0 w=0.42 l=0.15
X1196 v3_four_channel_bias_reference_distribution_0/v3_four_channel_phase_distribution_0/v3_four_channel_output_collection_0/v3_four_channel_placement_0/v3_channel_selector_late_promotion_3/v3_selector_route_pilot_0/G3_MUX_POS/a_439_47# v3_four_channel_bias_reference_distribution_0/v3_four_channel_phase_distribution_0/phase_0 v3_four_channel_bias_reference_distribution_0/v3_four_channel_phase_distribution_0/v3_four_channel_output_collection_0/v3_four_channel_placement_0/v3_channel_selector_late_promotion_3/v3_selector_route_pilot_0/G3_MUX_POS/a_76_199# VSUBS sky130_fd_pr__nfet_01v8 ad=0 pd=0 as=0.1995 ps=1.79 w=0.42 l=0.15
X1197 v3_four_channel_bias_reference_distribution_0/v3_four_channel_phase_distribution_0/v3_four_channel_output_collection_0/v3_four_channel_placement_0/v3_channel_selector_late_promotion_3/v3_selector_route_pilot_0/G3_MUX_POS/a_535_374# v3_four_channel_bias_reference_distribution_0/v3_four_channel_phase_distribution_0/phase_90 v3_four_channel_bias_reference_distribution_0/v3_four_channel_phase_distribution_0/v3_four_channel_output_collection_0/v3_four_channel_placement_0/v3_channel_selector_late_promotion_3/v3_selector_route_pilot_0/G3_MUX_POS/a_76_199# v3_four_channel_bias_reference_distribution_0/v3_four_channel_phase_distribution_0/v3_four_channel_output_collection_0/v3_four_channel_placement_0/v3_channel_selector_late_promotion_3/VPWR sky130_fd_pr__pfet_01v8_hvt ad=0 pd=0 as=0 ps=0 w=0.42 l=0.15
X1198 v3_four_channel_bias_reference_distribution_0/v3_four_channel_phase_distribution_0/v3_four_channel_output_collection_0/v3_four_channel_placement_0/v3_channel_selector_late_promotion_3/v3_selector_route_pilot_0/G3_MUX_POS/a_76_199# v3_four_channel_bias_reference_distribution_0/v3_four_channel_phase_distribution_0/phase_90 v3_four_channel_bias_reference_distribution_0/v3_four_channel_phase_distribution_0/v3_four_channel_output_collection_0/v3_four_channel_placement_0/v3_channel_selector_late_promotion_3/v3_selector_route_pilot_0/G3_MUX_POS/a_218_47# VSUBS sky130_fd_pr__nfet_01v8 ad=0 pd=0 as=0.1386 ps=1.5 w=0.42 l=0.15
X1199 v3_four_channel_bias_reference_distribution_0/v3_four_channel_phase_distribution_0/v3_four_channel_output_collection_0/v3_four_channel_placement_0/v3_channel_selector_late_promotion_3/v3_selector_route_pilot_0/G3_MUX_POS/a_218_47# v3_four_channel_bias_reference_distribution_0/v3_four_channel_phase_distribution_0/v3_four_channel_output_collection_0/v3_four_channel_placement_0/v3_channel_selector_late_promotion_3/group3_bit0 VSUBS VSUBS sky130_fd_pr__nfet_01v8 ad=0 pd=0 as=0 ps=0 w=0.42 l=0.15
X1200 v3_four_channel_bias_reference_distribution_0/v3_four_channel_phase_distribution_0/v3_four_channel_output_collection_0/v3_four_channel_placement_0/v3_channel_selector_late_promotion_3/VPWR v3_four_channel_bias_reference_distribution_0/v3_four_channel_phase_distribution_0/v3_four_channel_output_collection_0/v3_four_channel_placement_0/v3_channel_selector_late_promotion_3/v3_selector_route_pilot_0/G3_MUX_POS/a_76_199# v3_four_channel_bias_reference_distribution_0/v3_four_channel_phase_distribution_0/v3_four_channel_output_collection_0/v3_four_channel_placement_0/v3_channel_selector_late_promotion_3/v3_selector_route_pilot_0/G3_MUX_POS/X v3_four_channel_bias_reference_distribution_0/v3_four_channel_phase_distribution_0/v3_four_channel_output_collection_0/v3_four_channel_placement_0/v3_channel_selector_late_promotion_3/VPWR sky130_fd_pr__pfet_01v8_hvt ad=0 pd=0 as=0.26 ps=2.52 w=1 l=0.15
X1201 VSUBS v3_four_channel_bias_reference_distribution_0/v3_four_channel_phase_distribution_0/v3_four_channel_output_collection_0/v3_four_channel_placement_0/v3_channel_selector_late_promotion_3/v3_selector_route_pilot_0/G3_MUX_POS/a_76_199# v3_four_channel_bias_reference_distribution_0/v3_four_channel_phase_distribution_0/v3_four_channel_output_collection_0/v3_four_channel_placement_0/v3_channel_selector_late_promotion_3/v3_selector_route_pilot_0/G3_MUX_POS/X VSUBS sky130_fd_pr__nfet_01v8 ad=0 pd=0 as=0.169 ps=1.82 w=0.65 l=0.15
X1202 v3_four_channel_bias_reference_distribution_0/v3_four_channel_phase_distribution_0/v3_four_channel_output_collection_0/v3_four_channel_placement_0/v3_channel_selector_late_promotion_3/VPWR v3_four_channel_bias_reference_distribution_0/v3_four_channel_phase_distribution_0/v3_four_channel_output_collection_0/v3_four_channel_placement_0/v3_channel_selector_late_promotion_3/v3_selector_route_pilot_0/G3_MUX_NEG/a_505_21# v3_four_channel_bias_reference_distribution_0/v3_four_channel_phase_distribution_0/v3_four_channel_output_collection_0/v3_four_channel_placement_0/v3_channel_selector_late_promotion_3/v3_selector_route_pilot_0/G3_MUX_NEG/a_535_374# v3_four_channel_bias_reference_distribution_0/v3_four_channel_phase_distribution_0/v3_four_channel_output_collection_0/v3_four_channel_placement_0/v3_channel_selector_late_promotion_3/VPWR sky130_fd_pr__pfet_01v8_hvt ad=0 pd=0 as=0.0882 ps=1.26 w=0.42 l=0.15
X1203 v3_four_channel_bias_reference_distribution_0/v3_four_channel_phase_distribution_0/v3_four_channel_output_collection_0/v3_four_channel_placement_0/v3_channel_selector_late_promotion_3/v3_selector_route_pilot_0/G3_MUX_NEG/a_505_21# v3_four_channel_bias_reference_distribution_0/v3_four_channel_phase_distribution_0/v3_four_channel_output_collection_0/v3_four_channel_placement_0/v3_channel_selector_late_promotion_3/group3_bit0 v3_four_channel_bias_reference_distribution_0/v3_four_channel_phase_distribution_0/v3_four_channel_output_collection_0/v3_four_channel_placement_0/v3_channel_selector_late_promotion_3/VPWR v3_four_channel_bias_reference_distribution_0/v3_four_channel_phase_distribution_0/v3_four_channel_output_collection_0/v3_four_channel_placement_0/v3_channel_selector_late_promotion_3/VPWR sky130_fd_pr__pfet_01v8_hvt ad=0.1176 pd=1.4 as=0 ps=0 w=0.42 l=0.15
X1204 v3_four_channel_bias_reference_distribution_0/v3_four_channel_phase_distribution_0/v3_four_channel_output_collection_0/v3_four_channel_placement_0/v3_channel_selector_late_promotion_3/v3_selector_route_pilot_0/G3_MUX_NEG/a_218_374# v3_four_channel_bias_reference_distribution_0/v3_four_channel_phase_distribution_0/v3_four_channel_output_collection_0/v3_four_channel_placement_0/v3_channel_selector_late_promotion_3/group3_bit0 v3_four_channel_bias_reference_distribution_0/v3_four_channel_phase_distribution_0/v3_four_channel_output_collection_0/v3_four_channel_placement_0/v3_channel_selector_late_promotion_3/VPWR v3_four_channel_bias_reference_distribution_0/v3_four_channel_phase_distribution_0/v3_four_channel_output_collection_0/v3_four_channel_placement_0/v3_channel_selector_late_promotion_3/VPWR sky130_fd_pr__pfet_01v8_hvt ad=0.1533 pd=1.57 as=0 ps=0 w=0.42 l=0.15
X1205 VSUBS v3_four_channel_bias_reference_distribution_0/v3_four_channel_phase_distribution_0/v3_four_channel_output_collection_0/v3_four_channel_placement_0/v3_channel_selector_late_promotion_3/v3_selector_route_pilot_0/G3_MUX_NEG/a_505_21# v3_four_channel_bias_reference_distribution_0/v3_four_channel_phase_distribution_0/v3_four_channel_output_collection_0/v3_four_channel_placement_0/v3_channel_selector_late_promotion_3/v3_selector_route_pilot_0/G3_MUX_NEG/a_439_47# VSUBS sky130_fd_pr__nfet_01v8 ad=0 pd=0 as=0.1386 ps=1.5 w=0.42 l=0.15
X1206 v3_four_channel_bias_reference_distribution_0/v3_four_channel_phase_distribution_0/v3_four_channel_output_collection_0/v3_four_channel_placement_0/v3_channel_selector_late_promotion_3/v3_selector_route_pilot_0/G3_MUX_NEG/a_76_199# v3_four_channel_bias_reference_distribution_0/v3_four_channel_phase_distribution_0/phase_180 v3_four_channel_bias_reference_distribution_0/v3_four_channel_phase_distribution_0/v3_four_channel_output_collection_0/v3_four_channel_placement_0/v3_channel_selector_late_promotion_3/v3_selector_route_pilot_0/G3_MUX_NEG/a_218_374# v3_four_channel_bias_reference_distribution_0/v3_four_channel_phase_distribution_0/v3_four_channel_output_collection_0/v3_four_channel_placement_0/v3_channel_selector_late_promotion_3/VPWR sky130_fd_pr__pfet_01v8_hvt ad=0.3864 pd=2.68 as=0 ps=0 w=0.42 l=0.15
X1207 v3_four_channel_bias_reference_distribution_0/v3_four_channel_phase_distribution_0/v3_four_channel_output_collection_0/v3_four_channel_placement_0/v3_channel_selector_late_promotion_3/v3_selector_route_pilot_0/G3_MUX_NEG/a_505_21# v3_four_channel_bias_reference_distribution_0/v3_four_channel_phase_distribution_0/v3_four_channel_output_collection_0/v3_four_channel_placement_0/v3_channel_selector_late_promotion_3/group3_bit0 VSUBS VSUBS sky130_fd_pr__nfet_01v8 ad=0.1092 pd=1.36 as=0 ps=0 w=0.42 l=0.15
X1208 v3_four_channel_bias_reference_distribution_0/v3_four_channel_phase_distribution_0/v3_four_channel_output_collection_0/v3_four_channel_placement_0/v3_channel_selector_late_promotion_3/v3_selector_route_pilot_0/G3_MUX_NEG/a_439_47# v3_four_channel_bias_reference_distribution_0/v3_four_channel_phase_distribution_0/phase_180 v3_four_channel_bias_reference_distribution_0/v3_four_channel_phase_distribution_0/v3_four_channel_output_collection_0/v3_four_channel_placement_0/v3_channel_selector_late_promotion_3/v3_selector_route_pilot_0/G3_MUX_NEG/a_76_199# VSUBS sky130_fd_pr__nfet_01v8 ad=0 pd=0 as=0.1995 ps=1.79 w=0.42 l=0.15
X1209 v3_four_channel_bias_reference_distribution_0/v3_four_channel_phase_distribution_0/v3_four_channel_output_collection_0/v3_four_channel_placement_0/v3_channel_selector_late_promotion_3/v3_selector_route_pilot_0/G3_MUX_NEG/a_535_374# v3_four_channel_bias_reference_distribution_0/v3_four_channel_phase_distribution_0/phase_270 v3_four_channel_bias_reference_distribution_0/v3_four_channel_phase_distribution_0/v3_four_channel_output_collection_0/v3_four_channel_placement_0/v3_channel_selector_late_promotion_3/v3_selector_route_pilot_0/G3_MUX_NEG/a_76_199# v3_four_channel_bias_reference_distribution_0/v3_four_channel_phase_distribution_0/v3_four_channel_output_collection_0/v3_four_channel_placement_0/v3_channel_selector_late_promotion_3/VPWR sky130_fd_pr__pfet_01v8_hvt ad=0 pd=0 as=0 ps=0 w=0.42 l=0.15
X1210 v3_four_channel_bias_reference_distribution_0/v3_four_channel_phase_distribution_0/v3_four_channel_output_collection_0/v3_four_channel_placement_0/v3_channel_selector_late_promotion_3/v3_selector_route_pilot_0/G3_MUX_NEG/a_76_199# v3_four_channel_bias_reference_distribution_0/v3_four_channel_phase_distribution_0/phase_270 v3_four_channel_bias_reference_distribution_0/v3_four_channel_phase_distribution_0/v3_four_channel_output_collection_0/v3_four_channel_placement_0/v3_channel_selector_late_promotion_3/v3_selector_route_pilot_0/G3_MUX_NEG/a_218_47# VSUBS sky130_fd_pr__nfet_01v8 ad=0 pd=0 as=0.1386 ps=1.5 w=0.42 l=0.15
X1211 v3_four_channel_bias_reference_distribution_0/v3_four_channel_phase_distribution_0/v3_four_channel_output_collection_0/v3_four_channel_placement_0/v3_channel_selector_late_promotion_3/v3_selector_route_pilot_0/G3_MUX_NEG/a_218_47# v3_four_channel_bias_reference_distribution_0/v3_four_channel_phase_distribution_0/v3_four_channel_output_collection_0/v3_four_channel_placement_0/v3_channel_selector_late_promotion_3/group3_bit0 VSUBS VSUBS sky130_fd_pr__nfet_01v8 ad=0 pd=0 as=0 ps=0 w=0.42 l=0.15
X1212 v3_four_channel_bias_reference_distribution_0/v3_four_channel_phase_distribution_0/v3_four_channel_output_collection_0/v3_four_channel_placement_0/v3_channel_selector_late_promotion_3/VPWR v3_four_channel_bias_reference_distribution_0/v3_four_channel_phase_distribution_0/v3_four_channel_output_collection_0/v3_four_channel_placement_0/v3_channel_selector_late_promotion_3/v3_selector_route_pilot_0/G3_MUX_NEG/a_76_199# v3_four_channel_bias_reference_distribution_0/v3_four_channel_phase_distribution_0/v3_four_channel_output_collection_0/v3_four_channel_placement_0/v3_channel_selector_late_promotion_3/v3_selector_route_pilot_0/G3_MUX_NEG/X v3_four_channel_bias_reference_distribution_0/v3_four_channel_phase_distribution_0/v3_four_channel_output_collection_0/v3_four_channel_placement_0/v3_channel_selector_late_promotion_3/VPWR sky130_fd_pr__pfet_01v8_hvt ad=0 pd=0 as=0.26 ps=2.52 w=1 l=0.15
X1213 VSUBS v3_four_channel_bias_reference_distribution_0/v3_four_channel_phase_distribution_0/v3_four_channel_output_collection_0/v3_four_channel_placement_0/v3_channel_selector_late_promotion_3/v3_selector_route_pilot_0/G3_MUX_NEG/a_76_199# v3_four_channel_bias_reference_distribution_0/v3_four_channel_phase_distribution_0/v3_four_channel_output_collection_0/v3_four_channel_placement_0/v3_channel_selector_late_promotion_3/v3_selector_route_pilot_0/G3_MUX_NEG/X VSUBS sky130_fd_pr__nfet_01v8 ad=0 pd=0 as=0.169 ps=1.82 w=0.65 l=0.15
X1214 v3_four_channel_bias_reference_distribution_0/v3_four_channel_phase_distribution_0/v3_four_channel_output_collection_0/v3_four_channel_placement_0/v3_channel_selector_late_promotion_3/VPWR v3_four_channel_bias_reference_distribution_0/v3_four_channel_phase_distribution_0/v3_four_channel_output_collection_0/v3_four_channel_placement_0/v3_channel_selector_late_promotion_3/v3_selector_route_pilot_0/G3_LO_P_AND/B v3_four_channel_bias_reference_distribution_0/v3_four_channel_phase_distribution_0/v3_four_channel_output_collection_0/v3_four_channel_placement_0/v3_channel_selector_late_promotion_3/v3_selector_route_pilot_0/G0_LO_P_AND/a_59_75# v3_four_channel_bias_reference_distribution_0/v3_four_channel_phase_distribution_0/v3_four_channel_output_collection_0/v3_four_channel_placement_0/v3_channel_selector_late_promotion_3/VPWR sky130_fd_pr__pfet_01v8_hvt ad=0 pd=0 as=0.1134 ps=1.38 w=0.42 l=0.15
X1215 v3_four_channel_bias_reference_distribution_0/v3_four_channel_phase_distribution_0/v3_four_channel_output_collection_0/v3_four_channel_placement_0/v3_channel_selector_late_promotion_3/v3_selector_route_pilot_0/group0_lo_p v3_four_channel_bias_reference_distribution_0/v3_four_channel_phase_distribution_0/v3_four_channel_output_collection_0/v3_four_channel_placement_0/v3_channel_selector_late_promotion_3/v3_selector_route_pilot_0/G0_LO_P_AND/a_59_75# v3_four_channel_bias_reference_distribution_0/v3_four_channel_phase_distribution_0/v3_four_channel_output_collection_0/v3_four_channel_placement_0/v3_channel_selector_late_promotion_3/VPWR v3_four_channel_bias_reference_distribution_0/v3_four_channel_phase_distribution_0/v3_four_channel_output_collection_0/v3_four_channel_placement_0/v3_channel_selector_late_promotion_3/VPWR sky130_fd_pr__pfet_01v8_hvt ad=0.475 pd=2.95 as=0 ps=0 w=1 l=0.15
X1216 VSUBS v3_four_channel_bias_reference_distribution_0/v3_four_channel_phase_distribution_0/v3_four_channel_output_collection_0/v3_four_channel_placement_0/v3_channel_selector_late_promotion_3/v3_selector_route_pilot_0/G3_LO_P_AND/B v3_four_channel_bias_reference_distribution_0/v3_four_channel_phase_distribution_0/v3_four_channel_output_collection_0/v3_four_channel_placement_0/v3_channel_selector_late_promotion_3/v3_selector_route_pilot_0/G0_LO_P_AND/a_145_75# VSUBS sky130_fd_pr__nfet_01v8 ad=0 pd=0 as=0.1134 ps=1.38 w=0.42 l=0.15
X1217 v3_four_channel_bias_reference_distribution_0/v3_four_channel_phase_distribution_0/v3_four_channel_output_collection_0/v3_four_channel_placement_0/v3_channel_selector_late_promotion_3/v3_selector_route_pilot_0/G0_LO_P_AND/a_59_75# v3_four_channel_bias_reference_distribution_0/v3_four_channel_phase_distribution_0/v3_four_channel_output_collection_0/v3_four_channel_placement_0/v3_channel_selector_late_promotion_3/v3_selector_route_pilot_0/G0_MUX_AXIS/X v3_four_channel_bias_reference_distribution_0/v3_four_channel_phase_distribution_0/v3_four_channel_output_collection_0/v3_four_channel_placement_0/v3_channel_selector_late_promotion_3/VPWR v3_four_channel_bias_reference_distribution_0/v3_four_channel_phase_distribution_0/v3_four_channel_output_collection_0/v3_four_channel_placement_0/v3_channel_selector_late_promotion_3/VPWR sky130_fd_pr__pfet_01v8_hvt ad=0 pd=0 as=0 ps=0 w=0.42 l=0.15
X1218 v3_four_channel_bias_reference_distribution_0/v3_four_channel_phase_distribution_0/v3_four_channel_output_collection_0/v3_four_channel_placement_0/v3_channel_selector_late_promotion_3/v3_selector_route_pilot_0/group0_lo_p v3_four_channel_bias_reference_distribution_0/v3_four_channel_phase_distribution_0/v3_four_channel_output_collection_0/v3_four_channel_placement_0/v3_channel_selector_late_promotion_3/v3_selector_route_pilot_0/G0_LO_P_AND/a_59_75# VSUBS VSUBS sky130_fd_pr__nfet_01v8 ad=0.182 pd=1.86 as=0 ps=0 w=0.65 l=0.15
X1219 v3_four_channel_bias_reference_distribution_0/v3_four_channel_phase_distribution_0/v3_four_channel_output_collection_0/v3_four_channel_placement_0/v3_channel_selector_late_promotion_3/v3_selector_route_pilot_0/G0_LO_P_AND/a_145_75# v3_four_channel_bias_reference_distribution_0/v3_four_channel_phase_distribution_0/v3_four_channel_output_collection_0/v3_four_channel_placement_0/v3_channel_selector_late_promotion_3/v3_selector_route_pilot_0/G0_MUX_AXIS/X v3_four_channel_bias_reference_distribution_0/v3_four_channel_phase_distribution_0/v3_four_channel_output_collection_0/v3_four_channel_placement_0/v3_channel_selector_late_promotion_3/v3_selector_route_pilot_0/G0_LO_P_AND/a_59_75# VSUBS sky130_fd_pr__nfet_01v8 ad=0 pd=0 as=0.1176 ps=1.4 w=0.42 l=0.15
X1220 v3_four_channel_bias_reference_distribution_0/v3_four_channel_phase_distribution_0/v3_four_channel_output_collection_0/v3_four_channel_placement_0/v3_channel_selector_late_promotion_3/VPWR v3_four_channel_bias_reference_distribution_0/v3_four_channel_phase_distribution_0/v3_four_channel_output_collection_0/v3_four_channel_placement_0/v3_channel_selector_late_promotion_3/v3_selector_route_pilot_0/G3_LO_P_AND/B v3_four_channel_bias_reference_distribution_0/v3_four_channel_phase_distribution_0/v3_four_channel_output_collection_0/v3_four_channel_placement_0/v3_channel_selector_late_promotion_3/v3_selector_route_pilot_0/G3_LO_N_ANDNOT/a_207_413# v3_four_channel_bias_reference_distribution_0/v3_four_channel_phase_distribution_0/v3_four_channel_output_collection_0/v3_four_channel_placement_0/v3_channel_selector_late_promotion_3/VPWR sky130_fd_pr__pfet_01v8_hvt ad=0 pd=0 as=0.1218 ps=1.42 w=0.42 l=0.15
X1221 v3_four_channel_bias_reference_distribution_0/v3_four_channel_phase_distribution_0/v3_four_channel_output_collection_0/v3_four_channel_placement_0/v3_channel_selector_late_promotion_3/v3_selector_route_pilot_0/group3_lo_n v3_four_channel_bias_reference_distribution_0/v3_four_channel_phase_distribution_0/v3_four_channel_output_collection_0/v3_four_channel_placement_0/v3_channel_selector_late_promotion_3/v3_selector_route_pilot_0/G3_LO_N_ANDNOT/a_207_413# v3_four_channel_bias_reference_distribution_0/v3_four_channel_phase_distribution_0/v3_four_channel_output_collection_0/v3_four_channel_placement_0/v3_channel_selector_late_promotion_3/VPWR v3_four_channel_bias_reference_distribution_0/v3_four_channel_phase_distribution_0/v3_four_channel_output_collection_0/v3_four_channel_placement_0/v3_channel_selector_late_promotion_3/VPWR sky130_fd_pr__pfet_01v8_hvt ad=0.26 pd=2.52 as=0 ps=0 w=1 l=0.15
X1222 v3_four_channel_bias_reference_distribution_0/v3_four_channel_phase_distribution_0/v3_four_channel_output_collection_0/v3_four_channel_placement_0/v3_channel_selector_late_promotion_3/v3_selector_route_pilot_0/G3_LO_N_ANDNOT/a_297_47# v3_four_channel_bias_reference_distribution_0/v3_four_channel_phase_distribution_0/v3_four_channel_output_collection_0/v3_four_channel_placement_0/v3_channel_selector_late_promotion_3/v3_selector_route_pilot_0/G3_LO_N_ANDNOT/a_27_413# v3_four_channel_bias_reference_distribution_0/v3_four_channel_phase_distribution_0/v3_four_channel_output_collection_0/v3_four_channel_placement_0/v3_channel_selector_late_promotion_3/v3_selector_route_pilot_0/G3_LO_N_ANDNOT/a_207_413# VSUBS sky130_fd_pr__nfet_01v8 ad=0.1008 pd=1.32 as=0.1092 ps=1.36 w=0.42 l=0.15
X1223 v3_four_channel_bias_reference_distribution_0/v3_four_channel_phase_distribution_0/v3_four_channel_output_collection_0/v3_four_channel_placement_0/v3_channel_selector_late_promotion_3/v3_selector_route_pilot_0/group3_lo_n v3_four_channel_bias_reference_distribution_0/v3_four_channel_phase_distribution_0/v3_four_channel_output_collection_0/v3_four_channel_placement_0/v3_channel_selector_late_promotion_3/v3_selector_route_pilot_0/G3_LO_N_ANDNOT/a_207_413# VSUBS VSUBS sky130_fd_pr__nfet_01v8 ad=0.169 pd=1.82 as=0 ps=0 w=0.65 l=0.15
X1224 v3_four_channel_bias_reference_distribution_0/v3_four_channel_phase_distribution_0/v3_four_channel_output_collection_0/v3_four_channel_placement_0/v3_channel_selector_late_promotion_3/v3_selector_route_pilot_0/G3_LO_N_ANDNOT/a_207_413# v3_four_channel_bias_reference_distribution_0/v3_four_channel_phase_distribution_0/v3_four_channel_output_collection_0/v3_four_channel_placement_0/v3_channel_selector_late_promotion_3/v3_selector_route_pilot_0/G3_LO_N_ANDNOT/a_27_413# v3_four_channel_bias_reference_distribution_0/v3_four_channel_phase_distribution_0/v3_four_channel_output_collection_0/v3_four_channel_placement_0/v3_channel_selector_late_promotion_3/VPWR v3_four_channel_bias_reference_distribution_0/v3_four_channel_phase_distribution_0/v3_four_channel_output_collection_0/v3_four_channel_placement_0/v3_channel_selector_late_promotion_3/VPWR sky130_fd_pr__pfet_01v8_hvt ad=0 pd=0 as=0 ps=0 w=0.42 l=0.15
X1225 v3_four_channel_bias_reference_distribution_0/v3_four_channel_phase_distribution_0/v3_four_channel_output_collection_0/v3_four_channel_placement_0/v3_channel_selector_late_promotion_3/VPWR v3_four_channel_bias_reference_distribution_0/v3_four_channel_phase_distribution_0/v3_four_channel_output_collection_0/v3_four_channel_placement_0/v3_channel_selector_late_promotion_3/v3_selector_route_pilot_0/G3_MUX_AXIS/X v3_four_channel_bias_reference_distribution_0/v3_four_channel_phase_distribution_0/v3_four_channel_output_collection_0/v3_four_channel_placement_0/v3_channel_selector_late_promotion_3/v3_selector_route_pilot_0/G3_LO_N_ANDNOT/a_27_413# v3_four_channel_bias_reference_distribution_0/v3_four_channel_phase_distribution_0/v3_four_channel_output_collection_0/v3_four_channel_placement_0/v3_channel_selector_late_promotion_3/VPWR sky130_fd_pr__pfet_01v8_hvt ad=0 pd=0 as=0.1092 ps=1.36 w=0.42 l=0.15
X1226 VSUBS v3_four_channel_bias_reference_distribution_0/v3_four_channel_phase_distribution_0/v3_four_channel_output_collection_0/v3_four_channel_placement_0/v3_channel_selector_late_promotion_3/v3_selector_route_pilot_0/G3_LO_P_AND/B v3_four_channel_bias_reference_distribution_0/v3_four_channel_phase_distribution_0/v3_four_channel_output_collection_0/v3_four_channel_placement_0/v3_channel_selector_late_promotion_3/v3_selector_route_pilot_0/G3_LO_N_ANDNOT/a_297_47# VSUBS sky130_fd_pr__nfet_01v8 ad=0 pd=0 as=0 ps=0 w=0.42 l=0.15
X1227 v3_four_channel_bias_reference_distribution_0/v3_four_channel_phase_distribution_0/v3_four_channel_output_collection_0/v3_four_channel_placement_0/v3_channel_selector_late_promotion_3/v3_selector_route_pilot_0/G3_LO_N_ANDNOT/a_27_413# v3_four_channel_bias_reference_distribution_0/v3_four_channel_phase_distribution_0/v3_four_channel_output_collection_0/v3_four_channel_placement_0/v3_channel_selector_late_promotion_3/v3_selector_route_pilot_0/G3_MUX_AXIS/X VSUBS VSUBS sky130_fd_pr__nfet_01v8 ad=0.1092 pd=1.36 as=0 ps=0 w=0.42 l=0.15
X1228 v3_four_channel_bias_reference_distribution_0/v3_four_channel_phase_distribution_0/v3_four_channel_output_collection_0/v3_four_channel_placement_0/v3_channel_selector_late_promotion_3/VPWR v3_four_channel_bias_reference_distribution_0/v3_four_channel_phase_distribution_0/v3_four_channel_output_collection_0/v3_four_channel_placement_0/v3_channel_selector_late_promotion_3/v3_selector_route_pilot_0/G3_LO_P_AND/B v3_four_channel_bias_reference_distribution_0/v3_four_channel_phase_distribution_0/v3_four_channel_output_collection_0/v3_four_channel_placement_0/v3_channel_selector_late_promotion_3/v3_selector_route_pilot_0/G2_LO_N_ANDNOT/a_207_413# v3_four_channel_bias_reference_distribution_0/v3_four_channel_phase_distribution_0/v3_four_channel_output_collection_0/v3_four_channel_placement_0/v3_channel_selector_late_promotion_3/VPWR sky130_fd_pr__pfet_01v8_hvt ad=0 pd=0 as=0.1218 ps=1.42 w=0.42 l=0.15
X1229 v3_four_channel_bias_reference_distribution_0/v3_four_channel_phase_distribution_0/v3_four_channel_output_collection_0/v3_four_channel_placement_0/v3_channel_selector_late_promotion_3/v3_selector_route_pilot_0/group2_lo_n v3_four_channel_bias_reference_distribution_0/v3_four_channel_phase_distribution_0/v3_four_channel_output_collection_0/v3_four_channel_placement_0/v3_channel_selector_late_promotion_3/v3_selector_route_pilot_0/G2_LO_N_ANDNOT/a_207_413# v3_four_channel_bias_reference_distribution_0/v3_four_channel_phase_distribution_0/v3_four_channel_output_collection_0/v3_four_channel_placement_0/v3_channel_selector_late_promotion_3/VPWR v3_four_channel_bias_reference_distribution_0/v3_four_channel_phase_distribution_0/v3_four_channel_output_collection_0/v3_four_channel_placement_0/v3_channel_selector_late_promotion_3/VPWR sky130_fd_pr__pfet_01v8_hvt ad=0.26 pd=2.52 as=0 ps=0 w=1 l=0.15
X1230 v3_four_channel_bias_reference_distribution_0/v3_four_channel_phase_distribution_0/v3_four_channel_output_collection_0/v3_four_channel_placement_0/v3_channel_selector_late_promotion_3/v3_selector_route_pilot_0/G2_LO_N_ANDNOT/a_297_47# v3_four_channel_bias_reference_distribution_0/v3_four_channel_phase_distribution_0/v3_four_channel_output_collection_0/v3_four_channel_placement_0/v3_channel_selector_late_promotion_3/v3_selector_route_pilot_0/G2_LO_N_ANDNOT/a_27_413# v3_four_channel_bias_reference_distribution_0/v3_four_channel_phase_distribution_0/v3_four_channel_output_collection_0/v3_four_channel_placement_0/v3_channel_selector_late_promotion_3/v3_selector_route_pilot_0/G2_LO_N_ANDNOT/a_207_413# VSUBS sky130_fd_pr__nfet_01v8 ad=0.1008 pd=1.32 as=0.1092 ps=1.36 w=0.42 l=0.15
X1231 v3_four_channel_bias_reference_distribution_0/v3_four_channel_phase_distribution_0/v3_four_channel_output_collection_0/v3_four_channel_placement_0/v3_channel_selector_late_promotion_3/v3_selector_route_pilot_0/group2_lo_n v3_four_channel_bias_reference_distribution_0/v3_four_channel_phase_distribution_0/v3_four_channel_output_collection_0/v3_four_channel_placement_0/v3_channel_selector_late_promotion_3/v3_selector_route_pilot_0/G2_LO_N_ANDNOT/a_207_413# VSUBS VSUBS sky130_fd_pr__nfet_01v8 ad=0.169 pd=1.82 as=0 ps=0 w=0.65 l=0.15
X1232 v3_four_channel_bias_reference_distribution_0/v3_four_channel_phase_distribution_0/v3_four_channel_output_collection_0/v3_four_channel_placement_0/v3_channel_selector_late_promotion_3/v3_selector_route_pilot_0/G2_LO_N_ANDNOT/a_207_413# v3_four_channel_bias_reference_distribution_0/v3_four_channel_phase_distribution_0/v3_four_channel_output_collection_0/v3_four_channel_placement_0/v3_channel_selector_late_promotion_3/v3_selector_route_pilot_0/G2_LO_N_ANDNOT/a_27_413# v3_four_channel_bias_reference_distribution_0/v3_four_channel_phase_distribution_0/v3_four_channel_output_collection_0/v3_four_channel_placement_0/v3_channel_selector_late_promotion_3/VPWR v3_four_channel_bias_reference_distribution_0/v3_four_channel_phase_distribution_0/v3_four_channel_output_collection_0/v3_four_channel_placement_0/v3_channel_selector_late_promotion_3/VPWR sky130_fd_pr__pfet_01v8_hvt ad=0 pd=0 as=0 ps=0 w=0.42 l=0.15
X1233 v3_four_channel_bias_reference_distribution_0/v3_four_channel_phase_distribution_0/v3_four_channel_output_collection_0/v3_four_channel_placement_0/v3_channel_selector_late_promotion_3/VPWR v3_four_channel_bias_reference_distribution_0/v3_four_channel_phase_distribution_0/v3_four_channel_output_collection_0/v3_four_channel_placement_0/v3_channel_selector_late_promotion_3/v3_selector_route_pilot_0/G2_MUX_AXIS/X v3_four_channel_bias_reference_distribution_0/v3_four_channel_phase_distribution_0/v3_four_channel_output_collection_0/v3_four_channel_placement_0/v3_channel_selector_late_promotion_3/v3_selector_route_pilot_0/G2_LO_N_ANDNOT/a_27_413# v3_four_channel_bias_reference_distribution_0/v3_four_channel_phase_distribution_0/v3_four_channel_output_collection_0/v3_four_channel_placement_0/v3_channel_selector_late_promotion_3/VPWR sky130_fd_pr__pfet_01v8_hvt ad=0 pd=0 as=0.1092 ps=1.36 w=0.42 l=0.15
X1234 VSUBS v3_four_channel_bias_reference_distribution_0/v3_four_channel_phase_distribution_0/v3_four_channel_output_collection_0/v3_four_channel_placement_0/v3_channel_selector_late_promotion_3/v3_selector_route_pilot_0/G3_LO_P_AND/B v3_four_channel_bias_reference_distribution_0/v3_four_channel_phase_distribution_0/v3_four_channel_output_collection_0/v3_four_channel_placement_0/v3_channel_selector_late_promotion_3/v3_selector_route_pilot_0/G2_LO_N_ANDNOT/a_297_47# VSUBS sky130_fd_pr__nfet_01v8 ad=0 pd=0 as=0 ps=0 w=0.42 l=0.15
X1235 v3_four_channel_bias_reference_distribution_0/v3_four_channel_phase_distribution_0/v3_four_channel_output_collection_0/v3_four_channel_placement_0/v3_channel_selector_late_promotion_3/v3_selector_route_pilot_0/G2_LO_N_ANDNOT/a_27_413# v3_four_channel_bias_reference_distribution_0/v3_four_channel_phase_distribution_0/v3_four_channel_output_collection_0/v3_four_channel_placement_0/v3_channel_selector_late_promotion_3/v3_selector_route_pilot_0/G2_MUX_AXIS/X VSUBS VSUBS sky130_fd_pr__nfet_01v8 ad=0.1092 pd=1.36 as=0 ps=0 w=0.42 l=0.15
X1236 v3_four_channel_bias_reference_distribution_0/v3_four_channel_phase_distribution_0/v3_four_channel_output_collection_0/v3_four_channel_placement_0/v3_channel_selector_late_promotion_3/VPWR v3_four_channel_bias_reference_distribution_0/v3_four_channel_phase_distribution_0/v3_four_channel_output_collection_0/v3_four_channel_placement_0/v3_channel_selector_late_promotion_3/v3_selector_route_pilot_0/G3_LO_P_AND/B v3_four_channel_bias_reference_distribution_0/v3_four_channel_phase_distribution_0/v3_four_channel_output_collection_0/v3_four_channel_placement_0/v3_channel_selector_late_promotion_3/v3_selector_route_pilot_0/G0_LO_N_ANDNOT/a_207_413# v3_four_channel_bias_reference_distribution_0/v3_four_channel_phase_distribution_0/v3_four_channel_output_collection_0/v3_four_channel_placement_0/v3_channel_selector_late_promotion_3/VPWR sky130_fd_pr__pfet_01v8_hvt ad=0 pd=0 as=0.1218 ps=1.42 w=0.42 l=0.15
X1237 v3_four_channel_bias_reference_distribution_0/v3_four_channel_phase_distribution_0/v3_four_channel_output_collection_0/v3_four_channel_placement_0/v3_channel_selector_late_promotion_3/v3_selector_route_pilot_0/group0_lo_n v3_four_channel_bias_reference_distribution_0/v3_four_channel_phase_distribution_0/v3_four_channel_output_collection_0/v3_four_channel_placement_0/v3_channel_selector_late_promotion_3/v3_selector_route_pilot_0/G0_LO_N_ANDNOT/a_207_413# v3_four_channel_bias_reference_distribution_0/v3_four_channel_phase_distribution_0/v3_four_channel_output_collection_0/v3_four_channel_placement_0/v3_channel_selector_late_promotion_3/VPWR v3_four_channel_bias_reference_distribution_0/v3_four_channel_phase_distribution_0/v3_four_channel_output_collection_0/v3_four_channel_placement_0/v3_channel_selector_late_promotion_3/VPWR sky130_fd_pr__pfet_01v8_hvt ad=0.26 pd=2.52 as=0 ps=0 w=1 l=0.15
X1238 v3_four_channel_bias_reference_distribution_0/v3_four_channel_phase_distribution_0/v3_four_channel_output_collection_0/v3_four_channel_placement_0/v3_channel_selector_late_promotion_3/v3_selector_route_pilot_0/G0_LO_N_ANDNOT/a_297_47# v3_four_channel_bias_reference_distribution_0/v3_four_channel_phase_distribution_0/v3_four_channel_output_collection_0/v3_four_channel_placement_0/v3_channel_selector_late_promotion_3/v3_selector_route_pilot_0/G0_LO_N_ANDNOT/a_27_413# v3_four_channel_bias_reference_distribution_0/v3_four_channel_phase_distribution_0/v3_four_channel_output_collection_0/v3_four_channel_placement_0/v3_channel_selector_late_promotion_3/v3_selector_route_pilot_0/G0_LO_N_ANDNOT/a_207_413# VSUBS sky130_fd_pr__nfet_01v8 ad=0.1008 pd=1.32 as=0.1092 ps=1.36 w=0.42 l=0.15
X1239 v3_four_channel_bias_reference_distribution_0/v3_four_channel_phase_distribution_0/v3_four_channel_output_collection_0/v3_four_channel_placement_0/v3_channel_selector_late_promotion_3/v3_selector_route_pilot_0/group0_lo_n v3_four_channel_bias_reference_distribution_0/v3_four_channel_phase_distribution_0/v3_four_channel_output_collection_0/v3_four_channel_placement_0/v3_channel_selector_late_promotion_3/v3_selector_route_pilot_0/G0_LO_N_ANDNOT/a_207_413# VSUBS VSUBS sky130_fd_pr__nfet_01v8 ad=0.169 pd=1.82 as=0 ps=0 w=0.65 l=0.15
X1240 v3_four_channel_bias_reference_distribution_0/v3_four_channel_phase_distribution_0/v3_four_channel_output_collection_0/v3_four_channel_placement_0/v3_channel_selector_late_promotion_3/v3_selector_route_pilot_0/G0_LO_N_ANDNOT/a_207_413# v3_four_channel_bias_reference_distribution_0/v3_four_channel_phase_distribution_0/v3_four_channel_output_collection_0/v3_four_channel_placement_0/v3_channel_selector_late_promotion_3/v3_selector_route_pilot_0/G0_LO_N_ANDNOT/a_27_413# v3_four_channel_bias_reference_distribution_0/v3_four_channel_phase_distribution_0/v3_four_channel_output_collection_0/v3_four_channel_placement_0/v3_channel_selector_late_promotion_3/VPWR v3_four_channel_bias_reference_distribution_0/v3_four_channel_phase_distribution_0/v3_four_channel_output_collection_0/v3_four_channel_placement_0/v3_channel_selector_late_promotion_3/VPWR sky130_fd_pr__pfet_01v8_hvt ad=0 pd=0 as=0 ps=0 w=0.42 l=0.15
X1241 v3_four_channel_bias_reference_distribution_0/v3_four_channel_phase_distribution_0/v3_four_channel_output_collection_0/v3_four_channel_placement_0/v3_channel_selector_late_promotion_3/VPWR v3_four_channel_bias_reference_distribution_0/v3_four_channel_phase_distribution_0/v3_four_channel_output_collection_0/v3_four_channel_placement_0/v3_channel_selector_late_promotion_3/v3_selector_route_pilot_0/G0_MUX_AXIS/X v3_four_channel_bias_reference_distribution_0/v3_four_channel_phase_distribution_0/v3_four_channel_output_collection_0/v3_four_channel_placement_0/v3_channel_selector_late_promotion_3/v3_selector_route_pilot_0/G0_LO_N_ANDNOT/a_27_413# v3_four_channel_bias_reference_distribution_0/v3_four_channel_phase_distribution_0/v3_four_channel_output_collection_0/v3_four_channel_placement_0/v3_channel_selector_late_promotion_3/VPWR sky130_fd_pr__pfet_01v8_hvt ad=0 pd=0 as=0.1092 ps=1.36 w=0.42 l=0.15
X1242 VSUBS v3_four_channel_bias_reference_distribution_0/v3_four_channel_phase_distribution_0/v3_four_channel_output_collection_0/v3_four_channel_placement_0/v3_channel_selector_late_promotion_3/v3_selector_route_pilot_0/G3_LO_P_AND/B v3_four_channel_bias_reference_distribution_0/v3_four_channel_phase_distribution_0/v3_four_channel_output_collection_0/v3_four_channel_placement_0/v3_channel_selector_late_promotion_3/v3_selector_route_pilot_0/G0_LO_N_ANDNOT/a_297_47# VSUBS sky130_fd_pr__nfet_01v8 ad=0 pd=0 as=0 ps=0 w=0.42 l=0.15
X1243 v3_four_channel_bias_reference_distribution_0/v3_four_channel_phase_distribution_0/v3_four_channel_output_collection_0/v3_four_channel_placement_0/v3_channel_selector_late_promotion_3/v3_selector_route_pilot_0/G0_LO_N_ANDNOT/a_27_413# v3_four_channel_bias_reference_distribution_0/v3_four_channel_phase_distribution_0/v3_four_channel_output_collection_0/v3_four_channel_placement_0/v3_channel_selector_late_promotion_3/v3_selector_route_pilot_0/G0_MUX_AXIS/X VSUBS VSUBS sky130_fd_pr__nfet_01v8 ad=0.1092 pd=1.36 as=0 ps=0 w=0.42 l=0.15
X1244 v3_four_channel_bias_reference_distribution_0/v3_four_channel_phase_distribution_0/v3_four_channel_output_collection_0/v3_four_channel_placement_0/v3_channel_selector_late_promotion_3/VPWR v3_four_channel_bias_reference_distribution_0/v3_four_channel_phase_distribution_0/v3_four_channel_output_collection_0/v3_four_channel_placement_0/v3_channel_selector_late_promotion_3/v3_selector_route_pilot_0/G1_MUX_AXIS/a_505_21# v3_four_channel_bias_reference_distribution_0/v3_four_channel_phase_distribution_0/v3_four_channel_output_collection_0/v3_four_channel_placement_0/v3_channel_selector_late_promotion_3/v3_selector_route_pilot_0/G1_MUX_AXIS/a_535_374# v3_four_channel_bias_reference_distribution_0/v3_four_channel_phase_distribution_0/v3_four_channel_output_collection_0/v3_four_channel_placement_0/v3_channel_selector_late_promotion_3/VPWR sky130_fd_pr__pfet_01v8_hvt ad=0 pd=0 as=0.0882 ps=1.26 w=0.42 l=0.15
X1245 v3_four_channel_bias_reference_distribution_0/v3_four_channel_phase_distribution_0/v3_four_channel_output_collection_0/v3_four_channel_placement_0/v3_channel_selector_late_promotion_3/v3_selector_route_pilot_0/G1_MUX_AXIS/a_505_21# v3_four_channel_bias_reference_distribution_0/v3_four_channel_phase_distribution_0/v3_four_channel_output_collection_0/v3_four_channel_placement_0/v3_channel_selector_late_promotion_3/group1_bit1 v3_four_channel_bias_reference_distribution_0/v3_four_channel_phase_distribution_0/v3_four_channel_output_collection_0/v3_four_channel_placement_0/v3_channel_selector_late_promotion_3/VPWR v3_four_channel_bias_reference_distribution_0/v3_four_channel_phase_distribution_0/v3_four_channel_output_collection_0/v3_four_channel_placement_0/v3_channel_selector_late_promotion_3/VPWR sky130_fd_pr__pfet_01v8_hvt ad=0.1176 pd=1.4 as=0 ps=0 w=0.42 l=0.15
X1246 v3_four_channel_bias_reference_distribution_0/v3_four_channel_phase_distribution_0/v3_four_channel_output_collection_0/v3_four_channel_placement_0/v3_channel_selector_late_promotion_3/v3_selector_route_pilot_0/G1_MUX_AXIS/a_218_374# v3_four_channel_bias_reference_distribution_0/v3_four_channel_phase_distribution_0/v3_four_channel_output_collection_0/v3_four_channel_placement_0/v3_channel_selector_late_promotion_3/group1_bit1 v3_four_channel_bias_reference_distribution_0/v3_four_channel_phase_distribution_0/v3_four_channel_output_collection_0/v3_four_channel_placement_0/v3_channel_selector_late_promotion_3/VPWR v3_four_channel_bias_reference_distribution_0/v3_four_channel_phase_distribution_0/v3_four_channel_output_collection_0/v3_four_channel_placement_0/v3_channel_selector_late_promotion_3/VPWR sky130_fd_pr__pfet_01v8_hvt ad=0.1533 pd=1.57 as=0 ps=0 w=0.42 l=0.15
X1247 VSUBS v3_four_channel_bias_reference_distribution_0/v3_four_channel_phase_distribution_0/v3_four_channel_output_collection_0/v3_four_channel_placement_0/v3_channel_selector_late_promotion_3/v3_selector_route_pilot_0/G1_MUX_AXIS/a_505_21# v3_four_channel_bias_reference_distribution_0/v3_four_channel_phase_distribution_0/v3_four_channel_output_collection_0/v3_four_channel_placement_0/v3_channel_selector_late_promotion_3/v3_selector_route_pilot_0/G1_MUX_AXIS/a_439_47# VSUBS sky130_fd_pr__nfet_01v8 ad=0 pd=0 as=0.1386 ps=1.5 w=0.42 l=0.15
X1248 v3_four_channel_bias_reference_distribution_0/v3_four_channel_phase_distribution_0/v3_four_channel_output_collection_0/v3_four_channel_placement_0/v3_channel_selector_late_promotion_3/v3_selector_route_pilot_0/G1_MUX_AXIS/a_76_199# v3_four_channel_bias_reference_distribution_0/v3_four_channel_phase_distribution_0/v3_four_channel_output_collection_0/v3_four_channel_placement_0/v3_channel_selector_late_promotion_3/v3_selector_route_pilot_0/G1_MUX_POS/X v3_four_channel_bias_reference_distribution_0/v3_four_channel_phase_distribution_0/v3_four_channel_output_collection_0/v3_four_channel_placement_0/v3_channel_selector_late_promotion_3/v3_selector_route_pilot_0/G1_MUX_AXIS/a_218_374# v3_four_channel_bias_reference_distribution_0/v3_four_channel_phase_distribution_0/v3_four_channel_output_collection_0/v3_four_channel_placement_0/v3_channel_selector_late_promotion_3/VPWR sky130_fd_pr__pfet_01v8_hvt ad=0.3864 pd=2.68 as=0 ps=0 w=0.42 l=0.15
X1249 v3_four_channel_bias_reference_distribution_0/v3_four_channel_phase_distribution_0/v3_four_channel_output_collection_0/v3_four_channel_placement_0/v3_channel_selector_late_promotion_3/v3_selector_route_pilot_0/G1_MUX_AXIS/a_505_21# v3_four_channel_bias_reference_distribution_0/v3_four_channel_phase_distribution_0/v3_four_channel_output_collection_0/v3_four_channel_placement_0/v3_channel_selector_late_promotion_3/group1_bit1 VSUBS VSUBS sky130_fd_pr__nfet_01v8 ad=0.1092 pd=1.36 as=0 ps=0 w=0.42 l=0.15
X1250 v3_four_channel_bias_reference_distribution_0/v3_four_channel_phase_distribution_0/v3_four_channel_output_collection_0/v3_four_channel_placement_0/v3_channel_selector_late_promotion_3/v3_selector_route_pilot_0/G1_MUX_AXIS/a_439_47# v3_four_channel_bias_reference_distribution_0/v3_four_channel_phase_distribution_0/v3_four_channel_output_collection_0/v3_four_channel_placement_0/v3_channel_selector_late_promotion_3/v3_selector_route_pilot_0/G1_MUX_POS/X v3_four_channel_bias_reference_distribution_0/v3_four_channel_phase_distribution_0/v3_four_channel_output_collection_0/v3_four_channel_placement_0/v3_channel_selector_late_promotion_3/v3_selector_route_pilot_0/G1_MUX_AXIS/a_76_199# VSUBS sky130_fd_pr__nfet_01v8 ad=0 pd=0 as=0.1995 ps=1.79 w=0.42 l=0.15
X1251 v3_four_channel_bias_reference_distribution_0/v3_four_channel_phase_distribution_0/v3_four_channel_output_collection_0/v3_four_channel_placement_0/v3_channel_selector_late_promotion_3/v3_selector_route_pilot_0/G1_MUX_AXIS/a_535_374# v3_four_channel_bias_reference_distribution_0/v3_four_channel_phase_distribution_0/v3_four_channel_output_collection_0/v3_four_channel_placement_0/v3_channel_selector_late_promotion_3/v3_selector_route_pilot_0/G1_MUX_NEG/X v3_four_channel_bias_reference_distribution_0/v3_four_channel_phase_distribution_0/v3_four_channel_output_collection_0/v3_four_channel_placement_0/v3_channel_selector_late_promotion_3/v3_selector_route_pilot_0/G1_MUX_AXIS/a_76_199# v3_four_channel_bias_reference_distribution_0/v3_four_channel_phase_distribution_0/v3_four_channel_output_collection_0/v3_four_channel_placement_0/v3_channel_selector_late_promotion_3/VPWR sky130_fd_pr__pfet_01v8_hvt ad=0 pd=0 as=0 ps=0 w=0.42 l=0.15
X1252 v3_four_channel_bias_reference_distribution_0/v3_four_channel_phase_distribution_0/v3_four_channel_output_collection_0/v3_four_channel_placement_0/v3_channel_selector_late_promotion_3/v3_selector_route_pilot_0/G1_MUX_AXIS/a_76_199# v3_four_channel_bias_reference_distribution_0/v3_four_channel_phase_distribution_0/v3_four_channel_output_collection_0/v3_four_channel_placement_0/v3_channel_selector_late_promotion_3/v3_selector_route_pilot_0/G1_MUX_NEG/X v3_four_channel_bias_reference_distribution_0/v3_four_channel_phase_distribution_0/v3_four_channel_output_collection_0/v3_four_channel_placement_0/v3_channel_selector_late_promotion_3/v3_selector_route_pilot_0/G1_MUX_AXIS/a_218_47# VSUBS sky130_fd_pr__nfet_01v8 ad=0 pd=0 as=0.1386 ps=1.5 w=0.42 l=0.15
X1253 v3_four_channel_bias_reference_distribution_0/v3_four_channel_phase_distribution_0/v3_four_channel_output_collection_0/v3_four_channel_placement_0/v3_channel_selector_late_promotion_3/v3_selector_route_pilot_0/G1_MUX_AXIS/a_218_47# v3_four_channel_bias_reference_distribution_0/v3_four_channel_phase_distribution_0/v3_four_channel_output_collection_0/v3_four_channel_placement_0/v3_channel_selector_late_promotion_3/group1_bit1 VSUBS VSUBS sky130_fd_pr__nfet_01v8 ad=0 pd=0 as=0 ps=0 w=0.42 l=0.15
X1254 v3_four_channel_bias_reference_distribution_0/v3_four_channel_phase_distribution_0/v3_four_channel_output_collection_0/v3_four_channel_placement_0/v3_channel_selector_late_promotion_3/VPWR v3_four_channel_bias_reference_distribution_0/v3_four_channel_phase_distribution_0/v3_four_channel_output_collection_0/v3_four_channel_placement_0/v3_channel_selector_late_promotion_3/v3_selector_route_pilot_0/G1_MUX_AXIS/a_76_199# v3_four_channel_bias_reference_distribution_0/v3_four_channel_phase_distribution_0/v3_four_channel_output_collection_0/v3_four_channel_placement_0/v3_channel_selector_late_promotion_3/v3_selector_route_pilot_0/G1_MUX_AXIS/X v3_four_channel_bias_reference_distribution_0/v3_four_channel_phase_distribution_0/v3_four_channel_output_collection_0/v3_four_channel_placement_0/v3_channel_selector_late_promotion_3/VPWR sky130_fd_pr__pfet_01v8_hvt ad=0 pd=0 as=0.26 ps=2.52 w=1 l=0.15
X1255 VSUBS v3_four_channel_bias_reference_distribution_0/v3_four_channel_phase_distribution_0/v3_four_channel_output_collection_0/v3_four_channel_placement_0/v3_channel_selector_late_promotion_3/v3_selector_route_pilot_0/G1_MUX_AXIS/a_76_199# v3_four_channel_bias_reference_distribution_0/v3_four_channel_phase_distribution_0/v3_four_channel_output_collection_0/v3_four_channel_placement_0/v3_channel_selector_late_promotion_3/v3_selector_route_pilot_0/G1_MUX_AXIS/X VSUBS sky130_fd_pr__nfet_01v8 ad=0 pd=0 as=0.169 ps=1.82 w=0.65 l=0.15
X1256 v3_four_channel_bias_reference_distribution_0/v3_four_channel_phase_distribution_0/v3_four_channel_output_collection_0/v3_four_channel_placement_0/v3_channel_selector_late_promotion_3/VPWR v3_four_channel_bias_reference_distribution_0/v3_four_channel_phase_distribution_0/v3_four_channel_output_collection_0/v3_four_channel_placement_0/v3_channel_selector_late_promotion_3/v3_selector_route_pilot_0/G3_LO_P_AND/B v3_four_channel_bias_reference_distribution_0/v3_four_channel_phase_distribution_0/v3_four_channel_output_collection_0/v3_four_channel_placement_0/v3_channel_selector_late_promotion_3/v3_selector_route_pilot_0/G1_LO_N_ANDNOT/a_207_413# v3_four_channel_bias_reference_distribution_0/v3_four_channel_phase_distribution_0/v3_four_channel_output_collection_0/v3_four_channel_placement_0/v3_channel_selector_late_promotion_3/VPWR sky130_fd_pr__pfet_01v8_hvt ad=0 pd=0 as=0.1218 ps=1.42 w=0.42 l=0.15
X1257 v3_four_channel_bias_reference_distribution_0/v3_four_channel_phase_distribution_0/v3_four_channel_output_collection_0/v3_four_channel_placement_0/v3_channel_selector_late_promotion_3/v3_selector_route_pilot_0/group1_lo_n v3_four_channel_bias_reference_distribution_0/v3_four_channel_phase_distribution_0/v3_four_channel_output_collection_0/v3_four_channel_placement_0/v3_channel_selector_late_promotion_3/v3_selector_route_pilot_0/G1_LO_N_ANDNOT/a_207_413# v3_four_channel_bias_reference_distribution_0/v3_four_channel_phase_distribution_0/v3_four_channel_output_collection_0/v3_four_channel_placement_0/v3_channel_selector_late_promotion_3/VPWR v3_four_channel_bias_reference_distribution_0/v3_four_channel_phase_distribution_0/v3_four_channel_output_collection_0/v3_four_channel_placement_0/v3_channel_selector_late_promotion_3/VPWR sky130_fd_pr__pfet_01v8_hvt ad=0.26 pd=2.52 as=0 ps=0 w=1 l=0.15
X1258 v3_four_channel_bias_reference_distribution_0/v3_four_channel_phase_distribution_0/v3_four_channel_output_collection_0/v3_four_channel_placement_0/v3_channel_selector_late_promotion_3/v3_selector_route_pilot_0/G1_LO_N_ANDNOT/a_297_47# v3_four_channel_bias_reference_distribution_0/v3_four_channel_phase_distribution_0/v3_four_channel_output_collection_0/v3_four_channel_placement_0/v3_channel_selector_late_promotion_3/v3_selector_route_pilot_0/G1_LO_N_ANDNOT/a_27_413# v3_four_channel_bias_reference_distribution_0/v3_four_channel_phase_distribution_0/v3_four_channel_output_collection_0/v3_four_channel_placement_0/v3_channel_selector_late_promotion_3/v3_selector_route_pilot_0/G1_LO_N_ANDNOT/a_207_413# VSUBS sky130_fd_pr__nfet_01v8 ad=0.1008 pd=1.32 as=0.1092 ps=1.36 w=0.42 l=0.15
X1259 v3_four_channel_bias_reference_distribution_0/v3_four_channel_phase_distribution_0/v3_four_channel_output_collection_0/v3_four_channel_placement_0/v3_channel_selector_late_promotion_3/v3_selector_route_pilot_0/group1_lo_n v3_four_channel_bias_reference_distribution_0/v3_four_channel_phase_distribution_0/v3_four_channel_output_collection_0/v3_four_channel_placement_0/v3_channel_selector_late_promotion_3/v3_selector_route_pilot_0/G1_LO_N_ANDNOT/a_207_413# VSUBS VSUBS sky130_fd_pr__nfet_01v8 ad=0.169 pd=1.82 as=0 ps=0 w=0.65 l=0.15
X1260 v3_four_channel_bias_reference_distribution_0/v3_four_channel_phase_distribution_0/v3_four_channel_output_collection_0/v3_four_channel_placement_0/v3_channel_selector_late_promotion_3/v3_selector_route_pilot_0/G1_LO_N_ANDNOT/a_207_413# v3_four_channel_bias_reference_distribution_0/v3_four_channel_phase_distribution_0/v3_four_channel_output_collection_0/v3_four_channel_placement_0/v3_channel_selector_late_promotion_3/v3_selector_route_pilot_0/G1_LO_N_ANDNOT/a_27_413# v3_four_channel_bias_reference_distribution_0/v3_four_channel_phase_distribution_0/v3_four_channel_output_collection_0/v3_four_channel_placement_0/v3_channel_selector_late_promotion_3/VPWR v3_four_channel_bias_reference_distribution_0/v3_four_channel_phase_distribution_0/v3_four_channel_output_collection_0/v3_four_channel_placement_0/v3_channel_selector_late_promotion_3/VPWR sky130_fd_pr__pfet_01v8_hvt ad=0 pd=0 as=0 ps=0 w=0.42 l=0.15
X1261 v3_four_channel_bias_reference_distribution_0/v3_four_channel_phase_distribution_0/v3_four_channel_output_collection_0/v3_four_channel_placement_0/v3_channel_selector_late_promotion_3/VPWR v3_four_channel_bias_reference_distribution_0/v3_four_channel_phase_distribution_0/v3_four_channel_output_collection_0/v3_four_channel_placement_0/v3_channel_selector_late_promotion_3/v3_selector_route_pilot_0/G1_MUX_AXIS/X v3_four_channel_bias_reference_distribution_0/v3_four_channel_phase_distribution_0/v3_four_channel_output_collection_0/v3_four_channel_placement_0/v3_channel_selector_late_promotion_3/v3_selector_route_pilot_0/G1_LO_N_ANDNOT/a_27_413# v3_four_channel_bias_reference_distribution_0/v3_four_channel_phase_distribution_0/v3_four_channel_output_collection_0/v3_four_channel_placement_0/v3_channel_selector_late_promotion_3/VPWR sky130_fd_pr__pfet_01v8_hvt ad=0 pd=0 as=0.1092 ps=1.36 w=0.42 l=0.15
X1262 VSUBS v3_four_channel_bias_reference_distribution_0/v3_four_channel_phase_distribution_0/v3_four_channel_output_collection_0/v3_four_channel_placement_0/v3_channel_selector_late_promotion_3/v3_selector_route_pilot_0/G3_LO_P_AND/B v3_four_channel_bias_reference_distribution_0/v3_four_channel_phase_distribution_0/v3_four_channel_output_collection_0/v3_four_channel_placement_0/v3_channel_selector_late_promotion_3/v3_selector_route_pilot_0/G1_LO_N_ANDNOT/a_297_47# VSUBS sky130_fd_pr__nfet_01v8 ad=0 pd=0 as=0 ps=0 w=0.42 l=0.15
X1263 v3_four_channel_bias_reference_distribution_0/v3_four_channel_phase_distribution_0/v3_four_channel_output_collection_0/v3_four_channel_placement_0/v3_channel_selector_late_promotion_3/v3_selector_route_pilot_0/G1_LO_N_ANDNOT/a_27_413# v3_four_channel_bias_reference_distribution_0/v3_four_channel_phase_distribution_0/v3_four_channel_output_collection_0/v3_four_channel_placement_0/v3_channel_selector_late_promotion_3/v3_selector_route_pilot_0/G1_MUX_AXIS/X VSUBS VSUBS sky130_fd_pr__nfet_01v8 ad=0.1092 pd=1.36 as=0 ps=0 w=0.42 l=0.15
X1264 v3_four_channel_bias_reference_distribution_0/v3_four_channel_phase_distribution_0/v3_four_channel_output_collection_0/v3_four_channel_placement_0/v3_channel_selector_late_promotion_3/VPWR v3_four_channel_bias_reference_distribution_0/v3_four_channel_phase_distribution_0/v3_four_channel_output_collection_0/v3_four_channel_placement_0/v3_channel_selector_late_promotion_3/v3_selector_route_pilot_0/G3_LO_P_AND/B v3_four_channel_bias_reference_distribution_0/v3_four_channel_phase_distribution_0/v3_four_channel_output_collection_0/v3_four_channel_placement_0/v3_channel_selector_late_promotion_3/v3_selector_route_pilot_0/G3_LO_P_AND/a_59_75# v3_four_channel_bias_reference_distribution_0/v3_four_channel_phase_distribution_0/v3_four_channel_output_collection_0/v3_four_channel_placement_0/v3_channel_selector_late_promotion_3/VPWR sky130_fd_pr__pfet_01v8_hvt ad=0 pd=0 as=0.1134 ps=1.38 w=0.42 l=0.15
X1265 v3_four_channel_bias_reference_distribution_0/v3_four_channel_phase_distribution_0/v3_four_channel_output_collection_0/v3_four_channel_placement_0/v3_channel_selector_late_promotion_3/v3_selector_route_pilot_0/group3_lo_p v3_four_channel_bias_reference_distribution_0/v3_four_channel_phase_distribution_0/v3_four_channel_output_collection_0/v3_four_channel_placement_0/v3_channel_selector_late_promotion_3/v3_selector_route_pilot_0/G3_LO_P_AND/a_59_75# v3_four_channel_bias_reference_distribution_0/v3_four_channel_phase_distribution_0/v3_four_channel_output_collection_0/v3_four_channel_placement_0/v3_channel_selector_late_promotion_3/VPWR v3_four_channel_bias_reference_distribution_0/v3_four_channel_phase_distribution_0/v3_four_channel_output_collection_0/v3_four_channel_placement_0/v3_channel_selector_late_promotion_3/VPWR sky130_fd_pr__pfet_01v8_hvt ad=0.475 pd=2.95 as=0 ps=0 w=1 l=0.15
X1266 VSUBS v3_four_channel_bias_reference_distribution_0/v3_four_channel_phase_distribution_0/v3_four_channel_output_collection_0/v3_four_channel_placement_0/v3_channel_selector_late_promotion_3/v3_selector_route_pilot_0/G3_LO_P_AND/B v3_four_channel_bias_reference_distribution_0/v3_four_channel_phase_distribution_0/v3_four_channel_output_collection_0/v3_four_channel_placement_0/v3_channel_selector_late_promotion_3/v3_selector_route_pilot_0/G3_LO_P_AND/a_145_75# VSUBS sky130_fd_pr__nfet_01v8 ad=0 pd=0 as=0.1134 ps=1.38 w=0.42 l=0.15
X1267 v3_four_channel_bias_reference_distribution_0/v3_four_channel_phase_distribution_0/v3_four_channel_output_collection_0/v3_four_channel_placement_0/v3_channel_selector_late_promotion_3/v3_selector_route_pilot_0/G3_LO_P_AND/a_59_75# v3_four_channel_bias_reference_distribution_0/v3_four_channel_phase_distribution_0/v3_four_channel_output_collection_0/v3_four_channel_placement_0/v3_channel_selector_late_promotion_3/v3_selector_route_pilot_0/G3_MUX_AXIS/X v3_four_channel_bias_reference_distribution_0/v3_four_channel_phase_distribution_0/v3_four_channel_output_collection_0/v3_four_channel_placement_0/v3_channel_selector_late_promotion_3/VPWR v3_four_channel_bias_reference_distribution_0/v3_four_channel_phase_distribution_0/v3_four_channel_output_collection_0/v3_four_channel_placement_0/v3_channel_selector_late_promotion_3/VPWR sky130_fd_pr__pfet_01v8_hvt ad=0 pd=0 as=0 ps=0 w=0.42 l=0.15
X1268 v3_four_channel_bias_reference_distribution_0/v3_four_channel_phase_distribution_0/v3_four_channel_output_collection_0/v3_four_channel_placement_0/v3_channel_selector_late_promotion_3/v3_selector_route_pilot_0/group3_lo_p v3_four_channel_bias_reference_distribution_0/v3_four_channel_phase_distribution_0/v3_four_channel_output_collection_0/v3_four_channel_placement_0/v3_channel_selector_late_promotion_3/v3_selector_route_pilot_0/G3_LO_P_AND/a_59_75# VSUBS VSUBS sky130_fd_pr__nfet_01v8 ad=0.182 pd=1.86 as=0 ps=0 w=0.65 l=0.15
X1269 v3_four_channel_bias_reference_distribution_0/v3_four_channel_phase_distribution_0/v3_four_channel_output_collection_0/v3_four_channel_placement_0/v3_channel_selector_late_promotion_3/v3_selector_route_pilot_0/G3_LO_P_AND/a_145_75# v3_four_channel_bias_reference_distribution_0/v3_four_channel_phase_distribution_0/v3_four_channel_output_collection_0/v3_four_channel_placement_0/v3_channel_selector_late_promotion_3/v3_selector_route_pilot_0/G3_MUX_AXIS/X v3_four_channel_bias_reference_distribution_0/v3_four_channel_phase_distribution_0/v3_four_channel_output_collection_0/v3_four_channel_placement_0/v3_channel_selector_late_promotion_3/v3_selector_route_pilot_0/G3_LO_P_AND/a_59_75# VSUBS sky130_fd_pr__nfet_01v8 ad=0 pd=0 as=0.1176 ps=1.4 w=0.42 l=0.15
X1270 v3_four_channel_bias_reference_distribution_0/v3_four_channel_phase_distribution_0/v3_four_channel_output_collection_0/v3_four_channel_placement_0/v3_channel_selector_late_promotion_3/VPWR v3_four_channel_bias_reference_distribution_0/v3_four_channel_phase_distribution_0/v3_four_channel_output_collection_0/v3_four_channel_placement_0/v3_channel_selector_late_promotion_3/v3_selector_route_pilot_0/G2_MUX_POS/a_505_21# v3_four_channel_bias_reference_distribution_0/v3_four_channel_phase_distribution_0/v3_four_channel_output_collection_0/v3_four_channel_placement_0/v3_channel_selector_late_promotion_3/v3_selector_route_pilot_0/G2_MUX_POS/a_535_374# v3_four_channel_bias_reference_distribution_0/v3_four_channel_phase_distribution_0/v3_four_channel_output_collection_0/v3_four_channel_placement_0/v3_channel_selector_late_promotion_3/VPWR sky130_fd_pr__pfet_01v8_hvt ad=0 pd=0 as=0.0882 ps=1.26 w=0.42 l=0.15
X1271 v3_four_channel_bias_reference_distribution_0/v3_four_channel_phase_distribution_0/v3_four_channel_output_collection_0/v3_four_channel_placement_0/v3_channel_selector_late_promotion_3/v3_selector_route_pilot_0/G2_MUX_POS/a_505_21# v3_four_channel_bias_reference_distribution_0/v3_four_channel_phase_distribution_0/v3_four_channel_output_collection_0/v3_four_channel_placement_0/v3_channel_selector_late_promotion_3/group2_bit0 v3_four_channel_bias_reference_distribution_0/v3_four_channel_phase_distribution_0/v3_four_channel_output_collection_0/v3_four_channel_placement_0/v3_channel_selector_late_promotion_3/VPWR v3_four_channel_bias_reference_distribution_0/v3_four_channel_phase_distribution_0/v3_four_channel_output_collection_0/v3_four_channel_placement_0/v3_channel_selector_late_promotion_3/VPWR sky130_fd_pr__pfet_01v8_hvt ad=0.1176 pd=1.4 as=0 ps=0 w=0.42 l=0.15
X1272 v3_four_channel_bias_reference_distribution_0/v3_four_channel_phase_distribution_0/v3_four_channel_output_collection_0/v3_four_channel_placement_0/v3_channel_selector_late_promotion_3/v3_selector_route_pilot_0/G2_MUX_POS/a_218_374# v3_four_channel_bias_reference_distribution_0/v3_four_channel_phase_distribution_0/v3_four_channel_output_collection_0/v3_four_channel_placement_0/v3_channel_selector_late_promotion_3/group2_bit0 v3_four_channel_bias_reference_distribution_0/v3_four_channel_phase_distribution_0/v3_four_channel_output_collection_0/v3_four_channel_placement_0/v3_channel_selector_late_promotion_3/VPWR v3_four_channel_bias_reference_distribution_0/v3_four_channel_phase_distribution_0/v3_four_channel_output_collection_0/v3_four_channel_placement_0/v3_channel_selector_late_promotion_3/VPWR sky130_fd_pr__pfet_01v8_hvt ad=0.1533 pd=1.57 as=0 ps=0 w=0.42 l=0.15
X1273 VSUBS v3_four_channel_bias_reference_distribution_0/v3_four_channel_phase_distribution_0/v3_four_channel_output_collection_0/v3_four_channel_placement_0/v3_channel_selector_late_promotion_3/v3_selector_route_pilot_0/G2_MUX_POS/a_505_21# v3_four_channel_bias_reference_distribution_0/v3_four_channel_phase_distribution_0/v3_four_channel_output_collection_0/v3_four_channel_placement_0/v3_channel_selector_late_promotion_3/v3_selector_route_pilot_0/G2_MUX_POS/a_439_47# VSUBS sky130_fd_pr__nfet_01v8 ad=0 pd=0 as=0.1386 ps=1.5 w=0.42 l=0.15
X1274 v3_four_channel_bias_reference_distribution_0/v3_four_channel_phase_distribution_0/v3_four_channel_output_collection_0/v3_four_channel_placement_0/v3_channel_selector_late_promotion_3/v3_selector_route_pilot_0/G2_MUX_POS/a_76_199# v3_four_channel_bias_reference_distribution_0/v3_four_channel_phase_distribution_0/phase_0 v3_four_channel_bias_reference_distribution_0/v3_four_channel_phase_distribution_0/v3_four_channel_output_collection_0/v3_four_channel_placement_0/v3_channel_selector_late_promotion_3/v3_selector_route_pilot_0/G2_MUX_POS/a_218_374# v3_four_channel_bias_reference_distribution_0/v3_four_channel_phase_distribution_0/v3_four_channel_output_collection_0/v3_four_channel_placement_0/v3_channel_selector_late_promotion_3/VPWR sky130_fd_pr__pfet_01v8_hvt ad=0.3864 pd=2.68 as=0 ps=0 w=0.42 l=0.15
X1275 v3_four_channel_bias_reference_distribution_0/v3_four_channel_phase_distribution_0/v3_four_channel_output_collection_0/v3_four_channel_placement_0/v3_channel_selector_late_promotion_3/v3_selector_route_pilot_0/G2_MUX_POS/a_505_21# v3_four_channel_bias_reference_distribution_0/v3_four_channel_phase_distribution_0/v3_four_channel_output_collection_0/v3_four_channel_placement_0/v3_channel_selector_late_promotion_3/group2_bit0 VSUBS VSUBS sky130_fd_pr__nfet_01v8 ad=0.1092 pd=1.36 as=0 ps=0 w=0.42 l=0.15
X1276 v3_four_channel_bias_reference_distribution_0/v3_four_channel_phase_distribution_0/v3_four_channel_output_collection_0/v3_four_channel_placement_0/v3_channel_selector_late_promotion_3/v3_selector_route_pilot_0/G2_MUX_POS/a_439_47# v3_four_channel_bias_reference_distribution_0/v3_four_channel_phase_distribution_0/phase_0 v3_four_channel_bias_reference_distribution_0/v3_four_channel_phase_distribution_0/v3_four_channel_output_collection_0/v3_four_channel_placement_0/v3_channel_selector_late_promotion_3/v3_selector_route_pilot_0/G2_MUX_POS/a_76_199# VSUBS sky130_fd_pr__nfet_01v8 ad=0 pd=0 as=0.1995 ps=1.79 w=0.42 l=0.15
X1277 v3_four_channel_bias_reference_distribution_0/v3_four_channel_phase_distribution_0/v3_four_channel_output_collection_0/v3_four_channel_placement_0/v3_channel_selector_late_promotion_3/v3_selector_route_pilot_0/G2_MUX_POS/a_535_374# v3_four_channel_bias_reference_distribution_0/v3_four_channel_phase_distribution_0/phase_90 v3_four_channel_bias_reference_distribution_0/v3_four_channel_phase_distribution_0/v3_four_channel_output_collection_0/v3_four_channel_placement_0/v3_channel_selector_late_promotion_3/v3_selector_route_pilot_0/G2_MUX_POS/a_76_199# v3_four_channel_bias_reference_distribution_0/v3_four_channel_phase_distribution_0/v3_four_channel_output_collection_0/v3_four_channel_placement_0/v3_channel_selector_late_promotion_3/VPWR sky130_fd_pr__pfet_01v8_hvt ad=0 pd=0 as=0 ps=0 w=0.42 l=0.15
X1278 v3_four_channel_bias_reference_distribution_0/v3_four_channel_phase_distribution_0/v3_four_channel_output_collection_0/v3_four_channel_placement_0/v3_channel_selector_late_promotion_3/v3_selector_route_pilot_0/G2_MUX_POS/a_76_199# v3_four_channel_bias_reference_distribution_0/v3_four_channel_phase_distribution_0/phase_90 v3_four_channel_bias_reference_distribution_0/v3_four_channel_phase_distribution_0/v3_four_channel_output_collection_0/v3_four_channel_placement_0/v3_channel_selector_late_promotion_3/v3_selector_route_pilot_0/G2_MUX_POS/a_218_47# VSUBS sky130_fd_pr__nfet_01v8 ad=0 pd=0 as=0.1386 ps=1.5 w=0.42 l=0.15
X1279 v3_four_channel_bias_reference_distribution_0/v3_four_channel_phase_distribution_0/v3_four_channel_output_collection_0/v3_four_channel_placement_0/v3_channel_selector_late_promotion_3/v3_selector_route_pilot_0/G2_MUX_POS/a_218_47# v3_four_channel_bias_reference_distribution_0/v3_four_channel_phase_distribution_0/v3_four_channel_output_collection_0/v3_four_channel_placement_0/v3_channel_selector_late_promotion_3/group2_bit0 VSUBS VSUBS sky130_fd_pr__nfet_01v8 ad=0 pd=0 as=0 ps=0 w=0.42 l=0.15
X1280 v3_four_channel_bias_reference_distribution_0/v3_four_channel_phase_distribution_0/v3_four_channel_output_collection_0/v3_four_channel_placement_0/v3_channel_selector_late_promotion_3/VPWR v3_four_channel_bias_reference_distribution_0/v3_four_channel_phase_distribution_0/v3_four_channel_output_collection_0/v3_four_channel_placement_0/v3_channel_selector_late_promotion_3/v3_selector_route_pilot_0/G2_MUX_POS/a_76_199# v3_four_channel_bias_reference_distribution_0/v3_four_channel_phase_distribution_0/v3_four_channel_output_collection_0/v3_four_channel_placement_0/v3_channel_selector_late_promotion_3/v3_selector_route_pilot_0/G2_MUX_POS/X v3_four_channel_bias_reference_distribution_0/v3_four_channel_phase_distribution_0/v3_four_channel_output_collection_0/v3_four_channel_placement_0/v3_channel_selector_late_promotion_3/VPWR sky130_fd_pr__pfet_01v8_hvt ad=0 pd=0 as=0.26 ps=2.52 w=1 l=0.15
X1281 VSUBS v3_four_channel_bias_reference_distribution_0/v3_four_channel_phase_distribution_0/v3_four_channel_output_collection_0/v3_four_channel_placement_0/v3_channel_selector_late_promotion_3/v3_selector_route_pilot_0/G2_MUX_POS/a_76_199# v3_four_channel_bias_reference_distribution_0/v3_four_channel_phase_distribution_0/v3_four_channel_output_collection_0/v3_four_channel_placement_0/v3_channel_selector_late_promotion_3/v3_selector_route_pilot_0/G2_MUX_POS/X VSUBS sky130_fd_pr__nfet_01v8 ad=0 pd=0 as=0.169 ps=1.82 w=0.65 l=0.15
X1282 v3_four_channel_bias_reference_distribution_0/v3_four_channel_phase_distribution_0/v3_four_channel_output_collection_0/v3_four_channel_placement_0/v3_channel_selector_late_promotion_3/VPWR v3_four_channel_bias_reference_distribution_0/v3_four_channel_phase_distribution_0/v3_four_channel_output_collection_0/v3_four_channel_placement_0/v3_channel_selector_late_promotion_3/v3_selector_route_pilot_0/G2_MUX_NEG/a_505_21# v3_four_channel_bias_reference_distribution_0/v3_four_channel_phase_distribution_0/v3_four_channel_output_collection_0/v3_four_channel_placement_0/v3_channel_selector_late_promotion_3/v3_selector_route_pilot_0/G2_MUX_NEG/a_535_374# v3_four_channel_bias_reference_distribution_0/v3_four_channel_phase_distribution_0/v3_four_channel_output_collection_0/v3_four_channel_placement_0/v3_channel_selector_late_promotion_3/VPWR sky130_fd_pr__pfet_01v8_hvt ad=0 pd=0 as=0.0882 ps=1.26 w=0.42 l=0.15
X1283 v3_four_channel_bias_reference_distribution_0/v3_four_channel_phase_distribution_0/v3_four_channel_output_collection_0/v3_four_channel_placement_0/v3_channel_selector_late_promotion_3/v3_selector_route_pilot_0/G2_MUX_NEG/a_505_21# v3_four_channel_bias_reference_distribution_0/v3_four_channel_phase_distribution_0/v3_four_channel_output_collection_0/v3_four_channel_placement_0/v3_channel_selector_late_promotion_3/group2_bit0 v3_four_channel_bias_reference_distribution_0/v3_four_channel_phase_distribution_0/v3_four_channel_output_collection_0/v3_four_channel_placement_0/v3_channel_selector_late_promotion_3/VPWR v3_four_channel_bias_reference_distribution_0/v3_four_channel_phase_distribution_0/v3_four_channel_output_collection_0/v3_four_channel_placement_0/v3_channel_selector_late_promotion_3/VPWR sky130_fd_pr__pfet_01v8_hvt ad=0.1176 pd=1.4 as=0 ps=0 w=0.42 l=0.15
X1284 v3_four_channel_bias_reference_distribution_0/v3_four_channel_phase_distribution_0/v3_four_channel_output_collection_0/v3_four_channel_placement_0/v3_channel_selector_late_promotion_3/v3_selector_route_pilot_0/G2_MUX_NEG/a_218_374# v3_four_channel_bias_reference_distribution_0/v3_four_channel_phase_distribution_0/v3_four_channel_output_collection_0/v3_four_channel_placement_0/v3_channel_selector_late_promotion_3/group2_bit0 v3_four_channel_bias_reference_distribution_0/v3_four_channel_phase_distribution_0/v3_four_channel_output_collection_0/v3_four_channel_placement_0/v3_channel_selector_late_promotion_3/VPWR v3_four_channel_bias_reference_distribution_0/v3_four_channel_phase_distribution_0/v3_four_channel_output_collection_0/v3_four_channel_placement_0/v3_channel_selector_late_promotion_3/VPWR sky130_fd_pr__pfet_01v8_hvt ad=0.1533 pd=1.57 as=0 ps=0 w=0.42 l=0.15
X1285 VSUBS v3_four_channel_bias_reference_distribution_0/v3_four_channel_phase_distribution_0/v3_four_channel_output_collection_0/v3_four_channel_placement_0/v3_channel_selector_late_promotion_3/v3_selector_route_pilot_0/G2_MUX_NEG/a_505_21# v3_four_channel_bias_reference_distribution_0/v3_four_channel_phase_distribution_0/v3_four_channel_output_collection_0/v3_four_channel_placement_0/v3_channel_selector_late_promotion_3/v3_selector_route_pilot_0/G2_MUX_NEG/a_439_47# VSUBS sky130_fd_pr__nfet_01v8 ad=0 pd=0 as=0.1386 ps=1.5 w=0.42 l=0.15
X1286 v3_four_channel_bias_reference_distribution_0/v3_four_channel_phase_distribution_0/v3_four_channel_output_collection_0/v3_four_channel_placement_0/v3_channel_selector_late_promotion_3/v3_selector_route_pilot_0/G2_MUX_NEG/a_76_199# v3_four_channel_bias_reference_distribution_0/v3_four_channel_phase_distribution_0/phase_180 v3_four_channel_bias_reference_distribution_0/v3_four_channel_phase_distribution_0/v3_four_channel_output_collection_0/v3_four_channel_placement_0/v3_channel_selector_late_promotion_3/v3_selector_route_pilot_0/G2_MUX_NEG/a_218_374# v3_four_channel_bias_reference_distribution_0/v3_four_channel_phase_distribution_0/v3_four_channel_output_collection_0/v3_four_channel_placement_0/v3_channel_selector_late_promotion_3/VPWR sky130_fd_pr__pfet_01v8_hvt ad=0.3864 pd=2.68 as=0 ps=0 w=0.42 l=0.15
X1287 v3_four_channel_bias_reference_distribution_0/v3_four_channel_phase_distribution_0/v3_four_channel_output_collection_0/v3_four_channel_placement_0/v3_channel_selector_late_promotion_3/v3_selector_route_pilot_0/G2_MUX_NEG/a_505_21# v3_four_channel_bias_reference_distribution_0/v3_four_channel_phase_distribution_0/v3_four_channel_output_collection_0/v3_four_channel_placement_0/v3_channel_selector_late_promotion_3/group2_bit0 VSUBS VSUBS sky130_fd_pr__nfet_01v8 ad=0.1092 pd=1.36 as=0 ps=0 w=0.42 l=0.15
X1288 v3_four_channel_bias_reference_distribution_0/v3_four_channel_phase_distribution_0/v3_four_channel_output_collection_0/v3_four_channel_placement_0/v3_channel_selector_late_promotion_3/v3_selector_route_pilot_0/G2_MUX_NEG/a_439_47# v3_four_channel_bias_reference_distribution_0/v3_four_channel_phase_distribution_0/phase_180 v3_four_channel_bias_reference_distribution_0/v3_four_channel_phase_distribution_0/v3_four_channel_output_collection_0/v3_four_channel_placement_0/v3_channel_selector_late_promotion_3/v3_selector_route_pilot_0/G2_MUX_NEG/a_76_199# VSUBS sky130_fd_pr__nfet_01v8 ad=0 pd=0 as=0.1995 ps=1.79 w=0.42 l=0.15
X1289 v3_four_channel_bias_reference_distribution_0/v3_four_channel_phase_distribution_0/v3_four_channel_output_collection_0/v3_four_channel_placement_0/v3_channel_selector_late_promotion_3/v3_selector_route_pilot_0/G2_MUX_NEG/a_535_374# v3_four_channel_bias_reference_distribution_0/v3_four_channel_phase_distribution_0/phase_270 v3_four_channel_bias_reference_distribution_0/v3_four_channel_phase_distribution_0/v3_four_channel_output_collection_0/v3_four_channel_placement_0/v3_channel_selector_late_promotion_3/v3_selector_route_pilot_0/G2_MUX_NEG/a_76_199# v3_four_channel_bias_reference_distribution_0/v3_four_channel_phase_distribution_0/v3_four_channel_output_collection_0/v3_four_channel_placement_0/v3_channel_selector_late_promotion_3/VPWR sky130_fd_pr__pfet_01v8_hvt ad=0 pd=0 as=0 ps=0 w=0.42 l=0.15
X1290 v3_four_channel_bias_reference_distribution_0/v3_four_channel_phase_distribution_0/v3_four_channel_output_collection_0/v3_four_channel_placement_0/v3_channel_selector_late_promotion_3/v3_selector_route_pilot_0/G2_MUX_NEG/a_76_199# v3_four_channel_bias_reference_distribution_0/v3_four_channel_phase_distribution_0/phase_270 v3_four_channel_bias_reference_distribution_0/v3_four_channel_phase_distribution_0/v3_four_channel_output_collection_0/v3_four_channel_placement_0/v3_channel_selector_late_promotion_3/v3_selector_route_pilot_0/G2_MUX_NEG/a_218_47# VSUBS sky130_fd_pr__nfet_01v8 ad=0 pd=0 as=0.1386 ps=1.5 w=0.42 l=0.15
X1291 v3_four_channel_bias_reference_distribution_0/v3_four_channel_phase_distribution_0/v3_four_channel_output_collection_0/v3_four_channel_placement_0/v3_channel_selector_late_promotion_3/v3_selector_route_pilot_0/G2_MUX_NEG/a_218_47# v3_four_channel_bias_reference_distribution_0/v3_four_channel_phase_distribution_0/v3_four_channel_output_collection_0/v3_four_channel_placement_0/v3_channel_selector_late_promotion_3/group2_bit0 VSUBS VSUBS sky130_fd_pr__nfet_01v8 ad=0 pd=0 as=0 ps=0 w=0.42 l=0.15
X1292 v3_four_channel_bias_reference_distribution_0/v3_four_channel_phase_distribution_0/v3_four_channel_output_collection_0/v3_four_channel_placement_0/v3_channel_selector_late_promotion_3/VPWR v3_four_channel_bias_reference_distribution_0/v3_four_channel_phase_distribution_0/v3_four_channel_output_collection_0/v3_four_channel_placement_0/v3_channel_selector_late_promotion_3/v3_selector_route_pilot_0/G2_MUX_NEG/a_76_199# v3_four_channel_bias_reference_distribution_0/v3_four_channel_phase_distribution_0/v3_four_channel_output_collection_0/v3_four_channel_placement_0/v3_channel_selector_late_promotion_3/v3_selector_route_pilot_0/G2_MUX_NEG/X v3_four_channel_bias_reference_distribution_0/v3_four_channel_phase_distribution_0/v3_four_channel_output_collection_0/v3_four_channel_placement_0/v3_channel_selector_late_promotion_3/VPWR sky130_fd_pr__pfet_01v8_hvt ad=0 pd=0 as=0.26 ps=2.52 w=1 l=0.15
X1293 VSUBS v3_four_channel_bias_reference_distribution_0/v3_four_channel_phase_distribution_0/v3_four_channel_output_collection_0/v3_four_channel_placement_0/v3_channel_selector_late_promotion_3/v3_selector_route_pilot_0/G2_MUX_NEG/a_76_199# v3_four_channel_bias_reference_distribution_0/v3_four_channel_phase_distribution_0/v3_four_channel_output_collection_0/v3_four_channel_placement_0/v3_channel_selector_late_promotion_3/v3_selector_route_pilot_0/G2_MUX_NEG/X VSUBS sky130_fd_pr__nfet_01v8 ad=0 pd=0 as=0.169 ps=1.82 w=0.65 l=0.15
X1294 v3_four_channel_bias_reference_distribution_0/v3_four_channel_phase_distribution_0/v3_four_channel_output_collection_0/v3_four_channel_placement_0/v3_channel_selector_late_promotion_3/VPWR v3_four_channel_bias_reference_distribution_0/v3_four_channel_phase_distribution_0/v3_four_channel_output_collection_0/v3_four_channel_placement_0/v3_channel_selector_late_promotion_3/v3_selector_route_pilot_0/G0_MUX_AXIS/a_505_21# v3_four_channel_bias_reference_distribution_0/v3_four_channel_phase_distribution_0/v3_four_channel_output_collection_0/v3_four_channel_placement_0/v3_channel_selector_late_promotion_3/v3_selector_route_pilot_0/G0_MUX_AXIS/a_535_374# v3_four_channel_bias_reference_distribution_0/v3_four_channel_phase_distribution_0/v3_four_channel_output_collection_0/v3_four_channel_placement_0/v3_channel_selector_late_promotion_3/VPWR sky130_fd_pr__pfet_01v8_hvt ad=0 pd=0 as=0.0882 ps=1.26 w=0.42 l=0.15
X1295 v3_four_channel_bias_reference_distribution_0/v3_four_channel_phase_distribution_0/v3_four_channel_output_collection_0/v3_four_channel_placement_0/v3_channel_selector_late_promotion_3/v3_selector_route_pilot_0/G0_MUX_AXIS/a_505_21# v3_four_channel_bias_reference_distribution_0/v3_four_channel_phase_distribution_0/v3_four_channel_output_collection_0/v3_four_channel_placement_0/v3_channel_selector_late_promotion_3/group0_bit1 v3_four_channel_bias_reference_distribution_0/v3_four_channel_phase_distribution_0/v3_four_channel_output_collection_0/v3_four_channel_placement_0/v3_channel_selector_late_promotion_3/VPWR v3_four_channel_bias_reference_distribution_0/v3_four_channel_phase_distribution_0/v3_four_channel_output_collection_0/v3_four_channel_placement_0/v3_channel_selector_late_promotion_3/VPWR sky130_fd_pr__pfet_01v8_hvt ad=0.1176 pd=1.4 as=0 ps=0 w=0.42 l=0.15
X1296 v3_four_channel_bias_reference_distribution_0/v3_four_channel_phase_distribution_0/v3_four_channel_output_collection_0/v3_four_channel_placement_0/v3_channel_selector_late_promotion_3/v3_selector_route_pilot_0/G0_MUX_AXIS/a_218_374# v3_four_channel_bias_reference_distribution_0/v3_four_channel_phase_distribution_0/v3_four_channel_output_collection_0/v3_four_channel_placement_0/v3_channel_selector_late_promotion_3/group0_bit1 v3_four_channel_bias_reference_distribution_0/v3_four_channel_phase_distribution_0/v3_four_channel_output_collection_0/v3_four_channel_placement_0/v3_channel_selector_late_promotion_3/VPWR v3_four_channel_bias_reference_distribution_0/v3_four_channel_phase_distribution_0/v3_four_channel_output_collection_0/v3_four_channel_placement_0/v3_channel_selector_late_promotion_3/VPWR sky130_fd_pr__pfet_01v8_hvt ad=0.1533 pd=1.57 as=0 ps=0 w=0.42 l=0.15
X1297 VSUBS v3_four_channel_bias_reference_distribution_0/v3_four_channel_phase_distribution_0/v3_four_channel_output_collection_0/v3_four_channel_placement_0/v3_channel_selector_late_promotion_3/v3_selector_route_pilot_0/G0_MUX_AXIS/a_505_21# v3_four_channel_bias_reference_distribution_0/v3_four_channel_phase_distribution_0/v3_four_channel_output_collection_0/v3_four_channel_placement_0/v3_channel_selector_late_promotion_3/v3_selector_route_pilot_0/G0_MUX_AXIS/a_439_47# VSUBS sky130_fd_pr__nfet_01v8 ad=0 pd=0 as=0.1386 ps=1.5 w=0.42 l=0.15
X1298 v3_four_channel_bias_reference_distribution_0/v3_four_channel_phase_distribution_0/v3_four_channel_output_collection_0/v3_four_channel_placement_0/v3_channel_selector_late_promotion_3/v3_selector_route_pilot_0/G0_MUX_AXIS/a_76_199# v3_four_channel_bias_reference_distribution_0/v3_four_channel_phase_distribution_0/v3_four_channel_output_collection_0/v3_four_channel_placement_0/v3_channel_selector_late_promotion_3/v3_selector_route_pilot_0/G0_MUX_POS/X v3_four_channel_bias_reference_distribution_0/v3_four_channel_phase_distribution_0/v3_four_channel_output_collection_0/v3_four_channel_placement_0/v3_channel_selector_late_promotion_3/v3_selector_route_pilot_0/G0_MUX_AXIS/a_218_374# v3_four_channel_bias_reference_distribution_0/v3_four_channel_phase_distribution_0/v3_four_channel_output_collection_0/v3_four_channel_placement_0/v3_channel_selector_late_promotion_3/VPWR sky130_fd_pr__pfet_01v8_hvt ad=0.3864 pd=2.68 as=0 ps=0 w=0.42 l=0.15
X1299 v3_four_channel_bias_reference_distribution_0/v3_four_channel_phase_distribution_0/v3_four_channel_output_collection_0/v3_four_channel_placement_0/v3_channel_selector_late_promotion_3/v3_selector_route_pilot_0/G0_MUX_AXIS/a_505_21# v3_four_channel_bias_reference_distribution_0/v3_four_channel_phase_distribution_0/v3_four_channel_output_collection_0/v3_four_channel_placement_0/v3_channel_selector_late_promotion_3/group0_bit1 VSUBS VSUBS sky130_fd_pr__nfet_01v8 ad=0.1092 pd=1.36 as=0 ps=0 w=0.42 l=0.15
X1300 v3_four_channel_bias_reference_distribution_0/v3_four_channel_phase_distribution_0/v3_four_channel_output_collection_0/v3_four_channel_placement_0/v3_channel_selector_late_promotion_3/v3_selector_route_pilot_0/G0_MUX_AXIS/a_439_47# v3_four_channel_bias_reference_distribution_0/v3_four_channel_phase_distribution_0/v3_four_channel_output_collection_0/v3_four_channel_placement_0/v3_channel_selector_late_promotion_3/v3_selector_route_pilot_0/G0_MUX_POS/X v3_four_channel_bias_reference_distribution_0/v3_four_channel_phase_distribution_0/v3_four_channel_output_collection_0/v3_four_channel_placement_0/v3_channel_selector_late_promotion_3/v3_selector_route_pilot_0/G0_MUX_AXIS/a_76_199# VSUBS sky130_fd_pr__nfet_01v8 ad=0 pd=0 as=0.1995 ps=1.79 w=0.42 l=0.15
X1301 v3_four_channel_bias_reference_distribution_0/v3_four_channel_phase_distribution_0/v3_four_channel_output_collection_0/v3_four_channel_placement_0/v3_channel_selector_late_promotion_3/v3_selector_route_pilot_0/G0_MUX_AXIS/a_535_374# v3_four_channel_bias_reference_distribution_0/v3_four_channel_phase_distribution_0/v3_four_channel_output_collection_0/v3_four_channel_placement_0/v3_channel_selector_late_promotion_3/v3_selector_route_pilot_0/G0_MUX_NEG/X v3_four_channel_bias_reference_distribution_0/v3_four_channel_phase_distribution_0/v3_four_channel_output_collection_0/v3_four_channel_placement_0/v3_channel_selector_late_promotion_3/v3_selector_route_pilot_0/G0_MUX_AXIS/a_76_199# v3_four_channel_bias_reference_distribution_0/v3_four_channel_phase_distribution_0/v3_four_channel_output_collection_0/v3_four_channel_placement_0/v3_channel_selector_late_promotion_3/VPWR sky130_fd_pr__pfet_01v8_hvt ad=0 pd=0 as=0 ps=0 w=0.42 l=0.15
X1302 v3_four_channel_bias_reference_distribution_0/v3_four_channel_phase_distribution_0/v3_four_channel_output_collection_0/v3_four_channel_placement_0/v3_channel_selector_late_promotion_3/v3_selector_route_pilot_0/G0_MUX_AXIS/a_76_199# v3_four_channel_bias_reference_distribution_0/v3_four_channel_phase_distribution_0/v3_four_channel_output_collection_0/v3_four_channel_placement_0/v3_channel_selector_late_promotion_3/v3_selector_route_pilot_0/G0_MUX_NEG/X v3_four_channel_bias_reference_distribution_0/v3_four_channel_phase_distribution_0/v3_four_channel_output_collection_0/v3_four_channel_placement_0/v3_channel_selector_late_promotion_3/v3_selector_route_pilot_0/G0_MUX_AXIS/a_218_47# VSUBS sky130_fd_pr__nfet_01v8 ad=0 pd=0 as=0.1386 ps=1.5 w=0.42 l=0.15
X1303 v3_four_channel_bias_reference_distribution_0/v3_four_channel_phase_distribution_0/v3_four_channel_output_collection_0/v3_four_channel_placement_0/v3_channel_selector_late_promotion_3/v3_selector_route_pilot_0/G0_MUX_AXIS/a_218_47# v3_four_channel_bias_reference_distribution_0/v3_four_channel_phase_distribution_0/v3_four_channel_output_collection_0/v3_four_channel_placement_0/v3_channel_selector_late_promotion_3/group0_bit1 VSUBS VSUBS sky130_fd_pr__nfet_01v8 ad=0 pd=0 as=0 ps=0 w=0.42 l=0.15
X1304 v3_four_channel_bias_reference_distribution_0/v3_four_channel_phase_distribution_0/v3_four_channel_output_collection_0/v3_four_channel_placement_0/v3_channel_selector_late_promotion_3/VPWR v3_four_channel_bias_reference_distribution_0/v3_four_channel_phase_distribution_0/v3_four_channel_output_collection_0/v3_four_channel_placement_0/v3_channel_selector_late_promotion_3/v3_selector_route_pilot_0/G0_MUX_AXIS/a_76_199# v3_four_channel_bias_reference_distribution_0/v3_four_channel_phase_distribution_0/v3_four_channel_output_collection_0/v3_four_channel_placement_0/v3_channel_selector_late_promotion_3/v3_selector_route_pilot_0/G0_MUX_AXIS/X v3_four_channel_bias_reference_distribution_0/v3_four_channel_phase_distribution_0/v3_four_channel_output_collection_0/v3_four_channel_placement_0/v3_channel_selector_late_promotion_3/VPWR sky130_fd_pr__pfet_01v8_hvt ad=0 pd=0 as=0.26 ps=2.52 w=1 l=0.15
X1305 VSUBS v3_four_channel_bias_reference_distribution_0/v3_four_channel_phase_distribution_0/v3_four_channel_output_collection_0/v3_four_channel_placement_0/v3_channel_selector_late_promotion_3/v3_selector_route_pilot_0/G0_MUX_AXIS/a_76_199# v3_four_channel_bias_reference_distribution_0/v3_four_channel_phase_distribution_0/v3_four_channel_output_collection_0/v3_four_channel_placement_0/v3_channel_selector_late_promotion_3/v3_selector_route_pilot_0/G0_MUX_AXIS/X VSUBS sky130_fd_pr__nfet_01v8 ad=0 pd=0 as=0.169 ps=1.82 w=0.65 l=0.15
X1306 v3_four_channel_bias_reference_distribution_0/v3_four_channel_phase_distribution_0/v3_four_channel_output_collection_0/v3_four_channel_placement_0/v3_channel_selector_late_promotion_3/VPWR v3_four_channel_bias_reference_distribution_0/v3_four_channel_phase_distribution_0/v3_four_channel_output_collection_0/v3_four_channel_placement_0/v3_channel_selector_late_promotion_3/v3_selector_route_pilot_0/G3_LO_P_AND/B v3_four_channel_bias_reference_distribution_0/v3_four_channel_phase_distribution_0/v3_four_channel_output_collection_0/v3_four_channel_placement_0/v3_channel_selector_late_promotion_3/v3_selector_route_pilot_0/G2_LO_P_AND/a_59_75# v3_four_channel_bias_reference_distribution_0/v3_four_channel_phase_distribution_0/v3_four_channel_output_collection_0/v3_four_channel_placement_0/v3_channel_selector_late_promotion_3/VPWR sky130_fd_pr__pfet_01v8_hvt ad=0 pd=0 as=0.1134 ps=1.38 w=0.42 l=0.15
X1307 v3_four_channel_bias_reference_distribution_0/v3_four_channel_phase_distribution_0/v3_four_channel_output_collection_0/v3_four_channel_placement_0/v3_channel_selector_late_promotion_3/v3_selector_route_pilot_0/group2_lo_p v3_four_channel_bias_reference_distribution_0/v3_four_channel_phase_distribution_0/v3_four_channel_output_collection_0/v3_four_channel_placement_0/v3_channel_selector_late_promotion_3/v3_selector_route_pilot_0/G2_LO_P_AND/a_59_75# v3_four_channel_bias_reference_distribution_0/v3_four_channel_phase_distribution_0/v3_four_channel_output_collection_0/v3_four_channel_placement_0/v3_channel_selector_late_promotion_3/VPWR v3_four_channel_bias_reference_distribution_0/v3_four_channel_phase_distribution_0/v3_four_channel_output_collection_0/v3_four_channel_placement_0/v3_channel_selector_late_promotion_3/VPWR sky130_fd_pr__pfet_01v8_hvt ad=0.475 pd=2.95 as=0 ps=0 w=1 l=0.15
X1308 VSUBS v3_four_channel_bias_reference_distribution_0/v3_four_channel_phase_distribution_0/v3_four_channel_output_collection_0/v3_four_channel_placement_0/v3_channel_selector_late_promotion_3/v3_selector_route_pilot_0/G3_LO_P_AND/B v3_four_channel_bias_reference_distribution_0/v3_four_channel_phase_distribution_0/v3_four_channel_output_collection_0/v3_four_channel_placement_0/v3_channel_selector_late_promotion_3/v3_selector_route_pilot_0/G2_LO_P_AND/a_145_75# VSUBS sky130_fd_pr__nfet_01v8 ad=0 pd=0 as=0.1134 ps=1.38 w=0.42 l=0.15
X1309 v3_four_channel_bias_reference_distribution_0/v3_four_channel_phase_distribution_0/v3_four_channel_output_collection_0/v3_four_channel_placement_0/v3_channel_selector_late_promotion_3/v3_selector_route_pilot_0/G2_LO_P_AND/a_59_75# v3_four_channel_bias_reference_distribution_0/v3_four_channel_phase_distribution_0/v3_four_channel_output_collection_0/v3_four_channel_placement_0/v3_channel_selector_late_promotion_3/v3_selector_route_pilot_0/G2_MUX_AXIS/X v3_four_channel_bias_reference_distribution_0/v3_four_channel_phase_distribution_0/v3_four_channel_output_collection_0/v3_four_channel_placement_0/v3_channel_selector_late_promotion_3/VPWR v3_four_channel_bias_reference_distribution_0/v3_four_channel_phase_distribution_0/v3_four_channel_output_collection_0/v3_four_channel_placement_0/v3_channel_selector_late_promotion_3/VPWR sky130_fd_pr__pfet_01v8_hvt ad=0 pd=0 as=0 ps=0 w=0.42 l=0.15
X1310 v3_four_channel_bias_reference_distribution_0/v3_four_channel_phase_distribution_0/v3_four_channel_output_collection_0/v3_four_channel_placement_0/v3_channel_selector_late_promotion_3/v3_selector_route_pilot_0/group2_lo_p v3_four_channel_bias_reference_distribution_0/v3_four_channel_phase_distribution_0/v3_four_channel_output_collection_0/v3_four_channel_placement_0/v3_channel_selector_late_promotion_3/v3_selector_route_pilot_0/G2_LO_P_AND/a_59_75# VSUBS VSUBS sky130_fd_pr__nfet_01v8 ad=0.182 pd=1.86 as=0 ps=0 w=0.65 l=0.15
X1311 v3_four_channel_bias_reference_distribution_0/v3_four_channel_phase_distribution_0/v3_four_channel_output_collection_0/v3_four_channel_placement_0/v3_channel_selector_late_promotion_3/v3_selector_route_pilot_0/G2_LO_P_AND/a_145_75# v3_four_channel_bias_reference_distribution_0/v3_four_channel_phase_distribution_0/v3_four_channel_output_collection_0/v3_four_channel_placement_0/v3_channel_selector_late_promotion_3/v3_selector_route_pilot_0/G2_MUX_AXIS/X v3_four_channel_bias_reference_distribution_0/v3_four_channel_phase_distribution_0/v3_four_channel_output_collection_0/v3_four_channel_placement_0/v3_channel_selector_late_promotion_3/v3_selector_route_pilot_0/G2_LO_P_AND/a_59_75# VSUBS sky130_fd_pr__nfet_01v8 ad=0 pd=0 as=0.1176 ps=1.4 w=0.42 l=0.15
