* NGSPICE file created from tt_um_jjassonn69_beamformer_magic_flat.ext - technology: sky130A

X0 a_18212_36681# a_18427_33198# a_18354_36488# VDPWR sky130_fd_pr__pfet_01v8_hvt ad=0.1932 pd=1.34 as=0.07665 ps=0.785 w=0.42 l=0.15
X1 a_53574_34863# a_52816_34979# a_53011_34837# VDPWR sky130_fd_pr__pfet_01v8_hvt ad=0.0651 pd=0.73 as=0.07245 ps=0.765 w=0.42 l=0.15
X2 a_40827_40847# a_37795_40535# a_40464_40999# uio_oe[0] sky130_fd_pr__nfet_01v8 ad=0.0693 pd=0.75 as=0.09975 ps=0.895 w=0.42 l=0.15
X3 a_31180_10020# a_16812_8642# uio_oe[0] uio_oe[0] sky130_fd_pr__nfet_01v8 ad=1.4703 pd=10.72 as=1.4703 ps=10.72 w=5.07 l=1
X4 VDPWR a_40525_34293# a_40555_34646# VDPWR sky130_fd_pr__pfet_01v8_hvt ad=0.0693 pd=0.75 as=0.0441 ps=0.63 w=0.42 l=0.15
X5 a_57363_35549# a_41685_42479# uio_oe[0] uio_oe[0] sky130_fd_pr__nfet_01v8 ad=0.1092 pd=1.36 as=0.0567 ps=0.69 w=0.42 l=0.15
X6 a_58772_34471# a_58980_34293# a_58914_34319# uio_oe[0] sky130_fd_pr__nfet_01v8 ad=0.09975 pd=0.895 as=0.0693 ps=0.75 w=0.42 l=0.15
X7 a_41108_35095# a_36425_34293# a_41250_34902# VDPWR sky130_fd_pr__pfet_01v8_hvt ad=0.1932 pd=1.34 as=0.07665 ps=0.785 w=0.42 l=0.15
X8 VDPWR a_36631_41365# a_36661_41391# VDPWR sky130_fd_pr__pfet_01v8_hvt ad=0.135 pd=1.27 as=0.135 ps=1.27 w=1 l=0.15
X9 uio_oe[0] a_40464_40999# a_39759_42492# uio_oe[0] sky130_fd_pr__nfet_01v8 ad=0.11285 pd=1.045 as=0.169 ps=1.82 w=0.65 l=0.15
X10 a_40467_38101# a_40670_38259# VDPWR VDPWR sky130_fd_pr__pfet_01v8_hvt ad=0.0567 pd=0.69 as=0.1134 ps=1.38 w=0.42 l=0.15
X11 a_43837_37557# a_43504_37735# VDPWR VDPWR sky130_fd_pr__pfet_01v8_hvt ad=0.1176 pd=1.4 as=0.0693 ps=0.75 w=0.42 l=0.15
X12 a_61819_36469# a_61644_36495# a_61998_36495# uio_oe[0] sky130_fd_pr__nfet_01v8 ad=0.1092 pd=1.36 as=0.06405 ps=0.725 w=0.42 l=0.15
X13 VDPWR a_61644_35407# a_61819_35381# VDPWR sky130_fd_pr__pfet_01v8_hvt ad=0.1134 pd=1.38 as=0.0567 ps=0.69 w=0.42 l=0.15
X14 a_52573_42845# a_52538_42611# a_52335_42453# uio_oe[0] sky130_fd_pr__nfet_01v8 ad=0.06405 pd=0.725 as=0.1092 ps=1.36 w=0.42 l=0.15
X15 a_44719_40303# a_39947_42997# VDPWR VDPWR sky130_fd_pr__pfet_01v8_hvt ad=0.1092 pd=1.36 as=0.07035 ps=0.755 w=0.42 l=0.15
X16 a_38674_39759# a_38005_40847# uio_oe[0] uio_oe[0] sky130_fd_pr__nfet_01v8 ad=0.0693 pd=0.75 as=0.11285 ps=1.045 w=0.42 l=0.15
X17 a_28700_36057# a_28908_35879# a_28842_35905# uio_oe[0] sky130_fd_pr__nfet_01v8 ad=0.09975 pd=0.895 as=0.0693 ps=0.75 w=0.42 l=0.15
X18 uio_oe[0] a_16812_8642# a_31130_24730# uio_oe[0] sky130_fd_pr__nfet_01v8 ad=1.4703 pd=10.72 as=1.4703 ps=10.72 w=5.07 l=1
X19 a_25162_33224# a_25116_33417# VDPWR VDPWR sky130_fd_pr__pfet_01v8_hvt ad=0.07665 pd=0.785 as=0.15835 ps=1.395 w=0.42 l=0.15
X20 a_39686_41174# a_38005_40847# VDPWR VDPWR sky130_fd_pr__pfet_01v8_hvt ad=0.07665 pd=0.785 as=0.15835 ps=1.395 w=0.42 l=0.15
X21 a_52579_41174# a_51620_40821# a_52507_41174# VDPWR sky130_fd_pr__pfet_01v8_hvt ad=0.1932 pd=1.34 as=0.0441 ps=0.63 w=0.42 l=0.15
X22 a_43695_38645# a_43520_38671# a_43874_38671# uio_oe[0] sky130_fd_pr__nfet_01v8 ad=0.1092 pd=1.36 as=0.06405 ps=0.725 w=0.42 l=0.15
X23 VDPWR a_59860_35095# a_54479_34876# VDPWR sky130_fd_pr__pfet_01v8_hvt ad=0.149 pd=1.325 as=0.26 ps=2.52 w=1 l=0.15
X24 a_4259_24172# a_4259_22596# uio_oe[0] sky130_fd_pr__res_xhigh_po_1p41 l=5.88
X25 a_18641_33483# a_17388_33417# uio_oe[0] uio_oe[0] sky130_fd_pr__nfet_01v8 ad=0.1092 pd=1.36 as=0.1449 ps=1.11 w=0.42 l=0.15
X26 uio_oe[0] a_57012_41365# a_57148_41391# uio_oe[0] sky130_fd_pr__nfet_01v8 ad=0.1137 pd=1.01 as=0.1404 ps=1.6 w=0.54 l=0.15
X27 a_60729_35407# a_60563_35407# uio_oe[0] uio_oe[0] sky130_fd_pr__nfet_01v8 ad=0.1092 pd=1.36 as=0.0567 ps=0.69 w=0.42 l=0.15
X28 a_53719_35407# a_53203_35407# a_53624_35407# uio_oe[0] sky130_fd_pr__special_nfet_01v8 ad=0.0594 pd=0.69 as=0.066 ps=0.745 w=0.36 l=0.15
X29 a_43244_41935# a_42163_41935# a_42897_42177# VDPWR sky130_fd_pr__pfet_01v8_hvt ad=0.0588 pd=0.7 as=0.12915 ps=1.185 w=0.42 l=0.15
X30 a_53981_41935# a_53937_42177# a_53815_41935# uio_oe[0] sky130_fd_pr__nfet_01v8 ad=0.0441 pd=0.63 as=0.1401 ps=1.1 w=0.42 l=0.15
X31 a_60584_41705# a_60416_41669# a_60988_41391# VDPWR sky130_fd_pr__pfet_01v8_hvt ad=0.0567 pd=0.69 as=0.0945 ps=0.87 w=0.42 l=0.15
X32 a_54638_37583# a_46193_39759# uio_oe[0] uio_oe[0] sky130_fd_pr__nfet_01v8 ad=0.06405 pd=0.725 as=0.12495 ps=1.015 w=0.42 l=0.15
X33 a_25241_32641# a_24971_33007# a_25151_33007# uio_oe[0] sky130_fd_pr__nfet_01v8 ad=0.0504 pd=0.66 as=0.1092 ps=1.36 w=0.42 l=0.15
X34 uio_oe[0] a_21553_32641# a_22665_33729# uio_oe[0] sky130_fd_pr__nfet_01v8 ad=0.1013 pd=0.99 as=0.0504 ps=0.66 w=0.42 l=0.15
X35 a_53011_42453# a_52855_42721# a_53156_42479# VDPWR sky130_fd_pr__pfet_01v8_hvt ad=0.07245 pd=0.765 as=0.1155 ps=0.97 w=0.42 l=0.15
X36 a_53815_40847# a_53369_40847# a_53719_40847# uio_oe[0] sky130_fd_pr__special_nfet_01v8 ad=0.1401 pd=1.1 as=0.0594 ps=0.69 w=0.36 l=0.15
X37 a_57046_41099# a_57324_41115# a_57280_41213# VDPWR sky130_fd_pr__pfet_01v8_hvt ad=0.0588 pd=0.7 as=0.0567 ps=0.69 w=0.42 l=0.15
X38 a_20972_34969# a_21107_34273# a_21114_35144# VDPWR sky130_fd_pr__pfet_01v8_hvt ad=0.1932 pd=1.34 as=0.07665 ps=0.785 w=0.42 l=0.15
X39 a_36631_41365# uio_in[2] VDPWR VDPWR sky130_fd_pr__pfet_01v8_hvt ad=0.26 pd=2.52 as=0.135 ps=1.27 w=1 l=0.15
X40 a_38991_41174# a_38740_40821# a_38532_40999# VDPWR sky130_fd_pr__pfet_01v8_hvt ad=0.0441 pd=0.63 as=0.1932 ps=1.34 w=0.42 l=0.15
X41 a_38961_39733# a_38005_40847# VDPWR VDPWR sky130_fd_pr__pfet_01v8_hvt ad=0.1176 pd=1.4 as=0.0693 ps=0.75 w=0.42 l=0.15
X42 a_43638_38127# a_42919_38369# a_43075_38101# uio_oe[0] sky130_fd_pr__special_nfet_01v8 ad=0.066 pd=0.745 as=0.0594 ps=0.69 w=0.36 l=0.15
X43 a_37859_37405# a_37605_37078# uio_oe[0] uio_oe[0] sky130_fd_pr__nfet_01v8 ad=0.0693 pd=0.75 as=0.1449 ps=1.11 w=0.42 l=0.15
X44 a_37859_42518# a_36956_35095# a_37859_42845# uio_oe[0] sky130_fd_pr__nfet_01v8 ad=0.09975 pd=0.895 as=0.0693 ps=0.75 w=0.42 l=0.15
X45 a_42584_40847# ui_in[5] uio_oe[0] uio_oe[0] sky130_fd_pr__nfet_01v8 ad=0.066 pd=0.745 as=0.2205 ps=1.89 w=0.42 l=0.15
X46 a_54723_38166# a_51620_38395# a_54264_38359# VDPWR sky130_fd_pr__pfet_01v8_hvt ad=0.0441 pd=0.63 as=0.1932 ps=1.34 w=0.42 l=0.15
X47 a_50003_37281# a_41685_42479# VDPWR VDPWR sky130_fd_pr__pfet_01v8_hvt ad=0.1664 pd=1.8 as=0.0864 ps=0.91 w=0.64 l=0.15
X48 uio_oe[0] a_38005_41391# a_46027_43023# uio_oe[0] sky130_fd_pr__nfet_01v8 ad=0.0567 pd=0.69 as=0.1092 ps=1.36 w=0.42 l=0.15
X49 a_60984_37583# a_60365_37583# uio_oe[0] uio_oe[0] sky130_fd_pr__nfet_01v8 ad=0.066 pd=0.745 as=0.2205 ps=1.89 w=0.42 l=0.15
X50 a_37579_34863# a_37328_34979# VDPWR VDPWR sky130_fd_pr__pfet_01v8_hvt ad=0.34 pd=2.68 as=0.14575 ps=1.335 w=1 l=0.15
X51 a_47108_43023# a_46027_43023# a_46761_43265# VDPWR sky130_fd_pr__pfet_01v8_hvt ad=0.0588 pd=0.7 as=0.12915 ps=1.185 w=0.42 l=0.15
X52 VDPWR a_45176_41769# a_45351_41695# VDPWR sky130_fd_pr__pfet_01v8_hvt ad=0.1134 pd=1.38 as=0.0567 ps=0.69 w=0.42 l=0.15
X53 uio_oe[0] a_57519_35925# a_57450_35951# uio_oe[0] sky130_fd_pr__nfet_01v8 ad=0.1346 pd=1.15 as=0.0999 ps=0.985 w=0.64 l=0.15
X54 a_51554_41174# a_48677_39759# VDPWR VDPWR sky130_fd_pr__pfet_01v8_hvt ad=0.07665 pd=0.785 as=0.15835 ps=1.395 w=0.42 l=0.15
X55 uio_oe[0] a_39973_37557# a_39907_37583# uio_oe[0] sky130_fd_pr__nfet_01v8 ad=0.1449 pd=1.11 as=0.0693 ps=0.75 w=0.42 l=0.15
X56 a_42488_37735# a_37851_36647# a_42630_37910# VDPWR sky130_fd_pr__pfet_01v8_hvt ad=0.1932 pd=1.34 as=0.07665 ps=0.785 w=0.42 l=0.15
X57 a_53249_36317# a_46193_39759# uio_oe[0] uio_oe[0] sky130_fd_pr__nfet_01v8 ad=0.0441 pd=0.63 as=0.1346 ps=1.15 w=0.42 l=0.15
X58 uio_oe[0] uio_oe[0] uio_oe[0] uio_oe[0] sky130_fd_pr__nfet_01v8 ad=0.1885 pd=1.88 as=367.92319 ps=3.1147k w=0.65 l=0.15
X59 VDPWR a_43837_37557# a_43867_37910# VDPWR sky130_fd_pr__pfet_01v8_hvt ad=0.0693 pd=0.75 as=0.0441 ps=0.63 w=0.42 l=0.15
X60 uio_oe[0] a_37361_41391# a_52800_37583# uio_oe[0] sky130_fd_pr__nfet_01v8 ad=0.11285 pd=1.045 as=0.0693 ps=0.75 w=0.42 l=0.15
X61 uio_oe[0] a_59293_37337# a_59227_37405# uio_oe[0] sky130_fd_pr__nfet_01v8 ad=0.1449 pd=1.11 as=0.0693 ps=0.75 w=0.42 l=0.15
X62 a_29313_34571# a_28980_34505# VDPWR VDPWR sky130_fd_pr__pfet_01v8_hvt ad=0.1176 pd=1.4 as=0.0693 ps=0.75 w=0.42 l=0.15
X63 a_25265_34791# a_24932_34969# uio_oe[0] uio_oe[0] sky130_fd_pr__nfet_01v8 ad=0.1092 pd=1.36 as=0.1449 ps=1.11 w=0.42 l=0.15
X64 a_44516_41935# ui_in[3] uio_oe[0] uio_oe[0] sky130_fd_pr__nfet_01v8 ad=0.066 pd=0.745 as=0.2205 ps=1.89 w=0.42 l=0.15
X65 a_37837_40303# a_37795_40535# a_37755_40303# VDPWR sky130_fd_pr__pfet_01v8_hvt ad=0.135 pd=1.27 as=0.26 ps=2.52 w=1 l=0.15
X66 uio_oe[0] a_57519_39996# a_57450_40125# uio_oe[0] sky130_fd_pr__nfet_01v8 ad=0.1346 pd=1.15 as=0.0999 ps=0.985 w=0.64 l=0.15
X67 a_40987_39457# a_38005_41391# uio_oe[0] uio_oe[0] sky130_fd_pr__nfet_01v8 ad=0.1092 pd=1.36 as=0.0567 ps=0.69 w=0.42 l=0.15
X68 a_60365_39759# a_59939_40086# uio_oe[0] uio_oe[0] sky130_fd_pr__nfet_01v8 ad=0.169 pd=1.82 as=0.11285 ps=1.045 w=0.65 l=0.15
X69 a_57776_39581# a_57640_39529# VDPWR VDPWR sky130_fd_pr__pfet_01v8_hvt ad=0.0567 pd=0.69 as=0.0567 ps=0.69 w=0.42 l=0.15
X70 VDPWR a_61242_41621# a_61192_41391# VDPWR sky130_fd_pr__pfet_01v8_hvt ad=0.2184 pd=2.2 as=0.12495 ps=1.175 w=0.84 l=0.15
X71 uio_oe[0] a_25417_32641# a_26529_35905# uio_oe[0] sky130_fd_pr__nfet_01v8 ad=0.1013 pd=0.99 as=0.0504 ps=0.66 w=0.42 l=0.15
X72 uio_oe[0] a_46193_39759# a_61341_34319# uio_oe[0] sky130_fd_pr__nfet_01v8 ad=0.1346 pd=1.15 as=0.0441 ps=0.63 w=0.42 l=0.15
X73 a_36327_39189# a_36530_39347# VDPWR VDPWR sky130_fd_pr__pfet_01v8_hvt ad=0.0567 pd=0.69 as=0.1134 ps=1.38 w=0.42 l=0.15
X74 a_36835_38921# a_36875_38823# uio_oe[0] uio_oe[0] sky130_fd_pr__nfet_01v8 ad=0.08775 pd=0.92 as=0.169 ps=1.82 w=0.65 l=0.15
X75 VDPWR a_44905_38671# a_50304_38127# VDPWR sky130_fd_pr__pfet_01v8_hvt ad=0.07035 pd=0.755 as=0.1092 ps=1.36 w=0.42 l=0.15
X76 ua[4] a_20620_10782# a_20490_10020# uio_oe[0] sky130_fd_pr__nfet_01v8 ad=0.1885 pd=1.88 as=0.1885 ps=1.88 w=0.65 l=0.15
X77 a_59939_40086# a_51620_39733# a_59939_39759# uio_oe[0] sky130_fd_pr__nfet_01v8 ad=0.09975 pd=0.895 as=0.0693 ps=0.75 w=0.42 l=0.15
X78 VDPWR a_50159_37013# a_50090_37039# VDPWR sky130_fd_pr__pfet_01v8_hvt ad=0.2184 pd=2.2 as=0.12915 ps=1.185 w=0.84 l=0.15
X79 uio_oe[0] a_21553_32641# a_21961_35933# uio_oe[0] sky130_fd_pr__nfet_01v8 ad=0.1118 pd=1.04 as=0.0567 ps=0.69 w=0.42 l=0.15
X80 uio_oe[0] a_17721_34571# a_17655_34639# uio_oe[0] sky130_fd_pr__nfet_01v8 ad=0.1449 pd=1.11 as=0.0693 ps=0.75 w=0.42 l=0.15
X81 uio_oe[0] a_38532_41623# a_17388_34505# uio_oe[0] sky130_fd_pr__nfet_01v8 ad=0.11285 pd=1.045 as=0.169 ps=1.82 w=0.65 l=0.15
X82 a_56916_37271# a_57012_37013# VDPWR VDPWR sky130_fd_pr__pfet_01v8_hvt ad=0.1664 pd=1.8 as=0.149 ps=1.325 w=0.64 l=0.15
X83 uio_oe[0] a_25020_35593# a_24971_35361# uio_oe[0] sky130_fd_pr__nfet_01v8 ad=0.11285 pd=1.045 as=0.169 ps=1.82 w=0.65 l=0.15
X84 a_28642_10464# a_28348_10782# ua[5] uio_oe[0] sky130_fd_pr__nfet_01v8 ad=0.1885 pd=1.88 as=0.1885 ps=1.88 w=0.65 l=0.15
X85 a_22665_33729# a_22395_34095# a_22575_34095# uio_oe[0] sky130_fd_pr__nfet_01v8 ad=0.0504 pd=0.66 as=0.1092 ps=1.36 w=0.42 l=0.15
X86 uio_oe[0] a_36661_41391# a_59685_41174# uio_oe[0] sky130_fd_pr__nfet_01v8 ad=0.1449 pd=1.11 as=0.1092 ps=1.36 w=0.42 l=0.15
X87 a_47217_40681# a_46027_40309# a_47108_40681# uio_oe[0] sky130_fd_pr__special_nfet_01v8 ad=0.0669 pd=0.75 as=0.0711 ps=0.755 w=0.36 l=0.15
X88 a_58248_37039# a_57556_37013# a_57640_37353# VDPWR sky130_fd_pr__pfet_01v8_hvt ad=0.12495 pd=1.175 as=0.0567 ps=0.69 w=0.42 l=0.15
X89 ua[4] a_20620_10376# a_21882_22020# uio_oe[0] sky130_fd_pr__nfet_01v8 ad=0.1885 pd=1.88 as=0.1885 ps=1.88 w=0.65 l=0.15
X90 uio_oe[0] a_42953_34837# a_42985_35229# uio_oe[0] sky130_fd_pr__nfet_01v8 ad=0.1013 pd=0.99 as=0.0504 ps=0.66 w=0.42 l=0.15
X91 uio_oe[0] a_49483_35925# a_38771_35967# uio_oe[0] sky130_fd_pr__nfet_01v8 ad=0.2087 pd=2.02 as=0.169 ps=1.82 w=0.65 l=0.15
X92 a_49686_36083# a_50003_36193# a_49961_36317# uio_oe[0] sky130_fd_pr__special_nfet_01v8 ad=0.0711 pd=0.755 as=0.0669 ps=0.75 w=0.36 l=0.15
X93 a_39947_42997# a_41231_42997# VDPWR VDPWR sky130_fd_pr__pfet_01v8_hvt ad=0.135 pd=1.27 as=0.26 ps=2.52 w=1 l=0.15
X94 uio_oe[0] a_51841_37557# a_51775_37583# uio_oe[0] sky130_fd_pr__nfet_01v8 ad=0.1449 pd=1.11 as=0.0693 ps=0.75 w=0.42 l=0.15
X95 a_51841_36469# a_48677_38127# uio_oe[0] uio_oe[0] sky130_fd_pr__nfet_01v8 ad=0.1092 pd=1.36 as=0.1449 ps=1.11 w=0.42 l=0.15
X96 a_57363_42721# a_38649_43023# VDPWR VDPWR sky130_fd_pr__pfet_01v8_hvt ad=0.1664 pd=1.8 as=0.0864 ps=0.91 w=0.64 l=0.15
X97 a_57598_37405# a_57556_37013# a_57012_37013# uio_oe[0] sky130_fd_pr__nfet_01v8 ad=0.0441 pd=0.63 as=0.0693 ps=0.75 w=0.42 l=0.15
X98 a_30303_35183# a_30123_35183# VDPWR VDPWR sky130_fd_pr__pfet_01v8_hvt ad=0.0609 pd=0.71 as=0.0714 ps=0.76 w=0.42 l=0.15
X99 uio_oe[0] a_60371_42453# a_60302_42479# uio_oe[0] sky130_fd_pr__nfet_01v8 ad=0.1346 pd=1.15 as=0.0999 ps=0.985 w=0.64 l=0.15
X100 a_40606_41174# a_37661_37052# VDPWR VDPWR sky130_fd_pr__pfet_01v8_hvt ad=0.07665 pd=0.785 as=0.15835 ps=1.395 w=0.42 l=0.15
X101 a_41143_39996# a_40948_40027# a_41453_39759# uio_oe[0] sky130_fd_pr__special_nfet_01v8 ad=0.0594 pd=0.69 as=0.1401 ps=1.1 w=0.36 l=0.15
X102 a_23452_10020# a_4259_22596# a_23274_10020# uio_oe[0] sky130_fd_pr__nfet_01v8 ad=0.2436 pd=2.26 as=0.2436 ps=2.26 w=0.84 l=0.6
X103 a_18641_34571# a_17388_34505# VDPWR VDPWR sky130_fd_pr__pfet_01v8_hvt ad=0.1176 pd=1.4 as=0.0693 ps=0.75 w=0.42 l=0.15
X104 a_43419_42997# a_43244_43023# a_43598_43023# uio_oe[0] sky130_fd_pr__nfet_01v8 ad=0.1092 pd=1.36 as=0.06405 ps=0.725 w=0.42 l=0.15
X105 VDPWR a_59293_37337# a_59323_37078# VDPWR sky130_fd_pr__pfet_01v8_hvt ad=0.0693 pd=0.75 as=0.0441 ps=0.63 w=0.42 l=0.15
X106 uio_oe[0] a_60215_42721# a_60176_42595# uio_oe[0] sky130_fd_pr__nfet_01v8 ad=0.0567 pd=0.69 as=0.1092 ps=1.36 w=0.42 l=0.15
X107 VDPWR a_43244_41935# a_43419_41909# VDPWR sky130_fd_pr__pfet_01v8_hvt ad=0.1134 pd=1.38 as=0.0567 ps=0.69 w=0.42 l=0.15
X108 a_39544_40999# a_39759_41129# a_39686_41174# VDPWR sky130_fd_pr__pfet_01v8_hvt ad=0.1932 pd=1.34 as=0.07665 ps=0.785 w=0.42 l=0.15
X109 a_25020_33417# a_17507_33198# a_25162_33224# VDPWR sky130_fd_pr__pfet_01v8_hvt ad=0.1932 pd=1.34 as=0.07665 ps=0.785 w=0.42 l=0.15
X110 uio_oe[0] a_42499_34471# a_41316_35131# uio_oe[0] sky130_fd_pr__nfet_01v8 ad=0.1118 pd=1.04 as=0.182 ps=1.86 w=0.65 l=0.15
X111 a_60934_42479# a_60215_42721# a_60371_42453# uio_oe[0] sky130_fd_pr__special_nfet_01v8 ad=0.066 pd=0.745 as=0.0594 ps=0.69 w=0.36 l=0.15
X112 a_59135_40669# a_39752_40571# a_58772_40535# uio_oe[0] sky130_fd_pr__nfet_01v8 ad=0.0693 pd=0.75 as=0.09975 ps=0.895 w=0.42 l=0.15
X113 a_41250_35229# a_37661_38140# uio_oe[0] uio_oe[0] sky130_fd_pr__nfet_01v8 ad=0.0693 pd=0.75 as=0.11285 ps=1.045 w=0.42 l=0.15
X114 a_36327_34837# a_36503_35169# a_36455_35229# uio_oe[0] sky130_fd_pr__nfet_01v8 ad=0.1092 pd=1.36 as=0.0504 ps=0.66 w=0.42 l=0.15
X115 a_37241_39759# a_36607_39455# uio_oe[0] uio_oe[0] sky130_fd_pr__nfet_01v8 ad=0.0441 pd=0.63 as=0.1346 ps=1.15 w=0.42 l=0.15
X116 a_38895_39581# a_37795_40535# a_38532_39447# uio_oe[0] sky130_fd_pr__nfet_01v8 ad=0.0693 pd=0.75 as=0.09975 ps=0.895 w=0.42 l=0.15
X117 a_60302_38127# a_60215_38369# a_59898_38259# VDPWR sky130_fd_pr__pfet_01v8_hvt ad=0.12915 pd=1.185 as=0.0588 ps=0.7 w=0.42 l=0.15
X118 a_26529_35905# a_26259_36271# a_26439_36271# uio_oe[0] sky130_fd_pr__nfet_01v8 ad=0.0504 pd=0.66 as=0.1092 ps=1.36 w=0.42 l=0.15
X119 uio_oe[0] a_47959_43023# a_48125_43023# uio_oe[0] sky130_fd_pr__nfet_01v8 ad=0.169 pd=1.82 as=0.08775 ps=0.92 w=0.65 l=0.15
X120 a_38674_38671# a_38005_40847# uio_oe[0] uio_oe[0] sky130_fd_pr__nfet_01v8 ad=0.0693 pd=0.75 as=0.11285 ps=1.045 w=0.42 l=0.15
X121 ua[5] a_20620_14782# a_20490_22020# uio_oe[0] sky130_fd_pr__nfet_01v8 ad=0.1885 pd=1.88 as=0.1885 ps=1.88 w=0.65 l=0.15
X122 VDPWR a_47108_43023# a_47283_42997# VDPWR sky130_fd_pr__pfet_01v8_hvt ad=0.1134 pd=1.38 as=0.0567 ps=0.69 w=0.42 l=0.15
X123 a_57046_34571# a_57324_34587# a_57280_34685# VDPWR sky130_fd_pr__pfet_01v8_hvt ad=0.0588 pd=0.7 as=0.0567 ps=0.69 w=0.42 l=0.15
X124 VDPWR a_41231_42997# a_39947_42997# VDPWR sky130_fd_pr__pfet_01v8_hvt ad=0.135 pd=1.27 as=0.135 ps=1.27 w=1 l=0.15
X125 a_22012_18782# a_21875_33757# VDPWR VDPWR sky130_fd_pr__pfet_01v8_hvt ad=0.475 pd=2.95 as=0.16655 ps=1.39 w=1 l=0.15
X126 a_50469_40669# a_50090_40303# a_50397_40669# uio_oe[0] sky130_fd_pr__nfet_01v8 ad=0.1401 pd=1.1 as=0.0441 ps=0.63 w=0.42 l=0.15
X127 a_29946_35727# a_28980_35593# uio_oe[0] uio_oe[0] sky130_fd_pr__nfet_01v8 ad=0.0693 pd=0.75 as=0.11285 ps=1.045 w=0.42 l=0.15
X128 uio_oe[0] a_45351_40821# a_45285_40847# uio_oe[0] sky130_fd_pr__nfet_01v8 ad=0.12495 pd=1.015 as=0.0669 ps=0.75 w=0.42 l=0.15
X129 uio_oe[0] a_56843_36469# a_38740_36469# uio_oe[0] sky130_fd_pr__nfet_01v8 ad=0.2087 pd=2.02 as=0.169 ps=1.82 w=0.65 l=0.15
X130 VDPWR a_17721_35659# a_17751_35400# VDPWR sky130_fd_pr__pfet_01v8_hvt ad=0.0693 pd=0.75 as=0.0441 ps=0.63 w=0.42 l=0.15
X131 a_28884_35593# a_17507_33198# a_29026_35400# VDPWR sky130_fd_pr__pfet_01v8_hvt ad=0.1932 pd=1.34 as=0.07665 ps=0.785 w=0.42 l=0.15
X132 a_52507_35734# a_52325_35734# VDPWR VDPWR sky130_fd_pr__pfet_01v8_hvt ad=0.0441 pd=0.63 as=0.0693 ps=0.75 w=0.42 l=0.15
X133 a_53011_41365# a_52855_41633# a_53156_41391# VDPWR sky130_fd_pr__pfet_01v8_hvt ad=0.07245 pd=0.765 as=0.1155 ps=0.97 w=0.42 l=0.15
X134 a_51412_40999# a_39752_40821# a_51554_41174# VDPWR sky130_fd_pr__pfet_01v8_hvt ad=0.1932 pd=1.34 as=0.07665 ps=0.785 w=0.42 l=0.15
X135 a_46193_40309# a_46027_40309# uio_oe[0] uio_oe[0] sky130_fd_pr__nfet_01v8 ad=0.1092 pd=1.36 as=0.0567 ps=0.69 w=0.42 l=0.15
X136 a_62053_40601# a_36661_41391# VDPWR VDPWR sky130_fd_pr__pfet_01v8_hvt ad=0.1176 pd=1.4 as=0.0693 ps=0.75 w=0.42 l=0.15
X137 VDPWR a_21345_32899# a_21287_33007# VDPWR sky130_fd_pr__pfet_01v8_hvt ad=0.2279 pd=1.74 as=0.0609 ps=0.71 w=0.42 l=0.15
X138 a_36934_39215# a_36847_39457# a_36530_39347# VDPWR sky130_fd_pr__pfet_01v8_hvt ad=0.12915 pd=1.185 as=0.0588 ps=0.7 w=0.42 l=0.15
X139 a_50159_37820# a_49964_37851# a_50469_37583# uio_oe[0] sky130_fd_pr__special_nfet_01v8 ad=0.0594 pd=0.69 as=0.1401 ps=1.1 w=0.36 l=0.15
X140 a_42069_34863# a_37029_37583# a_41987_34863# VDPWR sky130_fd_pr__pfet_01v8_hvt ad=0.135 pd=1.27 as=0.26 ps=2.52 w=1 l=0.15
X141 a_42897_41089# a_42679_40847# uio_oe[0] uio_oe[0] sky130_fd_pr__nfet_01v8 ad=0.0999 pd=0.985 as=0.1346 ps=1.15 w=0.64 l=0.15
X142 uio_oe[0] a_52855_40545# a_52816_40419# uio_oe[0] sky130_fd_pr__nfet_01v8 ad=0.0567 pd=0.69 as=0.1092 ps=1.36 w=0.42 l=0.15
X143 a_61766_38493# a_37361_41391# uio_oe[0] uio_oe[0] sky130_fd_pr__nfet_01v8 ad=0.0693 pd=0.75 as=0.11285 ps=1.045 w=0.42 l=0.15
X144 ua[4] a_20620_14782# a_23274_14020# uio_oe[0] sky130_fd_pr__nfet_01v8 ad=0.1885 pd=1.88 as=0.1885 ps=1.88 w=0.65 l=0.15
X145 a_41685_42479# a_41519_42479# uio_oe[0] uio_oe[0] sky130_fd_pr__nfet_01v8 ad=0.08775 pd=0.92 as=0.08775 ps=0.92 w=0.65 l=0.15
X146 uio_oe[0] a_47283_41909# a_47217_41935# uio_oe[0] sky130_fd_pr__nfet_01v8 ad=0.12495 pd=1.015 as=0.0669 ps=0.75 w=0.42 l=0.15
X147 VDPWR a_45351_40607# a_45338_40303# VDPWR sky130_fd_pr__pfet_01v8_hvt ad=0.0819 pd=0.81 as=0.0567 ps=0.69 w=0.42 l=0.15
X148 uio_oe[0] a_58772_37735# a_58144_37832# uio_oe[0] sky130_fd_pr__nfet_01v8 ad=0.11285 pd=1.045 as=0.169 ps=1.82 w=0.65 l=0.15
X149 a_41039_36861# a_40415_36495# a_40931_36495# VDPWR sky130_fd_pr__pfet_01v8_hvt ad=0.1155 pd=0.97 as=0.07245 ps=0.765 w=0.42 l=0.15
X150 a_21298_35727# a_21252_35593# uio_oe[0] uio_oe[0] sky130_fd_pr__nfet_01v8 ad=0.0693 pd=0.75 as=0.11285 ps=1.045 w=0.42 l=0.15
X151 a_24532_10020# a_16812_8642# uio_oe[0] uio_oe[0] sky130_fd_pr__nfet_01v8 ad=1.4703 pd=10.72 as=1.4703 ps=10.72 w=5.07 l=1
X152 uio_oe[0] a_53636_38101# a_53574_38127# uio_oe[0] sky130_fd_pr__nfet_01v8 ad=0.2205 pd=1.89 as=0.066 ps=0.745 w=0.42 l=0.15
X153 a_61297_37825# a_61079_37583# uio_oe[0] uio_oe[0] sky130_fd_pr__nfet_01v8 ad=0.0999 pd=0.985 as=0.1346 ps=1.15 w=0.64 l=0.15
X154 a_21585_34571# a_21252_34505# uio_oe[0] uio_oe[0] sky130_fd_pr__nfet_01v8 ad=0.1092 pd=1.36 as=0.1449 ps=1.11 w=0.42 l=0.15
X155 a_18354_36815# a_17388_36681# uio_oe[0] uio_oe[0] sky130_fd_pr__nfet_01v8 ad=0.0693 pd=0.75 as=0.11285 ps=1.045 w=0.42 l=0.15
X156 a_36455_35229# a_36425_35078# uio_oe[0] uio_oe[0] sky130_fd_pr__nfet_01v8 ad=0.0504 pd=0.66 as=0.1013 ps=0.99 w=0.42 l=0.15
X157 a_52800_41935# a_51620_41909# a_52579_42262# uio_oe[0] sky130_fd_pr__nfet_01v8 ad=0.0693 pd=0.75 as=0.09975 ps=0.895 w=0.42 l=0.15
X158 a_42039_35592# a_37661_37052# uio_oe[0] uio_oe[0] sky130_fd_pr__nfet_01v8 ad=0.08775 pd=0.92 as=0.08775 ps=0.92 w=0.65 l=0.15
X159 a_44829_42177# a_44611_41935# uio_oe[0] uio_oe[0] sky130_fd_pr__nfet_01v8 ad=0.0999 pd=0.985 as=0.1346 ps=1.15 w=0.64 l=0.15
X160 uio_oe[0] a_58144_40008# a_58082_40125# uio_oe[0] sky130_fd_pr__nfet_01v8 ad=0.2205 pd=1.89 as=0.066 ps=0.745 w=0.42 l=0.15
X161 uio_oe[0] a_57519_38908# a_57450_39037# uio_oe[0] sky130_fd_pr__nfet_01v8 ad=0.1346 pd=1.15 as=0.0999 ps=0.985 w=0.64 l=0.15
X162 VDPWR a_37913_43023# a_53203_38671# VDPWR sky130_fd_pr__pfet_01v8_hvt ad=0.0864 pd=0.91 as=0.1664 ps=1.8 w=0.64 l=0.15
X163 a_60365_38671# a_59939_38998# uio_oe[0] uio_oe[0] sky130_fd_pr__nfet_01v8 ad=0.169 pd=1.82 as=0.11285 ps=1.045 w=0.65 l=0.15
X164 a_40836_36495# a_38285_38127# uio_oe[0] uio_oe[0] sky130_fd_pr__nfet_01v8 ad=0.066 pd=0.745 as=0.2205 ps=1.89 w=0.42 l=0.15
X165 a_38285_42479# a_37859_42518# uio_oe[0] uio_oe[0] sky130_fd_pr__nfet_01v8 ad=0.169 pd=1.82 as=0.11285 ps=1.045 w=0.65 l=0.15
X166 a_54406_34902# a_37361_41391# VDPWR VDPWR sky130_fd_pr__pfet_01v8_hvt ad=0.07665 pd=0.785 as=0.15835 ps=1.395 w=0.42 l=0.15
X167 a_40464_40999# a_37795_40535# a_40606_41174# VDPWR sky130_fd_pr__pfet_01v8_hvt ad=0.1932 pd=1.34 as=0.07665 ps=0.785 w=0.42 l=0.15
X168 a_59939_38998# a_51620_38645# a_59939_38671# uio_oe[0] sky130_fd_pr__nfet_01v8 ad=0.09975 pd=0.895 as=0.0693 ps=0.75 w=0.42 l=0.15
X169 a_38285_37583# a_37859_37910# VDPWR VDPWR sky130_fd_pr__pfet_01v8_hvt ad=0.26 pd=2.52 as=0.15835 ps=1.395 w=1 l=0.15
X170 uio_oe[0] a_17721_33483# a_17655_33551# uio_oe[0] sky130_fd_pr__nfet_01v8 ad=0.1449 pd=1.11 as=0.0693 ps=0.75 w=0.42 l=0.15
X171 a_41706_38127# a_40948_38243# a_41143_38101# VDPWR sky130_fd_pr__pfet_01v8_hvt ad=0.0651 pd=0.73 as=0.07245 ps=0.765 w=0.42 l=0.15
X172 a_19538_24730# ua[3] a_19410_26020# uio_oe[0] sky130_fd_pr__nfet_01v8 ad=0.2436 pd=2.26 as=0.2436 ps=2.26 w=0.84 l=0.6
X173 a_49686_34995# a_50003_35105# a_49961_35229# uio_oe[0] sky130_fd_pr__special_nfet_01v8 ad=0.0711 pd=0.755 as=0.0669 ps=0.75 w=0.36 l=0.15
X174 a_30123_35183# a_28651_34817# uio_oe[0] uio_oe[0] sky130_fd_pr__nfet_01v8 ad=0.1092 pd=1.36 as=0.1092 ps=1.36 w=0.42 l=0.15
X175 a_36934_40125# a_36808_40027# a_36530_40011# uio_oe[0] sky130_fd_pr__special_nfet_01v8 ad=0.0999 pd=0.985 as=0.0711 ps=0.755 w=0.36 l=0.15
X176 VDPWR a_38532_38359# a_25116_36681# VDPWR sky130_fd_pr__pfet_01v8_hvt ad=0.15835 pd=1.395 as=0.26 ps=2.52 w=1 l=0.15
X177 a_41453_38493# a_41074_38127# a_41381_38493# uio_oe[0] sky130_fd_pr__nfet_01v8 ad=0.1401 pd=1.1 as=0.0441 ps=0.63 w=0.42 l=0.15
X178 ua[5] a_20620_10782# a_23274_26020# uio_oe[0] sky130_fd_pr__nfet_01v8 ad=0.1885 pd=1.88 as=0.1885 ps=1.88 w=0.65 l=0.15
X179 a_46543_42857# a_46193_42485# a_46448_42845# VDPWR sky130_fd_pr__pfet_01v8_hvt ad=0.07245 pd=0.765 as=0.0651 ps=0.73 w=0.42 l=0.15
X180 uio_oe[0] a_44511_38645# a_42953_34837# uio_oe[0] sky130_fd_pr__nfet_01v8 ad=0.169 pd=1.82 as=0.08775 ps=0.92 w=0.65 l=0.15
X181 a_17689_32641# a_17423_33007# uio_oe[0] uio_oe[0] sky130_fd_pr__nfet_01v8 ad=0.169 pd=1.82 as=0.1013 ps=0.99 w=0.65 l=0.15
X182 VDPWR a_41149_37013# a_41039_37039# VDPWR sky130_fd_pr__pfet_01v8_hvt ad=0.07035 pd=0.755 as=0.1155 ps=0.97 w=0.42 l=0.15
X183 a_40987_39901# a_38005_41391# uio_oe[0] uio_oe[0] sky130_fd_pr__nfet_01v8 ad=0.1092 pd=1.36 as=0.0567 ps=0.69 w=0.42 l=0.15
X184 VDPWR a_51841_39513# a_51871_39254# VDPWR sky130_fd_pr__pfet_01v8_hvt ad=0.0693 pd=0.75 as=0.0441 ps=0.63 w=0.42 l=0.15
X185 a_39544_41623# a_39752_41659# a_39686_41757# uio_oe[0] sky130_fd_pr__nfet_01v8 ad=0.09975 pd=0.895 as=0.0693 ps=0.75 w=0.42 l=0.15
X186 a_42679_41769# a_42163_41397# a_42584_41757# uio_oe[0] sky130_fd_pr__special_nfet_01v8 ad=0.0594 pd=0.69 as=0.066 ps=0.745 w=0.36 l=0.15
X187 a_58248_37039# a_57472_37317# a_57640_37353# uio_oe[0] sky130_fd_pr__special_nfet_01v8 ad=0.0935 pd=0.965 as=0.072 ps=0.76 w=0.36 l=0.15
X188 VDPWR a_61624_36183# a_60996_35925# VDPWR sky130_fd_pr__pfet_01v8_hvt ad=0.15835 pd=1.395 as=0.26 ps=2.52 w=1 l=0.15
X189 a_57514_34863# a_57148_34863# VDPWR VDPWR sky130_fd_pr__pfet_01v8_hvt ad=0.0441 pd=0.63 as=0.1092 ps=1.36 w=0.42 l=0.15
X190 a_44369_40009# a_37851_36647# VDPWR VDPWR sky130_fd_pr__pfet_01v8_hvt ad=0.135 pd=1.27 as=0.26 ps=2.52 w=1 l=0.15
X191 uio_oe[0] a_41445_41689# a_41379_41757# uio_oe[0] sky130_fd_pr__nfet_01v8 ad=0.1449 pd=1.11 as=0.0693 ps=0.75 w=0.42 l=0.15
X192 a_50722_41213# a_49964_41115# a_50159_41084# VDPWR sky130_fd_pr__pfet_01v8_hvt ad=0.0651 pd=0.73 as=0.07245 ps=0.765 w=0.42 l=0.15
X193 a_59695_38101# a_59898_38259# VDPWR VDPWR sky130_fd_pr__pfet_01v8_hvt ad=0.0567 pd=0.69 as=0.1134 ps=1.38 w=0.42 l=0.15
X194 a_61808_35095# a_54479_34876# a_61950_35229# uio_oe[0] sky130_fd_pr__nfet_01v8 ad=0.09975 pd=0.895 as=0.0693 ps=0.75 w=0.42 l=0.15
X195 a_42863_39593# a_42513_39221# a_42768_39581# VDPWR sky130_fd_pr__pfet_01v8_hvt ad=0.07245 pd=0.765 as=0.0651 ps=0.73 w=0.42 l=0.15
X196 a_27316_14020# a_16812_8642# uio_oe[0] uio_oe[0] sky130_fd_pr__nfet_01v8 ad=1.4703 pd=10.72 as=1.4703 ps=10.72 w=5.07 l=1
X197 a_53011_42453# a_52816_42595# a_53321_42845# uio_oe[0] sky130_fd_pr__special_nfet_01v8 ad=0.0594 pd=0.69 as=0.1401 ps=1.1 w=0.36 l=0.15
X198 a_57757_41935# a_48125_43023# uio_oe[0] uio_oe[0] sky130_fd_pr__nfet_01v8 ad=0.0441 pd=0.63 as=0.1346 ps=1.15 w=0.42 l=0.15
X199 a_51620_37557# a_54459_37557# uio_oe[0] uio_oe[0] sky130_fd_pr__nfet_01v8 ad=0.169 pd=1.82 as=0.2087 ps=2.02 w=0.65 l=0.15
X200 a_21156_36681# a_17507_33198# a_21298_36488# VDPWR sky130_fd_pr__pfet_01v8_hvt ad=0.1932 pd=1.34 as=0.07665 ps=0.785 w=0.42 l=0.15
X201 a_37913_41935# a_37747_41935# VDPWR VDPWR sky130_fd_pr__pfet_01v8_hvt ad=0.135 pd=1.27 as=0.135 ps=1.27 w=1 l=0.15
X202 a_52855_41633# a_37913_43023# VDPWR VDPWR sky130_fd_pr__pfet_01v8_hvt ad=0.1664 pd=1.8 as=0.0864 ps=0.91 w=0.64 l=0.15
X203 a_49961_39581# a_49483_39189# uio_oe[0] uio_oe[0] sky130_fd_pr__nfet_01v8 ad=0.0669 pd=0.75 as=0.12495 ps=1.015 w=0.42 l=0.15
X204 uio_oe[0] a_37661_37052# a_38080_37405# uio_oe[0] sky130_fd_pr__nfet_01v8 ad=0.11285 pd=1.045 as=0.0693 ps=0.75 w=0.42 l=0.15
X205 VDPWR a_22505_36747# a_22535_36488# VDPWR sky130_fd_pr__pfet_01v8_hvt ad=0.0693 pd=0.75 as=0.0441 ps=0.63 w=0.42 l=0.15
X206 a_43157_35951# a_42685_36611# VDPWR VDPWR sky130_fd_pr__pfet_01v8_hvt ad=0.135 pd=1.27 as=0.135 ps=1.27 w=1 l=0.15
X207 a_43559_35407# a_43308_35657# VDPWR VDPWR sky130_fd_pr__pfet_01v8_hvt ad=0.34 pd=2.68 as=0.14575 ps=1.335 w=1 l=0.15
X208 a_46448_42845# a_46331_42650# uio_oe[0] uio_oe[0] sky130_fd_pr__nfet_01v8 ad=0.066 pd=0.745 as=0.2205 ps=1.89 w=0.42 l=0.15
X209 a_50003_42721# a_38649_43023# uio_oe[0] uio_oe[0] sky130_fd_pr__nfet_01v8 ad=0.1092 pd=1.36 as=0.0567 ps=0.69 w=0.42 l=0.15
X210 a_47108_41769# a_46193_41397# a_46761_41365# uio_oe[0] sky130_fd_pr__special_nfet_01v8 ad=0.0711 pd=0.755 as=0.0999 ps=0.985 w=0.36 l=0.15
X211 uio_oe[0] a_36721_37583# a_37195_36501# uio_oe[0] sky130_fd_pr__nfet_01v8 ad=0.1575 pd=1.17 as=0.1092 ps=1.36 w=0.42 l=0.15
X212 a_51554_36317# a_48677_38127# uio_oe[0] uio_oe[0] sky130_fd_pr__nfet_01v8 ad=0.0693 pd=0.75 as=0.11285 ps=1.045 w=0.42 l=0.15
X213 a_51412_41623# a_51620_41659# a_51554_41757# uio_oe[0] sky130_fd_pr__nfet_01v8 ad=0.09975 pd=0.895 as=0.0693 ps=0.75 w=0.42 l=0.15
X214 a_57046_40435# a_57363_40545# a_57321_40669# uio_oe[0] sky130_fd_pr__special_nfet_01v8 ad=0.0711 pd=0.755 as=0.0669 ps=0.75 w=0.36 l=0.15
X215 VDPWR a_36999_38101# a_37029_38127# VDPWR sky130_fd_pr__pfet_01v8_hvt ad=0.135 pd=1.27 as=0.135 ps=1.27 w=1 l=0.15
X216 VDPWR a_29281_32641# a_30303_37359# VDPWR sky130_fd_pr__pfet_01v8_hvt ad=0.2279 pd=1.74 as=0.0609 ps=0.71 w=0.42 l=0.15
X217 a_41496_37417# a_40581_37045# a_41149_37013# uio_oe[0] sky130_fd_pr__special_nfet_01v8 ad=0.0711 pd=0.755 as=0.0999 ps=0.985 w=0.36 l=0.15
X218 a_45530_40669# a_39947_42997# uio_oe[0] uio_oe[0] sky130_fd_pr__nfet_01v8 ad=0.06405 pd=0.725 as=0.12495 ps=1.015 w=0.42 l=0.15
X219 a_37566_39215# a_36808_39331# a_37003_39189# VDPWR sky130_fd_pr__pfet_01v8_hvt ad=0.0651 pd=0.73 as=0.07245 ps=0.765 w=0.42 l=0.15
X220 uio_oe[0] uio_oe[0] uio_oe[0] uio_oe[0] sky130_fd_pr__nfet_01v8 ad=0.1885 pd=1.88 as=0 ps=0 w=0.65 l=0.15
X221 a_44339_39944# a_37851_36647# a_44725_40009# VDPWR sky130_fd_pr__pfet_01v8_hvt ad=0.26 pd=2.52 as=0.135 ps=1.27 w=1 l=0.15
X222 VDPWR a_52335_39189# a_51620_39483# VDPWR sky130_fd_pr__pfet_01v8_hvt ad=0.3012 pd=2.66 as=0.26 ps=2.52 w=1 l=0.15
X223 VDPWR a_59201_38645# a_59231_38998# VDPWR sky130_fd_pr__pfet_01v8_hvt ad=0.0693 pd=0.75 as=0.0441 ps=0.63 w=0.42 l=0.15
X224 uio_oe[0] a_43897_36647# a_37829_37812# uio_oe[0] sky130_fd_pr__nfet_01v8 ad=0.10025 pd=0.985 as=0.169 ps=1.82 w=0.65 l=0.15
X225 a_38543_35559# a_37029_37583# VDPWR VDPWR sky130_fd_pr__pfet_01v8_hvt ad=0.0567 pd=0.69 as=0.16655 ps=1.39 w=0.42 l=0.15
X226 a_58082_34685# a_57363_34461# a_57519_34556# uio_oe[0] sky130_fd_pr__special_nfet_01v8 ad=0.066 pd=0.745 as=0.0594 ps=0.69 w=0.36 l=0.15
X227 uio_oe[0] a_60416_39493# a_60500_39189# uio_oe[0] sky130_fd_pr__nfet_01v8 ad=0.0567 pd=0.69 as=0.1092 ps=1.36 w=0.42 l=0.15
X228 VDPWR a_51841_38645# a_51871_38998# VDPWR sky130_fd_pr__pfet_01v8_hvt ad=0.0693 pd=0.75 as=0.0441 ps=0.63 w=0.42 l=0.15
X229 a_60215_36193# a_37913_41935# uio_oe[0] uio_oe[0] sky130_fd_pr__nfet_01v8 ad=0.1092 pd=1.36 as=0.0567 ps=0.69 w=0.42 l=0.15
X230 a_50722_34685# a_50003_34461# a_50159_34556# uio_oe[0] sky130_fd_pr__special_nfet_01v8 ad=0.066 pd=0.745 as=0.0594 ps=0.69 w=0.36 l=0.15
X231 a_17751_34312# a_17500_33453# a_17292_34505# VDPWR sky130_fd_pr__pfet_01v8_hvt ad=0.0441 pd=0.63 as=0.1932 ps=1.34 w=0.42 l=0.15
X232 VDPWR a_39544_42087# a_17204_36057# VDPWR sky130_fd_pr__pfet_01v8_hvt ad=0.15835 pd=1.395 as=0.26 ps=2.52 w=1 l=0.15
X233 a_47462_41757# a_39947_42997# uio_oe[0] uio_oe[0] sky130_fd_pr__nfet_01v8 ad=0.06405 pd=0.725 as=0.12495 ps=1.015 w=0.42 l=0.15
X234 a_38895_39759# a_37795_40535# a_38532_39911# uio_oe[0] sky130_fd_pr__nfet_01v8 ad=0.0693 pd=0.75 as=0.09975 ps=0.895 w=0.42 l=0.15
X235 a_36721_37039# a_36455_37039# uio_oe[0] uio_oe[0] sky130_fd_pr__nfet_01v8 ad=0.169 pd=1.82 as=0.1013 ps=0.99 w=0.65 l=0.15
X236 a_21585_33483# a_21252_33417# uio_oe[0] uio_oe[0] sky130_fd_pr__nfet_01v8 ad=0.1092 pd=1.36 as=0.1449 ps=1.11 w=0.42 l=0.15
X237 a_21335_33729# a_21107_33185# a_20972_33881# uio_oe[0] sky130_fd_pr__nfet_01v8 ad=0.0693 pd=0.75 as=0.09975 ps=0.895 w=0.42 l=0.15
X238 a_54264_35095# a_54479_34876# a_54406_34902# VDPWR sky130_fd_pr__pfet_01v8_hvt ad=0.1932 pd=1.34 as=0.07665 ps=0.785 w=0.42 l=0.15
X239 uio_oe[0] a_57363_40989# a_57324_41115# uio_oe[0] sky130_fd_pr__nfet_01v8 ad=0.0567 pd=0.69 as=0.1092 ps=1.36 w=0.42 l=0.15
X240 a_41850_37405# a_40379_35551# uio_oe[0] uio_oe[0] sky130_fd_pr__nfet_01v8 ad=0.06405 pd=0.725 as=0.12495 ps=1.015 w=0.42 l=0.15
X241 VDPWR a_18212_33417# a_17316_33703# VDPWR sky130_fd_pr__pfet_01v8_hvt ad=0.15835 pd=1.395 as=0.26 ps=2.52 w=1 l=0.15
X242 a_62267_34902# a_54479_34876# a_61808_35095# VDPWR sky130_fd_pr__pfet_01v8_hvt ad=0.0441 pd=0.63 as=0.1932 ps=1.34 w=0.42 l=0.15
X243 uio_oe[0] a_38532_39911# a_21252_35593# uio_oe[0] sky130_fd_pr__nfet_01v8 ad=0.11285 pd=1.045 as=0.169 ps=1.82 w=0.65 l=0.15
X244 uio_oe[0] a_58144_38920# a_58082_39037# uio_oe[0] sky130_fd_pr__nfet_01v8 ad=0.2205 pd=1.89 as=0.066 ps=0.745 w=0.42 l=0.15
X245 a_59939_36495# a_59685_36822# uio_oe[0] uio_oe[0] sky130_fd_pr__nfet_01v8 ad=0.0693 pd=0.75 as=0.1449 ps=1.11 w=0.42 l=0.15
X246 a_53624_34319# a_53005_34319# uio_oe[0] uio_oe[0] sky130_fd_pr__nfet_01v8 ad=0.066 pd=0.745 as=0.2205 ps=1.89 w=0.42 l=0.15
X247 a_50159_39189# a_50003_39457# a_50304_39215# VDPWR sky130_fd_pr__pfet_01v8_hvt ad=0.07245 pd=0.765 as=0.1155 ps=0.97 w=0.42 l=0.15
X248 a_59867_37910# a_59685_37910# VDPWR VDPWR sky130_fd_pr__pfet_01v8_hvt ad=0.0441 pd=0.63 as=0.0693 ps=0.75 w=0.42 l=0.15
X249 a_39548_43023# a_38285_42479# uio_oe[0] uio_oe[0] sky130_fd_pr__nfet_01v8 ad=0.066 pd=0.745 as=0.2205 ps=1.89 w=0.42 l=0.15
X250 a_36455_37949# a_36275_37949# VDPWR VDPWR sky130_fd_pr__pfet_01v8_hvt ad=0.0609 pd=0.71 as=0.0714 ps=0.76 w=0.42 l=0.15
X251 a_57046_40435# a_57324_40419# a_57280_40303# VDPWR sky130_fd_pr__pfet_01v8_hvt ad=0.0588 pd=0.7 as=0.0567 ps=0.69 w=0.42 l=0.15
X252 a_21431_37320# a_21180_36967# a_20972_37145# VDPWR sky130_fd_pr__pfet_01v8_hvt ad=0.0441 pd=0.63 as=0.1932 ps=1.34 w=0.42 l=0.15
X253 a_49721_37405# a_49686_37171# a_49483_37013# uio_oe[0] sky130_fd_pr__nfet_01v8 ad=0.06405 pd=0.725 as=0.1092 ps=1.36 w=0.42 l=0.15
X254 a_37183_40277# rst_n uio_oe[0] uio_oe[0] sky130_fd_pr__nfet_01v8 ad=0.169 pd=1.82 as=0.08775 ps=0.92 w=0.65 l=0.15
X255 VDPWR a_51412_42087# a_50784_42184# VDPWR sky130_fd_pr__pfet_01v8_hvt ad=0.15835 pd=1.395 as=0.26 ps=2.52 w=1 l=0.15
X256 uio_oe[0] a_37913_43023# a_60563_40847# uio_oe[0] sky130_fd_pr__nfet_01v8 ad=0.0567 pd=0.69 as=0.1092 ps=1.36 w=0.42 l=0.15
X257 a_61187_39037# a_60563_38671# a_61079_38671# VDPWR sky130_fd_pr__pfet_01v8_hvt ad=0.1155 pd=0.97 as=0.07245 ps=0.765 w=0.42 l=0.15
X258 a_41763_37557# a_40379_35551# VDPWR VDPWR sky130_fd_pr__pfet_01v8_hvt ad=0.0567 pd=0.69 as=0.0819 ps=0.81 w=0.42 l=0.15
X259 a_24484_10782# a_26439_37359# uio_oe[0] uio_oe[0] sky130_fd_pr__nfet_01v8 ad=0.169 pd=1.82 as=0.1013 ps=0.99 w=0.65 l=0.15
X260 a_25199_35905# a_24971_35361# a_24836_36057# uio_oe[0] sky130_fd_pr__nfet_01v8 ad=0.0693 pd=0.75 as=0.09975 ps=0.895 w=0.42 l=0.15
X261 a_47108_42857# a_46027_42485# a_46761_42453# VDPWR sky130_fd_pr__pfet_01v8_hvt ad=0.0588 pd=0.7 as=0.12915 ps=1.185 w=0.42 l=0.15
X262 a_49920_41213# a_49483_40821# VDPWR VDPWR sky130_fd_pr__pfet_01v8_hvt ad=0.0567 pd=0.69 as=0.0819 ps=0.81 w=0.42 l=0.15
X263 a_57519_34556# a_57324_34587# a_57829_34319# uio_oe[0] sky130_fd_pr__special_nfet_01v8 ad=0.0594 pd=0.69 as=0.1401 ps=1.1 w=0.36 l=0.15
X264 a_46543_41769# a_46193_41397# a_46448_41757# VDPWR sky130_fd_pr__pfet_01v8_hvt ad=0.07245 pd=0.765 as=0.0651 ps=0.73 w=0.42 l=0.15
X265 a_52772_38127# a_52335_38101# VDPWR VDPWR sky130_fd_pr__pfet_01v8_hvt ad=0.0567 pd=0.69 as=0.0819 ps=0.81 w=0.42 l=0.15
X266 VDPWR a_29129_36967# a_29159_37320# VDPWR sky130_fd_pr__pfet_01v8_hvt ad=0.0693 pd=0.75 as=0.0441 ps=0.63 w=0.42 l=0.15
X267 a_50722_34685# a_49964_34587# a_50159_34556# VDPWR sky130_fd_pr__pfet_01v8_hvt ad=0.0651 pd=0.73 as=0.07245 ps=0.765 w=0.42 l=0.15
X268 a_29946_35400# a_28980_35593# VDPWR VDPWR sky130_fd_pr__pfet_01v8_hvt ad=0.07665 pd=0.785 as=0.15835 ps=1.395 w=0.42 l=0.15
X269 a_61192_34863# a_60416_35141# a_60584_35177# uio_oe[0] sky130_fd_pr__special_nfet_01v8 ad=0.0935 pd=0.965 as=0.072 ps=0.76 w=0.36 l=0.15
X270 a_37085_38671# a_36425_35078# uio_oe[0] uio_oe[0] sky130_fd_pr__nfet_01v8 ad=0.08775 pd=0.92 as=0.08775 ps=0.92 w=0.65 l=0.15
X271 a_44044_37155# a_37639_36495# uio_oe[0] uio_oe[0] sky130_fd_pr__nfet_01v8 ad=0.0567 pd=0.69 as=0.1092 ps=1.36 w=0.42 l=0.15
X272 VDPWR a_36919_35951# a_37085_35951# VDPWR sky130_fd_pr__pfet_01v8_hvt ad=0.26 pd=2.52 as=0.135 ps=1.27 w=1 l=0.15
X273 VDPWR a_49483_34293# a_39783_34321# VDPWR sky130_fd_pr__pfet_01v8_hvt ad=0.3012 pd=2.66 as=0.26 ps=2.52 w=1 l=0.15
X274 a_42679_40681# a_42163_40309# a_42584_40669# uio_oe[0] sky130_fd_pr__special_nfet_01v8 ad=0.0594 pd=0.69 as=0.066 ps=0.745 w=0.36 l=0.15
X275 a_48677_38127# a_48511_38127# uio_oe[0] uio_oe[0] sky130_fd_pr__nfet_01v8 ad=0.08775 pd=0.92 as=0.08775 ps=0.92 w=0.65 l=0.15
X276 a_60416_37317# a_37913_41935# VDPWR VDPWR sky130_fd_pr__pfet_01v8_hvt ad=0.1664 pd=1.8 as=0.0864 ps=0.91 w=0.64 l=0.15
X277 uio_oe[0] a_54459_41909# a_54393_41935# uio_oe[0] sky130_fd_pr__nfet_01v8 ad=0.12495 pd=1.015 as=0.0669 ps=0.75 w=0.42 l=0.15
X278 VDPWR a_37795_40535# a_41593_41097# VDPWR sky130_fd_pr__pfet_01v8_hvt ad=0.26 pd=2.52 as=0.135 ps=1.27 w=1 l=0.15
X279 a_59231_38166# a_54479_38140# a_58772_38359# VDPWR sky130_fd_pr__pfet_01v8_hvt ad=0.0441 pd=0.63 as=0.1932 ps=1.34 w=0.42 l=0.15
X280 a_61192_37039# a_60500_37013# a_60584_37353# VDPWR sky130_fd_pr__pfet_01v8_hvt ad=0.12495 pd=1.175 as=0.0567 ps=0.69 w=0.42 l=0.15
X281 a_36607_39455# a_37183_40277# VDPWR VDPWR sky130_fd_pr__pfet_01v8_hvt ad=0.135 pd=1.27 as=0.135 ps=1.27 w=1 l=0.15
X282 uio_oe[0] a_36661_41391# a_60160_39759# uio_oe[0] sky130_fd_pr__nfet_01v8 ad=0.11285 pd=1.045 as=0.0693 ps=0.75 w=0.42 l=0.15
X283 a_43428_39593# a_42347_39221# a_43081_39189# VDPWR sky130_fd_pr__pfet_01v8_hvt ad=0.0588 pd=0.7 as=0.12915 ps=1.185 w=0.42 l=0.15
X284 VDPWR a_47283_40821# a_47270_41213# VDPWR sky130_fd_pr__pfet_01v8_hvt ad=0.0819 pd=0.81 as=0.0567 ps=0.69 w=0.42 l=0.15
X285 a_21298_35400# a_21252_35593# VDPWR VDPWR sky130_fd_pr__pfet_01v8_hvt ad=0.07665 pd=0.785 as=0.15835 ps=1.395 w=0.42 l=0.15
X286 a_49483_39189# a_49686_39347# VDPWR VDPWR sky130_fd_pr__pfet_01v8_hvt ad=0.0567 pd=0.69 as=0.1134 ps=1.38 w=0.42 l=0.15
X287 a_60374_39581# a_60092_39215# a_60298_39581# uio_oe[0] sky130_fd_pr__nfet_01v8 ad=0.0441 pd=0.63 as=0.0483 ps=0.65 w=0.42 l=0.15
X288 a_4259_27772# a_4259_24172# uio_oe[0] sky130_fd_pr__res_xhigh_po_1p41 l=5.88
X289 a_21585_34571# a_21252_34505# VDPWR VDPWR sky130_fd_pr__pfet_01v8_hvt ad=0.1176 pd=1.4 as=0.0693 ps=0.75 w=0.42 l=0.15
X290 uio_oe[0] a_39544_39447# a_21068_34969# uio_oe[0] sky130_fd_pr__nfet_01v8 ad=0.11285 pd=1.045 as=0.169 ps=1.82 w=0.65 l=0.15
X291 VDPWR a_54693_38425# a_54723_38166# VDPWR sky130_fd_pr__pfet_01v8_hvt ad=0.0693 pd=0.75 as=0.0441 ps=0.63 w=0.42 l=0.15
X292 a_41537_41909# a_38285_34863# uio_oe[0] uio_oe[0] sky130_fd_pr__nfet_01v8 ad=0.1092 pd=1.36 as=0.1449 ps=1.11 w=0.42 l=0.15
X293 a_47108_40681# a_46193_40309# a_46761_40277# uio_oe[0] sky130_fd_pr__special_nfet_01v8 ad=0.0711 pd=0.755 as=0.0999 ps=0.985 w=0.36 l=0.15
X294 uio_oe[0] a_62053_38425# a_61987_38493# uio_oe[0] sky130_fd_pr__nfet_01v8 ad=0.1449 pd=1.11 as=0.0693 ps=0.75 w=0.42 l=0.15
X295 a_60173_40669# a_59695_40277# uio_oe[0] uio_oe[0] sky130_fd_pr__nfet_01v8 ad=0.0669 pd=0.75 as=0.12495 ps=1.015 w=0.42 l=0.15
X296 a_29738_24730# ua[0] a_29610_26020# uio_oe[0] sky130_fd_pr__nfet_01v8 ad=0.2436 pd=2.26 as=0.2436 ps=2.26 w=0.84 l=0.6
X297 VDPWR a_29281_32641# a_30303_36271# VDPWR sky130_fd_pr__pfet_01v8_hvt ad=0.2279 pd=1.74 as=0.0609 ps=0.71 w=0.42 l=0.15
X298 VDPWR a_26369_34571# a_26399_34312# VDPWR sky130_fd_pr__pfet_01v8_hvt ad=0.0693 pd=0.75 as=0.0441 ps=0.63 w=0.42 l=0.15
X299 VDPWR a_46193_39759# a_53156_34863# VDPWR sky130_fd_pr__pfet_01v8_hvt ad=0.07035 pd=0.755 as=0.1092 ps=1.36 w=0.42 l=0.15
X300 uio_oe[0] a_61242_41621# a_61192_41391# uio_oe[0] sky130_fd_pr__nfet_01v8 ad=0.1664 pd=1.8 as=0.0935 ps=0.965 w=0.64 l=0.15
X301 a_54459_39733# a_48125_41935# VDPWR VDPWR sky130_fd_pr__pfet_01v8_hvt ad=0.0567 pd=0.69 as=0.0819 ps=0.81 w=0.42 l=0.15
X302 a_41471_35229# a_36425_34293# a_41108_35095# uio_oe[0] sky130_fd_pr__nfet_01v8 ad=0.0693 pd=0.75 as=0.09975 ps=0.895 w=0.42 l=0.15
X303 uio_oe[0] a_61624_40535# a_60996_40277# uio_oe[0] sky130_fd_pr__nfet_01v8 ad=0.11285 pd=1.045 as=0.169 ps=1.82 w=0.65 l=0.15
X304 a_53574_39215# a_52855_39457# a_53011_39189# uio_oe[0] sky130_fd_pr__special_nfet_01v8 ad=0.066 pd=0.745 as=0.0594 ps=0.69 w=0.36 l=0.15
X305 a_36327_34293# a_36503_34293# a_36455_34319# uio_oe[0] sky130_fd_pr__nfet_01v8 ad=0.1092 pd=1.36 as=0.0504 ps=0.66 w=0.42 l=0.15
X306 uio_oe[0] a_56916_35095# a_39647_34877# uio_oe[0] sky130_fd_pr__nfet_01v8 ad=0.097 pd=0.975 as=0.169 ps=1.82 w=0.65 l=0.15
X307 a_58914_42518# a_48677_39759# VDPWR VDPWR sky130_fd_pr__pfet_01v8_hvt ad=0.07665 pd=0.785 as=0.15835 ps=1.395 w=0.42 l=0.15
X308 a_44399_40474# a_45351_40821# VDPWR VDPWR sky130_fd_pr__pfet_01v8_hvt ad=0.26 pd=2.52 as=0.3012 ps=2.66 w=1 l=0.15
X309 uio_oe[0] a_44287_39215# a_44621_39535# uio_oe[0] sky130_fd_pr__nfet_01v8 ad=0.208 pd=1.94 as=0.25025 ps=1.42 w=0.65 l=0.15
X310 a_29788_10020# a_16812_8642# uio_oe[0] uio_oe[0] sky130_fd_pr__nfet_01v8 ad=1.4703 pd=10.72 as=1.4703 ps=10.72 w=5.07 l=1
X311 VDPWR a_57363_40989# a_57324_41115# VDPWR sky130_fd_pr__pfet_01v8_hvt ad=0.0864 pd=0.91 as=0.1664 ps=1.8 w=0.64 l=0.15
X312 a_38895_38671# a_37795_40535# a_38532_38823# uio_oe[0] sky130_fd_pr__nfet_01v8 ad=0.0693 pd=0.75 as=0.09975 ps=0.895 w=0.42 l=0.15
X313 a_37148_40125# a_36934_40125# VDPWR VDPWR sky130_fd_pr__pfet_01v8_hvt ad=0.1155 pd=0.97 as=0.07035 ps=0.755 w=0.42 l=0.15
X314 a_44537_38447# a_36425_36166# uio_oe[0] uio_oe[0] sky130_fd_pr__nfet_01v8 ad=0.08775 pd=0.92 as=0.08775 ps=0.92 w=0.65 l=0.15
X315 a_54406_35229# a_37361_41391# uio_oe[0] uio_oe[0] sky130_fd_pr__nfet_01v8 ad=0.0693 pd=0.75 as=0.11285 ps=1.045 w=0.42 l=0.15
X316 VDPWR a_47108_42857# a_47283_42783# VDPWR sky130_fd_pr__pfet_01v8_hvt ad=0.1134 pd=1.38 as=0.0567 ps=0.69 w=0.42 l=0.15
X317 uio_oe[0] a_51412_39447# a_50784_39189# uio_oe[0] sky130_fd_pr__nfet_01v8 ad=0.11285 pd=1.045 as=0.169 ps=1.82 w=0.65 l=0.15
X318 uio_oe[0] a_43713_36183# a_43504_37735# uio_oe[0] sky130_fd_pr__nfet_01v8 ad=0.10025 pd=0.985 as=0.169 ps=1.82 w=0.65 l=0.15
X319 a_54264_40535# a_51620_40571# a_54406_40669# uio_oe[0] sky130_fd_pr__nfet_01v8 ad=0.09975 pd=0.895 as=0.0693 ps=0.75 w=0.42 l=0.15
X320 a_49961_39759# a_49483_39733# uio_oe[0] uio_oe[0] sky130_fd_pr__nfet_01v8 ad=0.0669 pd=0.75 as=0.12495 ps=1.015 w=0.42 l=0.15
X321 uio_oe[0] a_38532_38823# a_21252_33417# uio_oe[0] sky130_fd_pr__nfet_01v8 ad=0.11285 pd=1.045 as=0.169 ps=1.82 w=0.65 l=0.15
X322 a_53937_34561# a_53719_34319# uio_oe[0] uio_oe[0] sky130_fd_pr__nfet_01v8 ad=0.0999 pd=0.985 as=0.1346 ps=1.15 w=0.64 l=0.15
X323 uio_oe[0] a_17689_32641# a_18801_33729# uio_oe[0] sky130_fd_pr__nfet_01v8 ad=0.1013 pd=0.99 as=0.0504 ps=0.66 w=0.42 l=0.15
X324 a_57664_40125# a_57450_40125# VDPWR VDPWR sky130_fd_pr__pfet_01v8_hvt ad=0.1155 pd=0.97 as=0.07035 ps=0.755 w=0.42 l=0.15
X325 a_51841_37557# a_48677_38127# VDPWR VDPWR sky130_fd_pr__pfet_01v8_hvt ad=0.1176 pd=1.4 as=0.0693 ps=0.75 w=0.42 l=0.15
X326 a_49920_34685# a_49483_34293# VDPWR VDPWR sky130_fd_pr__pfet_01v8_hvt ad=0.0567 pd=0.69 as=0.0819 ps=0.81 w=0.42 l=0.15
X327 a_37029_38127# a_36999_38101# VDPWR VDPWR sky130_fd_pr__pfet_01v8_hvt ad=0.135 pd=1.27 as=0.26 ps=2.52 w=1 l=0.15
X328 a_61987_38493# a_58980_38645# a_61624_38359# uio_oe[0] sky130_fd_pr__nfet_01v8 ad=0.0693 pd=0.75 as=0.09975 ps=0.895 w=0.42 l=0.15
X329 a_20972_34969# a_21180_34791# a_21114_34817# uio_oe[0] sky130_fd_pr__nfet_01v8 ad=0.09975 pd=0.895 as=0.0693 ps=0.75 w=0.42 l=0.15
X330 a_37361_41391# a_37195_41391# VDPWR VDPWR sky130_fd_pr__pfet_01v8_hvt ad=0.135 pd=1.27 as=0.135 ps=1.27 w=1 l=0.15
X331 a_41475_41430# a_41224_41659# a_41016_41623# VDPWR sky130_fd_pr__pfet_01v8_hvt ad=0.0441 pd=0.63 as=0.1932 ps=1.34 w=0.42 l=0.15
X332 a_40705_38493# a_40670_38259# a_40467_38101# uio_oe[0] sky130_fd_pr__nfet_01v8 ad=0.06405 pd=0.725 as=0.1092 ps=1.36 w=0.42 l=0.15
X333 a_21519_35727# a_17507_33198# a_21156_35593# uio_oe[0] sky130_fd_pr__nfet_01v8 ad=0.0693 pd=0.75 as=0.09975 ps=0.895 w=0.42 l=0.15
X334 VDPWR a_37913_43023# a_60563_40847# VDPWR sky130_fd_pr__pfet_01v8_hvt ad=0.0864 pd=0.91 as=0.1664 ps=1.8 w=0.64 l=0.15
X335 VDPWR a_43428_39593# a_43603_39519# VDPWR sky130_fd_pr__pfet_01v8_hvt ad=0.1134 pd=1.38 as=0.0567 ps=0.69 w=0.42 l=0.15
X336 uio_oe[0] a_22076_36681# a_21180_36967# uio_oe[0] sky130_fd_pr__nfet_01v8 ad=0.11285 pd=1.045 as=0.169 ps=1.82 w=0.65 l=0.15
X337 a_61175_41935# a_60729_41935# a_61079_41935# uio_oe[0] sky130_fd_pr__special_nfet_01v8 ad=0.1401 pd=1.1 as=0.0594 ps=0.69 w=0.36 l=0.15
X338 VDPWR a_39973_38425# a_40003_38166# VDPWR sky130_fd_pr__pfet_01v8_hvt ad=0.0693 pd=0.75 as=0.0441 ps=0.63 w=0.42 l=0.15
X339 a_18575_36815# a_18427_33198# a_18212_36681# uio_oe[0] sky130_fd_pr__nfet_01v8 ad=0.0693 pd=0.75 as=0.09975 ps=0.895 w=0.42 l=0.15
X340 a_25265_34791# a_24932_34969# VDPWR VDPWR sky130_fd_pr__pfet_01v8_hvt ad=0.1176 pd=1.4 as=0.0693 ps=0.75 w=0.42 l=0.15
X341 a_47108_41769# a_46027_41397# a_46761_41365# VDPWR sky130_fd_pr__pfet_01v8_hvt ad=0.0588 pd=0.7 as=0.12915 ps=1.185 w=0.42 l=0.15
X342 a_18442_26464# a_16756_10782# ua[4] uio_oe[0] sky130_fd_pr__nfet_01v8 ad=0.1885 pd=1.88 as=0.1885 ps=1.88 w=0.65 l=0.15
X343 a_57472_35141# a_41685_42479# VDPWR VDPWR sky130_fd_pr__pfet_01v8_hvt ad=0.1664 pd=1.8 as=0.0864 ps=0.91 w=0.64 l=0.15
X344 a_40769_38671# a_39127_34319# uio_oe[0] uio_oe[0] sky130_fd_pr__nfet_01v8 ad=0.0935 pd=0.965 as=0.1664 ps=1.8 w=0.64 l=0.15
X345 VDPWR a_56843_38645# a_38740_38645# VDPWR sky130_fd_pr__pfet_01v8_hvt ad=0.3012 pd=2.66 as=0.26 ps=2.52 w=1 l=0.15
X346 a_36455_34319# a_36425_34293# uio_oe[0] uio_oe[0] sky130_fd_pr__nfet_01v8 ad=0.0504 pd=0.66 as=0.1013 ps=0.99 w=0.42 l=0.15
X347 uio_oe[0] a_40467_39189# a_37335_37557# uio_oe[0] sky130_fd_pr__nfet_01v8 ad=0.2087 pd=2.02 as=0.169 ps=1.82 w=0.65 l=0.15
X348 a_42897_42453# a_42679_42857# VDPWR VDPWR sky130_fd_pr__pfet_01v8_hvt ad=0.12915 pd=1.185 as=0.2184 ps=2.2 w=0.84 l=0.15
X349 a_59860_41623# a_59956_41365# uio_oe[0] uio_oe[0] sky130_fd_pr__nfet_01v8 ad=0.1092 pd=1.36 as=0.097 ps=0.975 w=0.42 l=0.15
X350 a_60984_37583# a_60365_37583# VDPWR VDPWR sky130_fd_pr__pfet_01v8_hvt ad=0.0651 pd=0.73 as=0.1092 ps=1.36 w=0.42 l=0.15
X351 a_42651_39386# a_42643_36822# uio_oe[0] uio_oe[0] sky130_fd_pr__nfet_01v8 ad=0.169 pd=1.82 as=0.11285 ps=1.045 w=0.65 l=0.15
X352 a_40099_35925# a_40302_36083# VDPWR VDPWR sky130_fd_pr__pfet_01v8_hvt ad=0.0567 pd=0.69 as=0.1134 ps=1.38 w=0.42 l=0.15
X353 a_18442_26464# a_4259_22596# a_18146_24730# uio_oe[0] sky130_fd_pr__nfet_01v8 ad=0.2436 pd=2.26 as=0.2436 ps=2.26 w=0.84 l=0.6
X354 VDPWR a_37195_41391# a_37361_41391# VDPWR sky130_fd_pr__pfet_01v8_hvt ad=0.26 pd=2.52 as=0.135 ps=1.27 w=1 l=0.15
X355 VDPWR a_36661_41391# a_59685_41174# VDPWR sky130_fd_pr__pfet_01v8_hvt ad=0.0693 pd=0.75 as=0.1176 ps=1.4 w=0.42 l=0.15
X356 uio_oe[0] a_36661_41391# a_60160_38671# uio_oe[0] sky130_fd_pr__nfet_01v8 ad=0.11285 pd=1.045 as=0.0693 ps=0.75 w=0.42 l=0.15
X357 a_58772_38359# a_54479_38140# a_58914_38493# uio_oe[0] sky130_fd_pr__nfet_01v8 ad=0.09975 pd=0.895 as=0.0693 ps=0.75 w=0.42 l=0.15
X358 a_52579_35734# a_51620_35381# a_52507_35734# VDPWR sky130_fd_pr__pfet_01v8_hvt ad=0.1932 pd=1.34 as=0.0441 ps=0.63 w=0.42 l=0.15
X359 ua[4] a_16756_10376# a_18018_22020# uio_oe[0] sky130_fd_pr__nfet_01v8 ad=0.1885 pd=1.88 as=0.1885 ps=1.88 w=0.65 l=0.15
X360 VDPWR a_44327_38359# a_44537_38127# VDPWR sky130_fd_pr__pfet_01v8_hvt ad=0.26 pd=2.52 as=0.135 ps=1.27 w=1 l=0.15
X361 a_59956_37013# a_46193_39759# VDPWR VDPWR sky130_fd_pr__pfet_01v8_hvt ad=0.1092 pd=1.36 as=0.12285 ps=1.17 w=0.42 l=0.15
X362 a_42399_38101# a_42602_38259# VDPWR VDPWR sky130_fd_pr__pfet_01v8_hvt ad=0.0567 pd=0.69 as=0.1134 ps=1.38 w=0.42 l=0.15
X363 a_29129_36967# a_28796_37145# VDPWR VDPWR sky130_fd_pr__pfet_01v8_hvt ad=0.1176 pd=1.4 as=0.0693 ps=0.75 w=0.42 l=0.15
X364 VDPWR a_48125_43023# a_49483_41909# VDPWR sky130_fd_pr__pfet_01v8_hvt ad=0.0819 pd=0.81 as=0.0567 ps=0.69 w=0.42 l=0.15
X365 a_60988_39581# a_60720_39581# uio_oe[0] uio_oe[0] sky130_fd_pr__nfet_01v8 ad=0.06705 pd=0.75 as=0.0882 ps=0.84 w=0.42 l=0.15
X366 a_54393_36495# a_53203_36495# a_54284_36495# uio_oe[0] sky130_fd_pr__special_nfet_01v8 ad=0.0669 pd=0.75 as=0.0711 ps=0.755 w=0.36 l=0.15
X367 a_22218_33224# a_21252_33417# VDPWR VDPWR sky130_fd_pr__pfet_01v8_hvt ad=0.07665 pd=0.785 as=0.15835 ps=1.395 w=0.42 l=0.15
X368 VDPWR a_48125_41935# a_52335_39189# VDPWR sky130_fd_pr__pfet_01v8_hvt ad=0.0819 pd=0.81 as=0.0567 ps=0.69 w=0.42 l=0.15
X369 a_19588_10020# a_4259_22596# a_19410_10020# uio_oe[0] sky130_fd_pr__nfet_01v8 ad=0.2436 pd=2.26 as=0.2436 ps=2.26 w=0.84 l=0.6
X370 a_42329_42485# a_42163_42485# uio_oe[0] uio_oe[0] sky130_fd_pr__nfet_01v8 ad=0.1092 pd=1.36 as=0.0567 ps=0.69 w=0.42 l=0.15
X371 a_58772_42711# a_39752_42747# a_58914_42518# VDPWR sky130_fd_pr__pfet_01v8_hvt ad=0.1932 pd=1.34 as=0.07665 ps=0.785 w=0.42 l=0.15
X372 a_53005_40847# a_52579_41174# uio_oe[0] uio_oe[0] sky130_fd_pr__nfet_01v8 ad=0.169 pd=1.82 as=0.11285 ps=1.045 w=0.65 l=0.15
X373 uio_oe[0] a_39973_41689# a_39907_41757# uio_oe[0] sky130_fd_pr__nfet_01v8 ad=0.1449 pd=1.11 as=0.0693 ps=0.75 w=0.42 l=0.15
X374 VDPWR a_41040_38645# a_40950_39037# VDPWR sky130_fd_pr__pfet_01v8_hvt ad=0.0798 pd=0.8 as=0.0945 ps=0.87 w=0.42 l=0.15
X375 a_37661_37052# a_41763_37557# uio_oe[0] uio_oe[0] sky130_fd_pr__nfet_01v8 ad=0.169 pd=1.82 as=0.2087 ps=2.02 w=0.65 l=0.15
X376 a_40775_35644# a_40580_35675# a_41085_35407# uio_oe[0] sky130_fd_pr__special_nfet_01v8 ad=0.0594 pd=0.69 as=0.1401 ps=1.1 w=0.36 l=0.15
X377 a_36530_40011# a_36847_39901# a_36805_39759# uio_oe[0] sky130_fd_pr__special_nfet_01v8 ad=0.0711 pd=0.755 as=0.0669 ps=0.75 w=0.36 l=0.15
X378 a_53827_40125# a_48125_41935# VDPWR VDPWR sky130_fd_pr__pfet_01v8_hvt ad=0.1092 pd=1.36 as=0.07035 ps=0.755 w=0.42 l=0.15
X379 ua[5] a_20620_10376# a_23274_10020# uio_oe[0] sky130_fd_pr__nfet_01v8 ad=0.1885 pd=1.88 as=0.1885 ps=1.88 w=0.65 l=0.15
X380 a_52579_35407# a_52325_35734# uio_oe[0] uio_oe[0] sky130_fd_pr__nfet_01v8 ad=0.0693 pd=0.75 as=0.1449 ps=1.11 w=0.42 l=0.15
X381 a_45176_41935# a_44095_41935# a_44829_42177# VDPWR sky130_fd_pr__pfet_01v8_hvt ad=0.0588 pd=0.7 as=0.12915 ps=1.185 w=0.42 l=0.15
X382 a_39544_40999# a_39752_40821# a_39686_40847# uio_oe[0] sky130_fd_pr__nfet_01v8 ad=0.09975 pd=0.895 as=0.0693 ps=0.75 w=0.42 l=0.15
X383 a_36565_39581# a_36530_39347# a_36327_39189# uio_oe[0] sky130_fd_pr__nfet_01v8 ad=0.06405 pd=0.725 as=0.1092 ps=1.36 w=0.42 l=0.15
X384 a_22306_22464# a_20620_10782# ua[4] uio_oe[0] sky130_fd_pr__nfet_01v8 ad=0.1885 pd=1.88 as=0.1885 ps=1.88 w=0.65 l=0.15
X385 uio_oe[0] a_62237_35161# a_62171_35229# uio_oe[0] sky130_fd_pr__nfet_01v8 ad=0.1449 pd=1.11 as=0.0693 ps=0.75 w=0.42 l=0.15
X386 a_52579_41174# a_51620_41659# a_52579_40847# uio_oe[0] sky130_fd_pr__nfet_01v8 ad=0.09975 pd=0.895 as=0.0693 ps=0.75 w=0.42 l=0.15
X387 VDPWR a_43081_39189# a_42971_39215# VDPWR sky130_fd_pr__pfet_01v8_hvt ad=0.07035 pd=0.755 as=0.1155 ps=0.97 w=0.42 l=0.15
X388 a_51554_35734# a_48677_38127# VDPWR VDPWR sky130_fd_pr__pfet_01v8_hvt ad=0.07665 pd=0.785 as=0.15835 ps=1.395 w=0.42 l=0.15
X389 a_50722_40303# a_49964_40419# a_50159_40277# VDPWR sky130_fd_pr__pfet_01v8_hvt ad=0.0651 pd=0.73 as=0.07245 ps=0.765 w=0.42 l=0.15
X390 a_60365_39759# a_59939_40086# VDPWR VDPWR sky130_fd_pr__pfet_01v8_hvt ad=0.26 pd=2.52 as=0.15835 ps=1.395 w=1 l=0.15
X391 a_36425_35381# a_43695_38645# uio_oe[0] uio_oe[0] sky130_fd_pr__nfet_01v8 ad=0.169 pd=1.82 as=0.2087 ps=2.02 w=0.65 l=0.15
X392 a_19834_18464# a_16756_18782# ua[4] uio_oe[0] sky130_fd_pr__nfet_01v8 ad=0.1885 pd=1.88 as=0.1885 ps=1.88 w=0.65 l=0.15
X393 a_37913_41935# a_37747_41935# VDPWR VDPWR sky130_fd_pr__pfet_01v8_hvt ad=0.135 pd=1.27 as=0.135 ps=1.27 w=1 l=0.15
X394 a_18148_18782# a_18011_33757# VDPWR VDPWR sky130_fd_pr__pfet_01v8_hvt ad=0.475 pd=2.95 as=0.16655 ps=1.39 w=1 l=0.15
X395 VDPWR a_47108_41769# a_47283_41695# VDPWR sky130_fd_pr__pfet_01v8_hvt ad=0.1134 pd=1.38 as=0.0567 ps=0.69 w=0.42 l=0.15
X396 a_17423_33007# a_17243_33007# VDPWR VDPWR sky130_fd_pr__pfet_01v8_hvt ad=0.0609 pd=0.71 as=0.0714 ps=0.76 w=0.42 l=0.15
X397 a_49961_38671# a_49483_38645# uio_oe[0] uio_oe[0] sky130_fd_pr__nfet_01v8 ad=0.0669 pd=0.75 as=0.12495 ps=1.015 w=0.42 l=0.15
X398 a_51775_36317# a_38771_35967# a_51412_36183# uio_oe[0] sky130_fd_pr__nfet_01v8 ad=0.0693 pd=0.75 as=0.09975 ps=0.895 w=0.42 l=0.15
X399 a_22306_22464# a_4259_22596# a_22010_20730# uio_oe[0] sky130_fd_pr__nfet_01v8 ad=0.2436 pd=2.26 as=0.2436 ps=2.26 w=0.84 l=0.6
X400 a_53719_38671# a_53369_38671# a_53624_38671# VDPWR sky130_fd_pr__pfet_01v8_hvt ad=0.07245 pd=0.765 as=0.0651 ps=0.73 w=0.42 l=0.15
X401 a_46448_41935# ui_in[4] uio_oe[0] uio_oe[0] sky130_fd_pr__nfet_01v8 ad=0.066 pd=0.745 as=0.2205 ps=1.89 w=0.42 l=0.15
X402 a_50003_42077# a_38649_43023# uio_oe[0] uio_oe[0] sky130_fd_pr__nfet_01v8 ad=0.1092 pd=1.36 as=0.0567 ps=0.69 w=0.42 l=0.15
X403 uio_oe[0] a_51841_41689# a_51775_41757# uio_oe[0] sky130_fd_pr__nfet_01v8 ad=0.1449 pd=1.11 as=0.0693 ps=0.75 w=0.42 l=0.15
X404 a_51841_40601# a_48677_39759# uio_oe[0] uio_oe[0] sky130_fd_pr__nfet_01v8 ad=0.1092 pd=1.36 as=0.1449 ps=1.11 w=0.42 l=0.15
X405 uio_oe[0] a_52335_37013# a_51620_37307# uio_oe[0] sky130_fd_pr__nfet_01v8 ad=0.2087 pd=2.02 as=0.169 ps=1.82 w=0.65 l=0.15
X406 VDPWR a_41400_35656# a_41338_35773# VDPWR sky130_fd_pr__pfet_01v8_hvt ad=0.1092 pd=1.36 as=0.0651 ps=0.73 w=0.42 l=0.15
X407 a_19834_18464# ua[3] a_19588_18020# uio_oe[0] sky130_fd_pr__nfet_01v8 ad=0.2436 pd=2.26 as=0.2436 ps=2.26 w=0.84 l=0.6
X408 a_51554_35407# a_48677_38127# uio_oe[0] uio_oe[0] sky130_fd_pr__nfet_01v8 ad=0.0693 pd=0.75 as=0.11285 ps=1.045 w=0.42 l=0.15
X409 a_60302_40303# a_60176_40419# a_59898_40435# uio_oe[0] sky130_fd_pr__special_nfet_01v8 ad=0.0999 pd=0.985 as=0.0711 ps=0.755 w=0.36 l=0.15
X410 a_43419_41909# a_39947_42997# VDPWR VDPWR sky130_fd_pr__pfet_01v8_hvt ad=0.0567 pd=0.69 as=0.0819 ps=0.81 w=0.42 l=0.15
X411 a_51412_40999# a_51620_40821# a_51554_40847# uio_oe[0] sky130_fd_pr__nfet_01v8 ad=0.09975 pd=0.895 as=0.0693 ps=0.75 w=0.42 l=0.15
X412 uio_oe[0] a_59201_36469# a_59135_36495# uio_oe[0] sky130_fd_pr__nfet_01v8 ad=0.1449 pd=1.11 as=0.0693 ps=0.75 w=0.42 l=0.15
X413 uio_oe[0] a_37433_35665# a_37465_35407# uio_oe[0] sky130_fd_pr__nfet_01v8 ad=0.1013 pd=0.99 as=0.0504 ps=0.66 w=0.42 l=0.15
X414 ua[4] a_16756_14782# a_19410_14020# uio_oe[0] sky130_fd_pr__nfet_01v8 ad=0.1885 pd=1.88 as=0.1885 ps=1.88 w=0.65 l=0.15
X415 a_53156_42479# a_52942_42479# VDPWR VDPWR sky130_fd_pr__pfet_01v8_hvt ad=0.1155 pd=0.97 as=0.07035 ps=0.755 w=0.42 l=0.15
X416 a_53321_40669# a_52942_40303# a_53249_40669# uio_oe[0] sky130_fd_pr__nfet_01v8 ad=0.1401 pd=1.1 as=0.0441 ps=0.63 w=0.42 l=0.15
X417 a_50090_39215# a_49964_39331# a_49686_39347# uio_oe[0] sky130_fd_pr__special_nfet_01v8 ad=0.0999 pd=0.985 as=0.0711 ps=0.755 w=0.36 l=0.15
X418 uio_oe[0] a_54264_38359# a_53636_38101# uio_oe[0] sky130_fd_pr__nfet_01v8 ad=0.11285 pd=1.045 as=0.169 ps=1.82 w=0.65 l=0.15
X419 uio_oe[0] a_22076_35593# a_21180_35879# uio_oe[0] sky130_fd_pr__nfet_01v8 ad=0.11285 pd=1.045 as=0.169 ps=1.82 w=0.65 l=0.15
X420 a_17721_34571# a_17388_34505# uio_oe[0] uio_oe[0] sky130_fd_pr__nfet_01v8 ad=0.1092 pd=1.36 as=0.1449 ps=1.11 w=0.42 l=0.15
X421 a_57012_34837# a_57556_34837# a_57514_34863# VDPWR sky130_fd_pr__pfet_01v8_hvt ad=0.0819 pd=0.81 as=0.0441 ps=0.63 w=0.42 l=0.15
X422 uio_oe[0] a_42347_38127# a_45285_39581# uio_oe[0] sky130_fd_pr__nfet_01v8 ad=0.1013 pd=0.99 as=0.0504 ps=0.66 w=0.42 l=0.15
X423 uio_oe[0] a_43559_35407# a_46013_38823# uio_oe[0] sky130_fd_pr__nfet_01v8 ad=0.1092 pd=1.36 as=0.0567 ps=0.69 w=0.42 l=0.15
X424 ua[5] a_25876_18376# a_25746_18020# uio_oe[0] sky130_fd_pr__nfet_01v8 ad=0.1885 pd=1.88 as=0.1885 ps=1.88 w=0.65 l=0.15
X425 a_47462_40847# a_39947_42997# uio_oe[0] uio_oe[0] sky130_fd_pr__nfet_01v8 ad=0.06405 pd=0.725 as=0.12495 ps=1.015 w=0.42 l=0.15
X426 a_39947_42997# a_41231_42997# VDPWR VDPWR sky130_fd_pr__pfet_01v8_hvt ad=0.135 pd=1.27 as=0.135 ps=1.27 w=1 l=0.15
X427 a_38674_42845# a_38005_40847# uio_oe[0] uio_oe[0] sky130_fd_pr__nfet_01v8 ad=0.0693 pd=0.75 as=0.11285 ps=1.045 w=0.42 l=0.15
X428 VDPWR a_37029_42479# a_42163_42485# VDPWR sky130_fd_pr__pfet_01v8_hvt ad=0.0864 pd=0.91 as=0.1664 ps=1.8 w=0.64 l=0.15
X429 a_57450_40125# a_57363_39901# a_57046_40011# VDPWR sky130_fd_pr__pfet_01v8_hvt ad=0.12915 pd=1.185 as=0.0588 ps=0.7 w=0.42 l=0.15
X430 a_42897_41365# a_42679_41769# VDPWR VDPWR sky130_fd_pr__pfet_01v8_hvt ad=0.12915 pd=1.185 as=0.2184 ps=2.2 w=0.84 l=0.15
X431 a_58044_34863# a_57776_35229# VDPWR VDPWR sky130_fd_pr__pfet_01v8_hvt ad=0.0945 pd=0.87 as=0.0798 ps=0.8 w=0.42 l=0.15
X432 a_40003_42518# a_39752_42747# a_39544_42711# VDPWR sky130_fd_pr__pfet_01v8_hvt ad=0.0441 pd=0.63 as=0.1932 ps=1.34 w=0.42 l=0.15
X433 a_23698_14464# a_20620_14376# ua[4] uio_oe[0] sky130_fd_pr__nfet_01v8 ad=0.1885 pd=1.88 as=0.1885 ps=1.88 w=0.65 l=0.15
X434 VDPWR a_21553_32641# a_21875_33757# VDPWR sky130_fd_pr__pfet_01v8_hvt ad=0.16655 pd=1.39 as=0.0567 ps=0.69 w=0.42 l=0.15
X435 a_60984_36495# a_60365_36495# VDPWR VDPWR sky130_fd_pr__pfet_01v8_hvt ad=0.0651 pd=0.73 as=0.1092 ps=1.36 w=0.42 l=0.15
X436 VDPWR a_44905_38671# a_49483_35381# VDPWR sky130_fd_pr__pfet_01v8_hvt ad=0.0819 pd=0.81 as=0.0567 ps=0.69 w=0.42 l=0.15
X437 uio_oe[0] a_42793_35559# a_40403_34876# uio_oe[0] sky130_fd_pr__nfet_01v8 ad=0.10025 pd=0.985 as=0.169 ps=1.82 w=0.65 l=0.15
X438 a_41224_41659# a_45351_42783# VDPWR VDPWR sky130_fd_pr__pfet_01v8_hvt ad=0.26 pd=2.52 as=0.3012 ps=2.66 w=1 l=0.15
X439 uio_oe[0] a_37029_42479# a_46027_40309# uio_oe[0] sky130_fd_pr__nfet_01v8 ad=0.0567 pd=0.69 as=0.1092 ps=1.36 w=0.42 l=0.15
X440 a_29247_34639# a_17507_33198# a_28884_34505# uio_oe[0] sky130_fd_pr__nfet_01v8 ad=0.0693 pd=0.75 as=0.09975 ps=0.895 w=0.42 l=0.15
X441 VDPWR a_48125_43023# a_57664_42479# VDPWR sky130_fd_pr__pfet_01v8_hvt ad=0.07035 pd=0.755 as=0.1092 ps=1.36 w=0.42 l=0.15
X442 a_40464_40999# a_37579_34319# a_40606_40847# uio_oe[0] sky130_fd_pr__nfet_01v8 ad=0.09975 pd=0.895 as=0.0693 ps=0.75 w=0.42 l=0.15
X443 VDPWR a_61819_39733# a_61806_40125# VDPWR sky130_fd_pr__pfet_01v8_hvt ad=0.0819 pd=0.81 as=0.0567 ps=0.69 w=0.42 l=0.15
X444 a_40208_43023# a_39127_43023# a_39861_43265# VDPWR sky130_fd_pr__pfet_01v8_hvt ad=0.0588 pd=0.7 as=0.12915 ps=1.185 w=0.42 l=0.15
X445 uio_oe[0] a_59695_42453# a_54479_42492# uio_oe[0] sky130_fd_pr__nfet_01v8 ad=0.2087 pd=2.02 as=0.169 ps=1.82 w=0.65 l=0.15
X446 uio_oe[0] a_39555_36183# a_28796_37145# uio_oe[0] sky130_fd_pr__nfet_01v8 ad=0.1118 pd=1.04 as=0.182 ps=1.86 w=0.65 l=0.15
X447 a_58914_40847# a_48677_39759# uio_oe[0] uio_oe[0] sky130_fd_pr__nfet_01v8 ad=0.0693 pd=0.75 as=0.11285 ps=1.045 w=0.42 l=0.15
X448 uio_oe[0] a_37913_41935# a_53203_37583# uio_oe[0] sky130_fd_pr__nfet_01v8 ad=0.0567 pd=0.69 as=0.1092 ps=1.36 w=0.42 l=0.15
X449 a_37465_35407# a_37195_35773# a_37375_35773# uio_oe[0] sky130_fd_pr__nfet_01v8 ad=0.0504 pd=0.66 as=0.1092 ps=1.36 w=0.42 l=0.15
X450 a_28396_10020# a_16812_8642# uio_oe[0] uio_oe[0] sky130_fd_pr__nfet_01v8 ad=1.4703 pd=10.72 as=1.4703 ps=10.72 w=5.07 l=1
X451 ua[5] a_16756_10782# a_19410_26020# uio_oe[0] sky130_fd_pr__nfet_01v8 ad=0.1885 pd=1.88 as=0.1885 ps=1.88 w=0.65 l=0.15
X452 a_23698_14464# ua[2] a_23452_14020# uio_oe[0] sky130_fd_pr__nfet_01v8 ad=0.2436 pd=2.26 as=0.2436 ps=2.26 w=0.84 l=0.6
X453 a_30233_33483# a_28980_33417# VDPWR VDPWR sky130_fd_pr__pfet_01v8_hvt ad=0.1176 pd=1.4 as=0.0693 ps=0.75 w=0.42 l=0.15
X454 a_49920_40303# a_49483_40277# VDPWR VDPWR sky130_fd_pr__pfet_01v8_hvt ad=0.0567 pd=0.69 as=0.0819 ps=0.81 w=0.42 l=0.15
X455 a_53011_35925# a_52855_36193# a_53156_35951# VDPWR sky130_fd_pr__pfet_01v8_hvt ad=0.07245 pd=0.765 as=0.1155 ps=0.97 w=0.42 l=0.15
X456 a_51412_35559# a_39783_35409# a_51554_35734# VDPWR sky130_fd_pr__pfet_01v8_hvt ad=0.1932 pd=1.34 as=0.07665 ps=0.785 w=0.42 l=0.15
X457 a_36847_39901# a_37029_42479# VDPWR VDPWR sky130_fd_pr__pfet_01v8_hvt ad=0.1664 pd=1.8 as=0.0864 ps=0.91 w=0.64 l=0.15
X458 a_45285_39581# a_45015_39215# a_45195_39215# uio_oe[0] sky130_fd_pr__nfet_01v8 ad=0.0504 pd=0.66 as=0.1092 ps=1.36 w=0.42 l=0.15
X459 VDPWR a_17500_33453# a_18420_33453# VDPWR sky130_fd_pr__pfet_01v8_hvt ad=0.26 pd=2.52 as=0.26 ps=2.52 w=1 l=0.15
X460 uio_oe[0] a_60371_35925# a_60302_35951# uio_oe[0] sky130_fd_pr__nfet_01v8 ad=0.1346 pd=1.15 as=0.0999 ps=0.985 w=0.64 l=0.15
X461 VDPWR a_60215_40545# a_60176_40419# VDPWR sky130_fd_pr__pfet_01v8_hvt ad=0.0864 pd=0.91 as=0.1664 ps=1.8 w=0.64 l=0.15
X462 a_43006_38127# a_42880_38243# a_42602_38259# uio_oe[0] sky130_fd_pr__special_nfet_01v8 ad=0.0999 pd=0.985 as=0.0711 ps=0.755 w=0.36 l=0.15
X463 a_52855_38369# a_37913_41935# uio_oe[0] uio_oe[0] sky130_fd_pr__nfet_01v8 ad=0.1092 pd=1.36 as=0.0567 ps=0.69 w=0.42 l=0.15
X464 a_51871_42518# a_51620_42747# a_51412_42711# VDPWR sky130_fd_pr__pfet_01v8_hvt ad=0.0441 pd=0.63 as=0.1932 ps=1.34 w=0.42 l=0.15
X465 VDPWR a_62237_35161# a_62267_34902# VDPWR sky130_fd_pr__pfet_01v8_hvt ad=0.0693 pd=0.75 as=0.0441 ps=0.63 w=0.42 l=0.15
X466 a_28642_26464# a_28348_10782# ua[4] uio_oe[0] sky130_fd_pr__nfet_01v8 ad=0.1885 pd=1.88 as=0.1885 ps=1.88 w=0.65 l=0.15
X467 a_57363_39901# a_38649_43023# uio_oe[0] uio_oe[0] sky130_fd_pr__nfet_01v8 ad=0.1092 pd=1.36 as=0.0567 ps=0.69 w=0.42 l=0.15
X468 a_59939_37910# a_58980_37557# a_59867_37910# VDPWR sky130_fd_pr__pfet_01v8_hvt ad=0.1932 pd=1.34 as=0.0441 ps=0.63 w=0.42 l=0.15
X469 a_57829_36495# a_57450_36861# a_57757_36495# uio_oe[0] sky130_fd_pr__nfet_01v8 ad=0.1401 pd=1.1 as=0.0441 ps=0.63 w=0.42 l=0.15
X470 VDPWR a_48125_43023# a_50304_41213# VDPWR sky130_fd_pr__pfet_01v8_hvt ad=0.07035 pd=0.755 as=0.1092 ps=1.36 w=0.42 l=0.15
X471 a_23698_26464# a_20620_10376# ua[5] uio_oe[0] sky130_fd_pr__nfet_01v8 ad=0.1885 pd=1.88 as=0.1885 ps=1.88 w=0.65 l=0.15
X472 a_58980_34293# a_61819_34293# VDPWR VDPWR sky130_fd_pr__pfet_01v8_hvt ad=0.26 pd=2.52 as=0.3012 ps=2.66 w=1 l=0.15
X473 a_39548_43023# a_38285_42479# VDPWR VDPWR sky130_fd_pr__pfet_01v8_hvt ad=0.0651 pd=0.73 as=0.1092 ps=1.36 w=0.42 l=0.15
X474 a_41193_36495# a_41149_36737# a_41027_36495# uio_oe[0] sky130_fd_pr__nfet_01v8 ad=0.0441 pd=0.63 as=0.1401 ps=1.1 w=0.42 l=0.15
X475 VDPWR a_61297_41089# a_61187_41213# VDPWR sky130_fd_pr__pfet_01v8_hvt ad=0.07035 pd=0.755 as=0.1155 ps=0.97 w=0.42 l=0.15
X476 VDPWR a_47283_40607# a_47270_40303# VDPWR sky130_fd_pr__pfet_01v8_hvt ad=0.0819 pd=0.81 as=0.0567 ps=0.69 w=0.42 l=0.15
X477 a_28842_33729# a_28796_33881# uio_oe[0] uio_oe[0] sky130_fd_pr__nfet_01v8 ad=0.0693 pd=0.75 as=0.11285 ps=1.045 w=0.42 l=0.15
X478 a_57081_36495# a_57046_36747# a_56843_36469# uio_oe[0] sky130_fd_pr__nfet_01v8 ad=0.06405 pd=0.725 as=0.1092 ps=1.36 w=0.42 l=0.15
X479 a_28642_26464# a_4259_22596# a_28346_24730# uio_oe[0] sky130_fd_pr__nfet_01v8 ad=0.2436 pd=2.26 as=0.2436 ps=2.26 w=0.84 l=0.6
X480 a_60298_35229# a_46193_39759# uio_oe[0] uio_oe[0] sky130_fd_pr__nfet_01v8 ad=0.0483 pd=0.65 as=0.1137 ps=1.01 w=0.42 l=0.15
X481 a_25825_34845# a_24787_34817# a_25739_34845# uio_oe[0] sky130_fd_pr__nfet_01v8 ad=0.0567 pd=0.69 as=0.1176 ps=1.4 w=0.42 l=0.15
X482 a_42775_41935# a_42329_41935# a_42679_41935# uio_oe[0] sky130_fd_pr__special_nfet_01v8 ad=0.1401 pd=1.1 as=0.0594 ps=0.69 w=0.36 l=0.15
X483 a_43419_40607# a_43244_40681# a_43598_40669# uio_oe[0] sky130_fd_pr__nfet_01v8 ad=0.1092 pd=1.36 as=0.06405 ps=0.725 w=0.42 l=0.15
X484 a_42917_37557# a_38285_34863# VDPWR VDPWR sky130_fd_pr__pfet_01v8_hvt ad=0.1176 pd=1.4 as=0.0693 ps=0.75 w=0.42 l=0.15
X485 a_20620_14782# a_22575_36271# uio_oe[0] uio_oe[0] sky130_fd_pr__nfet_01v8 ad=0.169 pd=1.82 as=0.1013 ps=0.99 w=0.65 l=0.15
X486 VDPWR a_49483_34837# a_38771_34879# VDPWR sky130_fd_pr__pfet_01v8_hvt ad=0.3012 pd=2.66 as=0.26 ps=2.52 w=1 l=0.15
X487 a_62171_39581# a_58980_39733# a_61808_39447# uio_oe[0] sky130_fd_pr__nfet_01v8 ad=0.0693 pd=0.75 as=0.09975 ps=0.895 w=0.42 l=0.15
X488 a_42953_34837# a_43283_34319# uio_oe[0] uio_oe[0] sky130_fd_pr__nfet_01v8 ad=0.08775 pd=0.92 as=0.169 ps=1.82 w=0.65 l=0.15
X489 VDPWR a_25417_32641# a_26439_37359# VDPWR sky130_fd_pr__pfet_01v8_hvt ad=0.2279 pd=1.74 as=0.0609 ps=0.71 w=0.42 l=0.15
X490 uio_oe[0] a_52335_35925# a_51620_36219# uio_oe[0] sky130_fd_pr__nfet_01v8 ad=0.2087 pd=2.02 as=0.169 ps=1.82 w=0.65 l=0.15
X491 ua[4] a_28348_14376# a_28218_22020# uio_oe[0] sky130_fd_pr__nfet_01v8 ad=0.1885 pd=1.88 as=0.1885 ps=1.88 w=0.65 l=0.15
X492 VDPWR a_54264_42711# a_53636_42453# VDPWR sky130_fd_pr__pfet_01v8_hvt ad=0.15835 pd=1.395 as=0.26 ps=2.52 w=1 l=0.15
X493 a_50003_42077# a_38649_43023# VDPWR VDPWR sky130_fd_pr__pfet_01v8_hvt ad=0.1664 pd=1.8 as=0.0864 ps=0.91 w=0.64 l=0.15
X494 VDPWR a_53011_34837# a_52942_34863# VDPWR sky130_fd_pr__pfet_01v8_hvt ad=0.2184 pd=2.2 as=0.12915 ps=1.185 w=0.84 l=0.15
X495 a_60215_42721# a_37913_43023# VDPWR VDPWR sky130_fd_pr__pfet_01v8_hvt ad=0.1664 pd=1.8 as=0.0864 ps=0.91 w=0.64 l=0.15
X496 a_42863_39593# a_42347_39221# a_42768_39581# uio_oe[0] sky130_fd_pr__special_nfet_01v8 ad=0.0594 pd=0.69 as=0.066 ps=0.745 w=0.36 l=0.15
X497 uio_oe[0] a_22505_35659# a_22439_35727# uio_oe[0] sky130_fd_pr__nfet_01v8 ad=0.1449 pd=1.11 as=0.0693 ps=0.75 w=0.42 l=0.15
X498 a_53719_39759# a_53203_39759# a_53624_39759# uio_oe[0] sky130_fd_pr__special_nfet_01v8 ad=0.0594 pd=0.69 as=0.066 ps=0.745 w=0.36 l=0.15
X499 a_60729_39759# a_60563_39759# uio_oe[0] uio_oe[0] sky130_fd_pr__nfet_01v8 ad=0.1092 pd=1.36 as=0.0567 ps=0.69 w=0.42 l=0.15
X500 a_40673_37583# a_40507_37583# VDPWR VDPWR sky130_fd_pr__pfet_01v8_hvt ad=0.1664 pd=1.8 as=0.0864 ps=0.91 w=0.64 l=0.15
X501 a_36275_37039# a_18427_33198# uio_oe[0] uio_oe[0] sky130_fd_pr__nfet_01v8 ad=0.1092 pd=1.36 as=0.1092 ps=1.36 w=0.42 l=0.15
X502 a_41338_35951# a_40580_36067# a_40775_35925# VDPWR sky130_fd_pr__pfet_01v8_hvt ad=0.0651 pd=0.73 as=0.07245 ps=0.765 w=0.42 l=0.15
X503 a_25449_35659# a_25116_35593# uio_oe[0] uio_oe[0] sky130_fd_pr__nfet_01v8 ad=0.1092 pd=1.36 as=0.1449 ps=1.11 w=0.42 l=0.15
X504 a_36565_39759# a_36530_40011# a_36327_39733# uio_oe[0] sky130_fd_pr__nfet_01v8 ad=0.06405 pd=0.725 as=0.1092 ps=1.36 w=0.42 l=0.15
X505 a_59933_38493# a_59898_38259# a_59695_38101# uio_oe[0] sky130_fd_pr__nfet_01v8 ad=0.06405 pd=0.725 as=0.1092 ps=1.36 w=0.42 l=0.15
X506 a_29788_10020# a_4259_22596# a_29610_10020# uio_oe[0] sky130_fd_pr__nfet_01v8 ad=0.2436 pd=2.26 as=0.2436 ps=2.26 w=0.84 l=0.6
X507 a_17250_34817# a_17204_34969# uio_oe[0] uio_oe[0] sky130_fd_pr__nfet_01v8 ad=0.0693 pd=0.75 as=0.11285 ps=1.045 w=0.42 l=0.15
X508 a_53156_41391# a_52942_41391# VDPWR VDPWR sky130_fd_pr__pfet_01v8_hvt ad=0.1155 pd=0.97 as=0.07035 ps=0.755 w=0.42 l=0.15
X509 a_17721_33483# a_17388_33417# uio_oe[0] uio_oe[0] sky130_fd_pr__nfet_01v8 ad=0.1092 pd=1.36 as=0.1449 ps=1.11 w=0.42 l=0.15
X510 a_30167_34639# a_18427_33198# a_29804_34505# uio_oe[0] sky130_fd_pr__nfet_01v8 ad=0.0693 pd=0.75 as=0.09975 ps=0.895 w=0.42 l=0.15
X511 VDPWR a_40208_43023# a_40383_42997# VDPWR sky130_fd_pr__pfet_01v8_hvt ad=0.1134 pd=1.38 as=0.0567 ps=0.69 w=0.42 l=0.15
X512 a_43638_38127# a_42880_38243# a_43075_38101# VDPWR sky130_fd_pr__pfet_01v8_hvt ad=0.0651 pd=0.73 as=0.07245 ps=0.765 w=0.42 l=0.15
X513 a_36503_35381# a_17255_32793# VDPWR VDPWR sky130_fd_pr__pfet_01v8_hvt ad=0.1092 pd=1.36 as=0.0714 ps=0.76 w=0.42 l=0.15
X514 a_42605_38671# a_42439_38671# VDPWR VDPWR sky130_fd_pr__pfet_01v8_hvt ad=0.1664 pd=1.8 as=0.0864 ps=0.91 w=0.64 l=0.15
X515 a_54627_35229# a_54479_34876# a_54264_35095# uio_oe[0] sky130_fd_pr__nfet_01v8 ad=0.0693 pd=0.75 as=0.09975 ps=0.895 w=0.42 l=0.15
X516 uio_oe[0] a_54693_40601# a_54627_40669# uio_oe[0] sky130_fd_pr__nfet_01v8 ad=0.1449 pd=1.11 as=0.0693 ps=0.75 w=0.42 l=0.15
X517 uio_oe[0] a_37851_36647# a_40975_34569# uio_oe[0] sky130_fd_pr__nfet_01v8 ad=0.08775 pd=0.92 as=0.08775 ps=0.92 w=0.65 l=0.15
X518 a_50397_35229# a_44905_38671# uio_oe[0] uio_oe[0] sky130_fd_pr__nfet_01v8 ad=0.0441 pd=0.63 as=0.1346 ps=1.15 w=0.42 l=0.15
X519 VDPWR uio_in[0] a_37747_41935# VDPWR sky130_fd_pr__pfet_01v8_hvt ad=0.135 pd=1.27 as=0.26 ps=2.52 w=1 l=0.15
X520 a_58082_40125# a_57324_40027# a_57519_39996# VDPWR sky130_fd_pr__pfet_01v8_hvt ad=0.0651 pd=0.73 as=0.07245 ps=0.765 w=0.42 l=0.15
X521 uio_oe[0] a_60584_37353# a_60542_37405# uio_oe[0] sky130_fd_pr__nfet_01v8 ad=0.1092 pd=1.36 as=0.0441 ps=0.63 w=0.42 l=0.15
X522 a_41593_40847# a_41224_41659# uio_oe[0] uio_oe[0] sky130_fd_pr__nfet_01v8 ad=0.08775 pd=0.92 as=0.08775 ps=0.92 w=0.65 l=0.15
X523 a_59956_39189# a_60416_39493# a_60374_39581# uio_oe[0] sky130_fd_pr__nfet_01v8 ad=0.0693 pd=0.75 as=0.0441 ps=0.63 w=0.42 l=0.15
X524 a_29804_34505# a_18427_33198# a_29946_34312# VDPWR sky130_fd_pr__pfet_01v8_hvt ad=0.1932 pd=1.34 as=0.07665 ps=0.785 w=0.42 l=0.15
X525 a_40003_41430# a_39752_41659# a_39544_41623# VDPWR sky130_fd_pr__pfet_01v8_hvt ad=0.0441 pd=0.63 as=0.1932 ps=1.34 w=0.42 l=0.15
X526 a_42959_39759# a_42513_39759# a_42863_39759# uio_oe[0] sky130_fd_pr__special_nfet_01v8 ad=0.1401 pd=1.1 as=0.0594 ps=0.69 w=0.36 l=0.15
X527 VDPWR a_48125_43023# a_56843_42453# VDPWR sky130_fd_pr__pfet_01v8_hvt ad=0.0819 pd=0.81 as=0.0567 ps=0.69 w=0.42 l=0.15
X528 a_37029_38127# a_36999_38101# VDPWR VDPWR sky130_fd_pr__pfet_01v8_hvt ad=0.135 pd=1.27 as=0.135 ps=1.27 w=1 l=0.15
X529 a_17567_37320# a_17316_36967# a_17108_37145# VDPWR sky130_fd_pr__pfet_01v8_hvt ad=0.0441 pd=0.63 as=0.1932 ps=1.34 w=0.42 l=0.15
X530 a_29247_33551# a_17507_33198# a_28884_33417# uio_oe[0] sky130_fd_pr__nfet_01v8 ad=0.0693 pd=0.75 as=0.09975 ps=0.895 w=0.42 l=0.15
X531 a_41316_41909# a_45351_41695# VDPWR VDPWR sky130_fd_pr__pfet_01v8_hvt ad=0.26 pd=2.52 as=0.3012 ps=2.66 w=1 l=0.15
X532 uio_oe[0] a_29281_32641# a_29689_35933# uio_oe[0] sky130_fd_pr__nfet_01v8 ad=0.1118 pd=1.04 as=0.0567 ps=0.69 w=0.42 l=0.15
X533 VDPWR a_42917_37557# a_42947_37910# VDPWR sky130_fd_pr__pfet_01v8_hvt ad=0.0693 pd=0.75 as=0.0441 ps=0.63 w=0.42 l=0.15
X534 a_52855_36193# a_37913_41935# VDPWR VDPWR sky130_fd_pr__pfet_01v8_hvt ad=0.1664 pd=1.8 as=0.0864 ps=0.91 w=0.64 l=0.15
X535 uio_oe[0] a_61808_39447# a_61242_39445# uio_oe[0] sky130_fd_pr__nfet_01v8 ad=0.11285 pd=1.045 as=0.169 ps=1.82 w=0.65 l=0.15
X536 VDPWR a_36721_37039# a_37566_40125# VDPWR sky130_fd_pr__pfet_01v8_hvt ad=0.1092 pd=1.36 as=0.0651 ps=0.73 w=0.42 l=0.15
X537 a_43283_34319# a_43032_34569# VDPWR VDPWR sky130_fd_pr__pfet_01v8_hvt ad=0.34 pd=2.68 as=0.14575 ps=1.335 w=1 l=0.15
X538 uio_oe[0] uio_oe[0] uio_oe[0] uio_oe[0] sky130_fd_pr__nfet_01v8 ad=0.1885 pd=1.88 as=0 ps=0 w=0.65 l=0.15
X539 a_38532_39447# a_38740_39483# a_38674_39581# uio_oe[0] sky130_fd_pr__nfet_01v8 ad=0.09975 pd=0.895 as=0.0693 ps=0.75 w=0.42 l=0.15
X540 a_41528_39037# a_40581_38671# a_41420_39037# VDPWR sky130_fd_pr__pfet_01v8_hvt ad=0.0441 pd=0.63 as=0.0819 ps=0.81 w=0.42 l=0.15
X541 ua[4] a_28348_10782# a_29610_14020# uio_oe[0] sky130_fd_pr__nfet_01v8 ad=0.1885 pd=1.88 as=0.1885 ps=1.88 w=0.65 l=0.15
X542 a_57012_34837# a_57472_35141# a_57430_35229# uio_oe[0] sky130_fd_pr__nfet_01v8 ad=0.0693 pd=0.75 as=0.0441 ps=0.63 w=0.42 l=0.15
X543 a_56916_41623# a_57012_41365# uio_oe[0] uio_oe[0] sky130_fd_pr__nfet_01v8 ad=0.1092 pd=1.36 as=0.097 ps=0.975 w=0.42 l=0.15
X544 VDPWR a_21553_32641# a_22575_34095# VDPWR sky130_fd_pr__pfet_01v8_hvt ad=0.2279 pd=1.74 as=0.0609 ps=0.71 w=0.42 l=0.15
X545 a_53369_39759# a_53203_39759# VDPWR VDPWR sky130_fd_pr__pfet_01v8_hvt ad=0.1664 pd=1.8 as=0.0864 ps=0.91 w=0.64 l=0.15
X546 a_29063_36993# a_28835_36449# a_28700_37145# uio_oe[0] sky130_fd_pr__nfet_01v8 ad=0.0693 pd=0.75 as=0.09975 ps=0.895 w=0.42 l=0.15
X547 a_57450_35951# a_57324_36067# a_57046_36083# uio_oe[0] sky130_fd_pr__special_nfet_01v8 ad=0.0999 pd=0.985 as=0.0711 ps=0.755 w=0.36 l=0.15
X548 a_28884_35593# a_17500_33453# a_29026_35727# uio_oe[0] sky130_fd_pr__nfet_01v8 ad=0.09975 pd=0.895 as=0.0693 ps=0.75 w=0.42 l=0.15
X549 VDPWR a_44905_38671# a_50304_34685# VDPWR sky130_fd_pr__pfet_01v8_hvt ad=0.07035 pd=0.755 as=0.1092 ps=1.36 w=0.42 l=0.15
X550 a_51871_41430# a_51620_41659# a_51412_41623# VDPWR sky130_fd_pr__pfet_01v8_hvt ad=0.0441 pd=0.63 as=0.1932 ps=1.34 w=0.42 l=0.15
X551 a_51841_40601# a_48677_39759# VDPWR VDPWR sky130_fd_pr__pfet_01v8_hvt ad=0.1176 pd=1.4 as=0.0693 ps=0.75 w=0.42 l=0.15
X552 VDPWR a_39544_36647# a_24932_33881# VDPWR sky130_fd_pr__pfet_01v8_hvt ad=0.15835 pd=1.395 as=0.26 ps=2.52 w=1 l=0.15
X553 a_18442_10464# a_16756_10376# ua[4] uio_oe[0] sky130_fd_pr__nfet_01v8 ad=0.1885 pd=1.88 as=0.1885 ps=1.88 w=0.65 l=0.15
X554 VDPWR a_61297_34561# a_61187_34685# VDPWR sky130_fd_pr__pfet_01v8_hvt ad=0.07035 pd=0.755 as=0.1155 ps=0.97 w=0.42 l=0.15
X555 uio_oe[0] a_58144_42453# a_58082_42479# uio_oe[0] sky130_fd_pr__nfet_01v8 ad=0.2205 pd=1.89 as=0.066 ps=0.745 w=0.42 l=0.15
X556 a_57280_42301# a_56843_41909# VDPWR VDPWR sky130_fd_pr__pfet_01v8_hvt ad=0.0567 pd=0.69 as=0.0819 ps=0.81 w=0.42 l=0.15
X557 a_41039_37039# a_40415_37045# a_40931_37417# VDPWR sky130_fd_pr__pfet_01v8_hvt ad=0.1155 pd=0.97 as=0.07245 ps=0.765 w=0.42 l=0.15
X558 a_18801_34817# a_18531_35183# a_18711_35183# uio_oe[0] sky130_fd_pr__nfet_01v8 ad=0.0504 pd=0.66 as=0.1092 ps=1.36 w=0.42 l=0.15
X559 a_37003_39189# a_36808_39331# a_37313_39581# uio_oe[0] sky130_fd_pr__special_nfet_01v8 ad=0.0594 pd=0.69 as=0.1401 ps=1.1 w=0.36 l=0.15
X560 a_57363_38813# a_38649_43023# uio_oe[0] uio_oe[0] sky130_fd_pr__nfet_01v8 ad=0.1092 pd=1.36 as=0.0567 ps=0.69 w=0.42 l=0.15
X561 VDPWR a_38532_39911# a_21252_35593# VDPWR sky130_fd_pr__pfet_01v8_hvt ad=0.15835 pd=1.395 as=0.26 ps=2.52 w=1 l=0.15
X562 VDPWR a_43603_39733# a_43590_40125# VDPWR sky130_fd_pr__pfet_01v8_hvt ad=0.0819 pd=0.81 as=0.0567 ps=0.69 w=0.42 l=0.15
X563 a_53827_40125# a_53203_39759# a_53719_39759# VDPWR sky130_fd_pr__pfet_01v8_hvt ad=0.1155 pd=0.97 as=0.07245 ps=0.765 w=0.42 l=0.15
X564 VDPWR a_50003_38369# a_49964_38243# VDPWR sky130_fd_pr__pfet_01v8_hvt ad=0.0864 pd=0.91 as=0.1664 ps=1.8 w=0.64 l=0.15
X565 a_58772_37735# a_58980_37557# a_58914_37583# uio_oe[0] sky130_fd_pr__nfet_01v8 ad=0.09975 pd=0.895 as=0.0693 ps=0.75 w=0.42 l=0.15
X566 a_60934_42479# a_60176_42595# a_60371_42453# VDPWR sky130_fd_pr__pfet_01v8_hvt ad=0.0651 pd=0.73 as=0.07245 ps=0.765 w=0.42 l=0.15
X567 a_54638_40847# a_48125_41935# uio_oe[0] uio_oe[0] sky130_fd_pr__nfet_01v8 ad=0.06405 pd=0.725 as=0.12495 ps=1.015 w=0.42 l=0.15
X568 a_43695_38645# a_40379_35551# VDPWR VDPWR sky130_fd_pr__pfet_01v8_hvt ad=0.0567 pd=0.69 as=0.0819 ps=0.81 w=0.42 l=0.15
X569 a_17721_34571# a_17388_34505# VDPWR VDPWR sky130_fd_pr__pfet_01v8_hvt ad=0.1176 pd=1.4 as=0.0693 ps=0.75 w=0.42 l=0.15
X570 a_41537_41909# a_38285_34863# VDPWR VDPWR sky130_fd_pr__pfet_01v8_hvt ad=0.1176 pd=1.4 as=0.0693 ps=0.75 w=0.42 l=0.15
X571 a_61644_41935# a_60563_41935# a_61297_42177# VDPWR sky130_fd_pr__pfet_01v8_hvt ad=0.0588 pd=0.7 as=0.12915 ps=1.185 w=0.42 l=0.15
X572 a_18442_10464# ua[3] a_18196_10020# uio_oe[0] sky130_fd_pr__nfet_01v8 ad=0.2436 pd=2.26 as=0.2436 ps=2.26 w=0.84 l=0.6
X573 VDPWR a_41445_41689# a_41475_41430# VDPWR sky130_fd_pr__pfet_01v8_hvt ad=0.0693 pd=0.75 as=0.0441 ps=0.63 w=0.42 l=0.15
X574 VDPWR a_25940_36681# a_25044_36967# VDPWR sky130_fd_pr__pfet_01v8_hvt ad=0.15835 pd=1.395 as=0.26 ps=2.52 w=1 l=0.15
X575 a_16812_8642# a_16812_8642# uio_oe[0] uio_oe[0] sky130_fd_pr__nfet_01v8 ad=1.16 pd=8.29 as=1.16 ps=8.29 w=8 l=1
X576 a_29740_18782# a_29603_33757# VDPWR VDPWR sky130_fd_pr__pfet_01v8_hvt ad=0.475 pd=2.95 as=0.16655 ps=1.39 w=1 l=0.15
X577 a_50003_40545# a_38649_43023# VDPWR VDPWR sky130_fd_pr__pfet_01v8_hvt ad=0.1664 pd=1.8 as=0.0864 ps=0.91 w=0.64 l=0.15
X578 VDPWR a_60584_39529# a_60638_39215# VDPWR sky130_fd_pr__pfet_01v8_hvt ad=0.0567 pd=0.69 as=0.0483 ps=0.65 w=0.42 l=0.15
X579 VDPWR a_44905_38671# a_57664_37949# VDPWR sky130_fd_pr__pfet_01v8_hvt ad=0.07035 pd=0.755 as=0.1092 ps=1.36 w=0.42 l=0.15
X580 uio_oe[0] a_16812_8642# a_16754_16730# uio_oe[0] sky130_fd_pr__nfet_01v8 ad=1.4703 pd=10.72 as=1.4703 ps=10.72 w=5.07 l=1
X581 a_57640_35177# a_57556_34837# a_58044_35229# uio_oe[0] sky130_fd_pr__special_nfet_01v8 ad=0.072 pd=0.76 as=0.06705 ps=0.75 w=0.36 l=0.15
X582 a_60984_40847# a_60365_40847# uio_oe[0] uio_oe[0] sky130_fd_pr__nfet_01v8 ad=0.066 pd=0.745 as=0.2205 ps=1.89 w=0.42 l=0.15
X583 VDPWR a_25417_32641# a_26439_36271# VDPWR sky130_fd_pr__pfet_01v8_hvt ad=0.2279 pd=1.74 as=0.0609 ps=0.71 w=0.42 l=0.15
X584 a_42329_43023# a_42163_43023# VDPWR VDPWR sky130_fd_pr__pfet_01v8_hvt ad=0.1664 pd=1.8 as=0.0864 ps=0.91 w=0.64 l=0.15
X585 VDPWR a_54264_41623# a_53636_41365# VDPWR sky130_fd_pr__pfet_01v8_hvt ad=0.15835 pd=1.395 as=0.26 ps=2.52 w=1 l=0.15
X586 a_41612_38671# a_40415_38671# a_41420_39037# uio_oe[0] sky130_fd_pr__nfet_01v8 ad=0.0441 pd=0.63 as=0.0693 ps=0.75 w=0.42 l=0.15
X587 a_54284_36495# a_53369_36495# a_53937_36737# uio_oe[0] sky130_fd_pr__special_nfet_01v8 ad=0.0711 pd=0.755 as=0.0999 ps=0.985 w=0.36 l=0.15
X588 a_42329_41935# a_42163_41935# uio_oe[0] uio_oe[0] sky130_fd_pr__nfet_01v8 ad=0.1092 pd=1.36 as=0.0567 ps=0.69 w=0.42 l=0.15
X589 uio_oe[0] a_39973_40821# a_39907_40847# uio_oe[0] sky130_fd_pr__nfet_01v8 ad=0.1449 pd=1.11 as=0.0693 ps=0.75 w=0.42 l=0.15
X590 VDPWR a_51412_36647# a_50784_36744# VDPWR sky130_fd_pr__pfet_01v8_hvt ad=0.15835 pd=1.395 as=0.26 ps=2.52 w=1 l=0.15
X591 a_26170_18464# a_25876_18782# ua[5] uio_oe[0] sky130_fd_pr__nfet_01v8 ad=0.1885 pd=1.88 as=0.1885 ps=1.88 w=0.65 l=0.15
X592 ua[5] a_28348_10782# a_29610_26020# uio_oe[0] sky130_fd_pr__nfet_01v8 ad=0.1885 pd=1.88 as=0.1885 ps=1.88 w=0.65 l=0.15
X593 uio_oe[0] a_20972_34969# a_20923_34817# uio_oe[0] sky130_fd_pr__nfet_01v8 ad=0.11285 pd=1.045 as=0.169 ps=1.82 w=0.65 l=0.15
X594 uio_oe[0] a_36661_41391# a_52800_40847# uio_oe[0] sky130_fd_pr__nfet_01v8 ad=0.11285 pd=1.045 as=0.0693 ps=0.75 w=0.42 l=0.15
X595 a_53719_38671# a_53203_38671# a_53624_38671# uio_oe[0] sky130_fd_pr__special_nfet_01v8 ad=0.0594 pd=0.69 as=0.066 ps=0.745 w=0.36 l=0.15
X596 a_60729_38671# a_60563_38671# uio_oe[0] uio_oe[0] sky130_fd_pr__nfet_01v8 ad=0.1092 pd=1.36 as=0.0567 ps=0.69 w=0.42 l=0.15
X597 uio_oe[0] a_21553_32641# a_22665_36993# uio_oe[0] sky130_fd_pr__nfet_01v8 ad=0.1013 pd=0.99 as=0.0504 ps=0.66 w=0.42 l=0.15
X598 VDPWR a_60416_37317# a_60500_37013# VDPWR sky130_fd_pr__pfet_01v8_hvt ad=0.0864 pd=0.91 as=0.1664 ps=1.8 w=0.64 l=0.15
X599 a_42170_35990# a_37661_38140# VDPWR VDPWR sky130_fd_pr__pfet_01v8_hvt ad=0.07665 pd=0.785 as=0.15835 ps=1.395 w=0.42 l=0.15
X600 a_46331_40474# a_47283_40821# uio_oe[0] uio_oe[0] sky130_fd_pr__nfet_01v8 ad=0.169 pd=1.82 as=0.2087 ps=2.02 w=0.65 l=0.15
X601 a_60584_37353# a_60416_37317# a_60988_37039# VDPWR sky130_fd_pr__pfet_01v8_hvt ad=0.0567 pd=0.69 as=0.0945 ps=0.87 w=0.42 l=0.15
X602 VDPWR a_37183_40277# a_36607_39455# VDPWR sky130_fd_pr__pfet_01v8_hvt ad=0.135 pd=1.27 as=0.135 ps=1.27 w=1 l=0.15
X603 a_21401_36967# a_21068_37145# VDPWR VDPWR sky130_fd_pr__pfet_01v8_hvt ad=0.1176 pd=1.4 as=0.0693 ps=0.75 w=0.42 l=0.15
X604 a_29026_35727# a_28980_35593# uio_oe[0] uio_oe[0] sky130_fd_pr__nfet_01v8 ad=0.0693 pd=0.75 as=0.11285 ps=1.045 w=0.42 l=0.15
X605 a_18442_22464# a_16756_10376# ua[5] uio_oe[0] sky130_fd_pr__nfet_01v8 ad=0.1885 pd=1.88 as=0.1885 ps=1.88 w=0.65 l=0.15
X606 a_30167_33551# a_18427_33198# a_29804_33417# uio_oe[0] sky130_fd_pr__nfet_01v8 ad=0.0693 pd=0.75 as=0.09975 ps=0.895 w=0.42 l=0.15
X607 uio_oe[0] a_36835_38921# a_37169_38671# uio_oe[0] sky130_fd_pr__nfet_01v8 ad=0.208 pd=1.94 as=0.25025 ps=1.42 w=0.65 l=0.15
X608 uio_oe[0] a_36999_42453# a_37029_42479# uio_oe[0] sky130_fd_pr__nfet_01v8 ad=0.08775 pd=0.92 as=0.08775 ps=0.92 w=0.65 l=0.15
X609 a_24836_37145# a_24971_36449# a_24978_37320# VDPWR sky130_fd_pr__pfet_01v8_hvt ad=0.1932 pd=1.34 as=0.07665 ps=0.785 w=0.42 l=0.15
X610 a_60516_40303# a_60302_40303# VDPWR VDPWR sky130_fd_pr__pfet_01v8_hvt ad=0.1155 pd=0.97 as=0.07035 ps=0.755 w=0.42 l=0.15
X611 a_53249_39581# a_48125_41935# uio_oe[0] uio_oe[0] sky130_fd_pr__nfet_01v8 ad=0.0441 pd=0.63 as=0.1346 ps=1.15 w=0.42 l=0.15
X612 VDPWR a_36999_37557# a_37029_37583# VDPWR sky130_fd_pr__pfet_01v8_hvt ad=0.135 pd=1.27 as=0.135 ps=1.27 w=1 l=0.15
X613 a_48125_41935# a_47959_41935# VDPWR VDPWR sky130_fd_pr__pfet_01v8_hvt ad=0.135 pd=1.27 as=0.135 ps=1.27 w=1 l=0.15
X614 a_44905_38671# a_44739_38671# uio_oe[0] uio_oe[0] sky130_fd_pr__nfet_01v8 ad=0.08775 pd=0.92 as=0.08775 ps=0.92 w=0.65 l=0.15
X615 a_51775_35407# a_39783_35409# a_51412_35559# uio_oe[0] sky130_fd_pr__nfet_01v8 ad=0.0693 pd=0.75 as=0.09975 ps=0.895 w=0.42 l=0.15
X616 a_45351_42997# a_40379_35551# VDPWR VDPWR sky130_fd_pr__pfet_01v8_hvt ad=0.0567 pd=0.69 as=0.0819 ps=0.81 w=0.42 l=0.15
X617 VDPWR a_54459_41909# a_54446_42301# VDPWR sky130_fd_pr__pfet_01v8_hvt ad=0.0819 pd=0.81 as=0.0567 ps=0.69 w=0.42 l=0.15
X618 uio_oe[0] a_51841_40821# a_51775_40847# uio_oe[0] sky130_fd_pr__nfet_01v8 ad=0.1449 pd=1.11 as=0.0693 ps=0.75 w=0.42 l=0.15
X619 a_53937_41089# a_53719_40847# VDPWR VDPWR sky130_fd_pr__pfet_01v8_hvt ad=0.12915 pd=1.185 as=0.2184 ps=2.2 w=0.84 l=0.15
X620 VDPWR a_45431_39733# a_48511_38127# VDPWR sky130_fd_pr__pfet_01v8_hvt ad=0.135 pd=1.27 as=0.26 ps=2.52 w=1 l=0.15
X621 a_41143_39189# a_40987_39457# a_41288_39215# VDPWR sky130_fd_pr__pfet_01v8_hvt ad=0.07245 pd=0.765 as=0.1155 ps=0.97 w=0.42 l=0.15
X622 a_50304_39215# a_50090_39215# VDPWR VDPWR sky130_fd_pr__pfet_01v8_hvt ad=0.1155 pd=0.97 as=0.07035 ps=0.755 w=0.42 l=0.15
X623 uio_oe[0] a_46193_39759# a_61341_37583# uio_oe[0] sky130_fd_pr__nfet_01v8 ad=0.1346 pd=1.15 as=0.0441 ps=0.63 w=0.42 l=0.15
X624 a_59201_38425# a_48677_38127# VDPWR VDPWR sky130_fd_pr__pfet_01v8_hvt ad=0.1176 pd=1.4 as=0.0693 ps=0.75 w=0.42 l=0.15
X625 VDPWR a_61242_37269# a_61192_37039# VDPWR sky130_fd_pr__pfet_01v8_hvt ad=0.2184 pd=2.2 as=0.12495 ps=1.175 w=0.84 l=0.15
X626 a_20668_14020# a_16812_8642# uio_oe[0] uio_oe[0] sky130_fd_pr__nfet_01v8 ad=1.4703 pd=10.72 as=1.4703 ps=10.72 w=5.07 l=1
X627 a_59898_40435# a_60215_40545# a_60173_40669# uio_oe[0] sky130_fd_pr__special_nfet_01v8 ad=0.0711 pd=0.755 as=0.0669 ps=0.75 w=0.36 l=0.15
X628 a_41023_37583# a_40673_37583# a_40928_37583# VDPWR sky130_fd_pr__pfet_01v8_hvt ad=0.07245 pd=0.765 as=0.0651 ps=0.73 w=0.42 l=0.15
X629 a_24482_16730# ua[1] a_24354_18020# uio_oe[0] sky130_fd_pr__nfet_01v8 ad=0.2436 pd=2.26 as=0.2436 ps=2.26 w=0.84 l=0.6
X630 uio_oe[0] a_51412_35559# a_50784_35656# uio_oe[0] sky130_fd_pr__nfet_01v8 ad=0.11285 pd=1.045 as=0.169 ps=1.82 w=0.65 l=0.15
X631 VDPWR a_37433_35665# a_37375_35773# VDPWR sky130_fd_pr__pfet_01v8_hvt ad=0.2279 pd=1.74 as=0.0609 ps=0.71 w=0.42 l=0.15
X632 a_22665_36993# a_22395_37359# a_22575_37359# uio_oe[0] sky130_fd_pr__nfet_01v8 ad=0.0504 pd=0.66 as=0.1092 ps=1.36 w=0.42 l=0.15
X633 a_57280_35773# a_56843_35381# VDPWR VDPWR sky130_fd_pr__pfet_01v8_hvt ad=0.0567 pd=0.69 as=0.0819 ps=0.81 w=0.42 l=0.15
X634 a_38895_42845# a_37851_36647# a_38532_42711# uio_oe[0] sky130_fd_pr__nfet_01v8 ad=0.0693 pd=0.75 as=0.09975 ps=0.895 w=0.42 l=0.15
X635 VDPWR a_37335_37557# a_37839_40847# VDPWR sky130_fd_pr__pfet_01v8_hvt ad=0.135 pd=1.27 as=0.26 ps=2.52 w=1 l=0.15
X636 VDPWR a_42897_41089# a_42787_41213# VDPWR sky130_fd_pr__pfet_01v8_hvt ad=0.07035 pd=0.755 as=0.1155 ps=0.97 w=0.42 l=0.15
X637 a_49686_39347# a_50003_39457# a_49961_39581# uio_oe[0] sky130_fd_pr__special_nfet_01v8 ad=0.0711 pd=0.755 as=0.0669 ps=0.75 w=0.36 l=0.15
X638 VDPWR a_39555_34471# a_28796_33881# VDPWR sky130_fd_pr__pfet_01v8_hvt ad=0.16655 pd=1.39 as=0.475 ps=2.95 w=1 l=0.15
X639 a_38674_41935# a_38005_40847# uio_oe[0] uio_oe[0] sky130_fd_pr__nfet_01v8 ad=0.0693 pd=0.75 as=0.11285 ps=1.045 w=0.42 l=0.15
X640 a_22076_34505# a_18427_33198# a_22218_34312# VDPWR sky130_fd_pr__pfet_01v8_hvt ad=0.1932 pd=1.34 as=0.07665 ps=0.785 w=0.42 l=0.15
X641 a_53005_41935# a_52579_42262# VDPWR VDPWR sky130_fd_pr__pfet_01v8_hvt ad=0.26 pd=2.52 as=0.15835 ps=1.395 w=1 l=0.15
X642 uio_oe[0] a_16812_8642# a_22010_16730# uio_oe[0] sky130_fd_pr__nfet_01v8 ad=1.4703 pd=10.72 as=1.4703 ps=10.72 w=5.07 l=1
X643 a_61644_35407# a_60563_35407# a_61297_35649# VDPWR sky130_fd_pr__pfet_01v8_hvt ad=0.0588 pd=0.7 as=0.12915 ps=1.185 w=0.42 l=0.15
X644 a_50159_42172# a_50003_42077# a_50304_42301# VDPWR sky130_fd_pr__pfet_01v8_hvt ad=0.07245 pd=0.765 as=0.1155 ps=0.97 w=0.42 l=0.15
X645 a_22535_35400# a_18420_33453# a_22076_35593# VDPWR sky130_fd_pr__pfet_01v8_hvt ad=0.0441 pd=0.63 as=0.1932 ps=1.34 w=0.42 l=0.15
X646 VDPWR a_57363_35549# a_57324_35675# VDPWR sky130_fd_pr__pfet_01v8_hvt ad=0.0864 pd=0.91 as=0.1664 ps=1.8 w=0.64 l=0.15
X647 uio_oe[0] a_40893_40821# a_40827_40847# uio_oe[0] sky130_fd_pr__nfet_01v8 ad=0.1449 pd=1.11 as=0.0693 ps=0.75 w=0.42 l=0.15
X648 a_25449_35659# a_25116_35593# VDPWR VDPWR sky130_fd_pr__pfet_01v8_hvt ad=0.1176 pd=1.4 as=0.0693 ps=0.75 w=0.42 l=0.15
X649 a_19834_14464# a_16756_14782# ua[5] uio_oe[0] sky130_fd_pr__nfet_01v8 ad=0.1885 pd=1.88 as=0.1885 ps=1.88 w=0.65 l=0.15
X650 VDPWR a_40379_35551# a_41288_39215# VDPWR sky130_fd_pr__pfet_01v8_hvt ad=0.07035 pd=0.755 as=0.1092 ps=1.36 w=0.42 l=0.15
X651 a_43063_39037# a_40379_35551# VDPWR VDPWR sky130_fd_pr__pfet_01v8_hvt ad=0.1092 pd=1.36 as=0.07035 ps=0.755 w=0.42 l=0.15
X652 a_40525_34293# a_37661_37052# VDPWR VDPWR sky130_fd_pr__pfet_01v8_hvt ad=0.1176 pd=1.4 as=0.0693 ps=0.75 w=0.42 l=0.15
X653 VDPWR a_44905_38671# a_49483_34837# VDPWR sky130_fd_pr__pfet_01v8_hvt ad=0.0819 pd=0.81 as=0.0567 ps=0.69 w=0.42 l=0.15
X654 VDPWR uio_in[2] a_37195_41391# VDPWR sky130_fd_pr__pfet_01v8_hvt ad=0.135 pd=1.27 as=0.26 ps=2.52 w=1 l=0.15
X655 uio_oe[0] uio_oe[0] uio_oe[0] uio_oe[0] sky130_fd_pr__nfet_01v8 ad=0.1885 pd=1.88 as=0 ps=0 w=0.65 l=0.15
X656 uio_oe[0] a_43437_35095# a_43014_34471# uio_oe[0] sky130_fd_pr__nfet_01v8 ad=0.10025 pd=0.985 as=0.169 ps=1.82 w=0.65 l=0.15
X657 VDPWR a_41143_38101# a_41074_38127# VDPWR sky130_fd_pr__pfet_01v8_hvt ad=0.2184 pd=2.2 as=0.12915 ps=1.185 w=0.84 l=0.15
X658 a_52573_37405# a_52538_37171# a_52335_37013# uio_oe[0] sky130_fd_pr__nfet_01v8 ad=0.06405 pd=0.725 as=0.1092 ps=1.36 w=0.42 l=0.15
X659 a_42028_36183# a_36425_36166# a_42170_35990# VDPWR sky130_fd_pr__pfet_01v8_hvt ad=0.1932 pd=1.34 as=0.07665 ps=0.785 w=0.42 l=0.15
X660 a_50159_41084# a_49964_41115# a_50469_40847# uio_oe[0] sky130_fd_pr__special_nfet_01v8 ad=0.0594 pd=0.69 as=0.1401 ps=1.1 w=0.36 l=0.15
X661 VDPWR a_44905_38671# a_56843_37557# VDPWR sky130_fd_pr__pfet_01v8_hvt ad=0.0819 pd=0.81 as=0.0567 ps=0.69 w=0.42 l=0.15
X662 a_59231_37910# a_58980_37557# a_58772_37735# VDPWR sky130_fd_pr__pfet_01v8_hvt ad=0.0441 pd=0.63 as=0.1932 ps=1.34 w=0.42 l=0.15
X663 uio_oe[0] a_57363_36193# a_57324_36067# uio_oe[0] sky130_fd_pr__nfet_01v8 ad=0.0567 pd=0.69 as=0.1092 ps=1.36 w=0.42 l=0.15
X664 VDPWR a_25940_35593# a_25044_35879# VDPWR sky130_fd_pr__pfet_01v8_hvt ad=0.15835 pd=1.395 as=0.26 ps=2.52 w=1 l=0.15
X665 a_54723_40342# a_51620_40571# a_54264_40535# VDPWR sky130_fd_pr__pfet_01v8_hvt ad=0.0441 pd=0.63 as=0.1932 ps=1.34 w=0.42 l=0.15
X666 VDPWR a_44905_38671# a_57664_36861# VDPWR sky130_fd_pr__pfet_01v8_hvt ad=0.07035 pd=0.755 as=0.1092 ps=1.36 w=0.42 l=0.15
X667 uio_oe[0] a_58772_40999# a_58144_41096# uio_oe[0] sky130_fd_pr__nfet_01v8 ad=0.11285 pd=1.045 as=0.169 ps=1.82 w=0.65 l=0.15
X668 a_38532_39911# a_38740_39733# a_38674_39759# uio_oe[0] sky130_fd_pr__nfet_01v8 ad=0.09975 pd=0.895 as=0.0693 ps=0.75 w=0.42 l=0.15
X669 uio_oe[0] a_59956_34837# a_60092_34863# uio_oe[0] sky130_fd_pr__nfet_01v8 ad=0.1137 pd=1.01 as=0.1404 ps=1.6 w=0.54 l=0.15
X670 a_42329_41935# a_42163_41935# VDPWR VDPWR sky130_fd_pr__pfet_01v8_hvt ad=0.1664 pd=1.8 as=0.0864 ps=0.91 w=0.64 l=0.15
X671 uio_oe[0] a_53636_41365# a_53574_41391# uio_oe[0] sky130_fd_pr__nfet_01v8 ad=0.2205 pd=1.89 as=0.066 ps=0.745 w=0.42 l=0.15
X672 a_61297_41089# a_61079_40847# uio_oe[0] uio_oe[0] sky130_fd_pr__nfet_01v8 ad=0.0999 pd=0.985 as=0.1346 ps=1.15 w=0.64 l=0.15
X673 a_39759_36777# a_42039_35592# uio_oe[0] uio_oe[0] sky130_fd_pr__nfet_01v8 ad=0.25025 pd=1.42 as=0.208 ps=1.94 w=0.65 l=0.15
X674 ua[5] a_16756_10376# a_19410_10020# uio_oe[0] sky130_fd_pr__nfet_01v8 ad=0.1885 pd=1.88 as=0.1885 ps=1.88 w=0.65 l=0.15
X675 a_40525_34293# a_37661_37052# uio_oe[0] uio_oe[0] sky130_fd_pr__nfet_01v8 ad=0.1092 pd=1.36 as=0.1449 ps=1.11 w=0.42 l=0.15
X676 VDPWR a_37913_41935# a_60563_35407# VDPWR sky130_fd_pr__pfet_01v8_hvt ad=0.0864 pd=0.91 as=0.1664 ps=1.8 w=0.64 l=0.15
X677 uio_oe[0] a_61242_35093# a_61192_34863# uio_oe[0] sky130_fd_pr__nfet_01v8 ad=0.1664 pd=1.8 as=0.0935 ps=0.965 w=0.64 l=0.15
X678 uio_oe[0] a_57519_42172# a_57450_42301# uio_oe[0] sky130_fd_pr__nfet_01v8 ad=0.1346 pd=1.15 as=0.0999 ps=0.985 w=0.64 l=0.15
X679 uio_oe[0] a_45431_39733# a_48511_39759# uio_oe[0] sky130_fd_pr__nfet_01v8 ad=0.08775 pd=0.92 as=0.169 ps=1.82 w=0.65 l=0.15
X680 a_53011_37013# a_52855_37281# a_53156_37039# VDPWR sky130_fd_pr__pfet_01v8_hvt ad=0.07245 pd=0.765 as=0.1155 ps=0.97 w=0.42 l=0.15
X681 a_53815_35407# a_53369_35407# a_53719_35407# uio_oe[0] sky130_fd_pr__special_nfet_01v8 ad=0.1401 pd=1.1 as=0.0594 ps=0.69 w=0.36 l=0.15
X682 a_60365_41935# a_59939_42262# uio_oe[0] uio_oe[0] sky130_fd_pr__nfet_01v8 ad=0.169 pd=1.82 as=0.11285 ps=1.045 w=0.65 l=0.15
X683 a_37361_41391# a_37195_41391# VDPWR VDPWR sky130_fd_pr__pfet_01v8_hvt ad=0.135 pd=1.27 as=0.135 ps=1.27 w=1 l=0.15
X684 VDPWR a_36355_38101# a_36385_38127# VDPWR sky130_fd_pr__pfet_01v8_hvt ad=0.135 pd=1.27 as=0.135 ps=1.27 w=1 l=0.15
X685 uio_oe[0] a_48125_43023# a_57858_41757# uio_oe[0] sky130_fd_pr__nfet_01v8 ad=0.0882 pd=0.84 as=0.0441 ps=0.63 w=0.42 l=0.15
X686 VDPWR a_48125_43023# a_50304_40303# VDPWR sky130_fd_pr__pfet_01v8_hvt ad=0.07035 pd=0.755 as=0.1092 ps=1.36 w=0.42 l=0.15
X687 a_42637_38493# a_42602_38259# a_42399_38101# uio_oe[0] sky130_fd_pr__nfet_01v8 ad=0.06405 pd=0.725 as=0.1092 ps=1.36 w=0.42 l=0.15
X688 a_37859_37078# a_37901_37307# a_37859_37405# uio_oe[0] sky130_fd_pr__nfet_01v8 ad=0.09975 pd=0.895 as=0.0693 ps=0.75 w=0.42 l=0.15
X689 a_23452_18020# a_16812_8642# uio_oe[0] uio_oe[0] sky130_fd_pr__nfet_01v8 ad=1.4703 pd=10.72 as=1.4703 ps=10.72 w=5.07 l=1
X690 a_28642_10464# a_28348_10376# ua[4] uio_oe[0] sky130_fd_pr__nfet_01v8 ad=0.1885 pd=1.88 as=0.1885 ps=1.88 w=0.65 l=0.15
X691 VDPWR a_54459_35381# a_54446_35773# VDPWR sky130_fd_pr__pfet_01v8_hvt ad=0.0819 pd=0.81 as=0.0567 ps=0.69 w=0.42 l=0.15
X692 a_59939_42262# a_51620_41909# a_59939_41935# uio_oe[0] sky130_fd_pr__nfet_01v8 ad=0.09975 pd=0.895 as=0.0693 ps=0.75 w=0.42 l=0.15
X693 a_49483_41909# a_49686_42187# VDPWR VDPWR sky130_fd_pr__pfet_01v8_hvt ad=0.0567 pd=0.69 as=0.1134 ps=1.38 w=0.42 l=0.15
X694 a_23698_10464# a_20620_10782# ua[5] uio_oe[0] sky130_fd_pr__nfet_01v8 ad=0.1885 pd=1.88 as=0.1885 ps=1.88 w=0.65 l=0.15
X695 a_24836_36057# a_25044_35879# a_24978_35905# uio_oe[0] sky130_fd_pr__nfet_01v8 ad=0.09975 pd=0.895 as=0.0693 ps=0.75 w=0.42 l=0.15
X696 uio_oe[0] a_28700_33881# a_28651_33729# uio_oe[0] sky130_fd_pr__nfet_01v8 ad=0.11285 pd=1.045 as=0.169 ps=1.82 w=0.65 l=0.15
X697 VDPWR a_37361_41391# a_59685_35734# VDPWR sky130_fd_pr__pfet_01v8_hvt ad=0.0693 pd=0.75 as=0.1176 ps=1.4 w=0.42 l=0.15
X698 a_44829_42453# a_44611_42857# VDPWR VDPWR sky130_fd_pr__pfet_01v8_hvt ad=0.12915 pd=1.185 as=0.2184 ps=2.2 w=0.84 l=0.15
X699 a_53937_40001# a_53719_39759# VDPWR VDPWR sky130_fd_pr__pfet_01v8_hvt ad=0.12915 pd=1.185 as=0.2184 ps=2.2 w=0.84 l=0.15
X700 a_28642_10464# ua[0] a_28396_10020# uio_oe[0] sky130_fd_pr__nfet_01v8 ad=0.2436 pd=2.26 as=0.2436 ps=2.26 w=0.84 l=0.6
X701 a_45351_42783# a_45176_42857# a_45530_42845# uio_oe[0] sky130_fd_pr__nfet_01v8 ad=0.1092 pd=1.36 as=0.06405 ps=0.725 w=0.42 l=0.15
X702 VDPWR a_59201_42777# a_59231_42518# VDPWR sky130_fd_pr__pfet_01v8_hvt ad=0.0693 pd=0.75 as=0.0441 ps=0.63 w=0.42 l=0.15
X703 VDPWR a_37003_39189# a_36934_39215# VDPWR sky130_fd_pr__pfet_01v8_hvt ad=0.2184 pd=2.2 as=0.12915 ps=1.185 w=0.84 l=0.15
X704 VDPWR a_17292_33417# a_17243_33185# VDPWR sky130_fd_pr__pfet_01v8_hvt ad=0.15835 pd=1.395 as=0.26 ps=2.52 w=1 l=0.15
X705 VDPWR a_20923_34817# a_22395_35183# VDPWR sky130_fd_pr__pfet_01v8_hvt ad=0.0714 pd=0.76 as=0.1092 ps=1.36 w=0.42 l=0.15
X706 a_17471_34817# a_17243_34273# a_17108_34969# uio_oe[0] sky130_fd_pr__nfet_01v8 ad=0.0693 pd=0.75 as=0.09975 ps=0.895 w=0.42 l=0.15
X707 VDPWR a_51841_42777# a_51871_42518# VDPWR sky130_fd_pr__pfet_01v8_hvt ad=0.0693 pd=0.75 as=0.0441 ps=0.63 w=0.42 l=0.15
X708 uio_oe[0] a_41016_41623# a_40967_41391# uio_oe[0] sky130_fd_pr__nfet_01v8 ad=0.11285 pd=1.045 as=0.169 ps=1.82 w=0.65 l=0.15
X709 a_26439_34095# a_26259_34095# VDPWR VDPWR sky130_fd_pr__pfet_01v8_hvt ad=0.0609 pd=0.71 as=0.0714 ps=0.76 w=0.42 l=0.15
X710 a_61341_36495# a_61297_36737# a_61175_36495# uio_oe[0] sky130_fd_pr__nfet_01v8 ad=0.0441 pd=0.63 as=0.1401 ps=1.1 w=0.42 l=0.15
X711 a_36503_35169# a_17255_32793# VDPWR VDPWR sky130_fd_pr__pfet_01v8_hvt ad=0.1092 pd=1.36 as=0.0714 ps=0.76 w=0.42 l=0.15
X712 uio_oe[0] a_37361_41391# a_59685_35734# uio_oe[0] sky130_fd_pr__nfet_01v8 ad=0.1449 pd=1.11 as=0.1092 ps=1.36 w=0.42 l=0.15
X713 a_60302_40303# a_60215_40545# a_59898_40435# VDPWR sky130_fd_pr__pfet_01v8_hvt ad=0.12915 pd=1.185 as=0.0588 ps=0.7 w=0.42 l=0.15
X714 a_50159_35644# a_50003_35549# a_50304_35773# VDPWR sky130_fd_pr__pfet_01v8_hvt ad=0.07245 pd=0.765 as=0.1155 ps=0.97 w=0.42 l=0.15
X715 ua[4] a_20620_14376# a_20490_22020# uio_oe[0] sky130_fd_pr__nfet_01v8 ad=0.1885 pd=1.88 as=0.1885 ps=1.88 w=0.65 l=0.15
X716 uio_oe[0] a_17108_34969# a_17059_34817# uio_oe[0] sky130_fd_pr__nfet_01v8 ad=0.11285 pd=1.045 as=0.169 ps=1.82 w=0.65 l=0.15
X717 a_61766_42518# a_36661_41391# VDPWR VDPWR sky130_fd_pr__pfet_01v8_hvt ad=0.07665 pd=0.785 as=0.15835 ps=1.395 w=0.42 l=0.15
X718 VDPWR a_58864_39447# a_58298_39445# VDPWR sky130_fd_pr__pfet_01v8_hvt ad=0.15835 pd=1.395 as=0.26 ps=2.52 w=1 l=0.15
X719 uio_oe[0] a_40379_35551# a_41193_36495# uio_oe[0] sky130_fd_pr__nfet_01v8 ad=0.1346 pd=1.15 as=0.0441 ps=0.63 w=0.42 l=0.15
X720 VDPWR a_39783_35409# a_39555_35559# VDPWR sky130_fd_pr__pfet_01v8_hvt ad=0.1176 pd=1.4 as=0.0567 ps=0.69 w=0.42 l=0.15
X721 a_50397_34319# a_44905_38671# uio_oe[0] uio_oe[0] sky130_fd_pr__nfet_01v8 ad=0.0441 pd=0.63 as=0.1346 ps=1.15 w=0.42 l=0.15
X722 a_50159_38101# a_49964_38243# a_50469_38493# uio_oe[0] sky130_fd_pr__special_nfet_01v8 ad=0.0594 pd=0.69 as=0.1401 ps=1.1 w=0.36 l=0.15
X723 a_28642_22464# a_28348_14376# ua[5] uio_oe[0] sky130_fd_pr__nfet_01v8 ad=0.1885 pd=1.88 as=0.1885 ps=1.88 w=0.65 l=0.15
X724 a_57321_34319# a_56843_34293# uio_oe[0] uio_oe[0] sky130_fd_pr__nfet_01v8 ad=0.0669 pd=0.75 as=0.12495 ps=1.015 w=0.42 l=0.15
X725 a_51620_40821# a_54459_40821# uio_oe[0] uio_oe[0] sky130_fd_pr__nfet_01v8 ad=0.169 pd=1.82 as=0.2087 ps=2.02 w=0.65 l=0.15
X726 a_42897_43265# a_42679_43023# VDPWR VDPWR sky130_fd_pr__pfet_01v8_hvt ad=0.12915 pd=1.185 as=0.2184 ps=2.2 w=0.84 l=0.15
X727 a_49961_42845# a_49483_42453# uio_oe[0] uio_oe[0] sky130_fd_pr__nfet_01v8 ad=0.0669 pd=0.75 as=0.12495 ps=1.015 w=0.42 l=0.15
X728 a_39686_39581# a_38005_40847# uio_oe[0] uio_oe[0] sky130_fd_pr__nfet_01v8 ad=0.0693 pd=0.75 as=0.11285 ps=1.045 w=0.42 l=0.15
X729 a_50090_39215# a_50003_39457# a_49686_39347# VDPWR sky130_fd_pr__pfet_01v8_hvt ad=0.12915 pd=1.185 as=0.0588 ps=0.7 w=0.42 l=0.15
X730 a_61192_39215# a_60416_39493# a_60584_39529# uio_oe[0] sky130_fd_pr__special_nfet_01v8 ad=0.0935 pd=0.965 as=0.072 ps=0.76 w=0.36 l=0.15
X731 VDPWR a_39973_37557# a_40003_37910# VDPWR sky130_fd_pr__pfet_01v8_hvt ad=0.0693 pd=0.75 as=0.0441 ps=0.63 w=0.42 l=0.15
X732 a_41706_40125# a_40987_39901# a_41143_39996# uio_oe[0] sky130_fd_pr__special_nfet_01v8 ad=0.066 pd=0.745 as=0.0594 ps=0.69 w=0.36 l=0.15
X733 uio_oe[0] a_41040_38645# a_40974_38671# uio_oe[0] sky130_fd_pr__nfet_01v8 ad=0.0882 pd=0.84 as=0.06705 ps=0.75 w=0.42 l=0.15
X734 a_31180_18020# a_4259_22596# a_31002_18020# uio_oe[0] sky130_fd_pr__nfet_01v8 ad=0.2436 pd=2.26 as=0.2436 ps=2.26 w=0.84 l=0.6
X735 a_58914_41174# a_48677_39759# VDPWR VDPWR sky130_fd_pr__pfet_01v8_hvt ad=0.07665 pd=0.785 as=0.15835 ps=1.395 w=0.42 l=0.15
X736 a_59293_37337# a_48677_38127# VDPWR VDPWR sky130_fd_pr__pfet_01v8_hvt ad=0.1176 pd=1.4 as=0.0693 ps=0.75 w=0.42 l=0.15
X737 a_24978_35905# a_24932_36057# uio_oe[0] uio_oe[0] sky130_fd_pr__nfet_01v8 ad=0.0693 pd=0.75 as=0.11285 ps=1.045 w=0.42 l=0.15
X738 a_38543_34471# a_37029_37583# a_38717_34347# uio_oe[0] sky130_fd_pr__nfet_01v8 ad=0.1176 pd=1.4 as=0.0567 ps=0.69 w=0.42 l=0.15
X739 a_42971_39215# a_40379_35551# VDPWR VDPWR sky130_fd_pr__pfet_01v8_hvt ad=0.1092 pd=1.36 as=0.07035 ps=0.755 w=0.42 l=0.15
X740 a_29026_35400# a_28980_35593# VDPWR VDPWR sky130_fd_pr__pfet_01v8_hvt ad=0.07665 pd=0.785 as=0.15835 ps=1.395 w=0.42 l=0.15
X741 a_23402_20730# ua[2] a_23274_22020# uio_oe[0] sky130_fd_pr__nfet_01v8 ad=0.2436 pd=2.26 as=0.2436 ps=2.26 w=0.84 l=0.6
X742 a_26369_33483# a_25116_33417# VDPWR VDPWR sky130_fd_pr__pfet_01v8_hvt ad=0.1176 pd=1.4 as=0.0693 ps=0.75 w=0.42 l=0.15
X743 uio_oe[0] a_59201_40601# a_59135_40669# uio_oe[0] sky130_fd_pr__nfet_01v8 ad=0.1449 pd=1.11 as=0.0693 ps=0.75 w=0.42 l=0.15
X744 uio_oe[0] a_38961_39513# a_38895_39581# uio_oe[0] sky130_fd_pr__nfet_01v8 ad=0.1449 pd=1.11 as=0.0693 ps=0.75 w=0.42 l=0.15
X745 a_46013_38823# a_43609_37359# uio_oe[0] uio_oe[0] sky130_fd_pr__nfet_01v8 ad=0.0567 pd=0.69 as=0.10025 ps=0.985 w=0.42 l=0.15
X746 a_38961_38425# a_37029_37583# uio_oe[0] uio_oe[0] sky130_fd_pr__nfet_01v8 ad=0.1092 pd=1.36 as=0.1449 ps=1.11 w=0.42 l=0.15
X747 VDPWR a_44905_38671# a_56843_36469# VDPWR sky130_fd_pr__pfet_01v8_hvt ad=0.0819 pd=0.81 as=0.0567 ps=0.69 w=0.42 l=0.15
X748 a_42329_40309# a_42163_40309# VDPWR VDPWR sky130_fd_pr__pfet_01v8_hvt ad=0.1664 pd=1.8 as=0.0864 ps=0.91 w=0.64 l=0.15
X749 a_36455_37039# a_36275_37039# VDPWR VDPWR sky130_fd_pr__pfet_01v8_hvt ad=0.0609 pd=0.71 as=0.0714 ps=0.76 w=0.42 l=0.15
X750 a_46761_40277# a_46543_40681# uio_oe[0] uio_oe[0] sky130_fd_pr__nfet_01v8 ad=0.0999 pd=0.985 as=0.1346 ps=1.15 w=0.64 l=0.15
X751 a_38532_38823# a_38740_38645# a_38674_38671# uio_oe[0] sky130_fd_pr__nfet_01v8 ad=0.09975 pd=0.895 as=0.0693 ps=0.75 w=0.42 l=0.15
X752 VDPWR a_40864_38671# a_41040_38645# VDPWR sky130_fd_pr__pfet_01v8_hvt ad=0.0567 pd=0.69 as=0.0567 ps=0.69 w=0.42 l=0.15
X753 a_57776_35229# a_57640_35177# VDPWR VDPWR sky130_fd_pr__pfet_01v8_hvt ad=0.0567 pd=0.69 as=0.0567 ps=0.69 w=0.42 l=0.15
X754 a_20620_10782# a_22575_37359# VDPWR VDPWR sky130_fd_pr__pfet_01v8_hvt ad=0.26 pd=2.52 as=0.2279 ps=1.74 w=1 l=0.15
X755 a_44516_40847# ui_in[6] VDPWR VDPWR sky130_fd_pr__pfet_01v8_hvt ad=0.0651 pd=0.73 as=0.1092 ps=1.36 w=0.42 l=0.15
X756 a_51554_39581# a_48677_39759# uio_oe[0] uio_oe[0] sky130_fd_pr__nfet_01v8 ad=0.0693 pd=0.75 as=0.11285 ps=1.045 w=0.42 l=0.15
X757 a_50469_35229# a_50090_34863# a_50397_35229# uio_oe[0] sky130_fd_pr__nfet_01v8 ad=0.1401 pd=1.1 as=0.0441 ps=0.63 w=0.42 l=0.15
X758 uio_oe[0] a_58144_42184# a_58082_42301# uio_oe[0] sky130_fd_pr__nfet_01v8 ad=0.2205 pd=1.89 as=0.066 ps=0.745 w=0.42 l=0.15
X759 a_57046_36083# a_57363_36193# a_57321_36317# uio_oe[0] sky130_fd_pr__special_nfet_01v8 ad=0.0711 pd=0.755 as=0.0669 ps=0.75 w=0.36 l=0.15
X760 a_49483_35381# a_49686_35659# VDPWR VDPWR sky130_fd_pr__pfet_01v8_hvt ad=0.0567 pd=0.69 as=0.1134 ps=1.38 w=0.42 l=0.15
X761 uio_oe[0] a_44905_38671# a_57081_34319# uio_oe[0] sky130_fd_pr__nfet_01v8 ad=0.12495 pd=1.015 as=0.06405 ps=0.725 w=0.42 l=0.15
X762 a_58082_37949# a_57363_37725# a_57519_37820# uio_oe[0] sky130_fd_pr__special_nfet_01v8 ad=0.066 pd=0.745 as=0.0594 ps=0.69 w=0.36 l=0.15
X763 a_59201_36469# a_48677_38127# uio_oe[0] uio_oe[0] sky130_fd_pr__nfet_01v8 ad=0.1092 pd=1.36 as=0.1449 ps=1.11 w=0.42 l=0.15
X764 a_28842_34056# a_28796_33881# VDPWR VDPWR sky130_fd_pr__pfet_01v8_hvt ad=0.07665 pd=0.785 as=0.15835 ps=1.395 w=0.42 l=0.15
X765 a_61806_40125# a_60729_39759# a_61644_39759# VDPWR sky130_fd_pr__pfet_01v8_hvt ad=0.0567 pd=0.69 as=0.0588 ps=0.7 w=0.42 l=0.15
X766 VDPWR a_17537_36967# a_17567_37320# VDPWR sky130_fd_pr__pfet_01v8_hvt ad=0.0693 pd=0.75 as=0.0441 ps=0.63 w=0.42 l=0.15
X767 uio_oe[0] a_52855_35105# a_52816_34979# uio_oe[0] sky130_fd_pr__nfet_01v8 ad=0.0567 pd=0.69 as=0.1092 ps=1.36 w=0.42 l=0.15
X768 a_61624_38359# a_54479_38140# a_61766_38493# uio_oe[0] sky130_fd_pr__nfet_01v8 ad=0.09975 pd=0.895 as=0.0693 ps=0.75 w=0.42 l=0.15
X769 a_50722_37949# a_50003_37725# a_50159_37820# uio_oe[0] sky130_fd_pr__special_nfet_01v8 ad=0.066 pd=0.745 as=0.0594 ps=0.69 w=0.36 l=0.15
X770 a_21335_36993# a_21107_36449# a_20972_37145# uio_oe[0] sky130_fd_pr__nfet_01v8 ad=0.0693 pd=0.75 as=0.09975 ps=0.895 w=0.42 l=0.15
X771 a_16756_14782# a_18711_36271# uio_oe[0] uio_oe[0] sky130_fd_pr__nfet_01v8 ad=0.169 pd=1.82 as=0.1013 ps=0.99 w=0.65 l=0.15
X772 a_21156_35593# a_17500_33453# a_21298_35727# uio_oe[0] sky130_fd_pr__nfet_01v8 ad=0.09975 pd=0.895 as=0.0693 ps=0.75 w=0.42 l=0.15
X773 VDPWR a_50784_42453# a_50722_42479# VDPWR sky130_fd_pr__pfet_01v8_hvt ad=0.1092 pd=1.36 as=0.0651 ps=0.73 w=0.42 l=0.15
X774 a_18671_36488# a_18420_33453# a_18212_36681# VDPWR sky130_fd_pr__pfet_01v8_hvt ad=0.0441 pd=0.63 as=0.1932 ps=1.34 w=0.42 l=0.15
X775 a_18212_36681# a_18420_33453# a_18354_36815# uio_oe[0] sky130_fd_pr__nfet_01v8 ad=0.09975 pd=0.895 as=0.0693 ps=0.75 w=0.42 l=0.15
X776 ua[4] a_20620_10376# a_23274_26020# uio_oe[0] sky130_fd_pr__nfet_01v8 ad=0.1885 pd=1.88 as=0.1885 ps=1.88 w=0.65 l=0.15
X777 a_25417_32641# a_25151_33007# VDPWR VDPWR sky130_fd_pr__pfet_01v8_hvt ad=0.26 pd=2.52 as=0.2279 ps=1.74 w=1 l=0.15
X778 a_44829_41365# a_44611_41769# VDPWR VDPWR sky130_fd_pr__pfet_01v8_hvt ad=0.12915 pd=1.185 as=0.2184 ps=2.2 w=0.84 l=0.15
X779 VDPWR a_38532_40535# a_21252_36681# VDPWR sky130_fd_pr__pfet_01v8_hvt ad=0.15835 pd=1.395 as=0.26 ps=2.52 w=1 l=0.15
X780 VDPWR a_52855_39457# a_52816_39331# VDPWR sky130_fd_pr__pfet_01v8_hvt ad=0.0864 pd=0.91 as=0.1664 ps=1.8 w=0.64 l=0.15
X781 a_53624_37583# a_53005_37583# uio_oe[0] uio_oe[0] sky130_fd_pr__nfet_01v8 ad=0.066 pd=0.745 as=0.2205 ps=1.89 w=0.42 l=0.15
X782 a_40302_36083# a_40580_36067# a_40536_35951# VDPWR sky130_fd_pr__pfet_01v8_hvt ad=0.0588 pd=0.7 as=0.0567 ps=0.69 w=0.42 l=0.15
X783 VDPWR a_25020_34505# a_24971_34273# VDPWR sky130_fd_pr__pfet_01v8_hvt ad=0.15835 pd=1.395 as=0.26 ps=2.52 w=1 l=0.15
X784 a_61624_42711# uio_in[1] a_61766_42518# VDPWR sky130_fd_pr__pfet_01v8_hvt ad=0.1932 pd=1.34 as=0.07665 ps=0.785 w=0.42 l=0.15
X785 a_26082_35727# a_25116_35593# uio_oe[0] uio_oe[0] sky130_fd_pr__nfet_01v8 ad=0.0693 pd=0.75 as=0.11285 ps=1.045 w=0.42 l=0.15
X786 a_17250_35144# a_17204_34969# VDPWR VDPWR sky130_fd_pr__pfet_01v8_hvt ad=0.07665 pd=0.785 as=0.15835 ps=1.395 w=0.42 l=0.15
X787 a_42941_43023# a_42897_43265# a_42775_43023# uio_oe[0] sky130_fd_pr__nfet_01v8 ad=0.0441 pd=0.63 as=0.1401 ps=1.1 w=0.42 l=0.15
X788 a_38285_37039# a_37859_37078# uio_oe[0] uio_oe[0] sky130_fd_pr__nfet_01v8 ad=0.169 pd=1.82 as=0.11285 ps=1.045 w=0.65 l=0.15
X789 VDPWR a_51841_41689# a_51871_41430# VDPWR sky130_fd_pr__pfet_01v8_hvt ad=0.0693 pd=0.75 as=0.0441 ps=0.63 w=0.42 l=0.15
X790 a_47270_42301# a_46193_41935# a_47108_41935# VDPWR sky130_fd_pr__pfet_01v8_hvt ad=0.0567 pd=0.69 as=0.0588 ps=0.7 w=0.42 l=0.15
X791 a_57829_40669# a_57450_40303# a_57757_40669# uio_oe[0] sky130_fd_pr__nfet_01v8 ad=0.1401 pd=1.1 as=0.0441 ps=0.63 w=0.42 l=0.15
X792 a_42602_38259# a_42880_38243# a_42836_38127# VDPWR sky130_fd_pr__pfet_01v8_hvt ad=0.0588 pd=0.7 as=0.0567 ps=0.69 w=0.42 l=0.15
X793 ua[5] a_28348_10376# a_29610_10020# uio_oe[0] sky130_fd_pr__nfet_01v8 ad=0.1885 pd=1.88 as=0.1885 ps=1.88 w=0.65 l=0.15
X794 a_52793_41174# a_51620_41659# a_52579_41174# VDPWR sky130_fd_pr__pfet_01v8_hvt ad=0.07665 pd=0.785 as=0.1932 ps=1.34 w=0.42 l=0.15
X795 a_59695_40277# a_59898_40435# VDPWR VDPWR sky130_fd_pr__pfet_01v8_hvt ad=0.0567 pd=0.69 as=0.1134 ps=1.38 w=0.42 l=0.15
X796 a_59867_40086# a_59685_40086# VDPWR VDPWR sky130_fd_pr__pfet_01v8_hvt ad=0.0441 pd=0.63 as=0.0693 ps=0.75 w=0.42 l=0.15
X797 a_38961_39513# a_38005_40847# VDPWR VDPWR sky130_fd_pr__pfet_01v8_hvt ad=0.1176 pd=1.4 as=0.0693 ps=0.75 w=0.42 l=0.15
X798 uio_oe[0] a_50784_36744# a_50722_36861# uio_oe[0] sky130_fd_pr__nfet_01v8 ad=0.2205 pd=1.89 as=0.066 ps=0.745 w=0.42 l=0.15
X799 a_61753_34319# a_60563_34319# a_61644_34319# uio_oe[0] sky130_fd_pr__special_nfet_01v8 ad=0.0669 pd=0.75 as=0.0711 ps=0.755 w=0.36 l=0.15
X800 a_42985_35229# a_42715_34863# a_42895_34863# uio_oe[0] sky130_fd_pr__nfet_01v8 ad=0.0504 pd=0.66 as=0.1092 ps=1.36 w=0.42 l=0.15
X801 a_37839_34863# a_36427_36475# uio_oe[0] uio_oe[0] sky130_fd_pr__nfet_01v8 ad=0.1092 pd=1.36 as=0.1092 ps=1.36 w=0.42 l=0.15
X802 a_44707_43023# a_44261_43023# a_44611_43023# uio_oe[0] sky130_fd_pr__special_nfet_01v8 ad=0.1401 pd=1.1 as=0.0594 ps=0.69 w=0.36 l=0.15
X803 a_58772_40999# a_38740_40821# a_58914_41174# VDPWR sky130_fd_pr__pfet_01v8_hvt ad=0.1932 pd=1.34 as=0.07665 ps=0.785 w=0.42 l=0.15
X804 a_44905_38671# a_44739_38671# uio_oe[0] uio_oe[0] sky130_fd_pr__nfet_01v8 ad=0.08775 pd=0.92 as=0.08775 ps=0.92 w=0.65 l=0.15
X805 a_57519_37820# a_57324_37851# a_57829_37583# uio_oe[0] sky130_fd_pr__special_nfet_01v8 ad=0.0594 pd=0.69 as=0.1401 ps=1.1 w=0.36 l=0.15
X806 a_57081_40669# a_57046_40435# a_56843_40277# uio_oe[0] sky130_fd_pr__nfet_01v8 ad=0.06405 pd=0.725 as=0.1092 ps=1.36 w=0.42 l=0.15
X807 uio_oe[0] a_37661_38140# a_37605_38166# uio_oe[0] sky130_fd_pr__nfet_01v8 ad=0.1449 pd=1.11 as=0.1092 ps=1.36 w=0.42 l=0.15
X808 a_45351_42783# a_39947_42997# VDPWR VDPWR sky130_fd_pr__pfet_01v8_hvt ad=0.0567 pd=0.69 as=0.0819 ps=0.81 w=0.42 l=0.15
X809 a_60160_36495# a_58980_36469# a_59939_36822# uio_oe[0] sky130_fd_pr__nfet_01v8 ad=0.0693 pd=0.75 as=0.09975 ps=0.895 w=0.42 l=0.15
X810 VDPWR a_38483_43023# a_38649_43023# VDPWR sky130_fd_pr__pfet_01v8_hvt ad=0.26 pd=2.52 as=0.135 ps=1.27 w=1 l=0.15
X811 a_42775_41769# a_42329_41397# a_42679_41769# uio_oe[0] sky130_fd_pr__special_nfet_01v8 ad=0.1401 pd=1.1 as=0.0594 ps=0.69 w=0.36 l=0.15
X812 a_41684_38671# a_41570_38885# a_41612_38671# uio_oe[0] sky130_fd_pr__nfet_01v8 ad=0.0483 pd=0.65 as=0.0441 ps=0.63 w=0.42 l=0.15
X813 VDPWR a_38005_41391# a_40507_37583# VDPWR sky130_fd_pr__pfet_01v8_hvt ad=0.0864 pd=0.91 as=0.1664 ps=1.8 w=0.64 l=0.15
X814 uio_oe[0] a_53011_42453# a_52942_42479# uio_oe[0] sky130_fd_pr__nfet_01v8 ad=0.1346 pd=1.15 as=0.0999 ps=0.985 w=0.64 l=0.15
X815 uio_oe[0] a_16812_8642# a_25874_20730# uio_oe[0] sky130_fd_pr__nfet_01v8 ad=1.4703 pd=10.72 as=1.4703 ps=10.72 w=5.07 l=1
X816 a_18711_34095# a_18531_34095# VDPWR VDPWR sky130_fd_pr__pfet_01v8_hvt ad=0.0609 pd=0.71 as=0.0714 ps=0.76 w=0.42 l=0.15
X817 a_36847_39457# a_37029_37039# VDPWR VDPWR sky130_fd_pr__pfet_01v8_hvt ad=0.1664 pd=1.8 as=0.0864 ps=0.91 w=0.64 l=0.15
X818 uio_oe[0] a_36425_35381# a_44287_39215# uio_oe[0] sky130_fd_pr__nfet_01v8 ad=0.08775 pd=0.92 as=0.08775 ps=0.92 w=0.65 l=0.15
X819 VDPWR a_57519_42172# a_57450_42301# VDPWR sky130_fd_pr__pfet_01v8_hvt ad=0.2184 pd=2.2 as=0.12915 ps=1.185 w=0.84 l=0.15
X820 a_53011_37013# a_52816_37155# a_53321_37405# uio_oe[0] sky130_fd_pr__special_nfet_01v8 ad=0.0594 pd=0.69 as=0.1401 ps=1.1 w=0.36 l=0.15
X821 a_50003_36637# a_41685_42479# VDPWR VDPWR sky130_fd_pr__pfet_01v8_hvt ad=0.1664 pd=1.8 as=0.0864 ps=0.91 w=0.64 l=0.15
X822 uio_oe[0] a_40379_35551# a_40337_36317# uio_oe[0] sky130_fd_pr__nfet_01v8 ad=0.12495 pd=1.015 as=0.06405 ps=0.725 w=0.42 l=0.15
X823 a_53574_42479# a_52855_42721# a_53011_42453# uio_oe[0] sky130_fd_pr__special_nfet_01v8 ad=0.066 pd=0.745 as=0.0594 ps=0.69 w=0.36 l=0.15
X824 VDPWR a_36875_38823# a_45443_38823# VDPWR sky130_fd_pr__pfet_01v8_hvt ad=0.1176 pd=1.4 as=0.0567 ps=0.69 w=0.42 l=0.15
X825 VDPWR a_17689_32641# a_18011_35933# VDPWR sky130_fd_pr__pfet_01v8_hvt ad=0.16655 pd=1.39 as=0.0567 ps=0.69 w=0.42 l=0.15
X826 VDPWR a_17689_32641# a_18711_34095# VDPWR sky130_fd_pr__pfet_01v8_hvt ad=0.2279 pd=1.74 as=0.0609 ps=0.71 w=0.42 l=0.15
X827 a_44707_42857# a_44261_42485# a_44611_42857# uio_oe[0] sky130_fd_pr__special_nfet_01v8 ad=0.1401 pd=1.1 as=0.0594 ps=0.69 w=0.36 l=0.15
X828 a_28700_33881# a_28835_33185# a_28842_34056# VDPWR sky130_fd_pr__pfet_01v8_hvt ad=0.1932 pd=1.34 as=0.07665 ps=0.785 w=0.42 l=0.15
X829 a_40975_34569# a_37795_40535# uio_oe[0] uio_oe[0] sky130_fd_pr__nfet_01v8 ad=0.08775 pd=0.92 as=0.169 ps=1.82 w=0.65 l=0.15
X830 a_38895_41935# a_38089_40623# a_38532_42087# uio_oe[0] sky130_fd_pr__nfet_01v8 ad=0.0693 pd=0.75 as=0.09975 ps=0.895 w=0.42 l=0.15
X831 VDPWR a_42897_40277# a_42787_40303# VDPWR sky130_fd_pr__pfet_01v8_hvt ad=0.07035 pd=0.755 as=0.1155 ps=0.97 w=0.42 l=0.15
X832 uio_oe[0] a_41224_41659# a_41343_41097# uio_oe[0] sky130_fd_pr__nfet_01v8 ad=0.08775 pd=0.92 as=0.08775 ps=0.92 w=0.65 l=0.15
X833 a_38961_38645# a_38005_40847# VDPWR VDPWR sky130_fd_pr__pfet_01v8_hvt ad=0.1176 pd=1.4 as=0.0693 ps=0.75 w=0.42 l=0.15
X834 a_49686_38923# a_49964_38939# a_49920_39037# VDPWR sky130_fd_pr__pfet_01v8_hvt ad=0.0588 pd=0.7 as=0.0567 ps=0.69 w=0.42 l=0.15
X835 a_22505_36747# a_21252_36681# VDPWR VDPWR sky130_fd_pr__pfet_01v8_hvt ad=0.1176 pd=1.4 as=0.0693 ps=0.75 w=0.42 l=0.15
X836 a_53156_35951# a_52942_35951# VDPWR VDPWR sky130_fd_pr__pfet_01v8_hvt ad=0.1155 pd=0.97 as=0.07035 ps=0.755 w=0.42 l=0.15
X837 uio_oe[0] a_16812_8642# a_27266_24730# uio_oe[0] sky130_fd_pr__nfet_01v8 ad=1.4703 pd=10.72 as=1.4703 ps=10.72 w=5.07 l=1
X838 a_40893_40821# a_37661_37052# uio_oe[0] uio_oe[0] sky130_fd_pr__nfet_01v8 ad=0.1092 pd=1.36 as=0.1449 ps=1.11 w=0.42 l=0.15
X839 a_50003_37281# a_41685_42479# uio_oe[0] uio_oe[0] sky130_fd_pr__nfet_01v8 ad=0.1092 pd=1.36 as=0.0567 ps=0.69 w=0.42 l=0.15
X840 VDPWR a_46761_43265# a_46651_43389# VDPWR sky130_fd_pr__pfet_01v8_hvt ad=0.07035 pd=0.755 as=0.1155 ps=0.97 w=0.42 l=0.15
X841 uio_oe[0] a_38532_42087# a_17388_35593# uio_oe[0] sky130_fd_pr__nfet_01v8 ad=0.11285 pd=1.045 as=0.169 ps=1.82 w=0.65 l=0.15
X842 a_39686_39759# a_38005_40847# uio_oe[0] uio_oe[0] sky130_fd_pr__nfet_01v8 ad=0.0693 pd=0.75 as=0.11285 ps=1.045 w=0.42 l=0.15
X843 VDPWR a_20972_36057# a_20923_35905# VDPWR sky130_fd_pr__pfet_01v8_hvt ad=0.15835 pd=1.395 as=0.26 ps=2.52 w=1 l=0.15
X844 a_51412_36183# a_51620_36219# a_51554_36317# uio_oe[0] sky130_fd_pr__nfet_01v8 ad=0.09975 pd=0.895 as=0.0693 ps=0.75 w=0.42 l=0.15
X845 a_56843_42453# a_57046_42611# VDPWR VDPWR sky130_fd_pr__pfet_01v8_hvt ad=0.0567 pd=0.69 as=0.1134 ps=1.38 w=0.42 l=0.15
X846 a_52579_39759# a_52325_40086# uio_oe[0] uio_oe[0] sky130_fd_pr__nfet_01v8 ad=0.0693 pd=0.75 as=0.1449 ps=1.11 w=0.42 l=0.15
X847 a_29689_35933# a_28651_35905# a_29603_35933# uio_oe[0] sky130_fd_pr__nfet_01v8 ad=0.0567 pd=0.69 as=0.1176 ps=1.4 w=0.42 l=0.15
X848 uio_oe[0] uio_oe[0] uio_oe[0] uio_oe[0] sky130_fd_pr__nfet_01v8 ad=0.1885 pd=1.88 as=0 ps=0 w=0.65 l=0.15
X849 a_42897_42453# a_42679_42857# uio_oe[0] uio_oe[0] sky130_fd_pr__nfet_01v8 ad=0.0999 pd=0.985 as=0.1346 ps=1.15 w=0.64 l=0.15
X850 a_46331_41562# a_47283_41909# VDPWR VDPWR sky130_fd_pr__pfet_01v8_hvt ad=0.26 pd=2.52 as=0.3012 ps=2.66 w=1 l=0.15
X851 uio_oe[0] a_41343_41097# a_41677_40847# uio_oe[0] sky130_fd_pr__nfet_01v8 ad=0.208 pd=1.94 as=0.25025 ps=1.42 w=0.65 l=0.15
X852 uio_oe[0] a_49483_36469# a_39752_36469# uio_oe[0] sky130_fd_pr__nfet_01v8 ad=0.2087 pd=2.02 as=0.169 ps=1.82 w=0.65 l=0.15
X853 uio_oe[0] a_17689_32641# a_18097_37021# uio_oe[0] sky130_fd_pr__nfet_01v8 ad=0.1118 pd=1.04 as=0.0567 ps=0.69 w=0.42 l=0.15
X854 a_17108_34969# a_17243_34273# a_17250_35144# VDPWR sky130_fd_pr__pfet_01v8_hvt ad=0.1932 pd=1.34 as=0.07665 ps=0.785 w=0.42 l=0.15
X855 VDPWR clk a_37839_41391# VDPWR sky130_fd_pr__pfet_01v8_hvt ad=0.135 pd=1.27 as=0.26 ps=2.52 w=1 l=0.15
X856 a_39861_43265# a_39643_43023# uio_oe[0] uio_oe[0] sky130_fd_pr__nfet_01v8 ad=0.0999 pd=0.985 as=0.1346 ps=1.15 w=0.64 l=0.15
X857 VDPWR a_50784_41365# a_50722_41391# VDPWR sky130_fd_pr__pfet_01v8_hvt ad=0.1092 pd=1.36 as=0.0651 ps=0.73 w=0.42 l=0.15
X858 uio_oe[0] a_38961_39733# a_38895_39759# uio_oe[0] sky130_fd_pr__nfet_01v8 ad=0.1449 pd=1.11 as=0.0693 ps=0.75 w=0.42 l=0.15
X859 uio_oe[0] a_57363_35549# a_57324_35675# uio_oe[0] sky130_fd_pr__nfet_01v8 ad=0.0567 pd=0.69 as=0.1092 ps=1.36 w=0.42 l=0.15
X860 a_61187_41213# a_60563_40847# a_61079_40847# VDPWR sky130_fd_pr__pfet_01v8_hvt ad=0.1155 pd=0.97 as=0.07245 ps=0.765 w=0.42 l=0.15
X861 a_54406_38493# a_37361_41391# uio_oe[0] uio_oe[0] sky130_fd_pr__nfet_01v8 ad=0.0693 pd=0.75 as=0.11285 ps=1.045 w=0.42 l=0.15
X862 a_38674_37078# a_37029_37583# VDPWR VDPWR sky130_fd_pr__pfet_01v8_hvt ad=0.07665 pd=0.785 as=0.15835 ps=1.395 w=0.42 l=0.15
X863 uio_oe[0] a_21401_33703# a_21335_33729# uio_oe[0] sky130_fd_pr__nfet_01v8 ad=0.1449 pd=1.11 as=0.0693 ps=0.75 w=0.42 l=0.15
X864 a_41309_34319# a_37795_40535# a_41225_34319# uio_oe[0] sky130_fd_pr__nfet_01v8 ad=0.25025 pd=1.42 as=0.08775 ps=0.92 w=0.65 l=0.15
X865 a_24484_18782# a_25739_34845# uio_oe[0] uio_oe[0] sky130_fd_pr__nfet_01v8 ad=0.182 pd=1.86 as=0.1118 ps=1.04 w=0.65 l=0.15
X866 a_40003_41174# a_39752_40821# a_39544_40999# VDPWR sky130_fd_pr__pfet_01v8_hvt ad=0.0441 pd=0.63 as=0.1932 ps=1.34 w=0.42 l=0.15
X867 VDPWR a_36661_41391# a_52793_41174# VDPWR sky130_fd_pr__pfet_01v8_hvt ad=0.15835 pd=1.395 as=0.07665 ps=0.785 w=0.42 l=0.15
X868 VDPWR a_44905_38671# a_57664_35951# VDPWR sky130_fd_pr__pfet_01v8_hvt ad=0.07035 pd=0.755 as=0.1092 ps=1.36 w=0.42 l=0.15
X869 a_53937_37825# a_53719_37583# uio_oe[0] uio_oe[0] sky130_fd_pr__nfet_01v8 ad=0.0999 pd=0.985 as=0.1346 ps=1.15 w=0.64 l=0.15
X870 uio_oe[0] a_17689_32641# a_18801_36993# uio_oe[0] sky130_fd_pr__nfet_01v8 ad=0.1013 pd=0.99 as=0.0504 ps=0.66 w=0.42 l=0.15
X871 VDPWR a_37029_37583# a_39719_34953# VDPWR sky130_fd_pr__pfet_01v8_hvt ad=0.1092 pd=1.36 as=0.1176 ps=1.4 w=0.42 l=0.15
X872 a_52772_40303# a_52335_40277# VDPWR VDPWR sky130_fd_pr__pfet_01v8_hvt ad=0.0567 pd=0.69 as=0.0819 ps=0.81 w=0.42 l=0.15
X873 a_62083_42518# a_54479_42492# a_61624_42711# VDPWR sky130_fd_pr__pfet_01v8_hvt ad=0.0441 pd=0.63 as=0.1932 ps=1.34 w=0.42 l=0.15
X874 a_51554_39759# a_48677_39759# uio_oe[0] uio_oe[0] sky130_fd_pr__nfet_01v8 ad=0.0693 pd=0.75 as=0.11285 ps=1.045 w=0.42 l=0.15
X875 a_60681_38493# a_60302_38127# a_60609_38493# uio_oe[0] sky130_fd_pr__nfet_01v8 ad=0.1401 pd=1.1 as=0.0441 ps=0.63 w=0.42 l=0.15
X876 a_38077_34837# a_38019_35951# uio_oe[0] uio_oe[0] sky130_fd_pr__nfet_01v8 ad=0.169 pd=1.82 as=0.1013 ps=0.99 w=0.65 l=0.15
X877 uio_oe[0] a_40099_35381# a_36425_36166# uio_oe[0] sky130_fd_pr__nfet_01v8 ad=0.2087 pd=2.02 as=0.169 ps=1.82 w=0.65 l=0.15
X878 a_57363_42721# a_38649_43023# uio_oe[0] uio_oe[0] sky130_fd_pr__nfet_01v8 ad=0.1092 pd=1.36 as=0.0567 ps=0.69 w=0.42 l=0.15
X879 a_59231_40342# a_54479_40316# a_58772_40535# VDPWR sky130_fd_pr__pfet_01v8_hvt ad=0.0441 pd=0.63 as=0.1932 ps=1.34 w=0.42 l=0.15
X880 a_40581_38671# a_40415_38671# uio_oe[0] uio_oe[0] sky130_fd_pr__nfet_01v8 ad=0.1092 pd=1.36 as=0.0567 ps=0.69 w=0.42 l=0.15
X881 a_58914_36317# a_48677_38127# uio_oe[0] uio_oe[0] sky130_fd_pr__nfet_01v8 ad=0.0693 pd=0.75 as=0.11285 ps=1.045 w=0.42 l=0.15
X882 uio_oe[0] a_16812_8642# a_31130_20730# uio_oe[0] sky130_fd_pr__nfet_01v8 ad=1.4703 pd=10.72 as=1.4703 ps=10.72 w=5.07 l=1
X883 a_53369_34319# a_53203_34319# VDPWR VDPWR sky130_fd_pr__pfet_01v8_hvt ad=0.1664 pd=1.8 as=0.0864 ps=0.91 w=0.64 l=0.15
X884 a_57858_35229# a_57640_35177# a_57776_35229# uio_oe[0] sky130_fd_pr__nfet_01v8 ad=0.0441 pd=0.63 as=0.1092 ps=1.36 w=0.42 l=0.15
X885 uio_oe[0] a_36661_41391# a_60160_41935# uio_oe[0] sky130_fd_pr__nfet_01v8 ad=0.11285 pd=1.045 as=0.0693 ps=0.75 w=0.42 l=0.15
X886 a_51841_35161# a_48677_38127# VDPWR VDPWR sky130_fd_pr__pfet_01v8_hvt ad=0.1176 pd=1.4 as=0.0693 ps=0.75 w=0.42 l=0.15
X887 uio_oe[0] a_37913_41935# a_60563_35407# uio_oe[0] sky130_fd_pr__nfet_01v8 ad=0.0567 pd=0.69 as=0.1092 ps=1.36 w=0.42 l=0.15
X888 a_51871_41174# a_51620_40821# a_51412_40999# VDPWR sky130_fd_pr__pfet_01v8_hvt ad=0.0441 pd=0.63 as=0.1932 ps=1.34 w=0.42 l=0.15
X889 uio_oe[0] a_25265_35879# a_25199_35905# uio_oe[0] sky130_fd_pr__nfet_01v8 ad=0.1449 pd=1.11 as=0.0693 ps=0.75 w=0.42 l=0.15
X890 a_51841_39733# a_48677_39759# VDPWR VDPWR sky130_fd_pr__pfet_01v8_hvt ad=0.1176 pd=1.4 as=0.0693 ps=0.75 w=0.42 l=0.15
X891 VDPWR a_29281_32641# a_29603_33757# VDPWR sky130_fd_pr__pfet_01v8_hvt ad=0.16655 pd=1.39 as=0.0567 ps=0.69 w=0.42 l=0.15
X892 uio_oe[0] a_39544_41623# a_17204_34969# uio_oe[0] sky130_fd_pr__nfet_01v8 ad=0.11285 pd=1.045 as=0.169 ps=1.82 w=0.65 l=0.15
X893 VDPWR a_54693_40601# a_54723_40342# VDPWR sky130_fd_pr__pfet_01v8_hvt ad=0.0693 pd=0.75 as=0.0441 ps=0.63 w=0.42 l=0.15
X894 VDPWR a_52335_34837# a_51620_35131# VDPWR sky130_fd_pr__pfet_01v8_hvt ad=0.3012 pd=2.66 as=0.26 ps=2.52 w=1 l=0.15
X895 a_45351_41695# a_39947_42997# VDPWR VDPWR sky130_fd_pr__pfet_01v8_hvt ad=0.0567 pd=0.69 as=0.0819 ps=0.81 w=0.42 l=0.15
X896 a_41942_37583# a_40379_35551# uio_oe[0] uio_oe[0] sky130_fd_pr__nfet_01v8 ad=0.06405 pd=0.725 as=0.12495 ps=1.015 w=0.42 l=0.15
X897 a_44909_37735# a_42321_35183# uio_oe[0] uio_oe[0] sky130_fd_pr__nfet_01v8 ad=0.0567 pd=0.69 as=0.10025 ps=0.985 w=0.42 l=0.15
X898 a_18531_34095# a_17059_33729# uio_oe[0] uio_oe[0] sky130_fd_pr__nfet_01v8 ad=0.1092 pd=1.36 as=0.1092 ps=1.36 w=0.42 l=0.15
X899 VDPWR a_57519_35644# a_57450_35773# VDPWR sky130_fd_pr__pfet_01v8_hvt ad=0.2184 pd=2.2 as=0.12915 ps=1.185 w=0.84 l=0.15
X900 a_45351_41909# a_45176_41935# a_45530_41935# uio_oe[0] sky130_fd_pr__nfet_01v8 ad=0.1092 pd=1.36 as=0.06405 ps=0.725 w=0.42 l=0.15
X901 a_42775_40681# a_42329_40309# a_42679_40681# uio_oe[0] sky130_fd_pr__special_nfet_01v8 ad=0.1401 pd=1.1 as=0.0594 ps=0.69 w=0.36 l=0.15
X902 VDPWR a_50784_37832# a_50722_37949# VDPWR sky130_fd_pr__pfet_01v8_hvt ad=0.1092 pd=1.36 as=0.0651 ps=0.73 w=0.42 l=0.15
X903 a_38077_34577# a_36427_36475# VDPWR VDPWR sky130_fd_pr__pfet_01v8_hvt ad=0.135 pd=1.27 as=0.26 ps=2.52 w=1 l=0.15
X904 VDPWR a_36427_36475# a_37605_38998# VDPWR sky130_fd_pr__pfet_01v8_hvt ad=0.0693 pd=0.75 as=0.1176 ps=1.4 w=0.42 l=0.15
X905 uio_oe[0] a_58864_37271# a_58298_37269# uio_oe[0] sky130_fd_pr__nfet_01v8 ad=0.11285 pd=1.045 as=0.169 ps=1.82 w=0.65 l=0.15
X906 VDPWR a_56843_40821# a_38740_40821# VDPWR sky130_fd_pr__pfet_01v8_hvt ad=0.3012 pd=2.66 as=0.26 ps=2.52 w=1 l=0.15
X907 VDPWR a_54264_36183# a_53636_35925# VDPWR sky130_fd_pr__pfet_01v8_hvt ad=0.15835 pd=1.395 as=0.26 ps=2.52 w=1 l=0.15
X908 ua[5] a_24484_18376# a_24354_18020# uio_oe[0] sky130_fd_pr__nfet_01v8 ad=0.1885 pd=1.88 as=0.1885 ps=1.88 w=0.65 l=0.15
X909 a_43874_38671# a_40379_35551# uio_oe[0] uio_oe[0] sky130_fd_pr__nfet_01v8 ad=0.06405 pd=0.725 as=0.12495 ps=1.015 w=0.42 l=0.15
X910 VDPWR a_17689_32641# a_18011_34845# VDPWR sky130_fd_pr__pfet_01v8_hvt ad=0.16655 pd=1.39 as=0.0567 ps=0.69 w=0.42 l=0.15
X911 a_38674_42262# a_38005_40847# VDPWR VDPWR sky130_fd_pr__pfet_01v8_hvt ad=0.07665 pd=0.785 as=0.15835 ps=1.395 w=0.42 l=0.15
X912 a_50159_34837# a_50003_35105# a_50304_34863# VDPWR sky130_fd_pr__pfet_01v8_hvt ad=0.07245 pd=0.765 as=0.1155 ps=0.97 w=0.42 l=0.15
X913 a_54406_39254# a_36661_41391# VDPWR VDPWR sky130_fd_pr__pfet_01v8_hvt ad=0.07665 pd=0.785 as=0.15835 ps=1.395 w=0.42 l=0.15
X914 VDPWR a_58772_42087# a_58144_42184# VDPWR sky130_fd_pr__pfet_01v8_hvt ad=0.15835 pd=1.395 as=0.26 ps=2.52 w=1 l=0.15
X915 a_39907_39581# a_39759_39228# a_39544_39447# uio_oe[0] sky130_fd_pr__nfet_01v8 ad=0.0693 pd=0.75 as=0.09975 ps=0.895 w=0.42 l=0.15
X916 a_54693_38425# a_37361_41391# VDPWR VDPWR sky130_fd_pr__pfet_01v8_hvt ad=0.1176 pd=1.4 as=0.0693 ps=0.75 w=0.42 l=0.15
X917 uio_oe[0] a_51412_41623# a_50784_41365# uio_oe[0] sky130_fd_pr__nfet_01v8 ad=0.11285 pd=1.045 as=0.169 ps=1.82 w=0.65 l=0.15
X918 a_40923_41174# a_37579_34319# a_40464_40999# VDPWR sky130_fd_pr__pfet_01v8_hvt ad=0.0441 pd=0.63 as=0.1932 ps=1.34 w=0.42 l=0.15
X919 a_49961_41935# a_49483_41909# uio_oe[0] uio_oe[0] sky130_fd_pr__nfet_01v8 ad=0.0669 pd=0.75 as=0.12495 ps=1.015 w=0.42 l=0.15
X920 a_54446_42301# a_53369_41935# a_54284_41935# VDPWR sky130_fd_pr__pfet_01v8_hvt ad=0.0567 pd=0.69 as=0.0588 ps=0.7 w=0.42 l=0.15
X921 VDPWR a_57640_41705# a_57694_41391# VDPWR sky130_fd_pr__pfet_01v8_hvt ad=0.0567 pd=0.69 as=0.0483 ps=0.65 w=0.42 l=0.15
X922 a_39686_38671# a_38005_40847# uio_oe[0] uio_oe[0] sky130_fd_pr__nfet_01v8 ad=0.0693 pd=0.75 as=0.11285 ps=1.045 w=0.42 l=0.15
X923 a_26082_35400# a_25116_35593# VDPWR VDPWR sky130_fd_pr__pfet_01v8_hvt ad=0.07665 pd=0.785 as=0.15835 ps=1.395 w=0.42 l=0.15
X924 a_52579_38671# a_52325_38998# uio_oe[0] uio_oe[0] sky130_fd_pr__nfet_01v8 ad=0.0693 pd=0.75 as=0.1449 ps=1.11 w=0.42 l=0.15
X925 a_38532_37271# a_37851_36647# a_38674_37078# VDPWR sky130_fd_pr__pfet_01v8_hvt ad=0.1932 pd=1.34 as=0.07665 ps=0.785 w=0.42 l=0.15
X926 a_59293_37337# a_48677_38127# uio_oe[0] uio_oe[0] sky130_fd_pr__nfet_01v8 ad=0.1092 pd=1.36 as=0.1449 ps=1.11 w=0.42 l=0.15
X927 uio_oe[0] uio_oe[0] uio_oe[0] uio_oe[0] sky130_fd_pr__nfet_01v8 ad=0.1885 pd=1.88 as=0 ps=0 w=0.65 l=0.15
X928 a_61187_34685# a_60563_34319# a_61079_34319# VDPWR sky130_fd_pr__pfet_01v8_hvt ad=0.1155 pd=0.97 as=0.07245 ps=0.765 w=0.42 l=0.15
X929 VDPWR a_57363_42721# a_57324_42595# VDPWR sky130_fd_pr__pfet_01v8_hvt ad=0.0864 pd=0.91 as=0.1664 ps=1.8 w=0.64 l=0.15
X930 a_29740_18376# a_30303_34095# uio_oe[0] uio_oe[0] sky130_fd_pr__nfet_01v8 ad=0.169 pd=1.82 as=0.1013 ps=0.99 w=0.65 l=0.15
X931 a_40974_38671# a_40581_38671# a_40864_38671# uio_oe[0] sky130_fd_pr__special_nfet_01v8 ad=0.06705 pd=0.75 as=0.072 ps=0.76 w=0.36 l=0.15
X932 a_59135_34319# a_38651_34471# a_58772_34471# uio_oe[0] sky130_fd_pr__nfet_01v8 ad=0.0693 pd=0.75 as=0.09975 ps=0.895 w=0.42 l=0.15
X933 a_36427_36475# a_41990_38671# uio_oe[0] uio_oe[0] sky130_fd_pr__nfet_01v8 ad=0.169 pd=1.82 as=0.097 ps=0.975 w=0.65 l=0.15
X934 VDPWR a_40987_38369# a_40948_38243# VDPWR sky130_fd_pr__pfet_01v8_hvt ad=0.0864 pd=0.91 as=0.1664 ps=1.8 w=0.64 l=0.15
X935 a_61819_41909# a_48125_41935# VDPWR VDPWR sky130_fd_pr__pfet_01v8_hvt ad=0.0567 pd=0.69 as=0.0819 ps=0.81 w=0.42 l=0.15
X936 uio_oe[0] a_38961_38645# a_38895_38671# uio_oe[0] sky130_fd_pr__nfet_01v8 ad=0.1449 pd=1.11 as=0.0693 ps=0.75 w=0.42 l=0.15
X937 a_38961_37557# a_37029_37583# uio_oe[0] uio_oe[0] sky130_fd_pr__nfet_01v8 ad=0.1092 pd=1.36 as=0.1449 ps=1.11 w=0.42 l=0.15
X938 uio_oe[0] a_24836_36057# a_24787_35905# uio_oe[0] sky130_fd_pr__nfet_01v8 ad=0.11285 pd=1.045 as=0.169 ps=1.82 w=0.65 l=0.15
X939 a_17108_33881# a_17316_33703# a_17250_33729# uio_oe[0] sky130_fd_pr__nfet_01v8 ad=0.09975 pd=0.895 as=0.0693 ps=0.75 w=0.42 l=0.15
X940 a_29804_34505# a_18420_33453# a_29946_34639# uio_oe[0] sky130_fd_pr__nfet_01v8 ad=0.09975 pd=0.895 as=0.0693 ps=0.75 w=0.42 l=0.15
X941 a_50090_42479# a_49964_42595# a_49686_42611# uio_oe[0] sky130_fd_pr__special_nfet_01v8 ad=0.0999 pd=0.985 as=0.0711 ps=0.755 w=0.36 l=0.15
X942 VDPWR a_44905_38671# a_56843_35925# VDPWR sky130_fd_pr__pfet_01v8_hvt ad=0.0819 pd=0.81 as=0.0567 ps=0.69 w=0.42 l=0.15
X943 a_17434_35727# a_17388_35593# uio_oe[0] uio_oe[0] sky130_fd_pr__nfet_01v8 ad=0.0693 pd=0.75 as=0.11285 ps=1.045 w=0.42 l=0.15
X944 VDPWR a_39973_40601# a_40003_40342# VDPWR sky130_fd_pr__pfet_01v8_hvt ad=0.0693 pd=0.75 as=0.0441 ps=0.63 w=0.42 l=0.15
X945 VDPWR a_53636_38101# a_53574_38127# VDPWR sky130_fd_pr__pfet_01v8_hvt ad=0.1092 pd=1.36 as=0.0651 ps=0.73 w=0.42 l=0.15
X946 a_54264_35095# a_51620_35131# a_54406_35229# uio_oe[0] sky130_fd_pr__nfet_01v8 ad=0.09975 pd=0.895 as=0.0693 ps=0.75 w=0.42 l=0.15
X947 a_51775_39581# a_38740_39483# a_51412_39447# uio_oe[0] sky130_fd_pr__nfet_01v8 ad=0.0693 pd=0.75 as=0.09975 ps=0.895 w=0.42 l=0.15
X948 a_44516_40669# a_44399_40474# VDPWR VDPWR sky130_fd_pr__pfet_01v8_hvt ad=0.0651 pd=0.73 as=0.1092 ps=1.36 w=0.42 l=0.15
X949 uio_oe[0] uio_oe[0] uio_oe[0] uio_oe[0] sky130_fd_pr__nfet_01v8 ad=0.1885 pd=1.88 as=0 ps=0 w=0.65 l=0.15
X950 a_50469_34319# a_50090_34685# a_50397_34319# uio_oe[0] sky130_fd_pr__nfet_01v8 ad=0.1401 pd=1.1 as=0.0441 ps=0.63 w=0.42 l=0.15
X951 VDPWR a_28700_34969# a_28651_34817# VDPWR sky130_fd_pr__pfet_01v8_hvt ad=0.15835 pd=1.395 as=0.26 ps=2.52 w=1 l=0.15
X952 a_51554_38671# a_48677_39759# uio_oe[0] uio_oe[0] sky130_fd_pr__nfet_01v8 ad=0.0693 pd=0.75 as=0.11285 ps=1.045 w=0.42 l=0.15
X953 a_60302_35951# a_60176_36067# a_59898_36083# uio_oe[0] sky130_fd_pr__special_nfet_01v8 ad=0.0999 pd=0.985 as=0.0711 ps=0.755 w=0.36 l=0.15
X954 a_44611_40847# a_44095_40847# a_44516_40847# uio_oe[0] sky130_fd_pr__special_nfet_01v8 ad=0.0594 pd=0.69 as=0.066 ps=0.745 w=0.36 l=0.15
X955 uio_oe[0] a_60996_42453# a_60934_42479# uio_oe[0] sky130_fd_pr__nfet_01v8 ad=0.2205 pd=1.89 as=0.066 ps=0.745 w=0.42 l=0.15
X956 a_60609_40669# a_48125_41935# uio_oe[0] uio_oe[0] sky130_fd_pr__nfet_01v8 ad=0.0441 pd=0.63 as=0.1346 ps=1.15 w=0.42 l=0.15
X957 a_19588_18020# a_16812_8642# uio_oe[0] uio_oe[0] sky130_fd_pr__nfet_01v8 ad=1.4703 pd=10.72 as=1.4703 ps=10.72 w=5.07 l=1
X958 a_49483_34837# a_49686_34995# VDPWR VDPWR sky130_fd_pr__pfet_01v8_hvt ad=0.0567 pd=0.69 as=0.1134 ps=1.38 w=0.42 l=0.15
X959 a_53005_36495# a_52579_36822# VDPWR VDPWR sky130_fd_pr__pfet_01v8_hvt ad=0.26 pd=2.52 as=0.15835 ps=1.395 w=1 l=0.15
X960 uio_oe[0] a_21585_35659# a_21519_35727# uio_oe[0] sky130_fd_pr__nfet_01v8 ad=0.1449 pd=1.11 as=0.0693 ps=0.75 w=0.42 l=0.15
X961 a_61950_39581# a_36661_41391# uio_oe[0] uio_oe[0] sky130_fd_pr__nfet_01v8 ad=0.0693 pd=0.75 as=0.11285 ps=1.045 w=0.42 l=0.15
X962 a_56843_37557# a_57046_37835# VDPWR VDPWR sky130_fd_pr__pfet_01v8_hvt ad=0.0567 pd=0.69 as=0.1134 ps=1.38 w=0.42 l=0.15
X963 a_39973_38425# a_38005_40847# VDPWR VDPWR sky130_fd_pr__pfet_01v8_hvt ad=0.1176 pd=1.4 as=0.0693 ps=0.75 w=0.42 l=0.15
X964 uio_oe[0] a_56843_38101# a_39752_38395# uio_oe[0] sky130_fd_pr__nfet_01v8 ad=0.2087 pd=2.02 as=0.169 ps=1.82 w=0.65 l=0.15
X965 uio_oe[0] a_18641_36747# a_18575_36815# uio_oe[0] sky130_fd_pr__nfet_01v8 ad=0.1449 pd=1.11 as=0.0693 ps=0.75 w=0.42 l=0.15
X966 VDPWR a_17108_36057# a_17059_35905# VDPWR sky130_fd_pr__pfet_01v8_hvt ad=0.15835 pd=1.395 as=0.26 ps=2.52 w=1 l=0.15
X967 a_40238_34646# a_37661_37052# VDPWR VDPWR sky130_fd_pr__pfet_01v8_hvt ad=0.07665 pd=0.785 as=0.15835 ps=1.395 w=0.42 l=0.15
X968 VDPWR a_44829_41089# a_44719_41213# VDPWR sky130_fd_pr__pfet_01v8_hvt ad=0.07035 pd=0.755 as=0.1155 ps=0.97 w=0.42 l=0.15
X969 uio_oe[0] a_37913_43023# a_53203_40847# uio_oe[0] sky130_fd_pr__nfet_01v8 ad=0.0567 pd=0.69 as=0.1092 ps=1.36 w=0.42 l=0.15
X970 a_26259_35183# a_24787_34817# uio_oe[0] uio_oe[0] sky130_fd_pr__nfet_01v8 ad=0.1092 pd=1.36 as=0.1092 ps=1.36 w=0.42 l=0.15
X971 a_43598_43023# a_40379_35551# uio_oe[0] uio_oe[0] sky130_fd_pr__nfet_01v8 ad=0.06405 pd=0.725 as=0.12495 ps=1.015 w=0.42 l=0.15
X972 a_40811_37796# a_41171_40342# VDPWR VDPWR sky130_fd_pr__pfet_01v8_hvt ad=0.26 pd=2.52 as=0.15835 ps=1.395 w=1 l=0.15
X973 a_60934_35951# a_60176_36067# a_60371_35925# VDPWR sky130_fd_pr__pfet_01v8_hvt ad=0.0651 pd=0.73 as=0.07245 ps=0.765 w=0.42 l=0.15
X974 a_26303_35727# a_18427_33198# a_25940_35593# uio_oe[0] sky130_fd_pr__nfet_01v8 ad=0.0693 pd=0.75 as=0.09975 ps=0.895 w=0.42 l=0.15
X975 a_38532_42087# a_38089_40623# a_38674_42262# VDPWR sky130_fd_pr__pfet_01v8_hvt ad=0.1932 pd=1.34 as=0.07665 ps=0.785 w=0.42 l=0.15
X976 a_51620_41909# a_54459_41909# VDPWR VDPWR sky130_fd_pr__pfet_01v8_hvt ad=0.26 pd=2.52 as=0.3012 ps=2.66 w=1 l=0.15
X977 a_36661_41391# a_36631_41365# uio_oe[0] uio_oe[0] sky130_fd_pr__nfet_01v8 ad=0.08775 pd=0.92 as=0.169 ps=1.82 w=0.65 l=0.15
X978 a_44327_39447# a_45351_40607# uio_oe[0] uio_oe[0] sky130_fd_pr__nfet_01v8 ad=0.169 pd=1.82 as=0.2087 ps=2.02 w=0.65 l=0.15
X979 VDPWR a_37851_36647# a_37839_36861# VDPWR sky130_fd_pr__pfet_01v8_hvt ad=0.0714 pd=0.76 as=0.1092 ps=1.36 w=0.42 l=0.15
X980 a_29129_33703# a_28796_33881# uio_oe[0] uio_oe[0] sky130_fd_pr__nfet_01v8 ad=0.1092 pd=1.36 as=0.1449 ps=1.11 w=0.42 l=0.15
X981 a_54264_39447# a_54479_39228# a_54406_39254# VDPWR sky130_fd_pr__pfet_01v8_hvt ad=0.1932 pd=1.34 as=0.07665 ps=0.785 w=0.42 l=0.15
X982 VDPWR a_50784_36744# a_50722_36861# VDPWR sky130_fd_pr__pfet_01v8_hvt ad=0.1092 pd=1.36 as=0.0651 ps=0.73 w=0.42 l=0.15
X983 a_52855_41633# a_37913_43023# uio_oe[0] uio_oe[0] sky130_fd_pr__nfet_01v8 ad=0.1092 pd=1.36 as=0.0567 ps=0.69 w=0.42 l=0.15
X984 a_62267_39254# a_54479_39228# a_61808_39447# VDPWR sky130_fd_pr__pfet_01v8_hvt ad=0.0441 pd=0.63 as=0.1932 ps=1.34 w=0.42 l=0.15
X985 VDPWR a_39544_38359# a_24932_37145# VDPWR sky130_fd_pr__pfet_01v8_hvt ad=0.15835 pd=1.395 as=0.26 ps=2.52 w=1 l=0.15
X986 a_50090_36861# a_49964_36763# a_49686_36747# uio_oe[0] sky130_fd_pr__special_nfet_01v8 ad=0.0999 pd=0.985 as=0.0711 ps=0.755 w=0.36 l=0.15
X987 uio_oe[0] a_37661_37052# a_42257_35407# uio_oe[0] sky130_fd_pr__nfet_01v8 ad=0.08775 pd=0.92 as=0.08775 ps=0.92 w=0.65 l=0.15
X988 ua[4] a_20620_10782# a_23274_10020# uio_oe[0] sky130_fd_pr__nfet_01v8 ad=0.1885 pd=1.88 as=0.1885 ps=1.88 w=0.65 l=0.15
X989 a_54723_34902# a_51620_35131# a_54264_35095# VDPWR sky130_fd_pr__pfet_01v8_hvt ad=0.0441 pd=0.63 as=0.1932 ps=1.34 w=0.42 l=0.15
X990 a_41288_39215# a_41074_39215# VDPWR VDPWR sky130_fd_pr__pfet_01v8_hvt ad=0.1155 pd=0.97 as=0.07035 ps=0.755 w=0.42 l=0.15
X991 VDPWR a_50003_37725# a_49964_37851# VDPWR sky130_fd_pr__pfet_01v8_hvt ad=0.0864 pd=0.91 as=0.1664 ps=1.8 w=0.64 l=0.15
X992 a_41671_36469# a_41496_36495# a_41850_36495# uio_oe[0] sky130_fd_pr__nfet_01v8 ad=0.1092 pd=1.36 as=0.06405 ps=0.725 w=0.42 l=0.15
X993 a_25940_35593# a_18427_33198# a_26082_35400# VDPWR sky130_fd_pr__pfet_01v8_hvt ad=0.1932 pd=1.34 as=0.07665 ps=0.785 w=0.42 l=0.15
X994 a_36327_35381# a_36425_35381# VDPWR VDPWR sky130_fd_pr__pfet_01v8_hvt ad=0.0609 pd=0.71 as=0.2279 ps=1.74 w=0.42 l=0.15
X995 a_40238_34319# a_37661_37052# uio_oe[0] uio_oe[0] sky130_fd_pr__nfet_01v8 ad=0.0693 pd=0.75 as=0.11285 ps=1.045 w=0.42 l=0.15
X996 VDPWR a_45431_39733# a_48511_39759# VDPWR sky130_fd_pr__pfet_01v8_hvt ad=0.135 pd=1.27 as=0.26 ps=2.52 w=1 l=0.15
X997 uio_oe[0] a_50159_38101# a_50090_38127# uio_oe[0] sky130_fd_pr__nfet_01v8 ad=0.1346 pd=1.15 as=0.0999 ps=0.985 w=0.64 l=0.15
X998 a_54446_35773# a_53369_35407# a_54284_35407# VDPWR sky130_fd_pr__pfet_01v8_hvt ad=0.0567 pd=0.69 as=0.0588 ps=0.7 w=0.42 l=0.15
X999 a_59201_37557# a_48677_38127# VDPWR VDPWR sky130_fd_pr__pfet_01v8_hvt ad=0.1176 pd=1.4 as=0.0693 ps=0.75 w=0.42 l=0.15
X1000 a_37839_34685# a_37641_35407# uio_oe[0] uio_oe[0] sky130_fd_pr__nfet_01v8 ad=0.1092 pd=1.36 as=0.1092 ps=1.36 w=0.42 l=0.15
X1001 a_42237_34863# a_41316_41909# VDPWR VDPWR sky130_fd_pr__pfet_01v8_hvt ad=0.135 pd=1.27 as=0.135 ps=1.27 w=1 l=0.15
X1002 uio_oe[0] a_44905_38671# a_49721_36495# uio_oe[0] sky130_fd_pr__nfet_01v8 ad=0.12495 pd=1.015 as=0.06405 ps=0.725 w=0.42 l=0.15
X1003 a_27316_18020# a_4259_22596# a_27138_18020# uio_oe[0] sky130_fd_pr__nfet_01v8 ad=0.2436 pd=2.26 as=0.2436 ps=2.26 w=0.84 l=0.6
X1004 a_61644_34319# a_60729_34319# a_61297_34561# uio_oe[0] sky130_fd_pr__special_nfet_01v8 ad=0.0711 pd=0.755 as=0.0999 ps=0.985 w=0.36 l=0.15
X1005 a_53005_35407# a_52579_35734# uio_oe[0] uio_oe[0] sky130_fd_pr__nfet_01v8 ad=0.169 pd=1.82 as=0.11285 ps=1.045 w=0.65 l=0.15
X1006 a_41685_42479# a_41519_42479# uio_oe[0] uio_oe[0] sky130_fd_pr__nfet_01v8 ad=0.08775 pd=0.92 as=0.08775 ps=0.92 w=0.65 l=0.15
X1007 a_42787_41213# a_42163_40847# a_42679_40847# VDPWR sky130_fd_pr__pfet_01v8_hvt ad=0.1155 pd=0.97 as=0.07245 ps=0.765 w=0.42 l=0.15
X1008 VDPWR a_18641_36747# a_18671_36488# VDPWR sky130_fd_pr__pfet_01v8_hvt ad=0.0693 pd=0.75 as=0.0441 ps=0.63 w=0.42 l=0.15
X1009 uio_oe[0] a_36631_41365# a_36661_41391# uio_oe[0] sky130_fd_pr__nfet_01v8 ad=0.08775 pd=0.92 as=0.08775 ps=0.92 w=0.65 l=0.15
X1010 uio_oe[0] a_37661_37052# a_37605_37910# uio_oe[0] sky130_fd_pr__nfet_01v8 ad=0.1449 pd=1.11 as=0.1092 ps=1.36 w=0.42 l=0.15
X1011 a_24978_36232# a_24932_36057# VDPWR VDPWR sky130_fd_pr__pfet_01v8_hvt ad=0.07665 pd=0.785 as=0.15835 ps=1.395 w=0.42 l=0.15
X1012 a_61819_35381# a_46193_39759# VDPWR VDPWR sky130_fd_pr__pfet_01v8_hvt ad=0.0567 pd=0.69 as=0.0819 ps=0.81 w=0.42 l=0.15
X1013 a_53719_40847# a_53369_40847# a_53624_40847# VDPWR sky130_fd_pr__pfet_01v8_hvt ad=0.07245 pd=0.765 as=0.0651 ps=0.73 w=0.42 l=0.15
X1014 a_19538_20730# ua[3] a_19410_22020# uio_oe[0] sky130_fd_pr__nfet_01v8 ad=0.2436 pd=2.26 as=0.2436 ps=2.26 w=0.84 l=0.6
X1015 uio_oe[0] a_43419_42997# a_43353_43023# uio_oe[0] sky130_fd_pr__nfet_01v8 ad=0.12495 pd=1.015 as=0.0669 ps=0.75 w=0.42 l=0.15
X1016 a_50304_42301# a_50090_42301# VDPWR VDPWR sky130_fd_pr__pfet_01v8_hvt ad=0.1155 pd=0.97 as=0.07035 ps=0.755 w=0.42 l=0.15
X1017 a_54284_38671# a_53203_38671# a_53937_38913# VDPWR sky130_fd_pr__pfet_01v8_hvt ad=0.0588 pd=0.7 as=0.12915 ps=1.185 w=0.42 l=0.15
X1018 VDPWR a_51412_38359# a_50784_38101# VDPWR sky130_fd_pr__pfet_01v8_hvt ad=0.15835 pd=1.395 as=0.26 ps=2.52 w=1 l=0.15
X1019 ua[5] a_28348_18782# a_31002_18020# uio_oe[0] sky130_fd_pr__nfet_01v8 ad=0.1885 pd=1.88 as=0.1885 ps=1.88 w=0.65 l=0.15
X1020 uio_oe[0] a_37452_34953# a_37328_34979# uio_oe[0] sky130_fd_pr__nfet_01v8 ad=0.10025 pd=0.985 as=0.0567 ps=0.69 w=0.42 l=0.15
X1021 a_52579_35734# a_51620_36219# a_52579_35407# uio_oe[0] sky130_fd_pr__nfet_01v8 ad=0.09975 pd=0.895 as=0.0693 ps=0.75 w=0.42 l=0.15
X1022 a_44719_42301# a_44095_41935# a_44611_41935# VDPWR sky130_fd_pr__pfet_01v8_hvt ad=0.1155 pd=0.97 as=0.07245 ps=0.765 w=0.42 l=0.15
X1023 a_61187_42301# a_48125_41935# VDPWR VDPWR sky130_fd_pr__pfet_01v8_hvt ad=0.1092 pd=1.36 as=0.07035 ps=0.755 w=0.42 l=0.15
X1024 a_28842_36993# a_28796_37145# uio_oe[0] uio_oe[0] sky130_fd_pr__nfet_01v8 ad=0.0693 pd=0.75 as=0.11285 ps=1.045 w=0.42 l=0.15
X1025 ua[5] a_20620_14782# a_23274_22020# uio_oe[0] sky130_fd_pr__nfet_01v8 ad=0.1885 pd=1.88 as=0.1885 ps=1.88 w=0.65 l=0.15
X1026 a_29804_33417# a_18420_33453# a_29946_33551# uio_oe[0] sky130_fd_pr__nfet_01v8 ad=0.09975 pd=0.895 as=0.0693 ps=0.75 w=0.42 l=0.15
X1027 a_53937_34561# a_53719_34319# VDPWR VDPWR sky130_fd_pr__pfet_01v8_hvt ad=0.12915 pd=1.185 as=0.2184 ps=2.2 w=0.84 l=0.15
X1028 uio_oe[0] a_54264_40535# a_53636_40277# uio_oe[0] sky130_fd_pr__nfet_01v8 ad=0.11285 pd=1.045 as=0.169 ps=1.82 w=0.65 l=0.15
X1029 a_16756_10782# a_18711_37359# VDPWR VDPWR sky130_fd_pr__pfet_01v8_hvt ad=0.26 pd=2.52 as=0.2279 ps=1.74 w=1 l=0.15
X1030 uio_oe[0] a_40379_35551# a_40337_35407# uio_oe[0] sky130_fd_pr__nfet_01v8 ad=0.12495 pd=1.015 as=0.06405 ps=0.725 w=0.42 l=0.15
X1031 ua[4] a_25876_18782# a_25746_18020# uio_oe[0] sky130_fd_pr__nfet_01v8 ad=0.1885 pd=1.88 as=0.1885 ps=1.88 w=0.65 l=0.15
X1032 a_57640_39529# a_57556_39189# a_58044_39581# uio_oe[0] sky130_fd_pr__special_nfet_01v8 ad=0.072 pd=0.76 as=0.06705 ps=0.75 w=0.36 l=0.15
X1033 a_39555_35559# a_37029_37583# VDPWR VDPWR sky130_fd_pr__pfet_01v8_hvt ad=0.0567 pd=0.69 as=0.16655 ps=1.39 w=0.42 l=0.15
X1034 a_59939_40086# a_58980_39733# a_59867_40086# VDPWR sky130_fd_pr__pfet_01v8_hvt ad=0.1932 pd=1.34 as=0.0441 ps=0.63 w=0.42 l=0.15
X1035 a_57354_39581# a_48125_43023# uio_oe[0] uio_oe[0] sky130_fd_pr__nfet_01v8 ad=0.0483 pd=0.65 as=0.1137 ps=1.01 w=0.42 l=0.15
X1036 a_46193_41397# a_46027_41397# VDPWR VDPWR sky130_fd_pr__pfet_01v8_hvt ad=0.1664 pd=1.8 as=0.0864 ps=0.91 w=0.64 l=0.15
X1037 a_36530_40011# a_36808_40027# a_36764_40125# VDPWR sky130_fd_pr__pfet_01v8_hvt ad=0.0588 pd=0.7 as=0.0567 ps=0.69 w=0.42 l=0.15
X1038 a_39907_39759# a_38089_40623# a_39544_39911# uio_oe[0] sky130_fd_pr__nfet_01v8 ad=0.0693 pd=0.75 as=0.09975 ps=0.895 w=0.42 l=0.15
X1039 a_57519_38908# a_57363_38813# a_57664_39037# VDPWR sky130_fd_pr__pfet_01v8_hvt ad=0.07245 pd=0.765 as=0.1155 ps=0.97 w=0.42 l=0.15
X1040 a_49686_38259# a_49964_38243# a_49920_38127# VDPWR sky130_fd_pr__pfet_01v8_hvt ad=0.0588 pd=0.7 as=0.0567 ps=0.69 w=0.42 l=0.15
X1041 a_22505_36747# a_21252_36681# uio_oe[0] uio_oe[0] sky130_fd_pr__nfet_01v8 ad=0.1092 pd=1.36 as=0.1449 ps=1.11 w=0.42 l=0.15
X1042 uio_oe[0] a_51841_36249# a_51775_36317# uio_oe[0] sky130_fd_pr__nfet_01v8 ad=0.1449 pd=1.11 as=0.0693 ps=0.75 w=0.42 l=0.15
X1043 a_51841_35161# a_48677_38127# uio_oe[0] uio_oe[0] sky130_fd_pr__nfet_01v8 ad=0.1092 pd=1.36 as=0.1449 ps=1.11 w=0.42 l=0.15
X1044 a_47283_42783# a_47108_42857# a_47462_42845# uio_oe[0] sky130_fd_pr__nfet_01v8 ad=0.1092 pd=1.36 as=0.06405 ps=0.725 w=0.42 l=0.15
X1045 VDPWR a_46761_42453# a_46651_42479# VDPWR sky130_fd_pr__pfet_01v8_hvt ad=0.07035 pd=0.755 as=0.1155 ps=0.97 w=0.42 l=0.15
X1046 VDPWR a_52855_41633# a_52816_41507# VDPWR sky130_fd_pr__pfet_01v8_hvt ad=0.0864 pd=0.91 as=0.1664 ps=1.8 w=0.64 l=0.15
X1047 a_40581_37045# a_40415_37045# VDPWR VDPWR sky130_fd_pr__pfet_01v8_hvt ad=0.1664 pd=1.8 as=0.0864 ps=0.91 w=0.64 l=0.15
X1048 a_42643_36822# a_42685_36611# a_42643_36495# uio_oe[0] sky130_fd_pr__nfet_01v8 ad=0.09975 pd=0.895 as=0.0693 ps=0.75 w=0.42 l=0.15
X1049 VDPWR a_21401_34791# a_21431_35144# VDPWR sky130_fd_pr__pfet_01v8_hvt ad=0.0693 pd=0.75 as=0.0441 ps=0.63 w=0.42 l=0.15
X1050 a_51412_35559# a_51620_35381# a_51554_35407# uio_oe[0] sky130_fd_pr__nfet_01v8 ad=0.09975 pd=0.895 as=0.0693 ps=0.75 w=0.42 l=0.15
X1051 VDPWR a_56843_42453# a_39752_42747# VDPWR sky130_fd_pr__pfet_01v8_hvt ad=0.3012 pd=2.66 as=0.26 ps=2.52 w=1 l=0.15
X1052 a_38717_34347# a_38651_34471# uio_oe[0] uio_oe[0] sky130_fd_pr__nfet_01v8 ad=0.0567 pd=0.69 as=0.1118 ps=1.04 w=0.42 l=0.15
X1053 uio_oe[0] a_39544_39911# a_21068_36057# uio_oe[0] sky130_fd_pr__nfet_01v8 ad=0.11285 pd=1.045 as=0.169 ps=1.82 w=0.65 l=0.15
X1054 VDPWR a_40467_38101# a_37795_40535# VDPWR sky130_fd_pr__pfet_01v8_hvt ad=0.3012 pd=2.66 as=0.26 ps=2.52 w=1 l=0.15
X1055 a_53156_37039# a_52942_37039# VDPWR VDPWR sky130_fd_pr__pfet_01v8_hvt ad=0.1155 pd=0.97 as=0.07035 ps=0.755 w=0.42 l=0.15
X1056 VDPWR a_44327_39447# a_44339_37735# VDPWR sky130_fd_pr__pfet_01v8_hvt ad=0.1176 pd=1.4 as=0.0567 ps=0.69 w=0.42 l=0.15
X1057 a_37661_38140# a_38019_34685# VDPWR VDPWR sky130_fd_pr__pfet_01v8_hvt ad=0.26 pd=2.52 as=0.2279 ps=1.74 w=1 l=0.15
X1058 VDPWR a_46193_39759# a_52335_34837# VDPWR sky130_fd_pr__pfet_01v8_hvt ad=0.0819 pd=0.81 as=0.0567 ps=0.69 w=0.42 l=0.15
X1059 a_53321_35229# a_52942_34863# a_53249_35229# uio_oe[0] sky130_fd_pr__nfet_01v8 ad=0.1401 pd=1.1 as=0.0441 ps=0.63 w=0.42 l=0.15
X1060 a_36585_40847# a_36307_40875# VDPWR VDPWR sky130_fd_pr__pfet_01v8_hvt ad=0.475 pd=2.95 as=0.16655 ps=1.39 w=1 l=0.15
X1061 a_54627_38493# a_54479_38140# a_54264_38359# uio_oe[0] sky130_fd_pr__nfet_01v8 ad=0.0693 pd=0.75 as=0.09975 ps=0.895 w=0.42 l=0.15
X1062 VDPWR a_25417_32641# a_25739_37021# VDPWR sky130_fd_pr__pfet_01v8_hvt ad=0.16655 pd=1.39 as=0.0567 ps=0.69 w=0.42 l=0.15
X1063 a_60416_37317# a_37913_41935# uio_oe[0] uio_oe[0] sky130_fd_pr__nfet_01v8 ad=0.1092 pd=1.36 as=0.0567 ps=0.69 w=0.42 l=0.15
X1064 a_56843_36469# a_57046_36747# VDPWR VDPWR sky130_fd_pr__pfet_01v8_hvt ad=0.0567 pd=0.69 as=0.1134 ps=1.38 w=0.42 l=0.15
X1065 ua[4] a_16756_10376# a_19410_26020# uio_oe[0] sky130_fd_pr__nfet_01v8 ad=0.1885 pd=1.88 as=0.1885 ps=1.88 w=0.65 l=0.15
X1066 a_50397_38493# a_44905_38671# uio_oe[0] uio_oe[0] sky130_fd_pr__nfet_01v8 ad=0.0441 pd=0.63 as=0.1346 ps=1.15 w=0.42 l=0.15
X1067 a_58980_36469# a_61819_36469# uio_oe[0] uio_oe[0] sky130_fd_pr__nfet_01v8 ad=0.169 pd=1.82 as=0.2087 ps=2.02 w=0.65 l=0.15
X1068 a_41445_41689# a_38285_34863# uio_oe[0] uio_oe[0] sky130_fd_pr__nfet_01v8 ad=0.1092 pd=1.36 as=0.1449 ps=1.11 w=0.42 l=0.15
X1069 VDPWR a_37913_43023# a_53203_40847# VDPWR sky130_fd_pr__pfet_01v8_hvt ad=0.0864 pd=0.91 as=0.1664 ps=1.8 w=0.64 l=0.15
X1070 a_41040_38645# a_40379_35551# VDPWR VDPWR sky130_fd_pr__pfet_01v8_hvt ad=0.0567 pd=0.69 as=0.0798 ps=0.8 w=0.42 l=0.15
X1071 a_57321_38493# a_56843_38101# uio_oe[0] uio_oe[0] sky130_fd_pr__nfet_01v8 ad=0.0669 pd=0.75 as=0.12495 ps=1.015 w=0.42 l=0.15
X1072 a_38674_37405# a_37029_37583# uio_oe[0] uio_oe[0] sky130_fd_pr__nfet_01v8 ad=0.0693 pd=0.75 as=0.11285 ps=1.045 w=0.42 l=0.15
X1073 a_58914_35734# a_48677_38127# VDPWR VDPWR sky130_fd_pr__pfet_01v8_hvt ad=0.07665 pd=0.785 as=0.15835 ps=1.395 w=0.42 l=0.15
X1074 a_38532_42711# a_38740_42747# a_38674_42845# uio_oe[0] sky130_fd_pr__nfet_01v8 ad=0.09975 pd=0.895 as=0.0693 ps=0.75 w=0.42 l=0.15
X1075 a_51775_39759# a_39752_39733# a_51412_39911# uio_oe[0] sky130_fd_pr__nfet_01v8 ad=0.0693 pd=0.75 as=0.09975 ps=0.895 w=0.42 l=0.15
X1076 a_44829_43265# a_44611_43023# VDPWR VDPWR sky130_fd_pr__pfet_01v8_hvt ad=0.12915 pd=1.185 as=0.2184 ps=2.2 w=0.84 l=0.15
X1077 VDPWR a_49483_38645# a_39752_38645# VDPWR sky130_fd_pr__pfet_01v8_hvt ad=0.3012 pd=2.66 as=0.26 ps=2.52 w=1 l=0.15
X1078 a_60802_35229# a_60584_35177# a_60720_35229# uio_oe[0] sky130_fd_pr__nfet_01v8 ad=0.0441 pd=0.63 as=0.1092 ps=1.36 w=0.42 l=0.15
X1079 VDPWR a_36447_40849# a_36307_40875# VDPWR sky130_fd_pr__pfet_01v8_hvt ad=0.16655 pd=1.39 as=0.0567 ps=0.69 w=0.42 l=0.15
X1080 uio_oe[0] a_29313_34571# a_29247_34639# uio_oe[0] sky130_fd_pr__nfet_01v8 ad=0.1449 pd=1.11 as=0.0693 ps=0.75 w=0.42 l=0.15
X1081 uio_oe[0] a_51412_39911# a_50784_40008# uio_oe[0] sky130_fd_pr__nfet_01v8 ad=0.11285 pd=1.045 as=0.169 ps=1.82 w=0.65 l=0.15
X1082 a_57363_42077# a_38649_43023# uio_oe[0] uio_oe[0] sky130_fd_pr__nfet_01v8 ad=0.1092 pd=1.36 as=0.0567 ps=0.69 w=0.42 l=0.15
X1083 a_59201_40601# a_48677_39759# uio_oe[0] uio_oe[0] sky130_fd_pr__nfet_01v8 ad=0.1092 pd=1.36 as=0.1449 ps=1.11 w=0.42 l=0.15
X1084 uio_oe[0] a_50159_37013# a_50090_37039# uio_oe[0] sky130_fd_pr__nfet_01v8 ad=0.1346 pd=1.15 as=0.0999 ps=0.985 w=0.64 l=0.15
X1085 a_23698_26464# a_20620_10782# ua[4] uio_oe[0] sky130_fd_pr__nfet_01v8 ad=0.1885 pd=1.88 as=0.1885 ps=1.88 w=0.65 l=0.15
X1086 a_58914_35407# a_48677_38127# uio_oe[0] uio_oe[0] sky130_fd_pr__nfet_01v8 ad=0.0693 pd=0.75 as=0.11285 ps=1.045 w=0.42 l=0.15
X1087 uio_oe[0] a_39947_42997# a_42941_41757# uio_oe[0] sky130_fd_pr__nfet_01v8 ad=0.1346 pd=1.15 as=0.0441 ps=0.63 w=0.42 l=0.15
X1088 a_58772_40999# a_58980_40821# a_58914_40847# uio_oe[0] sky130_fd_pr__nfet_01v8 ad=0.09975 pd=0.895 as=0.0693 ps=0.75 w=0.42 l=0.15
X1089 a_43408_37735# a_42445_36469# a_43550_37583# uio_oe[0] sky130_fd_pr__nfet_01v8 ad=0.09975 pd=0.895 as=0.0693 ps=0.75 w=0.42 l=0.15
X1090 a_53719_34319# a_53369_34319# a_53624_34319# VDPWR sky130_fd_pr__pfet_01v8_hvt ad=0.07245 pd=0.765 as=0.0651 ps=0.73 w=0.42 l=0.15
X1091 a_37433_35665# a_44044_37155# uio_oe[0] uio_oe[0] sky130_fd_pr__nfet_01v8 ad=0.169 pd=1.82 as=0.10025 ps=0.985 w=0.65 l=0.15
X1092 a_17434_35400# a_17388_35593# VDPWR VDPWR sky130_fd_pr__pfet_01v8_hvt ad=0.07665 pd=0.785 as=0.15835 ps=1.395 w=0.42 l=0.15
X1093 a_50304_35773# a_50090_35773# VDPWR VDPWR sky130_fd_pr__pfet_01v8_hvt ad=0.1155 pd=0.97 as=0.07035 ps=0.755 w=0.42 l=0.15
X1094 uio_oe[0] a_16812_8642# a_29738_16730# uio_oe[0] sky130_fd_pr__nfet_01v8 ad=1.4703 pd=10.72 as=1.4703 ps=10.72 w=5.07 l=1
X1095 a_60153_42262# a_51620_41909# a_59939_42262# VDPWR sky130_fd_pr__pfet_01v8_hvt ad=0.07665 pd=0.785 as=0.1932 ps=1.34 w=0.42 l=0.15
X1096 a_41570_38885# a_41420_39037# VDPWR VDPWR sky130_fd_pr__pfet_01v8_hvt ad=0.2184 pd=2.2 as=0.12285 ps=1.17 w=0.84 l=0.15
X1097 VDPWR a_17059_36993# a_18531_37359# VDPWR sky130_fd_pr__pfet_01v8_hvt ad=0.0714 pd=0.76 as=0.1092 ps=1.36 w=0.42 l=0.15
X1098 a_61187_35773# a_46193_39759# VDPWR VDPWR sky130_fd_pr__pfet_01v8_hvt ad=0.1092 pd=1.36 as=0.07035 ps=0.755 w=0.42 l=0.15
X1099 a_23698_26464# a_4259_22596# a_23402_24730# uio_oe[0] sky130_fd_pr__nfet_01v8 ad=0.2436 pd=2.26 as=0.2436 ps=2.26 w=0.84 l=0.6
X1100 a_53369_34319# a_53203_34319# uio_oe[0] uio_oe[0] sky130_fd_pr__nfet_01v8 ad=0.1092 pd=1.36 as=0.0567 ps=0.69 w=0.42 l=0.15
X1101 uio_oe[0] a_44905_38671# a_57081_38493# uio_oe[0] sky130_fd_pr__nfet_01v8 ad=0.12495 pd=1.015 as=0.06405 ps=0.725 w=0.42 l=0.15
X1102 VDPWR a_25449_33483# a_25479_33224# VDPWR sky130_fd_pr__pfet_01v8_hvt ad=0.0693 pd=0.75 as=0.0441 ps=0.63 w=0.42 l=0.15
X1103 VDPWR a_36327_39189# a_18427_33198# VDPWR sky130_fd_pr__pfet_01v8_hvt ad=0.3012 pd=2.66 as=0.26 ps=2.52 w=1 l=0.15
X1104 a_41074_39215# a_40987_39457# a_40670_39347# VDPWR sky130_fd_pr__pfet_01v8_hvt ad=0.12915 pd=1.185 as=0.0588 ps=0.7 w=0.42 l=0.15
X1105 a_62237_35161# a_37361_41391# VDPWR VDPWR sky130_fd_pr__pfet_01v8_hvt ad=0.1176 pd=1.4 as=0.0693 ps=0.75 w=0.42 l=0.15
X1106 VDPWR clk a_38483_43023# VDPWR sky130_fd_pr__pfet_01v8_hvt ad=0.135 pd=1.27 as=0.26 ps=2.52 w=1 l=0.15
X1107 a_60638_41391# a_60416_41669# a_59956_41365# VDPWR sky130_fd_pr__pfet_01v8_hvt ad=0.0483 pd=0.65 as=0.0819 ps=0.81 w=0.42 l=0.15
X1108 VDPWR a_62053_42777# a_62083_42518# VDPWR sky130_fd_pr__pfet_01v8_hvt ad=0.0693 pd=0.75 as=0.0441 ps=0.63 w=0.42 l=0.15
X1109 a_53719_41935# a_53203_41935# a_53624_41935# uio_oe[0] sky130_fd_pr__special_nfet_01v8 ad=0.0594 pd=0.69 as=0.066 ps=0.745 w=0.36 l=0.15
X1110 a_60729_41935# a_60563_41935# uio_oe[0] uio_oe[0] sky130_fd_pr__nfet_01v8 ad=0.1092 pd=1.36 as=0.0567 ps=0.69 w=0.42 l=0.15
X1111 uio_oe[0] a_38285_34863# a_40917_40342# uio_oe[0] sky130_fd_pr__nfet_01v8 ad=0.1449 pd=1.11 as=0.1092 ps=1.36 w=0.42 l=0.15
X1112 uio_oe[0] a_40467_39733# a_37851_36647# uio_oe[0] sky130_fd_pr__nfet_01v8 ad=0.2087 pd=2.02 as=0.169 ps=1.82 w=0.65 l=0.15
X1113 a_21615_35400# a_17500_33453# a_21156_35593# VDPWR sky130_fd_pr__pfet_01v8_hvt ad=0.0441 pd=0.63 as=0.1932 ps=1.34 w=0.42 l=0.15
X1114 a_39973_36469# a_37029_37583# uio_oe[0] uio_oe[0] sky130_fd_pr__nfet_01v8 ad=0.1092 pd=1.36 as=0.1449 ps=1.11 w=0.42 l=0.15
X1115 a_40893_40821# a_37661_37052# VDPWR VDPWR sky130_fd_pr__pfet_01v8_hvt ad=0.1176 pd=1.4 as=0.0693 ps=0.75 w=0.42 l=0.15
X1116 uio_oe[0] a_50784_40277# a_50722_40303# uio_oe[0] sky130_fd_pr__nfet_01v8 ad=0.2205 pd=1.89 as=0.066 ps=0.745 w=0.42 l=0.15
X1117 uio_oe[0] a_59956_39189# a_60092_39215# uio_oe[0] sky130_fd_pr__nfet_01v8 ad=0.1137 pd=1.01 as=0.1404 ps=1.6 w=0.54 l=0.15
X1118 a_24484_14376# a_25739_35933# VDPWR VDPWR sky130_fd_pr__pfet_01v8_hvt ad=0.475 pd=2.95 as=0.16655 ps=1.39 w=1 l=0.15
X1119 VDPWR a_59201_40821# a_59231_41174# VDPWR sky130_fd_pr__pfet_01v8_hvt ad=0.0693 pd=0.75 as=0.0441 ps=0.63 w=0.42 l=0.15
X1120 a_39907_38671# a_38089_40623# a_39544_38823# uio_oe[0] sky130_fd_pr__nfet_01v8 ad=0.0693 pd=0.75 as=0.09975 ps=0.895 w=0.42 l=0.15
X1121 VDPWR a_54264_37271# a_53636_37013# VDPWR sky130_fd_pr__pfet_01v8_hvt ad=0.15835 pd=1.395 as=0.26 ps=2.52 w=1 l=0.15
X1122 VDPWR a_22076_34505# a_21180_34791# VDPWR sky130_fd_pr__pfet_01v8_hvt ad=0.15835 pd=1.395 as=0.26 ps=2.52 w=1 l=0.15
X1123 a_53249_42845# a_48125_41935# uio_oe[0] uio_oe[0] sky130_fd_pr__nfet_01v8 ad=0.0441 pd=0.63 as=0.1346 ps=1.15 w=0.42 l=0.15
X1124 a_25479_36488# a_17500_33453# a_25020_36681# VDPWR sky130_fd_pr__pfet_01v8_hvt ad=0.0441 pd=0.63 as=0.1932 ps=1.34 w=0.42 l=0.15
X1125 VDPWR a_29313_35659# a_29343_35400# VDPWR sky130_fd_pr__pfet_01v8_hvt ad=0.0693 pd=0.75 as=0.0441 ps=0.63 w=0.42 l=0.15
X1126 a_52793_35734# a_51620_36219# a_52579_35734# VDPWR sky130_fd_pr__pfet_01v8_hvt ad=0.07665 pd=0.785 as=0.1932 ps=1.34 w=0.42 l=0.15
X1127 a_50090_42301# a_50003_42077# a_49686_42187# VDPWR sky130_fd_pr__pfet_01v8_hvt ad=0.12915 pd=1.185 as=0.0588 ps=0.7 w=0.42 l=0.15
X1128 VDPWR a_46761_41365# a_46651_41391# VDPWR sky130_fd_pr__pfet_01v8_hvt ad=0.07035 pd=0.755 as=0.1155 ps=0.97 w=0.42 l=0.15
X1129 VDPWR a_51841_40821# a_51871_41174# VDPWR sky130_fd_pr__pfet_01v8_hvt ad=0.0693 pd=0.75 as=0.0441 ps=0.63 w=0.42 l=0.15
X1130 a_25020_36681# a_17500_33453# a_25162_36815# uio_oe[0] sky130_fd_pr__nfet_01v8 ad=0.09975 pd=0.895 as=0.0693 ps=0.75 w=0.42 l=0.15
X1131 a_59867_34646# a_59685_34646# VDPWR VDPWR sky130_fd_pr__pfet_01v8_hvt ad=0.0441 pd=0.63 as=0.0693 ps=0.75 w=0.42 l=0.15
X1132 a_38649_43023# a_38483_43023# VDPWR VDPWR sky130_fd_pr__pfet_01v8_hvt ad=0.135 pd=1.27 as=0.135 ps=1.27 w=1 l=0.15
X1133 a_53815_39759# a_53369_39759# a_53719_39759# uio_oe[0] sky130_fd_pr__special_nfet_01v8 ad=0.1401 pd=1.1 as=0.0594 ps=0.69 w=0.36 l=0.15
X1134 a_58772_35559# a_38771_35409# a_58914_35734# VDPWR sky130_fd_pr__pfet_01v8_hvt ad=0.1932 pd=1.34 as=0.07665 ps=0.785 w=0.42 l=0.15
X1135 uio_oe[0] a_39544_38823# a_21068_33881# uio_oe[0] sky130_fd_pr__nfet_01v8 ad=0.11285 pd=1.045 as=0.169 ps=1.82 w=0.65 l=0.15
X1136 a_42467_42650# a_43419_42997# uio_oe[0] uio_oe[0] sky130_fd_pr__nfet_01v8 ad=0.169 pd=1.82 as=0.2087 ps=2.02 w=0.65 l=0.15
X1137 a_46761_43265# a_46543_43023# uio_oe[0] uio_oe[0] sky130_fd_pr__nfet_01v8 ad=0.0999 pd=0.985 as=0.1346 ps=1.15 w=0.64 l=0.15
X1138 uio_oe[0] a_48125_41935# a_61341_40847# uio_oe[0] sky130_fd_pr__nfet_01v8 ad=0.1346 pd=1.15 as=0.0441 ps=0.63 w=0.42 l=0.15
X1139 a_44287_39215# a_44327_39447# uio_oe[0] uio_oe[0] sky130_fd_pr__nfet_01v8 ad=0.08775 pd=0.92 as=0.169 ps=1.82 w=0.65 l=0.15
X1140 uio_oe[0] a_38543_36183# a_28980_36681# uio_oe[0] sky130_fd_pr__nfet_01v8 ad=0.1118 pd=1.04 as=0.182 ps=1.86 w=0.65 l=0.15
X1141 a_21431_34056# a_21180_33703# a_20972_33881# VDPWR sky130_fd_pr__pfet_01v8_hvt ad=0.0441 pd=0.63 as=0.1932 ps=1.34 w=0.42 l=0.15
X1142 uio_oe[0] a_30233_34571# a_30167_34639# uio_oe[0] sky130_fd_pr__nfet_01v8 ad=0.1449 pd=1.11 as=0.0693 ps=0.75 w=0.42 l=0.15
X1143 a_17655_35727# a_17507_33198# a_17292_35593# uio_oe[0] sky130_fd_pr__nfet_01v8 ad=0.0693 pd=0.75 as=0.09975 ps=0.895 w=0.42 l=0.15
X1144 uio_oe[0] a_17537_33703# a_17471_33729# uio_oe[0] sky130_fd_pr__nfet_01v8 ad=0.1449 pd=1.11 as=0.0693 ps=0.75 w=0.42 l=0.15
X1145 uio_oe[0] a_61808_41623# a_61242_41621# uio_oe[0] sky130_fd_pr__nfet_01v8 ad=0.11285 pd=1.045 as=0.169 ps=1.82 w=0.65 l=0.15
X1146 a_45443_38823# a_36447_40849# VDPWR VDPWR sky130_fd_pr__pfet_01v8_hvt ad=0.0567 pd=0.69 as=0.16655 ps=1.39 w=0.42 l=0.15
X1147 uio_oe[0] a_18212_36681# a_17316_36967# uio_oe[0] sky130_fd_pr__nfet_01v8 ad=0.11285 pd=1.045 as=0.169 ps=1.82 w=0.65 l=0.15
X1148 a_29738_20730# ua[0] a_29610_22020# uio_oe[0] sky130_fd_pr__nfet_01v8 ad=0.2436 pd=2.26 as=0.2436 ps=2.26 w=0.84 l=0.6
X1149 uio_oe[0] a_54693_35161# a_54627_35229# uio_oe[0] sky130_fd_pr__nfet_01v8 ad=0.1449 pd=1.11 as=0.0693 ps=0.75 w=0.42 l=0.15
X1150 uio_oe[0] a_37361_41391# a_52325_36822# uio_oe[0] sky130_fd_pr__nfet_01v8 ad=0.1449 pd=1.11 as=0.1092 ps=1.36 w=0.42 l=0.15
X1151 a_18011_35933# a_17059_35905# VDPWR VDPWR sky130_fd_pr__pfet_01v8_hvt ad=0.0567 pd=0.69 as=0.1176 ps=1.4 w=0.42 l=0.15
X1152 a_46639_43023# a_46193_43023# a_46543_43023# uio_oe[0] sky130_fd_pr__special_nfet_01v8 ad=0.1401 pd=1.1 as=0.0594 ps=0.69 w=0.36 l=0.15
X1153 a_52335_42453# a_52538_42611# VDPWR VDPWR sky130_fd_pr__pfet_01v8_hvt ad=0.0567 pd=0.69 as=0.1134 ps=1.38 w=0.42 l=0.15
X1154 uio_oe[0] a_40379_35551# a_40705_39581# uio_oe[0] sky130_fd_pr__nfet_01v8 ad=0.12495 pd=1.015 as=0.06405 ps=0.725 w=0.42 l=0.15
X1155 a_51775_38671# a_39752_38645# a_51412_38823# uio_oe[0] sky130_fd_pr__nfet_01v8 ad=0.0693 pd=0.75 as=0.09975 ps=0.895 w=0.42 l=0.15
X1156 VDPWR a_46193_39759# a_60516_38127# VDPWR sky130_fd_pr__pfet_01v8_hvt ad=0.07035 pd=0.755 as=0.1092 ps=1.36 w=0.42 l=0.15
X1157 a_49686_42611# a_50003_42721# a_49961_42845# uio_oe[0] sky130_fd_pr__special_nfet_01v8 ad=0.0711 pd=0.755 as=0.0669 ps=0.75 w=0.36 l=0.15
X1158 a_60542_39581# a_60500_39189# a_59956_39189# uio_oe[0] sky130_fd_pr__nfet_01v8 ad=0.0441 pd=0.63 as=0.0693 ps=0.75 w=0.42 l=0.15
X1159 a_17292_35593# a_17507_33198# a_17434_35400# VDPWR sky130_fd_pr__pfet_01v8_hvt ad=0.1932 pd=1.34 as=0.07665 ps=0.785 w=0.42 l=0.15
X1160 VDPWR a_29129_33703# a_29159_34056# VDPWR sky130_fd_pr__pfet_01v8_hvt ad=0.0693 pd=0.75 as=0.0441 ps=0.63 w=0.42 l=0.15
X1161 VDPWR a_50003_35105# a_49964_34979# VDPWR sky130_fd_pr__pfet_01v8_hvt ad=0.0864 pd=0.91 as=0.1664 ps=1.8 w=0.64 l=0.15
X1162 VDPWR a_36661_41391# a_60153_42262# VDPWR sky130_fd_pr__pfet_01v8_hvt ad=0.15835 pd=1.395 as=0.07665 ps=0.785 w=0.42 l=0.15
X1163 VDPWR a_40893_40821# a_40923_41174# VDPWR sky130_fd_pr__pfet_01v8_hvt ad=0.0693 pd=0.75 as=0.0441 ps=0.63 w=0.42 l=0.15
X1164 a_62053_38425# a_37361_41391# uio_oe[0] uio_oe[0] sky130_fd_pr__nfet_01v8 ad=0.1092 pd=1.36 as=0.1449 ps=1.11 w=0.42 l=0.15
X1165 uio_oe[0] a_29313_33483# a_29247_33551# uio_oe[0] sky130_fd_pr__nfet_01v8 ad=0.1449 pd=1.11 as=0.0693 ps=0.75 w=0.42 l=0.15
X1166 uio_oe[0] a_51412_38823# a_50784_38920# uio_oe[0] sky130_fd_pr__nfet_01v8 ad=0.11285 pd=1.045 as=0.169 ps=1.82 w=0.65 l=0.15
X1167 uio_oe[0] a_59695_35925# a_54479_35964# uio_oe[0] sky130_fd_pr__nfet_01v8 ad=0.2087 pd=2.02 as=0.169 ps=1.82 w=0.65 l=0.15
X1168 a_59898_36083# a_60215_36193# a_60173_36317# uio_oe[0] sky130_fd_pr__special_nfet_01v8 ad=0.0711 pd=0.755 as=0.0669 ps=0.75 w=0.36 l=0.15
X1169 a_57363_42077# a_38649_43023# VDPWR VDPWR sky130_fd_pr__pfet_01v8_hvt ad=0.1664 pd=1.8 as=0.0864 ps=0.91 w=0.64 l=0.15
X1170 a_42919_38369# a_38005_41391# uio_oe[0] uio_oe[0] sky130_fd_pr__nfet_01v8 ad=0.1092 pd=1.36 as=0.0567 ps=0.69 w=0.42 l=0.15
X1171 a_18097_37021# a_17059_36993# a_18011_37021# uio_oe[0] sky130_fd_pr__nfet_01v8 ad=0.0567 pd=0.69 as=0.1176 ps=1.4 w=0.42 l=0.15
X1172 a_25295_36232# a_25044_35879# a_24836_36057# VDPWR sky130_fd_pr__pfet_01v8_hvt ad=0.0441 pd=0.63 as=0.1932 ps=1.34 w=0.42 l=0.15
X1173 uio_oe[0] a_40967_41391# a_41706_38127# uio_oe[0] sky130_fd_pr__nfet_01v8 ad=0.2205 pd=1.89 as=0.066 ps=0.745 w=0.42 l=0.15
X1174 a_42787_42301# a_39947_42997# VDPWR VDPWR sky130_fd_pr__pfet_01v8_hvt ad=0.1092 pd=1.36 as=0.07035 ps=0.755 w=0.42 l=0.15
X1175 uio_oe[0] a_36661_41391# a_59685_40086# uio_oe[0] sky130_fd_pr__nfet_01v8 ad=0.1449 pd=1.11 as=0.1092 ps=1.36 w=0.42 l=0.15
X1176 a_61819_34293# a_61644_34319# a_61998_34319# uio_oe[0] sky130_fd_pr__nfet_01v8 ad=0.1092 pd=1.36 as=0.06405 ps=0.725 w=0.42 l=0.15
X1177 a_46639_42857# a_46193_42485# a_46543_42857# uio_oe[0] sky130_fd_pr__special_nfet_01v8 ad=0.1401 pd=1.1 as=0.0594 ps=0.69 w=0.36 l=0.15
X1178 a_42941_40669# a_42897_40277# a_42775_40681# uio_oe[0] sky130_fd_pr__nfet_01v8 ad=0.0441 pd=0.63 as=0.1401 ps=1.1 w=0.42 l=0.15
X1179 VDPWR a_17059_35905# a_18531_36271# VDPWR sky130_fd_pr__pfet_01v8_hvt ad=0.0714 pd=0.76 as=0.1092 ps=1.36 w=0.42 l=0.15
X1180 a_18354_33224# a_17388_33417# VDPWR VDPWR sky130_fd_pr__pfet_01v8_hvt ad=0.07665 pd=0.785 as=0.15835 ps=1.395 w=0.42 l=0.15
X1181 VDPWR a_44829_40277# a_44719_40303# VDPWR sky130_fd_pr__pfet_01v8_hvt ad=0.07035 pd=0.755 as=0.1155 ps=0.97 w=0.42 l=0.15
X1182 VDPWR a_37433_35665# a_37839_35951# VDPWR sky130_fd_pr__pfet_01v8_hvt ad=0.0714 pd=0.76 as=0.1092 ps=1.36 w=0.42 l=0.15
X1183 VDPWR a_57472_35141# a_57556_34837# VDPWR sky130_fd_pr__pfet_01v8_hvt ad=0.0864 pd=0.91 as=0.1664 ps=1.8 w=0.64 l=0.15
X1184 a_46651_43389# a_40379_35551# VDPWR VDPWR sky130_fd_pr__pfet_01v8_hvt ad=0.1092 pd=1.36 as=0.07035 ps=0.755 w=0.42 l=0.15
X1185 VDPWR a_50784_35925# a_50722_35951# VDPWR sky130_fd_pr__pfet_01v8_hvt ad=0.1092 pd=1.36 as=0.0651 ps=0.73 w=0.42 l=0.15
X1186 uio_oe[0] a_53011_35925# a_52942_35951# uio_oe[0] sky130_fd_pr__nfet_01v8 ad=0.1346 pd=1.15 as=0.0999 ps=0.985 w=0.64 l=0.15
X1187 a_26170_18464# a_25876_18376# ua[4] uio_oe[0] sky130_fd_pr__nfet_01v8 ad=0.1885 pd=1.88 as=0.1885 ps=1.88 w=0.65 l=0.15
X1188 ua[4] a_28348_10376# a_29610_26020# uio_oe[0] sky130_fd_pr__nfet_01v8 ad=0.1885 pd=1.88 as=0.1885 ps=1.88 w=0.65 l=0.15
X1189 a_60729_41935# a_60563_41935# VDPWR VDPWR sky130_fd_pr__pfet_01v8_hvt ad=0.1664 pd=1.8 as=0.0864 ps=0.91 w=0.64 l=0.15
X1190 a_37566_39215# a_36847_39457# a_37003_39189# uio_oe[0] sky130_fd_pr__special_nfet_01v8 ad=0.066 pd=0.745 as=0.0594 ps=0.69 w=0.36 l=0.15
X1191 a_40459_34319# a_38285_36495# a_40096_34471# uio_oe[0] sky130_fd_pr__nfet_01v8 ad=0.0693 pd=0.75 as=0.09975 ps=0.895 w=0.42 l=0.15
X1192 a_44873_41757# a_44829_41365# a_44707_41769# uio_oe[0] sky130_fd_pr__nfet_01v8 ad=0.0441 pd=0.63 as=0.1401 ps=1.1 w=0.42 l=0.15
X1193 a_18442_22464# a_16756_10782# ua[4] uio_oe[0] sky130_fd_pr__nfet_01v8 ad=0.1885 pd=1.88 as=0.1885 ps=1.88 w=0.65 l=0.15
X1194 uio_oe[0] a_38005_41391# a_40415_38671# uio_oe[0] sky130_fd_pr__nfet_01v8 ad=0.0567 pd=0.69 as=0.1092 ps=1.36 w=0.42 l=0.15
X1195 a_49686_36747# a_50003_36637# a_49961_36495# uio_oe[0] sky130_fd_pr__special_nfet_01v8 ad=0.0711 pd=0.755 as=0.0669 ps=0.75 w=0.36 l=0.15
X1196 VDPWR a_37361_41391# a_52793_35734# VDPWR sky130_fd_pr__pfet_01v8_hvt ad=0.15835 pd=1.395 as=0.07665 ps=0.785 w=0.42 l=0.15
X1197 a_36327_34837# a_36425_35078# VDPWR VDPWR sky130_fd_pr__pfet_01v8_hvt ad=0.0609 pd=0.71 as=0.2279 ps=1.74 w=0.42 l=0.15
X1198 a_28348_18376# a_30303_35183# VDPWR VDPWR sky130_fd_pr__pfet_01v8_hvt ad=0.26 pd=2.52 as=0.2279 ps=1.74 w=1 l=0.15
X1199 a_54638_35407# a_46193_39759# uio_oe[0] uio_oe[0] sky130_fd_pr__nfet_01v8 ad=0.06405 pd=0.725 as=0.12495 ps=1.015 w=0.42 l=0.15
X1200 a_44060_36745# a_37452_34293# VDPWR VDPWR sky130_fd_pr__pfet_01v8_hvt ad=0.0441 pd=0.63 as=0.14575 ps=1.335 w=0.42 l=0.15
X1201 a_50090_35773# a_50003_35549# a_49686_35659# VDPWR sky130_fd_pr__pfet_01v8_hvt ad=0.12915 pd=1.185 as=0.0588 ps=0.7 w=0.42 l=0.15
X1202 a_38080_38493# a_37829_38140# a_37859_38166# uio_oe[0] sky130_fd_pr__nfet_01v8 ad=0.0693 pd=0.75 as=0.09975 ps=0.895 w=0.42 l=0.15
X1203 VDPWR a_24836_37145# a_24787_36993# VDPWR sky130_fd_pr__pfet_01v8_hvt ad=0.15835 pd=1.395 as=0.26 ps=2.52 w=1 l=0.15
X1204 a_26170_18464# a_4259_22596# a_25874_16730# uio_oe[0] sky130_fd_pr__nfet_01v8 ad=0.2436 pd=2.26 as=0.2436 ps=2.26 w=0.84 l=0.6
X1205 a_46805_42845# a_46761_42453# a_46639_42857# uio_oe[0] sky130_fd_pr__nfet_01v8 ad=0.0441 pd=0.63 as=0.1401 ps=1.1 w=0.42 l=0.15
X1206 a_41445_41689# a_38285_34863# VDPWR VDPWR sky130_fd_pr__pfet_01v8_hvt ad=0.1176 pd=1.4 as=0.0693 ps=0.75 w=0.42 l=0.15
X1207 a_41119_37583# a_40673_37583# a_41023_37583# uio_oe[0] sky130_fd_pr__special_nfet_01v8 ad=0.1401 pd=1.1 as=0.0594 ps=0.69 w=0.36 l=0.15
X1208 a_21401_33703# a_21068_33881# uio_oe[0] uio_oe[0] sky130_fd_pr__nfet_01v8 ad=0.1092 pd=1.36 as=0.1449 ps=1.11 w=0.42 l=0.15
X1209 a_52942_42479# a_52855_42721# a_52538_42611# VDPWR sky130_fd_pr__pfet_01v8_hvt ad=0.12915 pd=1.185 as=0.0588 ps=0.7 w=0.42 l=0.15
X1210 VDPWR a_40379_35551# a_40467_38101# VDPWR sky130_fd_pr__pfet_01v8_hvt ad=0.0819 pd=0.81 as=0.0567 ps=0.69 w=0.42 l=0.15
X1211 a_29603_33757# a_28651_33729# VDPWR VDPWR sky130_fd_pr__pfet_01v8_hvt ad=0.0567 pd=0.69 as=0.1176 ps=1.4 w=0.42 l=0.15
X1212 uio_oe[0] a_29804_34505# a_28908_34791# uio_oe[0] sky130_fd_pr__nfet_01v8 ad=0.11285 pd=1.045 as=0.169 ps=1.82 w=0.65 l=0.15
X1213 a_60984_35407# a_60365_35407# uio_oe[0] uio_oe[0] sky130_fd_pr__nfet_01v8 ad=0.066 pd=0.745 as=0.2205 ps=1.89 w=0.42 l=0.15
X1214 a_42787_40303# a_42163_40309# a_42679_40681# VDPWR sky130_fd_pr__pfet_01v8_hvt ad=0.1155 pd=0.97 as=0.07245 ps=0.765 w=0.42 l=0.15
X1215 a_18442_22464# a_4259_22596# a_18146_20730# uio_oe[0] sky130_fd_pr__nfet_01v8 ad=0.2436 pd=2.26 as=0.2436 ps=2.26 w=0.84 l=0.6
X1216 a_24778_18464# a_24484_18782# ua[5] uio_oe[0] sky130_fd_pr__nfet_01v8 ad=0.1885 pd=1.88 as=0.1885 ps=1.88 w=0.65 l=0.15
X1217 uio_oe[0] a_37361_41391# a_52800_35407# uio_oe[0] sky130_fd_pr__nfet_01v8 ad=0.11285 pd=1.045 as=0.0693 ps=0.75 w=0.42 l=0.15
X1218 a_53815_38671# a_53369_38671# a_53719_38671# uio_oe[0] sky130_fd_pr__special_nfet_01v8 ad=0.1401 pd=1.1 as=0.0594 ps=0.69 w=0.36 l=0.15
X1219 a_46651_43389# a_46027_43023# a_46543_43023# VDPWR sky130_fd_pr__pfet_01v8_hvt ad=0.1155 pd=0.97 as=0.07245 ps=0.765 w=0.42 l=0.15
X1220 uio_oe[0] a_37029_42479# a_42163_42485# uio_oe[0] sky130_fd_pr__nfet_01v8 ad=0.0567 pd=0.69 as=0.1092 ps=1.36 w=0.42 l=0.15
X1221 a_59231_40086# a_58980_39733# a_58772_39911# VDPWR sky130_fd_pr__pfet_01v8_hvt ad=0.0441 pd=0.63 as=0.1932 ps=1.34 w=0.42 l=0.15
X1222 uio_oe[0] a_37452_34293# a_37328_34569# uio_oe[0] sky130_fd_pr__nfet_01v8 ad=0.10025 pd=0.985 as=0.0567 ps=0.69 w=0.42 l=0.15
X1223 a_29343_34312# a_17500_33453# a_28884_34505# VDPWR sky130_fd_pr__pfet_01v8_hvt ad=0.0441 pd=0.63 as=0.1932 ps=1.34 w=0.42 l=0.15
X1224 uio_oe[0] a_36585_40847# a_37566_39215# uio_oe[0] sky130_fd_pr__nfet_01v8 ad=0.2205 pd=1.89 as=0.066 ps=0.745 w=0.42 l=0.15
X1225 VDPWR a_38771_35967# a_38543_36183# VDPWR sky130_fd_pr__pfet_01v8_hvt ad=0.1176 pd=1.4 as=0.0567 ps=0.69 w=0.42 l=0.15
X1226 a_51871_35734# a_51620_35381# a_51412_35559# VDPWR sky130_fd_pr__pfet_01v8_hvt ad=0.0441 pd=0.63 as=0.1932 ps=1.34 w=0.42 l=0.15
X1227 uio_oe[0] a_30233_33483# a_30167_33551# uio_oe[0] sky130_fd_pr__nfet_01v8 ad=0.1449 pd=1.11 as=0.0693 ps=0.75 w=0.42 l=0.15
X1228 a_51841_34293# a_48677_38127# VDPWR VDPWR sky130_fd_pr__pfet_01v8_hvt ad=0.1176 pd=1.4 as=0.0693 ps=0.75 w=0.42 l=0.15
X1229 a_25940_34505# a_18420_33453# a_26082_34639# uio_oe[0] sky130_fd_pr__nfet_01v8 ad=0.09975 pd=0.895 as=0.0693 ps=0.75 w=0.42 l=0.15
X1230 uio_oe[0] a_21156_34505# a_21107_34273# uio_oe[0] sky130_fd_pr__nfet_01v8 ad=0.11285 pd=1.045 as=0.169 ps=1.82 w=0.65 l=0.15
X1231 a_59201_40601# a_48677_39759# VDPWR VDPWR sky130_fd_pr__pfet_01v8_hvt ad=0.1176 pd=1.4 as=0.0693 ps=0.75 w=0.42 l=0.15
X1232 a_40536_35773# a_40099_35381# VDPWR VDPWR sky130_fd_pr__pfet_01v8_hvt ad=0.0567 pd=0.69 as=0.0819 ps=0.81 w=0.42 l=0.15
X1233 VDPWR a_54693_35161# a_54723_34902# VDPWR sky130_fd_pr__pfet_01v8_hvt ad=0.0693 pd=0.75 as=0.0441 ps=0.63 w=0.42 l=0.15
X1234 VDPWR a_62237_39513# a_62267_39254# VDPWR sky130_fd_pr__pfet_01v8_hvt ad=0.0693 pd=0.75 as=0.0441 ps=0.63 w=0.42 l=0.15
X1235 uio_oe[0] a_18212_35593# a_17316_35879# uio_oe[0] sky130_fd_pr__nfet_01v8 ad=0.11285 pd=1.045 as=0.169 ps=1.82 w=0.65 l=0.15
X1236 a_18011_34845# a_17059_34817# VDPWR VDPWR sky130_fd_pr__pfet_01v8_hvt ad=0.0567 pd=0.69 as=0.1176 ps=1.4 w=0.42 l=0.15
X1237 uio_oe[0] a_36999_37013# a_37029_37039# uio_oe[0] sky130_fd_pr__nfet_01v8 ad=0.08775 pd=0.92 as=0.08775 ps=0.92 w=0.65 l=0.15
X1238 a_52335_41365# a_52538_41523# VDPWR VDPWR sky130_fd_pr__pfet_01v8_hvt ad=0.0567 pd=0.69 as=0.1134 ps=1.38 w=0.42 l=0.15
X1239 uio_oe[0] a_28700_37145# a_28651_36993# uio_oe[0] sky130_fd_pr__nfet_01v8 ad=0.11285 pd=1.045 as=0.169 ps=1.82 w=0.65 l=0.15
X1240 uio_oe[0] a_25020_33417# a_24971_33185# uio_oe[0] sky130_fd_pr__nfet_01v8 ad=0.11285 pd=1.045 as=0.169 ps=1.82 w=0.65 l=0.15
X1241 a_39905_43023# a_39861_43265# a_39739_43023# uio_oe[0] sky130_fd_pr__nfet_01v8 ad=0.0441 pd=0.63 as=0.1401 ps=1.1 w=0.42 l=0.15
X1242 a_57519_38101# a_57363_38369# a_57664_38127# VDPWR sky130_fd_pr__pfet_01v8_hvt ad=0.07245 pd=0.765 as=0.1155 ps=0.97 w=0.42 l=0.15
X1243 VDPWR a_56843_35381# a_38771_35409# VDPWR sky130_fd_pr__pfet_01v8_hvt ad=0.3012 pd=2.66 as=0.26 ps=2.52 w=1 l=0.15
X1244 VDPWR a_37795_40535# a_40639_42087# VDPWR sky130_fd_pr__pfet_01v8_hvt ad=0.1092 pd=1.36 as=0.1176 ps=1.4 w=0.42 l=0.15
X1245 VDPWR a_58144_42184# a_58082_42301# VDPWR sky130_fd_pr__pfet_01v8_hvt ad=0.1092 pd=1.36 as=0.0651 ps=0.73 w=0.42 l=0.15
X1246 a_51841_34293# a_48677_38127# uio_oe[0] uio_oe[0] sky130_fd_pr__nfet_01v8 ad=0.1092 pd=1.36 as=0.1449 ps=1.11 w=0.42 l=0.15
X1247 uio_oe[0] a_51841_35381# a_51775_35407# uio_oe[0] sky130_fd_pr__nfet_01v8 ad=0.1449 pd=1.11 as=0.0693 ps=0.75 w=0.42 l=0.15
X1248 a_47283_41909# a_47108_41935# a_47462_41935# uio_oe[0] sky130_fd_pr__nfet_01v8 ad=0.1092 pd=1.36 as=0.06405 ps=0.725 w=0.42 l=0.15
X1249 a_57363_40545# a_38649_43023# VDPWR VDPWR sky130_fd_pr__pfet_01v8_hvt ad=0.1664 pd=1.8 as=0.0864 ps=0.91 w=0.64 l=0.15
X1250 a_38674_36822# a_37029_37583# VDPWR VDPWR sky130_fd_pr__pfet_01v8_hvt ad=0.07665 pd=0.785 as=0.15835 ps=1.395 w=0.42 l=0.15
X1251 uio_oe[0] a_36447_40849# a_38109_36317# uio_oe[0] sky130_fd_pr__nfet_01v8 ad=0.1013 pd=0.99 as=0.0504 ps=0.66 w=0.42 l=0.15
X1252 a_19834_14464# a_16756_14376# ua[4] uio_oe[0] sky130_fd_pr__nfet_01v8 ad=0.1885 pd=1.88 as=0.1885 ps=1.88 w=0.65 l=0.15
X1253 a_39686_42845# a_37029_38127# uio_oe[0] uio_oe[0] sky130_fd_pr__nfet_01v8 ad=0.0693 pd=0.75 as=0.11285 ps=1.045 w=0.42 l=0.15
X1254 a_18212_33417# a_18427_33198# a_18354_33224# VDPWR sky130_fd_pr__pfet_01v8_hvt ad=0.1932 pd=1.34 as=0.07665 ps=0.785 w=0.42 l=0.15
X1255 VDPWR a_38285_34863# a_40917_40342# VDPWR sky130_fd_pr__pfet_01v8_hvt ad=0.0693 pd=0.75 as=0.1176 ps=1.4 w=0.42 l=0.15
X1256 a_43428_39759# a_42513_39759# a_43081_40001# uio_oe[0] sky130_fd_pr__special_nfet_01v8 ad=0.0711 pd=0.755 as=0.0999 ps=0.985 w=0.36 l=0.15
X1257 VDPWR a_60584_35177# a_60638_34863# VDPWR sky130_fd_pr__pfet_01v8_hvt ad=0.0567 pd=0.69 as=0.0483 ps=0.65 w=0.42 l=0.15
X1258 VDPWR a_48125_43023# a_57776_39581# VDPWR sky130_fd_pr__pfet_01v8_hvt ad=0.0798 pd=0.8 as=0.0567 ps=0.69 w=0.42 l=0.15
X1259 VDPWR a_38961_37337# a_38991_37078# VDPWR sky130_fd_pr__pfet_01v8_hvt ad=0.0693 pd=0.75 as=0.0441 ps=0.63 w=0.42 l=0.15
X1260 VDPWR a_58772_36647# a_58144_36744# VDPWR sky130_fd_pr__pfet_01v8_hvt ad=0.15835 pd=1.395 as=0.26 ps=2.52 w=1 l=0.15
X1261 a_61808_41623# a_54479_41404# a_61950_41757# uio_oe[0] sky130_fd_pr__nfet_01v8 ad=0.09975 pd=0.895 as=0.0693 ps=0.75 w=0.42 l=0.15
X1262 uio_oe[0] a_36661_41391# a_59685_38998# uio_oe[0] sky130_fd_pr__nfet_01v8 ad=0.1449 pd=1.11 as=0.1092 ps=1.36 w=0.42 l=0.15
X1263 a_62237_35161# a_37361_41391# uio_oe[0] uio_oe[0] sky130_fd_pr__nfet_01v8 ad=0.1092 pd=1.36 as=0.1449 ps=1.11 w=0.42 l=0.15
X1264 VDPWR a_36607_39455# a_36327_39189# VDPWR sky130_fd_pr__pfet_01v8_hvt ad=0.0819 pd=0.81 as=0.0567 ps=0.69 w=0.42 l=0.15
X1265 a_38895_37405# a_37851_36647# a_38532_37271# uio_oe[0] sky130_fd_pr__nfet_01v8 ad=0.0693 pd=0.75 as=0.09975 ps=0.895 w=0.42 l=0.15
X1266 a_56843_35925# a_57046_36083# VDPWR VDPWR sky130_fd_pr__pfet_01v8_hvt ad=0.0567 pd=0.69 as=0.1134 ps=1.38 w=0.42 l=0.15
X1267 uio_oe[0] a_16812_8642# a_20618_24730# uio_oe[0] sky130_fd_pr__nfet_01v8 ad=1.4703 pd=10.72 as=1.4703 ps=10.72 w=5.07 l=1
X1268 a_29129_33703# a_28796_33881# VDPWR VDPWR sky130_fd_pr__pfet_01v8_hvt ad=0.1176 pd=1.4 as=0.0693 ps=0.75 w=0.42 l=0.15
X1269 uio_oe[0] a_38961_42777# a_38895_42845# uio_oe[0] sky130_fd_pr__nfet_01v8 ad=0.1449 pd=1.11 as=0.0693 ps=0.75 w=0.42 l=0.15
X1270 a_38961_41689# a_38005_40847# uio_oe[0] uio_oe[0] sky130_fd_pr__nfet_01v8 ad=0.1092 pd=1.36 as=0.1449 ps=1.11 w=0.42 l=0.15
X1271 a_60984_39759# a_60365_39759# VDPWR VDPWR sky130_fd_pr__pfet_01v8_hvt ad=0.0651 pd=0.73 as=0.1092 ps=1.36 w=0.42 l=0.15
X1272 a_50397_37583# a_44905_38671# uio_oe[0] uio_oe[0] sky130_fd_pr__nfet_01v8 ad=0.0441 pd=0.63 as=0.1346 ps=1.15 w=0.42 l=0.15
X1273 a_57321_37583# a_56843_37557# uio_oe[0] uio_oe[0] sky130_fd_pr__nfet_01v8 ad=0.0669 pd=0.75 as=0.12495 ps=1.015 w=0.42 l=0.15
X1274 a_19834_14464# ua[3] a_19588_14020# uio_oe[0] sky130_fd_pr__nfet_01v8 ad=0.2436 pd=2.26 as=0.2436 ps=2.26 w=0.84 l=0.6
X1275 a_60365_37583# a_59939_37910# VDPWR VDPWR sky130_fd_pr__pfet_01v8_hvt ad=0.26 pd=2.52 as=0.15835 ps=1.395 w=1 l=0.15
X1276 ua[4] a_16756_10782# a_19410_10020# uio_oe[0] sky130_fd_pr__nfet_01v8 ad=0.1885 pd=1.88 as=0.1885 ps=1.88 w=0.65 l=0.15
X1277 a_38532_42087# a_38740_41909# a_38674_41935# uio_oe[0] sky130_fd_pr__nfet_01v8 ad=0.09975 pd=0.895 as=0.0693 ps=0.75 w=0.42 l=0.15
X1278 uio_oe[0] a_40379_35551# a_40705_39759# uio_oe[0] sky130_fd_pr__nfet_01v8 ad=0.12495 pd=1.015 as=0.06405 ps=0.725 w=0.42 l=0.15
X1279 VDPWR a_41231_42997# a_39947_42997# VDPWR sky130_fd_pr__pfet_01v8_hvt ad=0.135 pd=1.27 as=0.135 ps=1.27 w=1 l=0.15
X1280 a_51554_42845# a_48677_39759# uio_oe[0] uio_oe[0] sky130_fd_pr__nfet_01v8 ad=0.0693 pd=0.75 as=0.11285 ps=1.045 w=0.42 l=0.15
X1281 a_46289_39447# a_44621_39535# a_46452_39331# VDPWR sky130_fd_pr__pfet_01v8_hvt ad=0.1092 pd=1.36 as=0.0441 ps=0.63 w=0.42 l=0.15
X1282 a_38285_34863# a_38019_34863# VDPWR VDPWR sky130_fd_pr__pfet_01v8_hvt ad=0.26 pd=2.52 as=0.2279 ps=1.74 w=1 l=0.15
X1283 a_59135_38493# a_39752_38395# a_58772_38359# uio_oe[0] sky130_fd_pr__nfet_01v8 ad=0.0693 pd=0.75 as=0.09975 ps=0.895 w=0.42 l=0.15
X1284 uio_oe[0] a_56843_34293# a_38651_34471# uio_oe[0] sky130_fd_pr__nfet_01v8 ad=0.2087 pd=2.02 as=0.169 ps=1.82 w=0.65 l=0.15
X1285 a_58980_38645# a_61819_38645# VDPWR VDPWR sky130_fd_pr__pfet_01v8_hvt ad=0.26 pd=2.52 as=0.3012 ps=2.66 w=1 l=0.15
X1286 uio_oe[0] a_43837_37557# a_43771_37583# uio_oe[0] sky130_fd_pr__nfet_01v8 ad=0.1449 pd=1.11 as=0.0693 ps=0.75 w=0.42 l=0.15
X1287 ua[5] a_24484_10376# a_25746_14020# uio_oe[0] sky130_fd_pr__nfet_01v8 ad=0.1885 pd=1.88 as=0.1885 ps=1.88 w=0.65 l=0.15
X1288 a_30263_34312# a_18420_33453# a_29804_34505# VDPWR sky130_fd_pr__pfet_01v8_hvt ad=0.0441 pd=0.63 as=0.1932 ps=1.34 w=0.42 l=0.15
X1289 a_58082_41213# a_57363_40989# a_57519_41084# uio_oe[0] sky130_fd_pr__special_nfet_01v8 ad=0.066 pd=0.745 as=0.0594 ps=0.69 w=0.36 l=0.15
X1290 a_38109_36317# a_37839_35951# a_38019_35951# uio_oe[0] sky130_fd_pr__nfet_01v8 ad=0.0504 pd=0.66 as=0.1092 ps=1.36 w=0.42 l=0.15
X1291 a_50159_35644# a_49964_35675# a_50469_35407# uio_oe[0] sky130_fd_pr__special_nfet_01v8 ad=0.0594 pd=0.69 as=0.1401 ps=1.1 w=0.36 l=0.15
X1292 a_60215_42721# a_37913_43023# uio_oe[0] uio_oe[0] sky130_fd_pr__nfet_01v8 ad=0.1092 pd=1.36 as=0.0567 ps=0.69 w=0.42 l=0.15
X1293 uio_oe[0] a_39947_42997# a_42941_40847# uio_oe[0] sky130_fd_pr__nfet_01v8 ad=0.1346 pd=1.15 as=0.0441 ps=0.63 w=0.42 l=0.15
X1294 VDPWR a_39973_39733# a_40003_40086# VDPWR sky130_fd_pr__pfet_01v8_hvt ad=0.0693 pd=0.75 as=0.0441 ps=0.63 w=0.42 l=0.15
X1295 a_61766_36317# a_37361_41391# uio_oe[0] uio_oe[0] sky130_fd_pr__nfet_01v8 ad=0.0693 pd=0.75 as=0.11285 ps=1.045 w=0.42 l=0.15
X1296 a_19834_26464# a_16756_10376# ua[5] uio_oe[0] sky130_fd_pr__nfet_01v8 ad=0.1885 pd=1.88 as=0.1885 ps=1.88 w=0.65 l=0.15
X1297 a_53574_42479# a_52816_42595# a_53011_42453# VDPWR sky130_fd_pr__pfet_01v8_hvt ad=0.0651 pd=0.73 as=0.07245 ps=0.765 w=0.42 l=0.15
X1298 a_50722_41213# a_50003_40989# a_50159_41084# uio_oe[0] sky130_fd_pr__special_nfet_01v8 ad=0.066 pd=0.745 as=0.0594 ps=0.69 w=0.36 l=0.15
X1299 uio_oe[0] a_58772_35559# a_58144_35656# uio_oe[0] sky130_fd_pr__nfet_01v8 ad=0.11285 pd=1.045 as=0.169 ps=1.82 w=0.65 l=0.15
X1300 a_46448_41935# ui_in[4] VDPWR VDPWR sky130_fd_pr__pfet_01v8_hvt ad=0.0651 pd=0.73 as=0.1092 ps=1.36 w=0.42 l=0.15
X1301 a_52942_41391# a_52855_41633# a_52538_41523# VDPWR sky130_fd_pr__pfet_01v8_hvt ad=0.12915 pd=1.185 as=0.0588 ps=0.7 w=0.42 l=0.15
X1302 uio_oe[0] a_50003_36637# a_49964_36763# uio_oe[0] sky130_fd_pr__nfet_01v8 ad=0.0567 pd=0.69 as=0.1092 ps=1.36 w=0.42 l=0.15
X1303 a_23698_10464# a_20620_10376# ua[4] uio_oe[0] sky130_fd_pr__nfet_01v8 ad=0.1885 pd=1.88 as=0.1885 ps=1.88 w=0.65 l=0.15
X1304 a_50304_34863# a_50090_34863# VDPWR VDPWR sky130_fd_pr__pfet_01v8_hvt ad=0.1155 pd=0.97 as=0.07035 ps=0.755 w=0.42 l=0.15
X1305 a_61297_35649# a_61079_35407# uio_oe[0] uio_oe[0] sky130_fd_pr__nfet_01v8 ad=0.0999 pd=0.985 as=0.1346 ps=1.15 w=0.64 l=0.15
X1306 a_50469_38493# a_50090_38127# a_50397_38493# uio_oe[0] sky130_fd_pr__nfet_01v8 ad=0.1401 pd=1.1 as=0.0441 ps=0.63 w=0.42 l=0.15
X1307 uio_oe[0] a_53636_35925# a_53574_35951# uio_oe[0] sky130_fd_pr__nfet_01v8 ad=0.2205 pd=1.89 as=0.066 ps=0.745 w=0.42 l=0.15
X1308 uio_oe[0] a_51412_35095# a_50784_34837# uio_oe[0] sky130_fd_pr__nfet_01v8 ad=0.11285 pd=1.045 as=0.169 ps=1.82 w=0.65 l=0.15
X1309 ua[5] a_24484_18782# a_27138_18020# uio_oe[0] sky130_fd_pr__nfet_01v8 ad=0.1885 pd=1.88 as=0.1885 ps=1.88 w=0.65 l=0.15
X1310 a_41231_42997# rst_n VDPWR VDPWR sky130_fd_pr__pfet_01v8_hvt ad=0.26 pd=2.52 as=0.135 ps=1.27 w=1 l=0.15
X1311 a_46543_40847# a_46027_40847# a_46448_40847# uio_oe[0] sky130_fd_pr__special_nfet_01v8 ad=0.0594 pd=0.69 as=0.066 ps=0.745 w=0.36 l=0.15
X1312 a_53624_40847# a_53005_40847# uio_oe[0] uio_oe[0] sky130_fd_pr__nfet_01v8 ad=0.066 pd=0.745 as=0.2205 ps=1.89 w=0.42 l=0.15
X1313 a_41171_40669# a_40917_40342# uio_oe[0] uio_oe[0] sky130_fd_pr__nfet_01v8 ad=0.0693 pd=0.75 as=0.1449 ps=1.11 w=0.42 l=0.15
X1314 uio_oe[0] a_44905_38671# a_57081_37583# uio_oe[0] sky130_fd_pr__nfet_01v8 ad=0.12495 pd=1.015 as=0.06405 ps=0.725 w=0.42 l=0.15
X1315 a_42257_35407# a_37851_36647# a_39759_36777# uio_oe[0] sky130_fd_pr__nfet_01v8 ad=0.08775 pd=0.92 as=0.25025 ps=1.42 w=0.65 l=0.15
X1316 VDPWR a_38961_41909# a_38991_42262# VDPWR sky130_fd_pr__pfet_01v8_hvt ad=0.0693 pd=0.75 as=0.0441 ps=0.63 w=0.42 l=0.15
X1317 uio_oe[0] a_37851_36647# a_37755_40303# uio_oe[0] sky130_fd_pr__nfet_01v8 ad=0.08775 pd=0.92 as=0.08775 ps=0.92 w=0.65 l=0.15
X1318 a_45195_39215# a_45015_39215# VDPWR VDPWR sky130_fd_pr__pfet_01v8_hvt ad=0.0609 pd=0.71 as=0.0714 ps=0.76 w=0.42 l=0.15
X1319 a_37787_38166# a_37605_38166# VDPWR VDPWR sky130_fd_pr__pfet_01v8_hvt ad=0.0441 pd=0.63 as=0.0693 ps=0.75 w=0.42 l=0.15
X1320 VDPWR a_53937_37825# a_53827_37949# VDPWR sky130_fd_pr__pfet_01v8_hvt ad=0.07035 pd=0.755 as=0.1155 ps=0.97 w=0.42 l=0.15
X1321 a_23698_10464# ua[2] a_23452_10020# uio_oe[0] sky130_fd_pr__nfet_01v8 ad=0.2436 pd=2.26 as=0.2436 ps=2.26 w=0.84 l=0.6
X1322 ua[5] a_16756_14782# a_19410_22020# uio_oe[0] sky130_fd_pr__nfet_01v8 ad=0.1885 pd=1.88 as=0.1885 ps=1.88 w=0.65 l=0.15
X1323 a_25940_33417# a_18420_33453# a_26082_33551# uio_oe[0] sky130_fd_pr__nfet_01v8 ad=0.09975 pd=0.895 as=0.0693 ps=0.75 w=0.42 l=0.15
X1324 uio_oe[0] a_46193_39759# a_60802_35229# uio_oe[0] sky130_fd_pr__nfet_01v8 ad=0.0882 pd=0.84 as=0.0441 ps=0.63 w=0.42 l=0.15
X1325 a_61079_41935# a_60729_41935# a_60984_41935# VDPWR sky130_fd_pr__pfet_01v8_hvt ad=0.07245 pd=0.765 as=0.0651 ps=0.73 w=0.42 l=0.15
X1326 uio_oe[0] a_52855_38369# a_52816_38243# uio_oe[0] sky130_fd_pr__nfet_01v8 ad=0.0567 pd=0.69 as=0.1092 ps=1.36 w=0.42 l=0.15
X1327 a_38532_36647# a_37851_36647# a_38674_36822# VDPWR sky130_fd_pr__pfet_01v8_hvt ad=0.1932 pd=1.34 as=0.07665 ps=0.785 w=0.42 l=0.15
X1328 VDPWR a_58144_35656# a_58082_35773# VDPWR sky130_fd_pr__pfet_01v8_hvt ad=0.1092 pd=1.36 as=0.0651 ps=0.73 w=0.42 l=0.15
X1329 a_61808_37271# a_58980_37557# a_61950_37078# VDPWR sky130_fd_pr__pfet_01v8_hvt ad=0.1932 pd=1.34 as=0.07665 ps=0.785 w=0.42 l=0.15
X1330 a_51620_36469# a_54459_36469# VDPWR VDPWR sky130_fd_pr__pfet_01v8_hvt ad=0.26 pd=2.52 as=0.3012 ps=2.66 w=1 l=0.15
X1331 uio_oe[0] a_57363_39901# a_57324_40027# uio_oe[0] sky130_fd_pr__nfet_01v8 ad=0.0567 pd=0.69 as=0.1092 ps=1.36 w=0.42 l=0.15
X1332 VDPWR a_38543_34471# a_28980_33417# VDPWR sky130_fd_pr__pfet_01v8_hvt ad=0.16655 pd=1.39 as=0.475 ps=2.95 w=1 l=0.15
X1333 a_38961_42777# a_38005_40847# VDPWR VDPWR sky130_fd_pr__pfet_01v8_hvt ad=0.1176 pd=1.4 as=0.0693 ps=0.75 w=0.42 l=0.15
X1334 a_31426_18464# a_28348_18376# ua[5] uio_oe[0] sky130_fd_pr__nfet_01v8 ad=0.1885 pd=1.88 as=0.1885 ps=1.88 w=0.65 l=0.15
X1335 uio_oe[0] a_41519_42479# a_41685_42479# uio_oe[0] sky130_fd_pr__nfet_01v8 ad=0.08775 pd=0.92 as=0.08775 ps=0.92 w=0.65 l=0.15
X1336 a_57694_39215# a_57472_39493# a_57012_39189# VDPWR sky130_fd_pr__pfet_01v8_hvt ad=0.0483 pd=0.65 as=0.0819 ps=0.81 w=0.42 l=0.15
X1337 uio_oe[0] a_38005_41391# a_42439_38671# uio_oe[0] sky130_fd_pr__nfet_01v8 ad=0.0567 pd=0.69 as=0.1092 ps=1.36 w=0.42 l=0.15
X1338 a_61297_36737# a_61079_36495# VDPWR VDPWR sky130_fd_pr__pfet_01v8_hvt ad=0.12915 pd=1.185 as=0.2184 ps=2.2 w=0.84 l=0.15
X1339 a_28642_22464# a_28348_14782# ua[4] uio_oe[0] sky130_fd_pr__nfet_01v8 ad=0.1885 pd=1.88 as=0.1885 ps=1.88 w=0.65 l=0.15
X1340 a_36661_41391# a_36631_41365# uio_oe[0] uio_oe[0] sky130_fd_pr__nfet_01v8 ad=0.08775 pd=0.92 as=0.08775 ps=0.92 w=0.65 l=0.15
X1341 a_57519_41084# a_57324_41115# a_57829_40847# uio_oe[0] sky130_fd_pr__special_nfet_01v8 ad=0.0594 pd=0.69 as=0.1401 ps=1.1 w=0.36 l=0.15
X1342 uio_oe[0] a_48125_43023# a_49721_40669# uio_oe[0] sky130_fd_pr__nfet_01v8 ad=0.12495 pd=1.015 as=0.06405 ps=0.725 w=0.42 l=0.15
X1343 uio_oe[0] a_25449_36747# a_25383_36815# uio_oe[0] sky130_fd_pr__nfet_01v8 ad=0.1449 pd=1.11 as=0.0693 ps=0.75 w=0.42 l=0.15
X1344 a_23698_22464# a_20620_14376# ua[5] uio_oe[0] sky130_fd_pr__nfet_01v8 ad=0.1885 pd=1.88 as=0.1885 ps=1.88 w=0.65 l=0.15
X1345 uio_oe[0] a_37851_36647# a_42039_35592# uio_oe[0] sky130_fd_pr__nfet_01v8 ad=0.169 pd=1.82 as=0.08775 ps=0.92 w=0.65 l=0.15
X1346 a_37328_34979# a_37310_34471# uio_oe[0] uio_oe[0] sky130_fd_pr__nfet_01v8 ad=0.0567 pd=0.69 as=0.1092 ps=1.36 w=0.42 l=0.15
X1347 a_43353_40847# a_42163_40847# a_43244_40847# uio_oe[0] sky130_fd_pr__special_nfet_01v8 ad=0.0669 pd=0.75 as=0.0711 ps=0.755 w=0.36 l=0.15
X1348 uio_oe[0] a_36721_37039# a_37566_40125# uio_oe[0] sky130_fd_pr__nfet_01v8 ad=0.2205 pd=1.89 as=0.066 ps=0.745 w=0.42 l=0.15
X1349 a_53369_38671# a_53203_38671# VDPWR VDPWR sky130_fd_pr__pfet_01v8_hvt ad=0.1664 pd=1.8 as=0.0864 ps=0.91 w=0.64 l=0.15
X1350 a_28642_22464# a_4259_22596# a_28346_20730# uio_oe[0] sky130_fd_pr__nfet_01v8 ad=0.2436 pd=2.26 as=0.2436 ps=2.26 w=0.84 l=0.6
X1351 uio_oe[0] a_37913_43023# a_60563_39759# uio_oe[0] sky130_fd_pr__nfet_01v8 ad=0.0567 pd=0.69 as=0.1092 ps=1.36 w=0.42 l=0.15
X1352 VDPWR a_28651_33729# a_30123_34095# VDPWR sky130_fd_pr__pfet_01v8_hvt ad=0.0714 pd=0.76 as=0.1092 ps=1.36 w=0.42 l=0.15
X1353 a_61753_37583# a_60563_37583# a_61644_37583# uio_oe[0] sky130_fd_pr__special_nfet_01v8 ad=0.0669 pd=0.75 as=0.0711 ps=0.755 w=0.36 l=0.15
X1354 a_22012_18376# a_22575_34095# VDPWR VDPWR sky130_fd_pr__pfet_01v8_hvt ad=0.26 pd=2.52 as=0.2279 ps=1.74 w=1 l=0.15
X1355 a_42602_38259# a_42919_38369# a_42877_38493# uio_oe[0] sky130_fd_pr__special_nfet_01v8 ad=0.0711 pd=0.755 as=0.0669 ps=0.75 w=0.36 l=0.15
X1356 VDPWR a_21585_35659# a_21615_35400# VDPWR sky130_fd_pr__pfet_01v8_hvt ad=0.0693 pd=0.75 as=0.0441 ps=0.63 w=0.42 l=0.15
X1357 VDPWR clk a_41519_42479# VDPWR sky130_fd_pr__pfet_01v8_hvt ad=0.135 pd=1.27 as=0.26 ps=2.52 w=1 l=0.15
X1358 VDPWR a_54284_41935# a_54459_41909# VDPWR sky130_fd_pr__pfet_01v8_hvt ad=0.1134 pd=1.38 as=0.0567 ps=0.69 w=0.42 l=0.15
X1359 a_58082_38127# a_57363_38369# a_57519_38101# uio_oe[0] sky130_fd_pr__special_nfet_01v8 ad=0.066 pd=0.745 as=0.0594 ps=0.69 w=0.36 l=0.15
X1360 VDPWR a_60371_38101# a_60302_38127# VDPWR sky130_fd_pr__pfet_01v8_hvt ad=0.2184 pd=2.2 as=0.12915 ps=1.185 w=0.84 l=0.15
X1361 a_51620_35381# a_54459_35381# uio_oe[0] uio_oe[0] sky130_fd_pr__nfet_01v8 ad=0.169 pd=1.82 as=0.2087 ps=2.02 w=0.65 l=0.15
X1362 a_45285_41935# a_44095_41935# a_45176_41935# uio_oe[0] sky130_fd_pr__special_nfet_01v8 ad=0.0669 pd=0.75 as=0.0711 ps=0.755 w=0.36 l=0.15
X1363 VDPWR a_37029_42479# a_46027_41397# VDPWR sky130_fd_pr__pfet_01v8_hvt ad=0.0864 pd=0.91 as=0.1664 ps=1.8 w=0.64 l=0.15
X1364 a_50722_38127# a_50003_38369# a_50159_38101# uio_oe[0] sky130_fd_pr__special_nfet_01v8 ad=0.066 pd=0.745 as=0.0594 ps=0.69 w=0.36 l=0.15
X1365 a_49961_37405# a_49483_37013# uio_oe[0] uio_oe[0] sky130_fd_pr__nfet_01v8 ad=0.0669 pd=0.75 as=0.12495 ps=1.015 w=0.42 l=0.15
X1366 a_39544_39447# a_39752_39483# a_39686_39581# uio_oe[0] sky130_fd_pr__nfet_01v8 ad=0.09975 pd=0.895 as=0.0693 ps=0.75 w=0.42 l=0.15
X1367 a_39973_37557# a_37029_37583# VDPWR VDPWR sky130_fd_pr__pfet_01v8_hvt ad=0.1176 pd=1.4 as=0.0693 ps=0.75 w=0.42 l=0.15
X1368 VDPWR a_38005_41391# a_40415_37045# VDPWR sky130_fd_pr__pfet_01v8_hvt ad=0.0864 pd=0.91 as=0.1664 ps=1.8 w=0.64 l=0.15
X1369 a_43598_40669# a_39947_42997# uio_oe[0] uio_oe[0] sky130_fd_pr__nfet_01v8 ad=0.06405 pd=0.725 as=0.12495 ps=1.015 w=0.42 l=0.15
X1370 a_59939_34646# a_58980_34293# a_59867_34646# VDPWR sky130_fd_pr__pfet_01v8_hvt ad=0.1932 pd=1.34 as=0.0441 ps=0.63 w=0.42 l=0.15
X1371 uio_oe[0] a_60416_37317# a_60500_37013# uio_oe[0] sky130_fd_pr__nfet_01v8 ad=0.0567 pd=0.69 as=0.1092 ps=1.36 w=0.42 l=0.15
X1372 VDPWR a_36329_36469# a_17255_32793# VDPWR sky130_fd_pr__pfet_01v8_hvt ad=0.14825 pd=1.34 as=0.27 ps=2.54 w=1 l=0.15
X1373 a_53574_41391# a_52816_41507# a_53011_41365# VDPWR sky130_fd_pr__pfet_01v8_hvt ad=0.0651 pd=0.73 as=0.07245 ps=0.765 w=0.42 l=0.15
X1374 VDPWR a_39544_39911# a_21068_36057# VDPWR sky130_fd_pr__pfet_01v8_hvt ad=0.15835 pd=1.395 as=0.26 ps=2.52 w=1 l=0.15
X1375 VDPWR a_41143_39996# a_41074_40125# VDPWR sky130_fd_pr__pfet_01v8_hvt ad=0.2184 pd=2.2 as=0.12915 ps=1.185 w=0.84 l=0.15
X1376 VDPWR a_52855_36193# a_52816_36067# VDPWR sky130_fd_pr__pfet_01v8_hvt ad=0.0864 pd=0.91 as=0.1664 ps=1.8 w=0.64 l=0.15
X1377 uio_oe[0] a_41143_38101# a_41074_38127# uio_oe[0] sky130_fd_pr__nfet_01v8 ad=0.1346 pd=1.15 as=0.0999 ps=0.985 w=0.64 l=0.15
X1378 uio_oe[0] a_36327_35925# a_17481_32899# uio_oe[0] sky130_fd_pr__nfet_01v8 ad=0.1013 pd=0.99 as=0.169 ps=1.82 w=0.65 l=0.15
X1379 a_41588_37583# a_40507_37583# a_41241_37825# VDPWR sky130_fd_pr__pfet_01v8_hvt ad=0.0588 pd=0.7 as=0.12915 ps=1.185 w=0.42 l=0.15
X1380 a_54406_41757# a_36661_41391# uio_oe[0] uio_oe[0] sky130_fd_pr__nfet_01v8 ad=0.0693 pd=0.75 as=0.11285 ps=1.045 w=0.42 l=0.15
X1381 a_61079_35407# a_60729_35407# a_60984_35407# VDPWR sky130_fd_pr__pfet_01v8_hvt ad=0.07245 pd=0.765 as=0.0651 ps=0.73 w=0.42 l=0.15
X1382 a_54693_40601# a_36661_41391# uio_oe[0] uio_oe[0] sky130_fd_pr__nfet_01v8 ad=0.1092 pd=1.36 as=0.1449 ps=1.11 w=0.42 l=0.15
X1383 a_51412_39447# a_51620_39483# a_51554_39581# uio_oe[0] sky130_fd_pr__nfet_01v8 ad=0.09975 pd=0.895 as=0.0693 ps=0.75 w=0.42 l=0.15
X1384 VDPWR a_37361_41391# a_52325_37910# VDPWR sky130_fd_pr__pfet_01v8_hvt ad=0.0693 pd=0.75 as=0.1176 ps=1.4 w=0.42 l=0.15
X1385 a_46651_42479# a_39947_42997# VDPWR VDPWR sky130_fd_pr__pfet_01v8_hvt ad=0.1092 pd=1.36 as=0.07035 ps=0.755 w=0.42 l=0.15
X1386 VDPWR a_37747_41935# a_37913_41935# VDPWR sky130_fd_pr__pfet_01v8_hvt ad=0.135 pd=1.27 as=0.135 ps=1.27 w=1 l=0.15
X1387 a_53937_41089# a_53719_40847# uio_oe[0] uio_oe[0] sky130_fd_pr__nfet_01v8 ad=0.0999 pd=0.985 as=0.1346 ps=1.15 w=0.64 l=0.15
X1388 a_59939_34319# a_59685_34646# uio_oe[0] uio_oe[0] sky130_fd_pr__nfet_01v8 ad=0.0693 pd=0.75 as=0.1449 ps=1.11 w=0.42 l=0.15
X1389 VDPWR a_37085_35951# a_37605_42518# VDPWR sky130_fd_pr__pfet_01v8_hvt ad=0.0693 pd=0.75 as=0.1176 ps=1.4 w=0.42 l=0.15
X1390 a_54459_38645# a_48125_41935# VDPWR VDPWR sky130_fd_pr__pfet_01v8_hvt ad=0.0567 pd=0.69 as=0.0819 ps=0.81 w=0.42 l=0.15
X1391 a_57519_38101# a_57324_38243# a_57829_38493# uio_oe[0] sky130_fd_pr__special_nfet_01v8 ad=0.0594 pd=0.69 as=0.1401 ps=1.1 w=0.36 l=0.15
X1392 VDPWR a_53937_36737# a_53827_36861# VDPWR sky130_fd_pr__pfet_01v8_hvt ad=0.07035 pd=0.755 as=0.1155 ps=0.97 w=0.42 l=0.15
X1393 VDPWR a_37913_41935# a_53203_35407# VDPWR sky130_fd_pr__pfet_01v8_hvt ad=0.0864 pd=0.91 as=0.1664 ps=1.8 w=0.64 l=0.15
X1394 a_43244_43023# a_42163_43023# a_42897_43265# VDPWR sky130_fd_pr__pfet_01v8_hvt ad=0.0588 pd=0.7 as=0.12915 ps=1.185 w=0.42 l=0.15
X1395 a_44873_40847# a_44829_41089# a_44707_40847# uio_oe[0] sky130_fd_pr__nfet_01v8 ad=0.0441 pd=0.63 as=0.1401 ps=1.1 w=0.42 l=0.15
X1396 a_21114_35905# a_21068_36057# uio_oe[0] uio_oe[0] sky130_fd_pr__nfet_01v8 ad=0.0693 pd=0.75 as=0.11285 ps=1.045 w=0.42 l=0.15
X1397 VDPWR a_58864_35095# a_58298_35093# VDPWR sky130_fd_pr__pfet_01v8_hvt ad=0.15835 pd=1.395 as=0.26 ps=2.52 w=1 l=0.15
X1398 a_36999_38101# a_37335_37557# VDPWR VDPWR sky130_fd_pr__pfet_01v8_hvt ad=0.26 pd=2.52 as=0.135 ps=1.27 w=1 l=0.15
X1399 a_17537_36967# a_17204_37145# VDPWR VDPWR sky130_fd_pr__pfet_01v8_hvt ad=0.1176 pd=1.4 as=0.0693 ps=0.75 w=0.42 l=0.15
X1400 ua[4] a_28348_10782# a_29610_10020# uio_oe[0] sky130_fd_pr__nfet_01v8 ad=0.1885 pd=1.88 as=0.1885 ps=1.88 w=0.65 l=0.15
X1401 VDPWR a_59860_41623# a_54479_41404# VDPWR sky130_fd_pr__pfet_01v8_hvt ad=0.149 pd=1.325 as=0.26 ps=2.52 w=1 l=0.15
X1402 VDPWR a_51412_39911# a_50784_40008# VDPWR sky130_fd_pr__pfet_01v8_hvt ad=0.15835 pd=1.395 as=0.26 ps=2.52 w=1 l=0.15
X1403 uio_oe[0] a_57363_38813# a_57324_38939# uio_oe[0] sky130_fd_pr__nfet_01v8 ad=0.0567 pd=0.69 as=0.1092 ps=1.36 w=0.42 l=0.15
X1404 a_38080_37583# a_37829_37812# a_37859_37910# uio_oe[0] sky130_fd_pr__nfet_01v8 ad=0.0693 pd=0.75 as=0.09975 ps=0.895 w=0.42 l=0.15
X1405 uio_oe[0] a_21401_36967# a_21335_36993# uio_oe[0] sky130_fd_pr__nfet_01v8 ad=0.1449 pd=1.11 as=0.0693 ps=0.75 w=0.42 l=0.15
X1406 VDPWR a_50784_37013# a_50722_37039# VDPWR sky130_fd_pr__pfet_01v8_hvt ad=0.1092 pd=1.36 as=0.0651 ps=0.73 w=0.42 l=0.15
X1407 VDPWR a_25265_35879# a_25295_36232# VDPWR sky130_fd_pr__pfet_01v8_hvt ad=0.0693 pd=0.75 as=0.0441 ps=0.63 w=0.42 l=0.15
X1408 a_50090_34863# a_50003_35105# a_49686_34995# VDPWR sky130_fd_pr__pfet_01v8_hvt ad=0.12915 pd=1.185 as=0.0588 ps=0.7 w=0.42 l=0.15
X1409 a_38961_41689# a_38005_40847# VDPWR VDPWR sky130_fd_pr__pfet_01v8_hvt ad=0.1176 pd=1.4 as=0.0693 ps=0.75 w=0.42 l=0.15
X1410 a_46805_41935# a_46761_42177# a_46639_41935# uio_oe[0] sky130_fd_pr__nfet_01v8 ad=0.0441 pd=0.63 as=0.1401 ps=1.1 w=0.42 l=0.15
X1411 uio_oe[0] a_43419_40607# a_43353_40681# uio_oe[0] sky130_fd_pr__nfet_01v8 ad=0.12495 pd=1.015 as=0.0669 ps=0.75 w=0.42 l=0.15
X1412 a_24484_18376# a_26439_35183# uio_oe[0] uio_oe[0] sky130_fd_pr__nfet_01v8 ad=0.169 pd=1.82 as=0.1013 ps=0.99 w=0.65 l=0.15
X1413 a_57664_39037# a_57450_39037# VDPWR VDPWR sky130_fd_pr__pfet_01v8_hvt ad=0.1155 pd=0.97 as=0.07035 ps=0.755 w=0.42 l=0.15
X1414 uio_oe[0] a_57640_35177# a_57598_35229# uio_oe[0] sky130_fd_pr__nfet_01v8 ad=0.1092 pd=1.36 as=0.0441 ps=0.63 w=0.42 l=0.15
X1415 a_17567_34056# a_17316_33703# a_17108_33881# VDPWR sky130_fd_pr__pfet_01v8_hvt ad=0.0441 pd=0.63 as=0.1932 ps=1.34 w=0.42 l=0.15
X1416 uio_oe[0] a_26369_34571# a_26303_34639# uio_oe[0] sky130_fd_pr__nfet_01v8 ad=0.1449 pd=1.11 as=0.0693 ps=0.75 w=0.42 l=0.15
X1417 VDPWR a_38005_41391# a_42163_43023# VDPWR sky130_fd_pr__pfet_01v8_hvt ad=0.0864 pd=0.91 as=0.1664 ps=1.8 w=0.64 l=0.15
X1418 a_44261_43023# a_44095_43023# uio_oe[0] uio_oe[0] sky130_fd_pr__nfet_01v8 ad=0.1092 pd=1.36 as=0.0567 ps=0.69 w=0.42 l=0.15
X1419 a_46651_42479# a_46027_42485# a_46543_42857# VDPWR sky130_fd_pr__pfet_01v8_hvt ad=0.1155 pd=0.97 as=0.07245 ps=0.765 w=0.42 l=0.15
X1420 a_54459_36469# a_54284_36495# a_54638_36495# uio_oe[0] sky130_fd_pr__nfet_01v8 ad=0.1092 pd=1.36 as=0.06405 ps=0.725 w=0.42 l=0.15
X1421 VDPWR a_54284_35407# a_54459_35381# VDPWR sky130_fd_pr__pfet_01v8_hvt ad=0.1134 pd=1.38 as=0.0567 ps=0.69 w=0.42 l=0.15
X1422 uio_oe[0] a_37029_42479# a_42163_41935# uio_oe[0] sky130_fd_pr__nfet_01v8 ad=0.0567 pd=0.69 as=0.1092 ps=1.36 w=0.42 l=0.15
X1423 VDPWR a_41671_36469# a_41658_36861# VDPWR sky130_fd_pr__pfet_01v8_hvt ad=0.0819 pd=0.81 as=0.0567 ps=0.69 w=0.42 l=0.15
X1424 a_60153_36822# a_51620_36469# a_59939_36822# VDPWR sky130_fd_pr__pfet_01v8_hvt ad=0.07665 pd=0.785 as=0.1932 ps=1.34 w=0.42 l=0.15
X1425 a_16804_14020# a_16812_8642# uio_oe[0] uio_oe[0] sky130_fd_pr__nfet_01v8 ad=1.4703 pd=10.72 as=1.4703 ps=10.72 w=5.07 l=1
X1426 a_53624_41935# a_53005_41935# VDPWR VDPWR sky130_fd_pr__pfet_01v8_hvt ad=0.0651 pd=0.73 as=0.1092 ps=1.36 w=0.42 l=0.15
X1427 uio_oe[0] a_37913_43023# a_60563_38671# uio_oe[0] sky130_fd_pr__nfet_01v8 ad=0.0567 pd=0.69 as=0.1092 ps=1.36 w=0.42 l=0.15
X1428 uio_oe[0] a_39947_42997# a_44873_41757# uio_oe[0] sky130_fd_pr__nfet_01v8 ad=0.1346 pd=1.15 as=0.0441 ps=0.63 w=0.42 l=0.15
X1429 a_57472_35141# a_41685_42479# uio_oe[0] uio_oe[0] sky130_fd_pr__nfet_01v8 ad=0.1092 pd=1.36 as=0.0567 ps=0.69 w=0.42 l=0.15
X1430 uio_oe[0] a_38532_42711# a_17388_36681# uio_oe[0] sky130_fd_pr__nfet_01v8 ad=0.11285 pd=1.045 as=0.169 ps=1.82 w=0.65 l=0.15
X1431 VDPWR a_40467_39733# a_37851_36647# VDPWR sky130_fd_pr__pfet_01v8_hvt ad=0.3012 pd=2.66 as=0.26 ps=2.52 w=1 l=0.15
X1432 VDPWR a_57012_39189# a_57148_39215# VDPWR sky130_fd_pr__pfet_01v8_hvt ad=0.12285 pd=1.17 as=0.2184 ps=2.2 w=0.84 l=0.15
X1433 VDPWR a_38532_37735# a_25116_35593# VDPWR sky130_fd_pr__pfet_01v8_hvt ad=0.15835 pd=1.395 as=0.26 ps=2.52 w=1 l=0.15
X1434 a_43897_36647# a_38285_36495# a_44060_36745# VDPWR sky130_fd_pr__pfet_01v8_hvt ad=0.1092 pd=1.36 as=0.0441 ps=0.63 w=0.42 l=0.15
X1435 a_26170_14464# a_24484_10782# ua[5] uio_oe[0] sky130_fd_pr__nfet_01v8 ad=0.1885 pd=1.88 as=0.1885 ps=1.88 w=0.65 l=0.15
X1436 uio_oe[0] uio_oe[0] uio_oe[0] uio_oe[0] sky130_fd_pr__nfet_01v8 ad=0.1885 pd=1.88 as=0 ps=0 w=0.65 l=0.15
X1437 ua[5] a_28348_10782# a_29610_22020# uio_oe[0] sky130_fd_pr__nfet_01v8 ad=0.1885 pd=1.88 as=0.1885 ps=1.88 w=0.65 l=0.15
X1438 a_39973_40601# a_38005_40847# uio_oe[0] uio_oe[0] sky130_fd_pr__nfet_01v8 ad=0.1092 pd=1.36 as=0.1449 ps=1.11 w=0.42 l=0.15
X1439 a_60374_37405# a_60092_37039# a_60298_37405# uio_oe[0] sky130_fd_pr__nfet_01v8 ad=0.0441 pd=0.63 as=0.0483 ps=0.65 w=0.42 l=0.15
X1440 a_42028_36183# a_42236_36219# a_42170_36317# uio_oe[0] sky130_fd_pr__nfet_01v8 ad=0.09975 pd=0.895 as=0.0693 ps=0.75 w=0.42 l=0.15
X1441 VDPWR a_22505_33483# a_22535_33224# VDPWR sky130_fd_pr__pfet_01v8_hvt ad=0.0693 pd=0.75 as=0.0441 ps=0.63 w=0.42 l=0.15
X1442 a_21156_33417# a_17507_33198# a_21298_33224# VDPWR sky130_fd_pr__pfet_01v8_hvt ad=0.1932 pd=1.34 as=0.07665 ps=0.785 w=0.42 l=0.15
X1443 a_54406_42518# a_36661_41391# VDPWR VDPWR sky130_fd_pr__pfet_01v8_hvt ad=0.07665 pd=0.785 as=0.15835 ps=1.395 w=0.42 l=0.15
X1444 a_42971_39215# a_42347_39221# a_42863_39593# VDPWR sky130_fd_pr__pfet_01v8_hvt ad=0.1155 pd=0.97 as=0.07245 ps=0.765 w=0.42 l=0.15
X1445 a_40945_38493# a_40467_38101# uio_oe[0] uio_oe[0] sky130_fd_pr__nfet_01v8 ad=0.0669 pd=0.75 as=0.12495 ps=1.015 w=0.42 l=0.15
X1446 a_18531_37359# a_17059_36993# uio_oe[0] uio_oe[0] sky130_fd_pr__nfet_01v8 ad=0.1092 pd=1.36 as=0.1092 ps=1.36 w=0.42 l=0.15
X1447 uio_oe[0] a_62053_36249# a_61987_36317# uio_oe[0] sky130_fd_pr__nfet_01v8 ad=0.1449 pd=1.11 as=0.0693 ps=0.75 w=0.42 l=0.15
X1448 a_39907_42845# a_39759_42492# a_39544_42711# uio_oe[0] sky130_fd_pr__nfet_01v8 ad=0.0693 pd=0.75 as=0.09975 ps=0.895 w=0.42 l=0.15
X1449 uio_oe[0] a_39947_42997# a_46805_42845# uio_oe[0] sky130_fd_pr__nfet_01v8 ad=0.1346 pd=1.15 as=0.0441 ps=0.63 w=0.42 l=0.15
X1450 a_49686_41099# a_49964_41115# a_49920_41213# VDPWR sky130_fd_pr__pfet_01v8_hvt ad=0.0588 pd=0.7 as=0.0567 ps=0.69 w=0.42 l=0.15
X1451 a_57472_39493# a_38649_43023# VDPWR VDPWR sky130_fd_pr__pfet_01v8_hvt ad=0.1664 pd=1.8 as=0.0864 ps=0.91 w=0.64 l=0.15
X1452 VDPWR a_48125_41935# a_60720_39581# VDPWR sky130_fd_pr__pfet_01v8_hvt ad=0.0798 pd=0.8 as=0.0567 ps=0.69 w=0.42 l=0.15
X1453 uio_oe[0] a_16812_8642# a_18146_16730# uio_oe[0] sky130_fd_pr__nfet_01v8 ad=1.4703 pd=10.72 as=1.4703 ps=10.72 w=5.07 l=1
X1454 uio_oe[0] a_17689_32641# a_18097_33757# uio_oe[0] sky130_fd_pr__nfet_01v8 ad=0.1118 pd=1.04 as=0.0567 ps=0.69 w=0.42 l=0.15
X1455 a_41171_40342# a_41141_40316# a_41099_40342# VDPWR sky130_fd_pr__pfet_01v8_hvt ad=0.1932 pd=1.34 as=0.0441 ps=0.63 w=0.42 l=0.15
X1456 a_52538_38259# a_52816_38243# a_52772_38127# VDPWR sky130_fd_pr__pfet_01v8_hvt ad=0.0588 pd=0.7 as=0.0567 ps=0.69 w=0.42 l=0.15
X1457 a_42630_37583# a_38285_34863# uio_oe[0] uio_oe[0] sky130_fd_pr__nfet_01v8 ad=0.0693 pd=0.75 as=0.11285 ps=1.045 w=0.42 l=0.15
X1458 uio_oe[0] a_37851_36647# a_38109_35407# uio_oe[0] sky130_fd_pr__nfet_01v8 ad=0.1013 pd=0.99 as=0.0504 ps=0.66 w=0.42 l=0.15
X1459 a_39686_41935# a_38005_40847# uio_oe[0] uio_oe[0] sky130_fd_pr__nfet_01v8 ad=0.0693 pd=0.75 as=0.11285 ps=1.045 w=0.42 l=0.15
X1460 VDPWR rst_n a_47959_41935# VDPWR sky130_fd_pr__pfet_01v8_hvt ad=0.135 pd=1.27 as=0.26 ps=2.52 w=1 l=0.15
X1461 VDPWR a_43244_43023# a_43419_42997# VDPWR sky130_fd_pr__pfet_01v8_hvt ad=0.1134 pd=1.38 as=0.0567 ps=0.69 w=0.42 l=0.15
X1462 a_52579_41935# a_52325_42262# uio_oe[0] uio_oe[0] sky130_fd_pr__nfet_01v8 ad=0.0693 pd=0.75 as=0.1449 ps=1.11 w=0.42 l=0.15
X1463 uio_oe[0] a_62237_41689# a_62171_41757# uio_oe[0] sky130_fd_pr__nfet_01v8 ad=0.1449 pd=1.11 as=0.0693 ps=0.75 w=0.42 l=0.15
X1464 a_37169_38671# a_36875_38823# a_37085_38671# uio_oe[0] sky130_fd_pr__nfet_01v8 ad=0.25025 pd=1.42 as=0.08775 ps=0.92 w=0.65 l=0.15
X1465 uio_oe[0] a_43161_34863# a_44044_37155# uio_oe[0] sky130_fd_pr__nfet_01v8 ad=0.10025 pd=0.985 as=0.0567 ps=0.69 w=0.42 l=0.15
X1466 VDPWR a_59201_35381# a_59231_35734# VDPWR sky130_fd_pr__pfet_01v8_hvt ad=0.0693 pd=0.75 as=0.0441 ps=0.63 w=0.42 l=0.15
X1467 a_42679_41935# a_42329_41935# a_42584_41935# VDPWR sky130_fd_pr__pfet_01v8_hvt ad=0.07245 pd=0.765 as=0.0651 ps=0.73 w=0.42 l=0.15
X1468 a_53574_37039# a_52855_37281# a_53011_37013# uio_oe[0] sky130_fd_pr__special_nfet_01v8 ad=0.066 pd=0.745 as=0.0594 ps=0.69 w=0.36 l=0.15
X1469 VDPWR a_51841_35381# a_51871_35734# VDPWR sky130_fd_pr__pfet_01v8_hvt ad=0.0693 pd=0.75 as=0.0441 ps=0.63 w=0.42 l=0.15
X1470 a_43114_34569# a_43014_34471# a_43032_34569# VDPWR sky130_fd_pr__pfet_01v8_hvt ad=0.0441 pd=0.63 as=0.1092 ps=1.36 w=0.42 l=0.15
X1471 VDPWR a_37183_40277# a_36607_39455# VDPWR sky130_fd_pr__pfet_01v8_hvt ad=0.135 pd=1.27 as=0.135 ps=1.27 w=1 l=0.15
X1472 VDPWR a_56843_35925# a_39783_35967# VDPWR sky130_fd_pr__pfet_01v8_hvt ad=0.3012 pd=2.66 as=0.26 ps=2.52 w=1 l=0.15
X1473 uio_oe[0] a_38961_41909# a_38895_41935# uio_oe[0] sky130_fd_pr__nfet_01v8 ad=0.1449 pd=1.11 as=0.0693 ps=0.75 w=0.42 l=0.15
X1474 a_38961_40821# a_38005_40847# uio_oe[0] uio_oe[0] sky130_fd_pr__nfet_01v8 ad=0.1092 pd=1.36 as=0.1449 ps=1.11 w=0.42 l=0.15
X1475 a_53005_39759# a_52579_40086# uio_oe[0] uio_oe[0] sky130_fd_pr__nfet_01v8 ad=0.169 pd=1.82 as=0.11285 ps=1.045 w=0.65 l=0.15
X1476 a_60173_38493# a_59695_38101# uio_oe[0] uio_oe[0] sky130_fd_pr__nfet_01v8 ad=0.0669 pd=0.75 as=0.12495 ps=1.015 w=0.42 l=0.15
X1477 uio_oe[0] a_36999_42453# a_37029_42479# uio_oe[0] sky130_fd_pr__nfet_01v8 ad=0.08775 pd=0.92 as=0.08775 ps=0.92 w=0.65 l=0.15
X1478 a_24532_14020# a_4259_22596# a_24354_14020# uio_oe[0] sky130_fd_pr__nfet_01v8 ad=0.2436 pd=2.26 as=0.2436 ps=2.26 w=0.84 l=0.6
X1479 a_51775_42845# a_38740_42747# a_51412_42711# uio_oe[0] sky130_fd_pr__nfet_01v8 ad=0.0693 pd=0.75 as=0.09975 ps=0.895 w=0.42 l=0.15
X1480 a_46651_41391# a_39947_42997# VDPWR VDPWR sky130_fd_pr__pfet_01v8_hvt ad=0.1092 pd=1.36 as=0.07035 ps=0.755 w=0.42 l=0.15
X1481 a_53827_39037# a_48125_41935# VDPWR VDPWR sky130_fd_pr__pfet_01v8_hvt ad=0.1092 pd=1.36 as=0.07035 ps=0.755 w=0.42 l=0.15
X1482 VDPWR a_36999_37557# a_37029_37583# VDPWR sky130_fd_pr__pfet_01v8_hvt ad=0.135 pd=1.27 as=0.135 ps=1.27 w=1 l=0.15
X1483 VDPWR a_57640_37353# a_57694_37039# VDPWR sky130_fd_pr__pfet_01v8_hvt ad=0.0567 pd=0.69 as=0.0483 ps=0.65 w=0.42 l=0.15
X1484 uio_oe[0] a_39947_42997# a_39905_43023# uio_oe[0] sky130_fd_pr__nfet_01v8 ad=0.1346 pd=1.15 as=0.0441 ps=0.63 w=0.42 l=0.15
X1485 a_48125_41935# a_47959_41935# VDPWR VDPWR sky130_fd_pr__pfet_01v8_hvt ad=0.135 pd=1.27 as=0.135 ps=1.27 w=1 l=0.15
X1486 a_39544_39911# a_39752_39733# a_39686_39759# uio_oe[0] sky130_fd_pr__nfet_01v8 ad=0.09975 pd=0.895 as=0.0693 ps=0.75 w=0.42 l=0.15
X1487 uio_oe[0] a_45443_38823# a_37829_38140# uio_oe[0] sky130_fd_pr__nfet_01v8 ad=0.1118 pd=1.04 as=0.182 ps=1.86 w=0.65 l=0.15
X1488 a_43837_37557# a_43504_37735# uio_oe[0] uio_oe[0] sky130_fd_pr__nfet_01v8 ad=0.1092 pd=1.36 as=0.1449 ps=1.11 w=0.42 l=0.15
X1489 a_51554_41935# a_48677_39759# uio_oe[0] uio_oe[0] sky130_fd_pr__nfet_01v8 ad=0.0693 pd=0.75 as=0.11285 ps=1.045 w=0.42 l=0.15
X1490 a_52579_40086# a_51620_40571# a_52579_39759# uio_oe[0] sky130_fd_pr__nfet_01v8 ad=0.09975 pd=0.895 as=0.0693 ps=0.75 w=0.42 l=0.15
X1491 a_59135_37583# a_38740_37557# a_58772_37735# uio_oe[0] sky130_fd_pr__nfet_01v8 ad=0.0693 pd=0.75 as=0.09975 ps=0.895 w=0.42 l=0.15
X1492 a_28348_10782# a_30303_37359# uio_oe[0] uio_oe[0] sky130_fd_pr__nfet_01v8 ad=0.169 pd=1.82 as=0.1013 ps=0.99 w=0.65 l=0.15
X1493 VDPWR a_17721_36747# a_17751_36488# VDPWR sky130_fd_pr__pfet_01v8_hvt ad=0.0693 pd=0.75 as=0.0441 ps=0.63 w=0.42 l=0.15
X1494 a_28884_36681# a_17507_33198# a_29026_36488# VDPWR sky130_fd_pr__pfet_01v8_hvt ad=0.1932 pd=1.34 as=0.07665 ps=0.785 w=0.42 l=0.15
X1495 VDPWR a_48125_43023# a_57664_40125# VDPWR sky130_fd_pr__pfet_01v8_hvt ad=0.07035 pd=0.755 as=0.1092 ps=1.36 w=0.42 l=0.15
X1496 a_50722_39215# a_49964_39331# a_50159_39189# VDPWR sky130_fd_pr__pfet_01v8_hvt ad=0.0651 pd=0.73 as=0.07245 ps=0.765 w=0.42 l=0.15
X1497 VDPWR a_48511_38127# a_48677_38127# VDPWR sky130_fd_pr__pfet_01v8_hvt ad=0.135 pd=1.27 as=0.135 ps=1.27 w=1 l=0.15
X1498 a_61987_36317# a_58980_36469# a_61624_36183# uio_oe[0] sky130_fd_pr__nfet_01v8 ad=0.0693 pd=0.75 as=0.09975 ps=0.895 w=0.42 l=0.15
X1499 a_21401_33703# a_21068_33881# VDPWR VDPWR sky130_fd_pr__pfet_01v8_hvt ad=0.1176 pd=1.4 as=0.0693 ps=0.75 w=0.42 l=0.15
X1500 a_53937_38913# a_53719_38671# VDPWR VDPWR sky130_fd_pr__pfet_01v8_hvt ad=0.12915 pd=1.185 as=0.2184 ps=2.2 w=0.84 l=0.15
X1501 VDPWR a_41241_37825# a_41131_37949# VDPWR sky130_fd_pr__pfet_01v8_hvt ad=0.07035 pd=0.755 as=0.1155 ps=0.97 w=0.42 l=0.15
X1502 a_17108_37145# a_17316_36967# a_17250_36993# uio_oe[0] sky130_fd_pr__nfet_01v8 ad=0.09975 pd=0.895 as=0.0693 ps=0.75 w=0.42 l=0.15
X1503 a_38109_35407# a_37839_35773# a_38019_35773# uio_oe[0] sky130_fd_pr__nfet_01v8 ad=0.0504 pd=0.66 as=0.1092 ps=1.36 w=0.42 l=0.15
X1504 a_22060_14020# a_16812_8642# uio_oe[0] uio_oe[0] sky130_fd_pr__nfet_01v8 ad=1.4703 pd=10.72 as=1.4703 ps=10.72 w=5.07 l=1
X1505 a_54264_38359# a_51620_38395# a_54406_38493# uio_oe[0] sky130_fd_pr__nfet_01v8 ad=0.09975 pd=0.895 as=0.0693 ps=0.75 w=0.42 l=0.15
X1506 VDPWR a_37361_41391# a_60153_36822# VDPWR sky130_fd_pr__pfet_01v8_hvt ad=0.15835 pd=1.395 as=0.07665 ps=0.785 w=0.42 l=0.15
X1507 a_51554_35990# a_48677_38127# VDPWR VDPWR sky130_fd_pr__pfet_01v8_hvt ad=0.07665 pd=0.785 as=0.15835 ps=1.395 w=0.42 l=0.15
X1508 a_52507_42262# a_52325_42262# VDPWR VDPWR sky130_fd_pr__pfet_01v8_hvt ad=0.0441 pd=0.63 as=0.0693 ps=0.75 w=0.42 l=0.15
X1509 a_24836_33881# a_24971_33185# a_24978_34056# VDPWR sky130_fd_pr__pfet_01v8_hvt ad=0.1932 pd=1.34 as=0.07665 ps=0.785 w=0.42 l=0.15
X1510 a_57363_36637# a_41685_42479# VDPWR VDPWR sky130_fd_pr__pfet_01v8_hvt ad=0.1664 pd=1.8 as=0.0864 ps=0.91 w=0.64 l=0.15
X1511 a_19834_10464# a_16756_10782# ua[5] uio_oe[0] sky130_fd_pr__nfet_01v8 ad=0.1885 pd=1.88 as=0.1885 ps=1.88 w=0.65 l=0.15
X1512 a_53624_35407# a_53005_35407# VDPWR VDPWR sky130_fd_pr__pfet_01v8_hvt ad=0.0651 pd=0.73 as=0.1092 ps=1.36 w=0.42 l=0.15
X1513 a_41392_40669# a_41141_40316# a_41171_40342# uio_oe[0] sky130_fd_pr__nfet_01v8 ad=0.0693 pd=0.75 as=0.09975 ps=0.895 w=0.42 l=0.15
X1514 a_40904_40125# a_40467_39733# VDPWR VDPWR sky130_fd_pr__pfet_01v8_hvt ad=0.0567 pd=0.69 as=0.0819 ps=0.81 w=0.42 l=0.15
X1515 a_50469_37583# a_50090_37949# a_50397_37583# uio_oe[0] sky130_fd_pr__nfet_01v8 ad=0.1401 pd=1.1 as=0.0441 ps=0.63 w=0.42 l=0.15
X1516 uio_oe[0] a_26369_33483# a_26303_33551# uio_oe[0] sky130_fd_pr__nfet_01v8 ad=0.1449 pd=1.11 as=0.0693 ps=0.75 w=0.42 l=0.15
X1517 VDPWR a_37029_42479# a_42163_41935# VDPWR sky130_fd_pr__pfet_01v8_hvt ad=0.0864 pd=0.91 as=0.1664 ps=1.8 w=0.64 l=0.15
X1518 a_46651_41391# a_46027_41397# a_46543_41769# VDPWR sky130_fd_pr__pfet_01v8_hvt ad=0.1155 pd=0.97 as=0.07245 ps=0.765 w=0.42 l=0.15
X1519 a_51412_39911# a_51620_39733# a_51554_39759# uio_oe[0] sky130_fd_pr__nfet_01v8 ad=0.09975 pd=0.895 as=0.0693 ps=0.75 w=0.42 l=0.15
X1520 a_54264_42711# a_54479_42492# a_54406_42518# VDPWR sky130_fd_pr__pfet_01v8_hvt ad=0.1932 pd=1.34 as=0.07665 ps=0.785 w=0.42 l=0.15
X1521 uio_oe[0] a_61808_35095# a_61242_35093# uio_oe[0] sky130_fd_pr__nfet_01v8 ad=0.11285 pd=1.045 as=0.169 ps=1.82 w=0.65 l=0.15
X1522 a_58772_36183# a_54479_35964# a_58914_36317# uio_oe[0] sky130_fd_pr__nfet_01v8 ad=0.09975 pd=0.895 as=0.0693 ps=0.75 w=0.42 l=0.15
X1523 ua[4] a_24484_18782# a_24354_18020# uio_oe[0] sky130_fd_pr__nfet_01v8 ad=0.1885 pd=1.88 as=0.1885 ps=1.88 w=0.65 l=0.15
X1524 a_49686_34571# a_49964_34587# a_49920_34685# VDPWR sky130_fd_pr__pfet_01v8_hvt ad=0.0588 pd=0.7 as=0.0567 ps=0.69 w=0.42 l=0.15
X1525 a_44719_42301# a_39947_42997# VDPWR VDPWR sky130_fd_pr__pfet_01v8_hvt ad=0.1092 pd=1.36 as=0.07035 ps=0.755 w=0.42 l=0.15
X1526 uio_oe[0] a_43359_37583# a_43638_38127# uio_oe[0] sky130_fd_pr__nfet_01v8 ad=0.2205 pd=1.89 as=0.066 ps=0.745 w=0.42 l=0.15
X1527 VDPWR a_37195_41391# a_37361_41391# VDPWR sky130_fd_pr__pfet_01v8_hvt ad=0.135 pd=1.27 as=0.135 ps=1.27 w=1 l=0.15
X1528 a_60729_36495# a_60563_36495# VDPWR VDPWR sky130_fd_pr__pfet_01v8_hvt ad=0.1664 pd=1.8 as=0.0864 ps=0.91 w=0.64 l=0.15
X1529 VDPWR a_30233_34571# a_30263_34312# VDPWR sky130_fd_pr__pfet_01v8_hvt ad=0.0693 pd=0.75 as=0.0441 ps=0.63 w=0.42 l=0.15
X1530 a_41751_34471# a_47283_41695# uio_oe[0] uio_oe[0] sky130_fd_pr__nfet_01v8 ad=0.169 pd=1.82 as=0.2087 ps=2.02 w=0.65 l=0.15
X1531 a_57450_39037# a_57363_38813# a_57046_38923# VDPWR sky130_fd_pr__pfet_01v8_hvt ad=0.12915 pd=1.185 as=0.0588 ps=0.7 w=0.42 l=0.15
X1532 VDPWR a_36425_36166# a_44369_38127# VDPWR sky130_fd_pr__pfet_01v8_hvt ad=0.135 pd=1.27 as=0.135 ps=1.27 w=1 l=0.15
X1533 a_60988_37405# a_60720_37405# uio_oe[0] uio_oe[0] sky130_fd_pr__nfet_01v8 ad=0.06705 pd=0.75 as=0.0882 ps=0.84 w=0.42 l=0.15
X1534 a_54393_34319# a_53203_34319# a_54284_34319# uio_oe[0] sky130_fd_pr__special_nfet_01v8 ad=0.0669 pd=0.75 as=0.0711 ps=0.755 w=0.36 l=0.15
X1535 a_54406_41430# a_36661_41391# VDPWR VDPWR sky130_fd_pr__pfet_01v8_hvt ad=0.07665 pd=0.785 as=0.15835 ps=1.395 w=0.42 l=0.15
X1536 a_59860_39447# a_59956_39189# uio_oe[0] uio_oe[0] sky130_fd_pr__nfet_01v8 ad=0.1092 pd=1.36 as=0.097 ps=0.975 w=0.42 l=0.15
X1537 a_29159_37320# a_28908_36967# a_28700_37145# VDPWR sky130_fd_pr__pfet_01v8_hvt ad=0.0441 pd=0.63 as=0.1932 ps=1.34 w=0.42 l=0.15
X1538 a_29129_36967# a_28796_37145# uio_oe[0] uio_oe[0] sky130_fd_pr__nfet_01v8 ad=0.1092 pd=1.36 as=0.1449 ps=1.11 w=0.42 l=0.15
X1539 VDPWR a_42347_38127# a_42715_34863# VDPWR sky130_fd_pr__pfet_01v8_hvt ad=0.0714 pd=0.76 as=0.1092 ps=1.36 w=0.42 l=0.15
X1540 a_40379_35551# a_40495_42453# uio_oe[0] uio_oe[0] sky130_fd_pr__nfet_01v8 ad=0.08775 pd=0.92 as=0.169 ps=1.82 w=0.65 l=0.15
X1541 a_54693_40601# a_36661_41391# VDPWR VDPWR sky130_fd_pr__pfet_01v8_hvt ad=0.1176 pd=1.4 as=0.0693 ps=0.75 w=0.42 l=0.15
X1542 a_44621_39535# a_44287_39215# a_44537_39215# VDPWR sky130_fd_pr__pfet_01v8_hvt ad=0.3 pd=2.6 as=0.26 ps=2.52 w=1 l=0.15
X1543 a_23452_14020# a_16812_8642# uio_oe[0] uio_oe[0] sky130_fd_pr__nfet_01v8 ad=1.4703 pd=10.72 as=1.4703 ps=10.72 w=5.07 l=1
X1544 a_37328_34569# a_37310_34471# uio_oe[0] uio_oe[0] sky130_fd_pr__nfet_01v8 ad=0.0567 pd=0.69 as=0.1092 ps=1.36 w=0.42 l=0.15
X1545 VDPWR a_61819_38645# a_61806_39037# VDPWR sky130_fd_pr__pfet_01v8_hvt ad=0.0819 pd=0.81 as=0.0567 ps=0.69 w=0.42 l=0.15
X1546 a_38543_36183# a_37029_37583# VDPWR VDPWR sky130_fd_pr__pfet_01v8_hvt ad=0.0567 pd=0.69 as=0.16655 ps=1.39 w=0.42 l=0.15
X1547 a_21875_35933# a_20923_35905# VDPWR VDPWR sky130_fd_pr__pfet_01v8_hvt ad=0.0567 pd=0.69 as=0.1176 ps=1.4 w=0.42 l=0.15
X1548 VDPWR a_38543_35095# a_28980_34505# VDPWR sky130_fd_pr__pfet_01v8_hvt ad=0.16655 pd=1.39 as=0.475 ps=2.95 w=1 l=0.15
X1549 uio_oe[0] a_48511_39759# a_48677_39759# uio_oe[0] sky130_fd_pr__nfet_01v8 ad=0.08775 pd=0.92 as=0.08775 ps=0.92 w=0.65 l=0.15
X1550 a_58914_39759# a_48677_39759# uio_oe[0] uio_oe[0] sky130_fd_pr__nfet_01v8 ad=0.0693 pd=0.75 as=0.11285 ps=1.045 w=0.42 l=0.15
X1551 a_57012_39189# a_48125_43023# VDPWR VDPWR sky130_fd_pr__pfet_01v8_hvt ad=0.1092 pd=1.36 as=0.12285 ps=1.17 w=0.42 l=0.15
X1552 a_37859_38166# a_37829_38140# a_37787_38166# VDPWR sky130_fd_pr__pfet_01v8_hvt ad=0.1932 pd=1.34 as=0.0441 ps=0.63 w=0.42 l=0.15
X1553 a_41085_36317# a_40706_35951# a_41013_36317# uio_oe[0] sky130_fd_pr__nfet_01v8 ad=0.1401 pd=1.1 as=0.0441 ps=0.63 w=0.42 l=0.15
X1554 a_42584_42845# a_42467_42650# uio_oe[0] uio_oe[0] sky130_fd_pr__nfet_01v8 ad=0.066 pd=0.745 as=0.2205 ps=1.89 w=0.42 l=0.15
X1555 a_39555_34471# a_39783_34321# a_39729_34347# uio_oe[0] sky130_fd_pr__nfet_01v8 ad=0.1176 pd=1.4 as=0.0567 ps=0.69 w=0.42 l=0.15
X1556 a_57514_41391# a_57148_41391# VDPWR VDPWR sky130_fd_pr__pfet_01v8_hvt ad=0.0441 pd=0.63 as=0.1092 ps=1.36 w=0.42 l=0.15
X1557 a_60584_41705# a_60500_41365# a_60988_41757# uio_oe[0] sky130_fd_pr__special_nfet_01v8 ad=0.072 pd=0.76 as=0.06705 ps=0.75 w=0.36 l=0.15
X1558 a_43244_40847# a_42329_40847# a_42897_41089# uio_oe[0] sky130_fd_pr__special_nfet_01v8 ad=0.0711 pd=0.755 as=0.0999 ps=0.985 w=0.36 l=0.15
X1559 a_49920_39215# a_49483_39189# VDPWR VDPWR sky130_fd_pr__pfet_01v8_hvt ad=0.0567 pd=0.69 as=0.0819 ps=0.81 w=0.42 l=0.15
X1560 a_59231_34646# a_58980_34293# a_58772_34471# VDPWR sky130_fd_pr__pfet_01v8_hvt ad=0.0441 pd=0.63 as=0.1932 ps=1.34 w=0.42 l=0.15
X1561 a_60298_41757# a_48125_41935# uio_oe[0] uio_oe[0] sky130_fd_pr__nfet_01v8 ad=0.0483 pd=0.65 as=0.1137 ps=1.01 w=0.42 l=0.15
X1562 a_53005_38671# a_52579_38998# uio_oe[0] uio_oe[0] sky130_fd_pr__nfet_01v8 ad=0.169 pd=1.82 as=0.11285 ps=1.045 w=0.65 l=0.15
X1563 a_61644_37583# a_60729_37583# a_61297_37825# uio_oe[0] sky130_fd_pr__special_nfet_01v8 ad=0.0711 pd=0.755 as=0.0999 ps=0.985 w=0.36 l=0.15
X1564 a_42499_34471# a_36447_40849# VDPWR VDPWR sky130_fd_pr__pfet_01v8_hvt ad=0.0567 pd=0.69 as=0.16655 ps=1.39 w=0.42 l=0.15
X1565 VDPWR a_53636_40277# a_53574_40303# VDPWR sky130_fd_pr__pfet_01v8_hvt ad=0.1092 pd=1.36 as=0.0651 ps=0.73 w=0.42 l=0.15
X1566 uio_oe[0] a_39973_39513# a_39907_39581# uio_oe[0] sky130_fd_pr__nfet_01v8 ad=0.1449 pd=1.11 as=0.0693 ps=0.75 w=0.42 l=0.15
X1567 a_42488_37735# a_42696_37557# a_42630_37583# uio_oe[0] sky130_fd_pr__nfet_01v8 ad=0.09975 pd=0.895 as=0.0693 ps=0.75 w=0.42 l=0.15
X1568 a_39293_43023# a_39127_43023# VDPWR VDPWR sky130_fd_pr__pfet_01v8_hvt ad=0.1664 pd=1.8 as=0.0864 ps=0.91 w=0.64 l=0.15
X1569 a_51412_36183# a_38771_35967# a_51554_35990# VDPWR sky130_fd_pr__pfet_01v8_hvt ad=0.1932 pd=1.34 as=0.07665 ps=0.785 w=0.42 l=0.15
X1570 VDPWR a_36327_34293# a_29073_32899# VDPWR sky130_fd_pr__pfet_01v8_hvt ad=0.2279 pd=1.74 as=0.26 ps=2.52 w=1 l=0.15
X1571 a_45176_41935# a_44261_41935# a_44829_42177# uio_oe[0] sky130_fd_pr__special_nfet_01v8 ad=0.0711 pd=0.755 as=0.0999 ps=0.985 w=0.36 l=0.15
X1572 VDPWR a_48125_43023# a_56843_39733# VDPWR sky130_fd_pr__pfet_01v8_hvt ad=0.0819 pd=0.81 as=0.0567 ps=0.69 w=0.42 l=0.15
X1573 a_59201_39733# a_48677_39759# VDPWR VDPWR sky130_fd_pr__pfet_01v8_hvt ad=0.1176 pd=1.4 as=0.0693 ps=0.75 w=0.42 l=0.15
X1574 a_39544_38823# a_39752_38645# a_39686_38671# uio_oe[0] sky130_fd_pr__nfet_01v8 ad=0.09975 pd=0.895 as=0.0693 ps=0.75 w=0.42 l=0.15
X1575 a_52579_38998# a_51620_39483# a_52579_38671# uio_oe[0] sky130_fd_pr__nfet_01v8 ad=0.09975 pd=0.895 as=0.0693 ps=0.75 w=0.42 l=0.15
X1576 a_21961_37021# a_20923_36993# a_21875_37021# uio_oe[0] sky130_fd_pr__nfet_01v8 ad=0.0567 pd=0.69 as=0.1176 ps=1.4 w=0.42 l=0.15
X1577 a_22439_36815# a_18427_33198# a_22076_36681# uio_oe[0] sky130_fd_pr__nfet_01v8 ad=0.0693 pd=0.75 as=0.09975 ps=0.895 w=0.42 l=0.15
X1578 a_26399_34312# a_18420_33453# a_25940_34505# VDPWR sky130_fd_pr__pfet_01v8_hvt ad=0.0441 pd=0.63 as=0.1932 ps=1.34 w=0.42 l=0.15
X1579 a_52335_35925# a_52538_36083# VDPWR VDPWR sky130_fd_pr__pfet_01v8_hvt ad=0.0567 pd=0.69 as=0.1134 ps=1.38 w=0.42 l=0.15
X1580 a_37579_34319# a_37328_34569# uio_oe[0] uio_oe[0] sky130_fd_pr__nfet_01v8 ad=0.169 pd=1.82 as=0.10025 ps=0.985 w=0.65 l=0.15
X1581 uio_oe[0] a_59201_34293# a_59135_34319# uio_oe[0] sky130_fd_pr__nfet_01v8 ad=0.1449 pd=1.11 as=0.0693 ps=0.75 w=0.42 l=0.15
X1582 uio_oe[0] a_16812_8642# a_28346_16730# uio_oe[0] sky130_fd_pr__nfet_01v8 ad=1.4703 pd=10.72 as=1.4703 ps=10.72 w=5.07 l=1
X1583 a_50090_37039# a_49964_37155# a_49686_37171# uio_oe[0] sky130_fd_pr__special_nfet_01v8 ad=0.0999 pd=0.985 as=0.0711 ps=0.755 w=0.36 l=0.15
X1584 a_61998_36495# a_46193_39759# uio_oe[0] uio_oe[0] sky130_fd_pr__nfet_01v8 ad=0.06405 pd=0.725 as=0.12495 ps=1.015 w=0.42 l=0.15
X1585 uio_oe[0] a_22076_33417# a_21180_33703# uio_oe[0] sky130_fd_pr__nfet_01v8 ad=0.11285 pd=1.045 as=0.169 ps=1.82 w=0.65 l=0.15
X1586 VDPWR a_48125_41935# a_53156_42479# VDPWR sky130_fd_pr__pfet_01v8_hvt ad=0.07035 pd=0.755 as=0.1092 ps=1.36 w=0.42 l=0.15
X1587 a_54627_41757# a_54479_41404# a_54264_41623# uio_oe[0] sky130_fd_pr__nfet_01v8 ad=0.0693 pd=0.75 as=0.09975 ps=0.895 w=0.42 l=0.15
X1588 a_17292_35593# a_17500_33453# a_17434_35727# uio_oe[0] sky130_fd_pr__nfet_01v8 ad=0.09975 pd=0.895 as=0.0693 ps=0.75 w=0.42 l=0.15
X1589 a_31180_14020# a_4259_22596# a_31002_14020# uio_oe[0] sky130_fd_pr__nfet_01v8 ad=0.2436 pd=2.26 as=0.2436 ps=2.26 w=0.84 l=0.6
X1590 a_50397_41757# a_48125_43023# uio_oe[0] uio_oe[0] sky130_fd_pr__nfet_01v8 ad=0.0441 pd=0.63 as=0.1346 ps=1.15 w=0.42 l=0.15
X1591 a_39973_40601# a_38005_40847# VDPWR VDPWR sky130_fd_pr__pfet_01v8_hvt ad=0.1176 pd=1.4 as=0.0693 ps=0.75 w=0.42 l=0.15
X1592 uio_oe[0] a_56843_40277# a_39752_40571# uio_oe[0] sky130_fd_pr__nfet_01v8 ad=0.2087 pd=2.02 as=0.169 ps=1.82 w=0.65 l=0.15
X1593 uio_oe[0] a_51841_39513# a_51775_39581# uio_oe[0] sky130_fd_pr__nfet_01v8 ad=0.1449 pd=1.11 as=0.0693 ps=0.75 w=0.42 l=0.15
X1594 VDPWR a_37747_41935# a_37913_41935# VDPWR sky130_fd_pr__pfet_01v8_hvt ad=0.26 pd=2.52 as=0.135 ps=1.27 w=1 l=0.15
X1595 VDPWR a_37029_42479# a_42163_40309# VDPWR sky130_fd_pr__pfet_01v8_hvt ad=0.0864 pd=0.91 as=0.1664 ps=1.8 w=0.64 l=0.15
X1596 a_51841_38425# a_48677_38127# uio_oe[0] uio_oe[0] sky130_fd_pr__nfet_01v8 ad=0.1092 pd=1.36 as=0.1449 ps=1.11 w=0.42 l=0.15
X1597 uio_oe[0] uio_in[2] a_36919_35951# uio_oe[0] sky130_fd_pr__nfet_01v8 ad=0.08775 pd=0.92 as=0.169 ps=1.82 w=0.65 l=0.15
X1598 a_25162_34639# a_25116_34505# uio_oe[0] uio_oe[0] sky130_fd_pr__nfet_01v8 ad=0.0693 pd=0.75 as=0.11285 ps=1.045 w=0.42 l=0.15
X1599 a_51412_38823# a_51620_38645# a_51554_38671# uio_oe[0] sky130_fd_pr__nfet_01v8 ad=0.09975 pd=0.895 as=0.0693 ps=0.75 w=0.42 l=0.15
X1600 a_37029_42479# a_36999_42453# uio_oe[0] uio_oe[0] sky130_fd_pr__nfet_01v8 ad=0.08775 pd=0.92 as=0.169 ps=1.82 w=0.65 l=0.15
X1601 a_59867_38998# a_59685_38998# VDPWR VDPWR sky130_fd_pr__pfet_01v8_hvt ad=0.0441 pd=0.63 as=0.0693 ps=0.75 w=0.42 l=0.15
X1602 VDPWR a_50159_37820# a_50090_37949# VDPWR sky130_fd_pr__pfet_01v8_hvt ad=0.2184 pd=2.2 as=0.12915 ps=1.185 w=0.84 l=0.15
X1603 a_54264_41623# a_54479_41404# a_54406_41430# VDPWR sky130_fd_pr__pfet_01v8_hvt ad=0.1932 pd=1.34 as=0.07665 ps=0.785 w=0.42 l=0.15
X1604 a_37029_37583# a_36999_37557# VDPWR VDPWR sky130_fd_pr__pfet_01v8_hvt ad=0.135 pd=1.27 as=0.26 ps=2.52 w=1 l=0.15
X1605 a_43244_42857# a_42163_42485# a_42897_42453# VDPWR sky130_fd_pr__pfet_01v8_hvt ad=0.0588 pd=0.7 as=0.12915 ps=1.185 w=0.42 l=0.15
X1606 a_62267_41430# a_54479_41404# a_61808_41623# VDPWR sky130_fd_pr__pfet_01v8_hvt ad=0.0441 pd=0.63 as=0.1932 ps=1.34 w=0.42 l=0.15
X1607 VDPWR a_39544_40535# a_21068_37145# VDPWR sky130_fd_pr__pfet_01v8_hvt ad=0.15835 pd=1.395 as=0.26 ps=2.52 w=1 l=0.15
X1608 a_53321_38493# a_52942_38127# a_53249_38493# uio_oe[0] sky130_fd_pr__nfet_01v8 ad=0.1401 pd=1.1 as=0.0441 ps=0.63 w=0.42 l=0.15
X1609 uio_oe[0] a_43432_35381# a_43308_35657# uio_oe[0] sky130_fd_pr__nfet_01v8 ad=0.10025 pd=0.985 as=0.0567 ps=0.69 w=0.42 l=0.15
X1610 uio_oe[0] a_50159_40277# a_50090_40303# uio_oe[0] sky130_fd_pr__nfet_01v8 ad=0.1346 pd=1.15 as=0.0999 ps=0.985 w=0.64 l=0.15
X1611 a_42955_38671# a_42605_38671# a_42860_38671# VDPWR sky130_fd_pr__pfet_01v8_hvt ad=0.07245 pd=0.765 as=0.0651 ps=0.73 w=0.42 l=0.15
X1612 a_58082_39037# a_57324_38939# a_57519_38908# VDPWR sky130_fd_pr__pfet_01v8_hvt ad=0.0651 pd=0.73 as=0.07245 ps=0.765 w=0.42 l=0.15
X1613 a_42069_35657# a_42039_35592# a_39759_36777# VDPWR sky130_fd_pr__pfet_01v8_hvt ad=0.26 pd=2.52 as=0.3 ps=2.6 w=1 l=0.15
X1614 uio_oe[0] a_37913_41935# a_53203_35407# uio_oe[0] sky130_fd_pr__nfet_01v8 ad=0.0567 pd=0.69 as=0.1092 ps=1.36 w=0.42 l=0.15
X1615 uio_oe[0] a_50003_40545# a_49964_40419# uio_oe[0] sky130_fd_pr__nfet_01v8 ad=0.0567 pd=0.69 as=0.1092 ps=1.36 w=0.42 l=0.15
X1616 a_57012_41365# a_57472_41669# a_57430_41757# uio_oe[0] sky130_fd_pr__nfet_01v8 ad=0.0693 pd=0.75 as=0.0441 ps=0.63 w=0.42 l=0.15
X1617 uio_oe[0] a_17292_36681# a_17243_36449# uio_oe[0] sky130_fd_pr__nfet_01v8 ad=0.11285 pd=1.045 as=0.169 ps=1.82 w=0.65 l=0.15
X1618 a_57450_42479# a_57324_42595# a_57046_42611# uio_oe[0] sky130_fd_pr__special_nfet_01v8 ad=0.0999 pd=0.985 as=0.0711 ps=0.755 w=0.36 l=0.15
X1619 a_57664_38127# a_57450_38127# VDPWR VDPWR sky130_fd_pr__pfet_01v8_hvt ad=0.1155 pd=0.97 as=0.07035 ps=0.755 w=0.42 l=0.15
X1620 a_29946_36488# a_28980_36681# VDPWR VDPWR sky130_fd_pr__pfet_01v8_hvt ad=0.07665 pd=0.785 as=0.15835 ps=1.395 w=0.42 l=0.15
X1621 uio_oe[0] a_61819_36469# a_61753_36495# uio_oe[0] sky130_fd_pr__nfet_01v8 ad=0.12495 pd=1.015 as=0.0669 ps=0.75 w=0.42 l=0.15
X1622 a_29313_35659# a_28980_35593# uio_oe[0] uio_oe[0] sky130_fd_pr__nfet_01v8 ad=0.1092 pd=1.36 as=0.1449 ps=1.11 w=0.42 l=0.15
X1623 uio_oe[0] a_45351_42783# a_45285_42857# uio_oe[0] sky130_fd_pr__nfet_01v8 ad=0.12495 pd=1.015 as=0.0669 ps=0.75 w=0.42 l=0.15
X1624 VDPWR a_43419_40821# a_43406_41213# VDPWR sky130_fd_pr__pfet_01v8_hvt ad=0.0819 pd=0.81 as=0.0567 ps=0.69 w=0.42 l=0.15
X1625 a_52855_36193# a_37913_41935# uio_oe[0] uio_oe[0] sky130_fd_pr__nfet_01v8 ad=0.1092 pd=1.36 as=0.0567 ps=0.69 w=0.42 l=0.15
X1626 ua[4] a_28348_18376# a_31002_18020# uio_oe[0] sky130_fd_pr__nfet_01v8 ad=0.1885 pd=1.88 as=0.1885 ps=1.88 w=0.65 l=0.15
X1627 uio_oe[0] a_17481_32899# a_17513_32641# uio_oe[0] sky130_fd_pr__nfet_01v8 ad=0.1013 pd=0.99 as=0.0504 ps=0.66 w=0.42 l=0.15
X1628 a_52942_35951# a_52855_36193# a_52538_36083# VDPWR sky130_fd_pr__pfet_01v8_hvt ad=0.12915 pd=1.185 as=0.0588 ps=0.7 w=0.42 l=0.15
X1629 a_21287_33007# a_21107_33007# VDPWR VDPWR sky130_fd_pr__pfet_01v8_hvt ad=0.0609 pd=0.71 as=0.0714 ps=0.76 w=0.42 l=0.15
X1630 a_18148_18376# a_18711_34095# VDPWR VDPWR sky130_fd_pr__pfet_01v8_hvt ad=0.26 pd=2.52 as=0.2279 ps=1.74 w=1 l=0.15
X1631 a_54284_40847# a_53203_40847# a_53937_41089# VDPWR sky130_fd_pr__pfet_01v8_hvt ad=0.0588 pd=0.7 as=0.12915 ps=1.185 w=0.42 l=0.15
X1632 VDPWR a_51412_40535# a_50784_40277# VDPWR sky130_fd_pr__pfet_01v8_hvt ad=0.15835 pd=1.395 as=0.26 ps=2.52 w=1 l=0.15
X1633 a_57829_34319# a_57450_34685# a_57757_34319# uio_oe[0] sky130_fd_pr__nfet_01v8 ad=0.1401 pd=1.1 as=0.0441 ps=0.63 w=0.42 l=0.15
X1634 a_21875_34845# a_20923_34817# VDPWR VDPWR sky130_fd_pr__pfet_01v8_hvt ad=0.0567 pd=0.69 as=0.1176 ps=1.4 w=0.42 l=0.15
X1635 a_58914_38671# a_48677_39759# uio_oe[0] uio_oe[0] sky130_fd_pr__nfet_01v8 ad=0.0693 pd=0.75 as=0.11285 ps=1.045 w=0.42 l=0.15
X1636 ua[4] a_20620_14376# a_23274_22020# uio_oe[0] sky130_fd_pr__nfet_01v8 ad=0.1885 pd=1.88 as=0.1885 ps=1.88 w=0.65 l=0.15
X1637 a_40096_34471# a_40304_34293# a_40238_34319# uio_oe[0] sky130_fd_pr__nfet_01v8 ad=0.09975 pd=0.895 as=0.0693 ps=0.75 w=0.42 l=0.15
X1638 VDPWR a_45351_41909# a_45338_42301# VDPWR sky130_fd_pr__pfet_01v8_hvt ad=0.0819 pd=0.81 as=0.0567 ps=0.69 w=0.42 l=0.15
X1639 uio_oe[0] a_39947_42997# a_44873_40847# uio_oe[0] sky130_fd_pr__nfet_01v8 ad=0.1346 pd=1.15 as=0.0441 ps=0.63 w=0.42 l=0.15
X1640 a_41381_39581# a_40379_35551# uio_oe[0] uio_oe[0] sky130_fd_pr__nfet_01v8 ad=0.0441 pd=0.63 as=0.1346 ps=1.15 w=0.42 l=0.15
X1641 a_38073_38166# a_36425_35078# a_37859_38166# VDPWR sky130_fd_pr__pfet_01v8_hvt ad=0.07665 pd=0.785 as=0.1932 ps=1.34 w=0.42 l=0.15
X1642 VDPWR a_49483_40821# a_39752_40821# VDPWR sky130_fd_pr__pfet_01v8_hvt ad=0.3012 pd=2.66 as=0.26 ps=2.52 w=1 l=0.15
X1643 uio_oe[0] a_44339_37735# a_42613_37052# uio_oe[0] sky130_fd_pr__nfet_01v8 ad=0.1118 pd=1.04 as=0.182 ps=1.86 w=0.65 l=0.15
X1644 VDPWR a_61644_37583# a_61819_37557# VDPWR sky130_fd_pr__pfet_01v8_hvt ad=0.1134 pd=1.38 as=0.0567 ps=0.69 w=0.42 l=0.15
X1645 a_21298_36488# a_21252_36681# VDPWR VDPWR sky130_fd_pr__pfet_01v8_hvt ad=0.07665 pd=0.785 as=0.15835 ps=1.395 w=0.42 l=0.15
X1646 a_38285_36495# a_38019_36861# uio_oe[0] uio_oe[0] sky130_fd_pr__nfet_01v8 ad=0.169 pd=1.82 as=0.1013 ps=0.99 w=0.65 l=0.15
X1647 uio_oe[0] a_42457_36249# a_42391_36317# uio_oe[0] sky130_fd_pr__nfet_01v8 ad=0.1449 pd=1.11 as=0.0693 ps=0.75 w=0.42 l=0.15
X1648 VDPWR a_38961_36469# a_38991_36822# VDPWR sky130_fd_pr__pfet_01v8_hvt ad=0.0693 pd=0.75 as=0.0441 ps=0.63 w=0.42 l=0.15
X1649 a_37913_41935# a_37747_41935# uio_oe[0] uio_oe[0] sky130_fd_pr__nfet_01v8 ad=0.08775 pd=0.92 as=0.08775 ps=0.92 w=0.65 l=0.15
X1650 VDPWR a_60215_38369# a_60176_38243# VDPWR sky130_fd_pr__pfet_01v8_hvt ad=0.0864 pd=0.91 as=0.1664 ps=1.8 w=0.64 l=0.15
X1651 a_53369_37583# a_53203_37583# uio_oe[0] uio_oe[0] sky130_fd_pr__nfet_01v8 ad=0.1092 pd=1.36 as=0.0567 ps=0.69 w=0.42 l=0.15
X1652 a_36499_36647# a_36447_40849# uio_oe[0] uio_oe[0] sky130_fd_pr__nfet_01v8 ad=0.1092 pd=1.36 as=0.1575 ps=1.17 w=0.42 l=0.15
X1653 a_57081_34319# a_57046_34571# a_56843_34293# uio_oe[0] sky130_fd_pr__nfet_01v8 ad=0.06405 pd=0.725 as=0.1092 ps=1.36 w=0.42 l=0.15
X1654 a_51841_39513# a_48677_39759# VDPWR VDPWR sky130_fd_pr__pfet_01v8_hvt ad=0.1176 pd=1.4 as=0.0693 ps=0.75 w=0.42 l=0.15
X1655 a_39907_41935# a_39759_41129# a_39544_42087# uio_oe[0] sky130_fd_pr__nfet_01v8 ad=0.0693 pd=0.75 as=0.09975 ps=0.895 w=0.42 l=0.15
X1656 uio_oe[0] a_39947_42997# a_46805_41935# uio_oe[0] sky130_fd_pr__nfet_01v8 ad=0.1346 pd=1.15 as=0.0441 ps=0.63 w=0.42 l=0.15
X1657 a_57519_41084# a_57363_40989# a_57664_41213# VDPWR sky130_fd_pr__pfet_01v8_hvt ad=0.07245 pd=0.765 as=0.1155 ps=0.97 w=0.42 l=0.15
X1658 a_49686_40435# a_49964_40419# a_49920_40303# VDPWR sky130_fd_pr__pfet_01v8_hvt ad=0.0588 pd=0.7 as=0.0567 ps=0.69 w=0.42 l=0.15
X1659 a_60371_38101# a_60215_38369# a_60516_38127# VDPWR sky130_fd_pr__pfet_01v8_hvt ad=0.07245 pd=0.765 as=0.1155 ps=0.97 w=0.42 l=0.15
X1660 a_42851_37583# a_37851_36647# a_42488_37735# uio_oe[0] sky130_fd_pr__nfet_01v8 ad=0.0693 pd=0.75 as=0.09975 ps=0.895 w=0.42 l=0.15
X1661 a_62171_37405# a_58980_37557# a_61808_37271# uio_oe[0] sky130_fd_pr__nfet_01v8 ad=0.0693 pd=0.75 as=0.09975 ps=0.895 w=0.42 l=0.15
X1662 a_18641_35659# a_17388_35593# uio_oe[0] uio_oe[0] sky130_fd_pr__nfet_01v8 ad=0.1092 pd=1.36 as=0.1449 ps=1.11 w=0.42 l=0.15
X1663 a_60215_40545# a_37913_43023# VDPWR VDPWR sky130_fd_pr__pfet_01v8_hvt ad=0.1664 pd=1.8 as=0.0864 ps=0.91 w=0.64 l=0.15
X1664 a_53827_39037# a_53203_38671# a_53719_38671# VDPWR sky130_fd_pr__pfet_01v8_hvt ad=0.1155 pd=0.97 as=0.07245 ps=0.765 w=0.42 l=0.15
X1665 a_60638_37039# a_60416_37317# a_59956_37013# VDPWR sky130_fd_pr__pfet_01v8_hvt ad=0.0483 pd=0.65 as=0.0819 ps=0.81 w=0.42 l=0.15
X1666 VDPWR a_43244_42857# a_43419_42783# VDPWR sky130_fd_pr__pfet_01v8_hvt ad=0.1134 pd=1.38 as=0.0567 ps=0.69 w=0.42 l=0.15
X1667 a_54638_39759# a_48125_41935# uio_oe[0] uio_oe[0] sky130_fd_pr__nfet_01v8 ad=0.06405 pd=0.725 as=0.12495 ps=1.015 w=0.42 l=0.15
X1668 VDPWR a_37851_36647# a_38019_35773# VDPWR sky130_fd_pr__pfet_01v8_hvt ad=0.2279 pd=1.74 as=0.0609 ps=0.71 w=0.42 l=0.15
X1669 VDPWR a_17537_33703# a_17567_34056# VDPWR sky130_fd_pr__pfet_01v8_hvt ad=0.0693 pd=0.75 as=0.0441 ps=0.63 w=0.42 l=0.15
X1670 uio_oe[0] a_39544_42087# a_17204_36057# uio_oe[0] sky130_fd_pr__nfet_01v8 ad=0.11285 pd=1.045 as=0.169 ps=1.82 w=0.65 l=0.15
X1671 a_59933_36317# a_59898_36083# a_59695_35925# uio_oe[0] sky130_fd_pr__nfet_01v8 ad=0.06405 pd=0.725 as=0.1092 ps=1.36 w=0.42 l=0.15
X1672 a_57450_36861# a_57324_36763# a_57046_36747# uio_oe[0] sky130_fd_pr__special_nfet_01v8 ad=0.0999 pd=0.985 as=0.0711 ps=0.755 w=0.36 l=0.15
X1673 a_17513_32641# a_17243_33007# a_17423_33007# uio_oe[0] sky130_fd_pr__nfet_01v8 ad=0.0504 pd=0.66 as=0.1092 ps=1.36 w=0.42 l=0.15
X1674 VDPWR a_48125_41935# a_53156_41391# VDPWR sky130_fd_pr__pfet_01v8_hvt ad=0.07035 pd=0.755 as=0.1092 ps=1.36 w=0.42 l=0.15
X1675 a_42768_39581# a_42651_39386# uio_oe[0] uio_oe[0] sky130_fd_pr__nfet_01v8 ad=0.066 pd=0.745 as=0.2205 ps=1.89 w=0.42 l=0.15
X1676 a_43501_36523# a_37795_40535# uio_oe[0] uio_oe[0] sky130_fd_pr__nfet_01v8 ad=0.0567 pd=0.69 as=0.1118 ps=1.04 w=0.42 l=0.15
X1677 a_47217_43023# a_46027_43023# a_47108_43023# uio_oe[0] sky130_fd_pr__special_nfet_01v8 ad=0.0669 pd=0.75 as=0.0711 ps=0.755 w=0.36 l=0.15
X1678 a_60984_39759# a_60365_39759# uio_oe[0] uio_oe[0] sky130_fd_pr__nfet_01v8 ad=0.066 pd=0.745 as=0.2205 ps=1.89 w=0.42 l=0.15
X1679 uio_oe[0] a_57519_38101# a_57450_38127# uio_oe[0] sky130_fd_pr__nfet_01v8 ad=0.1346 pd=1.15 as=0.0999 ps=0.985 w=0.64 l=0.15
X1680 a_24484_14782# a_26439_36271# VDPWR VDPWR sky130_fd_pr__pfet_01v8_hvt ad=0.26 pd=2.52 as=0.2279 ps=1.74 w=1 l=0.15
X1681 a_25162_33551# a_25116_33417# uio_oe[0] uio_oe[0] sky130_fd_pr__nfet_01v8 ad=0.0693 pd=0.75 as=0.11285 ps=1.045 w=0.42 l=0.15
X1682 uio_oe[0] a_39973_39733# a_39907_39759# uio_oe[0] sky130_fd_pr__nfet_01v8 ad=0.1449 pd=1.11 as=0.0693 ps=0.75 w=0.42 l=0.15
X1683 uio_oe[0] a_46193_39759# a_53981_36495# uio_oe[0] sky130_fd_pr__nfet_01v8 ad=0.1346 pd=1.15 as=0.0441 ps=0.63 w=0.42 l=0.15
X1684 uio_oe[0] a_25417_32641# a_25825_34845# uio_oe[0] sky130_fd_pr__nfet_01v8 ad=0.1118 pd=1.04 as=0.0567 ps=0.69 w=0.42 l=0.15
X1685 a_59898_42611# a_60176_42595# a_60132_42479# VDPWR sky130_fd_pr__pfet_01v8_hvt ad=0.0588 pd=0.7 as=0.0567 ps=0.69 w=0.42 l=0.15
X1686 a_51775_41935# a_39752_41909# a_51412_42087# uio_oe[0] sky130_fd_pr__nfet_01v8 ad=0.0693 pd=0.75 as=0.09975 ps=0.895 w=0.42 l=0.15
X1687 uio_oe[0] a_36661_41391# a_52800_39759# uio_oe[0] sky130_fd_pr__nfet_01v8 ad=0.11285 pd=1.045 as=0.0693 ps=0.75 w=0.42 l=0.15
X1688 a_39686_37078# a_37029_37583# VDPWR VDPWR sky130_fd_pr__pfet_01v8_hvt ad=0.07665 pd=0.785 as=0.15835 ps=1.395 w=0.42 l=0.15
X1689 a_59956_37013# a_60416_37317# a_60374_37405# uio_oe[0] sky130_fd_pr__nfet_01v8 ad=0.0693 pd=0.75 as=0.0441 ps=0.63 w=0.42 l=0.15
X1690 a_21114_36232# a_21068_36057# VDPWR VDPWR sky130_fd_pr__pfet_01v8_hvt ad=0.07665 pd=0.785 as=0.15835 ps=1.395 w=0.42 l=0.15
X1691 uio_oe[0] a_28884_34505# a_28835_34273# uio_oe[0] sky130_fd_pr__nfet_01v8 ad=0.11285 pd=1.045 as=0.169 ps=1.82 w=0.65 l=0.15
X1692 a_43244_41769# a_42163_41397# a_42897_41365# VDPWR sky130_fd_pr__pfet_01v8_hvt ad=0.0588 pd=0.7 as=0.12915 ps=1.185 w=0.42 l=0.15
X1693 a_45285_41769# a_44095_41397# a_45176_41769# uio_oe[0] sky130_fd_pr__special_nfet_01v8 ad=0.0669 pd=0.75 as=0.0711 ps=0.755 w=0.36 l=0.15
X1694 a_51841_38645# a_48677_39759# VDPWR VDPWR sky130_fd_pr__pfet_01v8_hvt ad=0.1176 pd=1.4 as=0.0693 ps=0.75 w=0.42 l=0.15
X1695 uio_oe[0] a_17537_36967# a_17471_36993# uio_oe[0] sky130_fd_pr__nfet_01v8 ad=0.1449 pd=1.11 as=0.0693 ps=0.75 w=0.42 l=0.15
X1696 uio_oe[0] a_51412_42087# a_50784_42184# uio_oe[0] sky130_fd_pr__nfet_01v8 ad=0.11285 pd=1.045 as=0.169 ps=1.82 w=0.65 l=0.15
X1697 a_40920_35773# a_40706_35773# VDPWR VDPWR sky130_fd_pr__pfet_01v8_hvt ad=0.1155 pd=0.97 as=0.07035 ps=0.755 w=0.42 l=0.15
X1698 uio_oe[0] a_54693_38425# a_54627_38493# uio_oe[0] sky130_fd_pr__nfet_01v8 ad=0.1449 pd=1.11 as=0.0693 ps=0.75 w=0.42 l=0.15
X1699 VDPWR a_58772_38359# a_58144_38101# VDPWR sky130_fd_pr__pfet_01v8_hvt ad=0.15835 pd=1.395 as=0.26 ps=2.52 w=1 l=0.15
X1700 a_37787_37910# a_37605_37910# VDPWR VDPWR sky130_fd_pr__pfet_01v8_hvt ad=0.0441 pd=0.63 as=0.0693 ps=0.75 w=0.42 l=0.15
X1701 uio_oe[0] a_16812_8642# a_27266_20730# uio_oe[0] sky130_fd_pr__nfet_01v8 ad=1.4703 pd=10.72 as=1.4703 ps=10.72 w=5.07 l=1
X1702 a_52813_40669# a_52335_40277# uio_oe[0] uio_oe[0] sky130_fd_pr__nfet_01v8 ad=0.0669 pd=0.75 as=0.12495 ps=1.015 w=0.42 l=0.15
X1703 a_43520_38671# a_42439_38671# a_43173_38913# VDPWR sky130_fd_pr__pfet_01v8_hvt ad=0.0588 pd=0.7 as=0.12915 ps=1.185 w=0.42 l=0.15
X1704 a_38991_37078# a_38740_37307# a_38532_37271# VDPWR sky130_fd_pr__pfet_01v8_hvt ad=0.0441 pd=0.63 as=0.1932 ps=1.34 w=0.42 l=0.15
X1705 a_47217_42857# a_46027_42485# a_47108_42857# uio_oe[0] sky130_fd_pr__special_nfet_01v8 ad=0.0669 pd=0.75 as=0.0711 ps=0.755 w=0.36 l=0.15
X1706 a_38532_37271# a_38740_37307# a_38674_37405# uio_oe[0] sky130_fd_pr__nfet_01v8 ad=0.09975 pd=0.895 as=0.0693 ps=0.75 w=0.42 l=0.15
X1707 a_54284_34319# a_53203_34319# a_53937_34561# VDPWR sky130_fd_pr__pfet_01v8_hvt ad=0.0588 pd=0.7 as=0.12915 ps=1.185 w=0.42 l=0.15
X1708 VDPWR a_43156_34293# a_43114_34569# VDPWR sky130_fd_pr__pfet_01v8_hvt ad=0.14575 pd=1.335 as=0.0441 ps=0.63 w=0.42 l=0.15
X1709 uio_oe[0] a_18427_33198# a_17507_33198# uio_oe[0] sky130_fd_pr__nfet_01v8 ad=0.169 pd=1.82 as=0.169 ps=1.82 w=0.65 l=0.15
X1710 VDPWR a_37661_38140# a_38073_38166# VDPWR sky130_fd_pr__pfet_01v8_hvt ad=0.15835 pd=1.395 as=0.07665 ps=0.785 w=0.42 l=0.15
X1711 uio_oe[0] a_49483_38101# a_38740_38395# uio_oe[0] sky130_fd_pr__nfet_01v8 ad=0.2087 pd=2.02 as=0.169 ps=1.82 w=0.65 l=0.15
X1712 uio_oe[0] a_17292_35593# a_17243_35361# uio_oe[0] sky130_fd_pr__nfet_01v8 ad=0.11285 pd=1.045 as=0.169 ps=1.82 w=0.65 l=0.15
X1713 uio_oe[0] a_51841_39733# a_51775_39759# uio_oe[0] sky130_fd_pr__nfet_01v8 ad=0.1449 pd=1.11 as=0.0693 ps=0.75 w=0.42 l=0.15
X1714 a_29063_34817# a_28835_34273# a_28700_34969# uio_oe[0] sky130_fd_pr__nfet_01v8 ad=0.0693 pd=0.75 as=0.09975 ps=0.895 w=0.42 l=0.15
X1715 a_30303_37359# a_30123_37359# VDPWR VDPWR sky130_fd_pr__pfet_01v8_hvt ad=0.0609 pd=0.71 as=0.0714 ps=0.76 w=0.42 l=0.15
X1716 a_51554_37078# a_48677_38127# VDPWR VDPWR sky130_fd_pr__pfet_01v8_hvt ad=0.07665 pd=0.785 as=0.15835 ps=1.395 w=0.42 l=0.15
X1717 a_57472_41669# a_38649_43023# VDPWR VDPWR sky130_fd_pr__pfet_01v8_hvt ad=0.1664 pd=1.8 as=0.0864 ps=0.91 w=0.64 l=0.15
X1718 a_41677_40847# a_37795_40535# a_41593_40847# uio_oe[0] sky130_fd_pr__nfet_01v8 ad=0.25025 pd=1.42 as=0.08775 ps=0.92 w=0.65 l=0.15
X1719 a_53574_35951# a_52816_36067# a_53011_35925# VDPWR sky130_fd_pr__pfet_01v8_hvt ad=0.0651 pd=0.73 as=0.07245 ps=0.765 w=0.42 l=0.15
X1720 a_40769_38671# a_39127_34319# VDPWR VDPWR sky130_fd_pr__pfet_01v8_hvt ad=0.12495 pd=1.175 as=0.2184 ps=2.2 w=0.84 l=0.15
X1721 uio_oe[0] a_36427_36475# a_37387_36745# uio_oe[0] sky130_fd_pr__nfet_01v8 ad=0.10187 pd=0.99 as=0.0567 ps=0.69 w=0.42 l=0.15
X1722 a_61819_37557# a_61644_37583# a_61998_37583# uio_oe[0] sky130_fd_pr__nfet_01v8 ad=0.1092 pd=1.36 as=0.06405 ps=0.725 w=0.42 l=0.15
X1723 a_37641_35407# a_37375_35773# VDPWR VDPWR sky130_fd_pr__pfet_01v8_hvt ad=0.26 pd=2.52 as=0.2279 ps=1.74 w=1 l=0.15
X1724 a_57519_34556# a_57363_34461# a_57664_34685# VDPWR sky130_fd_pr__pfet_01v8_hvt ad=0.07245 pd=0.765 as=0.1155 ps=0.97 w=0.42 l=0.15
X1725 a_37042_34863# a_36956_35095# VDPWR VDPWR sky130_fd_pr__pfet_01v8_hvt ad=0.26 pd=2.52 as=0.26 ps=2.52 w=1 l=0.15
X1726 a_58772_35559# a_58980_35381# a_58914_35407# uio_oe[0] sky130_fd_pr__nfet_01v8 ad=0.09975 pd=0.895 as=0.0693 ps=0.75 w=0.42 l=0.15
X1727 a_40467_39189# a_40670_39347# VDPWR VDPWR sky130_fd_pr__pfet_01v8_hvt ad=0.0567 pd=0.69 as=0.1134 ps=1.38 w=0.42 l=0.15
X1728 a_56916_39447# a_57012_39189# uio_oe[0] uio_oe[0] sky130_fd_pr__nfet_01v8 ad=0.1092 pd=1.36 as=0.097 ps=0.975 w=0.42 l=0.15
X1729 VDPWR a_61644_36495# a_61819_36469# VDPWR sky130_fd_pr__pfet_01v8_hvt ad=0.1134 pd=1.38 as=0.0567 ps=0.69 w=0.42 l=0.15
X1730 uio_oe[0] a_57363_42721# a_57324_42595# uio_oe[0] sky130_fd_pr__nfet_01v8 ad=0.0567 pd=0.69 as=0.1092 ps=1.36 w=0.42 l=0.15
X1731 VDPWR a_56916_39447# a_39752_39483# VDPWR sky130_fd_pr__pfet_01v8_hvt ad=0.149 pd=1.325 as=0.26 ps=2.52 w=1 l=0.15
X1732 a_39686_42262# a_38005_40847# VDPWR VDPWR sky130_fd_pr__pfet_01v8_hvt ad=0.07665 pd=0.785 as=0.15835 ps=1.395 w=0.42 l=0.15
X1733 a_52942_41391# a_52816_41507# a_52538_41523# uio_oe[0] sky130_fd_pr__special_nfet_01v8 ad=0.0999 pd=0.985 as=0.0711 ps=0.755 w=0.36 l=0.15
X1734 uio_oe[0] a_59956_41365# a_60092_41391# uio_oe[0] sky130_fd_pr__nfet_01v8 ad=0.1137 pd=1.01 as=0.1404 ps=1.6 w=0.54 l=0.15
X1735 a_57450_38127# a_57363_38369# a_57046_38259# VDPWR sky130_fd_pr__pfet_01v8_hvt ad=0.12915 pd=1.185 as=0.0588 ps=0.7 w=0.42 l=0.15
X1736 a_25162_34312# a_25116_34505# VDPWR VDPWR sky130_fd_pr__pfet_01v8_hvt ad=0.07665 pd=0.785 as=0.15835 ps=1.395 w=0.42 l=0.15
X1737 a_52579_42262# a_51620_41909# a_52507_42262# VDPWR sky130_fd_pr__pfet_01v8_hvt ad=0.1932 pd=1.34 as=0.0441 ps=0.63 w=0.42 l=0.15
X1738 VDPWR a_17255_32793# a_24971_33007# VDPWR sky130_fd_pr__pfet_01v8_hvt ad=0.0714 pd=0.76 as=0.1092 ps=1.36 w=0.42 l=0.15
X1739 uio_oe[0] a_48125_41935# a_52573_40669# uio_oe[0] sky130_fd_pr__nfet_01v8 ad=0.12495 pd=1.015 as=0.06405 ps=0.725 w=0.42 l=0.15
X1740 a_43173_38913# a_42955_38671# uio_oe[0] uio_oe[0] sky130_fd_pr__nfet_01v8 ad=0.0999 pd=0.985 as=0.1346 ps=1.15 w=0.64 l=0.15
X1741 a_54284_34319# a_53369_34319# a_53937_34561# uio_oe[0] sky130_fd_pr__special_nfet_01v8 ad=0.0711 pd=0.755 as=0.0999 ps=0.985 w=0.36 l=0.15
X1742 a_58864_35095# a_39647_34877# a_59006_34902# VDPWR sky130_fd_pr__pfet_01v8_hvt ad=0.1932 pd=1.34 as=0.07665 ps=0.785 w=0.42 l=0.15
X1743 uio_oe[0] a_38005_41391# a_44095_43023# uio_oe[0] sky130_fd_pr__nfet_01v8 ad=0.0567 pd=0.69 as=0.1092 ps=1.36 w=0.42 l=0.15
X1744 a_41444_38671# a_40864_38671# uio_oe[0] uio_oe[0] sky130_fd_pr__nfet_01v8 ad=0.0441 pd=0.63 as=0.1092 ps=1.36 w=0.42 l=0.15
X1745 a_45176_43023# a_44095_43023# a_44829_43265# VDPWR sky130_fd_pr__pfet_01v8_hvt ad=0.0588 pd=0.7 as=0.12915 ps=1.185 w=0.42 l=0.15
X1746 a_53815_41935# a_53369_41935# a_53719_41935# uio_oe[0] sky130_fd_pr__special_nfet_01v8 ad=0.1401 pd=1.1 as=0.0594 ps=0.69 w=0.36 l=0.15
X1747 VDPWR a_43244_41769# a_43419_41695# VDPWR sky130_fd_pr__pfet_01v8_hvt ad=0.1134 pd=1.38 as=0.0567 ps=0.69 w=0.42 l=0.15
X1748 a_54638_38671# a_48125_41935# uio_oe[0] uio_oe[0] sky130_fd_pr__nfet_01v8 ad=0.06405 pd=0.725 as=0.12495 ps=1.015 w=0.42 l=0.15
X1749 a_41658_36861# a_40581_36495# a_41496_36495# VDPWR sky130_fd_pr__pfet_01v8_hvt ad=0.0567 pd=0.69 as=0.0588 ps=0.7 w=0.42 l=0.15
X1750 uio_oe[0] a_21553_32641# a_22665_34817# uio_oe[0] sky130_fd_pr__nfet_01v8 ad=0.1013 pd=0.99 as=0.0504 ps=0.66 w=0.42 l=0.15
X1751 a_62053_42777# a_36661_41391# VDPWR VDPWR sky130_fd_pr__pfet_01v8_hvt ad=0.1176 pd=1.4 as=0.0693 ps=0.75 w=0.42 l=0.15
X1752 a_57046_42187# a_57324_42203# a_57280_42301# VDPWR sky130_fd_pr__pfet_01v8_hvt ad=0.0588 pd=0.7 as=0.0567 ps=0.69 w=0.42 l=0.15
X1753 a_20972_36057# a_21107_35361# a_21114_36232# VDPWR sky130_fd_pr__pfet_01v8_hvt ad=0.1932 pd=1.34 as=0.07665 ps=0.785 w=0.42 l=0.15
X1754 a_42793_35559# a_37795_40535# a_42956_35657# VDPWR sky130_fd_pr__pfet_01v8_hvt ad=0.1092 pd=1.36 as=0.0441 ps=0.63 w=0.42 l=0.15
X1755 a_38991_42262# a_38740_41909# a_38532_42087# VDPWR sky130_fd_pr__pfet_01v8_hvt ad=0.0441 pd=0.63 as=0.1932 ps=1.34 w=0.42 l=0.15
X1756 a_38961_40821# a_38005_40847# VDPWR VDPWR sky130_fd_pr__pfet_01v8_hvt ad=0.1176 pd=1.4 as=0.0693 ps=0.75 w=0.42 l=0.15
X1757 a_44399_40474# a_45351_40821# uio_oe[0] uio_oe[0] sky130_fd_pr__nfet_01v8 ad=0.169 pd=1.82 as=0.2087 ps=2.02 w=0.65 l=0.15
X1758 a_50159_39996# a_49964_40027# a_50469_39759# uio_oe[0] sky130_fd_pr__special_nfet_01v8 ad=0.0594 pd=0.69 as=0.1401 ps=1.1 w=0.36 l=0.15
X1759 a_43051_38671# a_42605_38671# a_42955_38671# uio_oe[0] sky130_fd_pr__special_nfet_01v8 ad=0.1401 pd=1.1 as=0.0594 ps=0.69 w=0.36 l=0.15
X1760 a_39544_37271# a_38285_37583# a_39686_37078# VDPWR sky130_fd_pr__pfet_01v8_hvt ad=0.1932 pd=1.34 as=0.07665 ps=0.785 w=0.42 l=0.15
X1761 a_41085_35407# a_40706_35773# a_41013_35407# uio_oe[0] sky130_fd_pr__nfet_01v8 ad=0.1401 pd=1.1 as=0.0441 ps=0.63 w=0.42 l=0.15
X1762 a_42584_41935# ui_in[2] uio_oe[0] uio_oe[0] sky130_fd_pr__nfet_01v8 ad=0.066 pd=0.745 as=0.2205 ps=1.89 w=0.42 l=0.15
X1763 a_54723_39254# a_51620_39483# a_54264_39447# VDPWR sky130_fd_pr__pfet_01v8_hvt ad=0.0441 pd=0.63 as=0.1932 ps=1.34 w=0.42 l=0.15
X1764 a_50003_38369# a_41685_42479# VDPWR VDPWR sky130_fd_pr__pfet_01v8_hvt ad=0.1664 pd=1.8 as=0.0864 ps=0.91 w=0.64 l=0.15
X1765 a_21401_36967# a_21068_37145# uio_oe[0] uio_oe[0] sky130_fd_pr__nfet_01v8 ad=0.1092 pd=1.36 as=0.1449 ps=1.11 w=0.42 l=0.15
X1766 a_58044_35229# a_57776_35229# uio_oe[0] uio_oe[0] sky130_fd_pr__nfet_01v8 ad=0.06705 pd=0.75 as=0.0882 ps=0.84 w=0.42 l=0.15
X1767 uio_oe[0] a_50784_34837# a_50722_34863# uio_oe[0] sky130_fd_pr__nfet_01v8 ad=0.2205 pd=1.89 as=0.066 ps=0.745 w=0.42 l=0.15
X1768 a_41381_39759# a_40379_35551# uio_oe[0] uio_oe[0] sky130_fd_pr__nfet_01v8 ad=0.0441 pd=0.63 as=0.1346 ps=1.15 w=0.42 l=0.15
X1769 uio_oe[0] a_58772_39911# a_58144_40008# uio_oe[0] sky130_fd_pr__nfet_01v8 ad=0.11285 pd=1.045 as=0.169 ps=1.82 w=0.65 l=0.15
X1770 a_61297_40001# a_61079_39759# uio_oe[0] uio_oe[0] sky130_fd_pr__nfet_01v8 ad=0.0999 pd=0.985 as=0.1346 ps=1.15 w=0.64 l=0.15
X1771 VDPWR a_43520_38671# a_43695_38645# VDPWR sky130_fd_pr__pfet_01v8_hvt ad=0.1134 pd=1.38 as=0.0567 ps=0.69 w=0.42 l=0.15
X1772 a_60984_38671# a_60365_38671# uio_oe[0] uio_oe[0] sky130_fd_pr__nfet_01v8 ad=0.066 pd=0.745 as=0.2205 ps=1.89 w=0.42 l=0.15
X1773 a_44829_40277# a_44611_40681# uio_oe[0] uio_oe[0] sky130_fd_pr__nfet_01v8 ad=0.0999 pd=0.985 as=0.1346 ps=1.15 w=0.64 l=0.15
X1774 a_51554_42262# a_48677_39759# VDPWR VDPWR sky130_fd_pr__pfet_01v8_hvt ad=0.07665 pd=0.785 as=0.15835 ps=1.395 w=0.42 l=0.15
X1775 uio_oe[0] a_39973_38645# a_39907_38671# uio_oe[0] sky130_fd_pr__nfet_01v8 ad=0.1449 pd=1.11 as=0.0693 ps=0.75 w=0.42 l=0.15
X1776 a_43525_37359# a_41141_40316# uio_oe[0] uio_oe[0] sky130_fd_pr__nfet_01v8 ad=0.08775 pd=0.92 as=0.08775 ps=0.92 w=0.65 l=0.15
X1777 a_53249_37405# a_46193_39759# uio_oe[0] uio_oe[0] sky130_fd_pr__nfet_01v8 ad=0.0441 pd=0.63 as=0.1346 ps=1.15 w=0.42 l=0.15
X1778 a_25265_35879# a_24932_36057# uio_oe[0] uio_oe[0] sky130_fd_pr__nfet_01v8 ad=0.1092 pd=1.36 as=0.1449 ps=1.11 w=0.42 l=0.15
X1779 VDPWR a_48125_41935# a_60516_40303# VDPWR sky130_fd_pr__pfet_01v8_hvt ad=0.07035 pd=0.755 as=0.1092 ps=1.36 w=0.42 l=0.15
X1780 a_60720_39581# a_60584_39529# VDPWR VDPWR sky130_fd_pr__pfet_01v8_hvt ad=0.0567 pd=0.69 as=0.0567 ps=0.69 w=0.42 l=0.15
X1781 uio_oe[0] a_36661_41391# a_52800_38671# uio_oe[0] sky130_fd_pr__nfet_01v8 ad=0.11285 pd=1.045 as=0.0693 ps=0.75 w=0.42 l=0.15
X1782 a_29313_35659# a_28980_35593# VDPWR VDPWR sky130_fd_pr__pfet_01v8_hvt ad=0.1176 pd=1.4 as=0.0693 ps=0.75 w=0.42 l=0.15
X1783 uio_oe[0] uio_oe[0] uio_oe[0] uio_oe[0] sky130_fd_pr__nfet_01v8 ad=0.1885 pd=1.88 as=0 ps=0 w=0.65 l=0.15
X1784 a_18097_33757# a_17059_33729# a_18011_33757# uio_oe[0] sky130_fd_pr__nfet_01v8 ad=0.0567 pd=0.69 as=0.1176 ps=1.4 w=0.42 l=0.15
X1785 VDPWR a_36503_34293# a_36327_34293# VDPWR sky130_fd_pr__pfet_01v8_hvt ad=0.0714 pd=0.76 as=0.0609 ps=0.71 w=0.42 l=0.15
X1786 ua[5] a_24484_14376# a_24354_14020# uio_oe[0] sky130_fd_pr__nfet_01v8 ad=0.1885 pd=1.88 as=0.1885 ps=1.88 w=0.65 l=0.15
X1787 a_45285_40681# a_44095_40309# a_45176_40681# uio_oe[0] sky130_fd_pr__special_nfet_01v8 ad=0.0669 pd=0.75 as=0.0711 ps=0.755 w=0.36 l=0.15
X1788 a_43419_42997# a_40379_35551# VDPWR VDPWR sky130_fd_pr__pfet_01v8_hvt ad=0.0567 pd=0.69 as=0.0819 ps=0.81 w=0.42 l=0.15
X1789 uio_oe[0] a_46193_39759# a_61341_35407# uio_oe[0] sky130_fd_pr__nfet_01v8 ad=0.1346 pd=1.15 as=0.0441 ps=0.63 w=0.42 l=0.15
X1790 VDPWR a_49483_42453# a_38740_42747# VDPWR sky130_fd_pr__pfet_01v8_hvt ad=0.3012 pd=2.66 as=0.26 ps=2.52 w=1 l=0.15
X1791 VDPWR a_48125_43023# a_50304_39215# VDPWR sky130_fd_pr__pfet_01v8_hvt ad=0.07035 pd=0.755 as=0.1092 ps=1.36 w=0.42 l=0.15
X1792 a_51412_37271# a_38740_37307# a_51554_37078# VDPWR sky130_fd_pr__pfet_01v8_hvt ad=0.1932 pd=1.34 as=0.07665 ps=0.785 w=0.42 l=0.15
X1793 VDPWR a_50159_38101# a_50090_38127# VDPWR sky130_fd_pr__pfet_01v8_hvt ad=0.2184 pd=2.2 as=0.12915 ps=1.185 w=0.84 l=0.15
X1794 a_61079_36495# a_60563_36495# a_60984_36495# uio_oe[0] sky130_fd_pr__special_nfet_01v8 ad=0.0594 pd=0.69 as=0.066 ps=0.745 w=0.36 l=0.15
X1795 uio_oe[0] a_17721_35659# a_17655_35727# uio_oe[0] sky130_fd_pr__nfet_01v8 ad=0.1449 pd=1.11 as=0.0693 ps=0.75 w=0.42 l=0.15
X1796 VDPWR a_53011_42453# a_52942_42479# VDPWR sky130_fd_pr__pfet_01v8_hvt ad=0.2184 pd=2.2 as=0.12915 ps=1.185 w=0.84 l=0.15
X1797 a_52335_37013# a_52538_37171# VDPWR VDPWR sky130_fd_pr__pfet_01v8_hvt ad=0.0567 pd=0.69 as=0.1134 ps=1.38 w=0.42 l=0.15
X1798 a_22665_34817# a_22395_35183# a_22575_35183# uio_oe[0] sky130_fd_pr__nfet_01v8 ad=0.0504 pd=0.66 as=0.1092 ps=1.36 w=0.42 l=0.15
X1799 uio_oe[0] a_36661_41391# a_59685_42262# uio_oe[0] sky130_fd_pr__nfet_01v8 ad=0.1449 pd=1.11 as=0.1092 ps=1.36 w=0.42 l=0.15
X1800 a_25383_34639# a_17507_33198# a_25020_34505# uio_oe[0] sky130_fd_pr__nfet_01v8 ad=0.0693 pd=0.75 as=0.09975 ps=0.895 w=0.42 l=0.15
X1801 VDPWR a_36327_34837# a_25209_32899# VDPWR sky130_fd_pr__pfet_01v8_hvt ad=0.2279 pd=1.74 as=0.26 ps=2.52 w=1 l=0.15
X1802 a_42768_39759# a_42149_37039# uio_oe[0] uio_oe[0] sky130_fd_pr__nfet_01v8 ad=0.066 pd=0.745 as=0.2205 ps=1.89 w=0.42 l=0.15
X1803 a_49686_37171# a_50003_37281# a_49961_37405# uio_oe[0] sky130_fd_pr__special_nfet_01v8 ad=0.0711 pd=0.755 as=0.0669 ps=0.75 w=0.36 l=0.15
X1804 a_37029_42479# a_36999_42453# uio_oe[0] uio_oe[0] sky130_fd_pr__nfet_01v8 ad=0.08775 pd=0.92 as=0.08775 ps=0.92 w=0.65 l=0.15
X1805 a_50397_40847# a_48125_43023# uio_oe[0] uio_oe[0] sky130_fd_pr__nfet_01v8 ad=0.0441 pd=0.63 as=0.1346 ps=1.15 w=0.42 l=0.15
X1806 a_57321_40847# a_56843_40821# uio_oe[0] uio_oe[0] sky130_fd_pr__nfet_01v8 ad=0.0669 pd=0.75 as=0.12495 ps=1.015 w=0.42 l=0.15
X1807 a_42955_38671# a_42439_38671# a_42860_38671# uio_oe[0] sky130_fd_pr__special_nfet_01v8 ad=0.0594 pd=0.69 as=0.066 ps=0.745 w=0.36 l=0.15
X1808 uio_oe[0] a_51841_38645# a_51775_38671# uio_oe[0] sky130_fd_pr__nfet_01v8 ad=0.1449 pd=1.11 as=0.0693 ps=0.75 w=0.42 l=0.15
X1809 a_51841_37557# a_48677_38127# uio_oe[0] uio_oe[0] sky130_fd_pr__nfet_01v8 ad=0.1092 pd=1.36 as=0.1449 ps=1.11 w=0.42 l=0.15
X1810 a_57012_41365# a_57556_41365# a_57514_41391# VDPWR sky130_fd_pr__pfet_01v8_hvt ad=0.0819 pd=0.81 as=0.0441 ps=0.63 w=0.42 l=0.15
X1811 a_37029_37583# a_36999_37557# VDPWR VDPWR sky130_fd_pr__pfet_01v8_hvt ad=0.135 pd=1.27 as=0.135 ps=1.27 w=1 l=0.15
X1812 a_30303_36271# a_30123_36271# VDPWR VDPWR sky130_fd_pr__pfet_01v8_hvt ad=0.0609 pd=0.71 as=0.0714 ps=0.76 w=0.42 l=0.15
X1813 VDPWR a_47959_41935# a_48125_41935# VDPWR sky130_fd_pr__pfet_01v8_hvt ad=0.135 pd=1.27 as=0.135 ps=1.27 w=1 l=0.15
X1814 a_53005_39759# a_52579_40086# VDPWR VDPWR sky130_fd_pr__pfet_01v8_hvt ad=0.26 pd=2.52 as=0.15835 ps=1.395 w=1 l=0.15
X1815 a_18641_35659# a_17388_35593# VDPWR VDPWR sky130_fd_pr__pfet_01v8_hvt ad=0.1176 pd=1.4 as=0.0693 ps=0.75 w=0.42 l=0.15
X1816 uio_oe[0] a_44739_38671# a_44905_38671# uio_oe[0] sky130_fd_pr__nfet_01v8 ad=0.08775 pd=0.92 as=0.08775 ps=0.92 w=0.65 l=0.15
X1817 VDPWR a_24836_33881# a_24787_33729# VDPWR sky130_fd_pr__pfet_01v8_hvt ad=0.15835 pd=1.395 as=0.26 ps=2.52 w=1 l=0.15
X1818 a_39544_42087# a_39759_41129# a_39686_42262# VDPWR sky130_fd_pr__pfet_01v8_hvt ad=0.1932 pd=1.34 as=0.07665 ps=0.785 w=0.42 l=0.15
X1819 a_48677_38127# a_48511_38127# VDPWR VDPWR sky130_fd_pr__pfet_01v8_hvt ad=0.135 pd=1.27 as=0.135 ps=1.27 w=1 l=0.15
X1820 a_60371_38101# a_60176_38243# a_60681_38493# uio_oe[0] sky130_fd_pr__special_nfet_01v8 ad=0.0594 pd=0.69 as=0.1401 ps=1.1 w=0.36 l=0.15
X1821 a_25020_34505# a_17507_33198# a_25162_34312# VDPWR sky130_fd_pr__pfet_01v8_hvt ad=0.1932 pd=1.34 as=0.07665 ps=0.785 w=0.42 l=0.15
X1822 a_36545_37583# a_36275_37949# a_36455_37949# uio_oe[0] sky130_fd_pr__nfet_01v8 ad=0.0504 pd=0.66 as=0.1092 ps=1.36 w=0.42 l=0.15
X1823 a_36327_35925# a_36503_36257# a_36455_36317# uio_oe[0] sky130_fd_pr__nfet_01v8 ad=0.1092 pd=1.36 as=0.0504 ps=0.66 w=0.42 l=0.15
X1824 a_58044_41391# a_57776_41757# VDPWR VDPWR sky130_fd_pr__pfet_01v8_hvt ad=0.0945 pd=0.87 as=0.0798 ps=0.8 w=0.42 l=0.15
X1825 VDPWR a_43173_38913# a_43063_39037# VDPWR sky130_fd_pr__pfet_01v8_hvt ad=0.07035 pd=0.755 as=0.1155 ps=0.97 w=0.42 l=0.15
X1826 a_40555_34646# a_40304_34293# a_40096_34471# VDPWR sky130_fd_pr__pfet_01v8_hvt ad=0.0441 pd=0.63 as=0.1932 ps=1.34 w=0.42 l=0.15
X1827 VDPWR a_50784_40008# a_50722_40125# VDPWR sky130_fd_pr__pfet_01v8_hvt ad=0.1092 pd=1.36 as=0.0651 ps=0.73 w=0.42 l=0.15
X1828 a_30034_18464# a_29740_18782# ua[5] uio_oe[0] sky130_fd_pr__nfet_01v8 ad=0.1885 pd=1.88 as=0.1885 ps=1.88 w=0.65 l=0.15
X1829 a_58082_38127# a_57324_38243# a_57519_38101# VDPWR sky130_fd_pr__pfet_01v8_hvt ad=0.0651 pd=0.73 as=0.07245 ps=0.765 w=0.42 l=0.15
X1830 a_43161_34863# a_42895_34863# VDPWR VDPWR sky130_fd_pr__pfet_01v8_hvt ad=0.26 pd=2.52 as=0.2279 ps=1.74 w=1 l=0.15
X1831 a_44261_40309# a_44095_40309# uio_oe[0] uio_oe[0] sky130_fd_pr__nfet_01v8 ad=0.1092 pd=1.36 as=0.0567 ps=0.69 w=0.42 l=0.15
X1832 a_52942_40303# a_52816_40419# a_52538_40435# uio_oe[0] sky130_fd_pr__special_nfet_01v8 ad=0.0999 pd=0.985 as=0.0711 ps=0.755 w=0.36 l=0.15
X1833 a_51620_39733# a_54459_39733# uio_oe[0] uio_oe[0] sky130_fd_pr__nfet_01v8 ad=0.169 pd=1.82 as=0.2087 ps=2.02 w=0.65 l=0.15
X1834 a_19588_14020# a_16812_8642# uio_oe[0] uio_oe[0] sky130_fd_pr__nfet_01v8 ad=1.4703 pd=10.72 as=1.4703 ps=10.72 w=5.07 l=1
X1835 a_57046_35659# a_57324_35675# a_57280_35773# VDPWR sky130_fd_pr__pfet_01v8_hvt ad=0.0588 pd=0.7 as=0.0567 ps=0.69 w=0.42 l=0.15
X1836 a_50469_41757# a_50090_41391# a_50397_41757# uio_oe[0] sky130_fd_pr__nfet_01v8 ad=0.1401 pd=1.1 as=0.0441 ps=0.63 w=0.42 l=0.15
X1837 a_38005_40847# a_37839_40847# VDPWR VDPWR sky130_fd_pr__pfet_01v8_hvt ad=0.135 pd=1.27 as=0.135 ps=1.27 w=1 l=0.15
X1838 a_29946_36815# a_28980_36681# uio_oe[0] uio_oe[0] sky130_fd_pr__nfet_01v8 ad=0.0693 pd=0.75 as=0.11285 ps=1.045 w=0.42 l=0.15
X1839 a_40581_36495# a_40415_36495# VDPWR VDPWR sky130_fd_pr__pfet_01v8_hvt ad=0.1664 pd=1.8 as=0.0864 ps=0.91 w=0.64 l=0.15
X1840 a_24778_18464# a_24484_18376# ua[4] uio_oe[0] sky130_fd_pr__nfet_01v8 ad=0.1885 pd=1.88 as=0.1885 ps=1.88 w=0.65 l=0.15
X1841 uio_oe[0] a_45351_41909# a_45285_41935# uio_oe[0] sky130_fd_pr__nfet_01v8 ad=0.12495 pd=1.015 as=0.0669 ps=0.75 w=0.42 l=0.15
X1842 VDPWR a_43419_40607# a_43406_40303# VDPWR sky130_fd_pr__pfet_01v8_hvt ad=0.0819 pd=0.81 as=0.0567 ps=0.69 w=0.42 l=0.15
X1843 uio_oe[0] a_56843_37557# a_38740_37557# uio_oe[0] sky130_fd_pr__nfet_01v8 ad=0.2087 pd=2.02 as=0.169 ps=1.82 w=0.65 l=0.15
X1844 a_39947_42997# a_41231_42997# uio_oe[0] uio_oe[0] sky130_fd_pr__nfet_01v8 ad=0.08775 pd=0.92 as=0.169 ps=1.82 w=0.65 l=0.15
X1845 a_57046_42611# a_57363_42721# a_57321_42845# uio_oe[0] sky130_fd_pr__special_nfet_01v8 ad=0.0711 pd=0.755 as=0.0669 ps=0.75 w=0.36 l=0.15
X1846 a_46193_41397# a_46027_41397# uio_oe[0] uio_oe[0] sky130_fd_pr__nfet_01v8 ad=0.1092 pd=1.36 as=0.0567 ps=0.69 w=0.42 l=0.15
X1847 VDPWR a_48511_38127# a_48677_38127# VDPWR sky130_fd_pr__pfet_01v8_hvt ad=0.26 pd=2.52 as=0.135 ps=1.27 w=1 l=0.15
X1848 a_52507_36822# a_52325_36822# VDPWR VDPWR sky130_fd_pr__pfet_01v8_hvt ad=0.0441 pd=0.63 as=0.0693 ps=0.75 w=0.42 l=0.15
X1849 uio_oe[0] a_40525_34293# a_40459_34319# uio_oe[0] sky130_fd_pr__nfet_01v8 ad=0.1449 pd=1.11 as=0.0693 ps=0.75 w=0.42 l=0.15
X1850 a_51412_42087# a_39752_41909# a_51554_42262# VDPWR sky130_fd_pr__pfet_01v8_hvt ad=0.1932 pd=1.34 as=0.07665 ps=0.785 w=0.42 l=0.15
X1851 uio_oe[0] a_48125_43023# a_57081_40847# uio_oe[0] sky130_fd_pr__nfet_01v8 ad=0.12495 pd=1.015 as=0.06405 ps=0.725 w=0.42 l=0.15
X1852 a_59939_38998# a_58980_38645# a_59867_38998# VDPWR sky130_fd_pr__pfet_01v8_hvt ad=0.1932 pd=1.34 as=0.0441 ps=0.63 w=0.42 l=0.15
X1853 a_50159_38908# a_49964_38939# a_50469_38671# uio_oe[0] sky130_fd_pr__special_nfet_01v8 ad=0.0594 pd=0.69 as=0.1401 ps=1.1 w=0.36 l=0.15
X1854 a_40581_37045# a_40415_37045# uio_oe[0] uio_oe[0] sky130_fd_pr__nfet_01v8 ad=0.1092 pd=1.36 as=0.0567 ps=0.69 w=0.42 l=0.15
X1855 a_42897_42177# a_42679_41935# uio_oe[0] uio_oe[0] sky130_fd_pr__nfet_01v8 ad=0.0999 pd=0.985 as=0.1346 ps=1.15 w=0.64 l=0.15
X1856 uio_oe[0] a_52855_41633# a_52816_41507# uio_oe[0] sky130_fd_pr__nfet_01v8 ad=0.0567 pd=0.69 as=0.1092 ps=1.36 w=0.42 l=0.15
X1857 a_41131_37949# a_40379_35551# VDPWR VDPWR sky130_fd_pr__pfet_01v8_hvt ad=0.1092 pd=1.36 as=0.07035 ps=0.755 w=0.42 l=0.15
X1858 a_24778_18464# a_4259_22596# a_24482_16730# uio_oe[0] sky130_fd_pr__nfet_01v8 ad=0.2436 pd=2.26 as=0.2436 ps=2.26 w=0.84 l=0.6
X1859 a_37913_41935# a_37747_41935# uio_oe[0] uio_oe[0] sky130_fd_pr__nfet_01v8 ad=0.08775 pd=0.92 as=0.08775 ps=0.92 w=0.65 l=0.15
X1860 VDPWR a_62237_41689# a_62267_41430# VDPWR sky130_fd_pr__pfet_01v8_hvt ad=0.0693 pd=0.75 as=0.0441 ps=0.63 w=0.42 l=0.15
X1861 a_43918_36041# a_45095_39733# uio_oe[0] uio_oe[0] sky130_fd_pr__nfet_01v8 ad=0.08775 pd=0.92 as=0.169 ps=1.82 w=0.65 l=0.15
X1862 uio_oe[0] a_58772_38823# a_58144_38920# uio_oe[0] sky130_fd_pr__nfet_01v8 ad=0.11285 pd=1.045 as=0.169 ps=1.82 w=0.65 l=0.15
X1863 a_61297_38913# a_61079_38671# uio_oe[0] uio_oe[0] sky130_fd_pr__nfet_01v8 ad=0.0999 pd=0.985 as=0.1346 ps=1.15 w=0.64 l=0.15
X1864 a_52942_37039# a_52855_37281# a_52538_37171# VDPWR sky130_fd_pr__pfet_01v8_hvt ad=0.12915 pd=1.185 as=0.0588 ps=0.7 w=0.42 l=0.15
X1865 a_21298_36815# a_21252_36681# uio_oe[0] uio_oe[0] sky130_fd_pr__nfet_01v8 ad=0.0693 pd=0.75 as=0.11285 ps=1.045 w=0.42 l=0.15
X1866 uio_oe[0] a_53636_39189# a_53574_39215# uio_oe[0] sky130_fd_pr__nfet_01v8 ad=0.2205 pd=1.89 as=0.066 ps=0.745 w=0.42 l=0.15
X1867 a_44369_38127# a_44327_38359# a_44287_38127# VDPWR sky130_fd_pr__pfet_01v8_hvt ad=0.135 pd=1.27 as=0.26 ps=2.52 w=1 l=0.15
X1868 a_36455_36317# a_36425_36166# uio_oe[0] uio_oe[0] sky130_fd_pr__nfet_01v8 ad=0.0504 pd=0.66 as=0.1013 ps=0.99 w=0.42 l=0.15
X1869 a_21585_35659# a_21252_35593# uio_oe[0] uio_oe[0] sky130_fd_pr__nfet_01v8 ad=0.1092 pd=1.36 as=0.1449 ps=1.11 w=0.42 l=0.15
X1870 a_58980_40821# a_61819_40821# VDPWR VDPWR sky130_fd_pr__pfet_01v8_hvt ad=0.26 pd=2.52 as=0.3012 ps=2.66 w=1 l=0.15
X1871 VDPWR a_41671_37343# a_41658_37039# VDPWR sky130_fd_pr__pfet_01v8_hvt ad=0.0819 pd=0.81 as=0.0567 ps=0.69 w=0.42 l=0.15
X1872 VDPWR a_41108_42087# a_41059_41935# VDPWR sky130_fd_pr__pfet_01v8_hvt ad=0.15835 pd=1.395 as=0.26 ps=2.52 w=1 l=0.15
X1873 a_57519_40277# a_57363_40545# a_57664_40303# VDPWR sky130_fd_pr__pfet_01v8_hvt ad=0.07245 pd=0.765 as=0.1155 ps=0.97 w=0.42 l=0.15
X1874 uio_oe[0] a_36499_36647# a_36329_36469# uio_oe[0] sky130_fd_pr__nfet_01v8 ad=0.1575 pd=1.17 as=0.0567 ps=0.69 w=0.42 l=0.15
X1875 uio_oe[0] a_41231_42997# a_39947_42997# uio_oe[0] sky130_fd_pr__nfet_01v8 ad=0.08775 pd=0.92 as=0.08775 ps=0.92 w=0.65 l=0.15
X1876 VDPWR a_60996_42453# a_60934_42479# VDPWR sky130_fd_pr__pfet_01v8_hvt ad=0.1092 pd=1.36 as=0.0651 ps=0.73 w=0.42 l=0.15
X1877 a_42679_43023# a_42163_43023# a_42584_43023# uio_oe[0] sky130_fd_pr__special_nfet_01v8 ad=0.0594 pd=0.69 as=0.066 ps=0.745 w=0.36 l=0.15
X1878 a_61806_39037# a_60729_38671# a_61644_38671# VDPWR sky130_fd_pr__pfet_01v8_hvt ad=0.0567 pd=0.69 as=0.0588 ps=0.7 w=0.42 l=0.15
X1879 a_22012_18782# a_21875_33757# uio_oe[0] uio_oe[0] sky130_fd_pr__nfet_01v8 ad=0.182 pd=1.86 as=0.1118 ps=1.04 w=0.65 l=0.15
X1880 VDPWR a_49483_41365# a_38740_41659# VDPWR sky130_fd_pr__pfet_01v8_hvt ad=0.3012 pd=2.66 as=0.26 ps=2.52 w=1 l=0.15
X1881 uio_oe[0] a_48125_43023# a_57858_39581# uio_oe[0] sky130_fd_pr__nfet_01v8 ad=0.0882 pd=0.84 as=0.0441 ps=0.63 w=0.42 l=0.15
X1882 a_38285_38671# a_37859_38998# VDPWR VDPWR sky130_fd_pr__pfet_01v8_hvt ad=0.26 pd=2.52 as=0.15835 ps=1.395 w=1 l=0.15
X1883 a_48677_39759# a_48511_39759# uio_oe[0] uio_oe[0] sky130_fd_pr__nfet_01v8 ad=0.08775 pd=0.92 as=0.08775 ps=0.92 w=0.65 l=0.15
X1884 a_62237_39513# a_36661_41391# VDPWR VDPWR sky130_fd_pr__pfet_01v8_hvt ad=0.1176 pd=1.4 as=0.0693 ps=0.75 w=0.42 l=0.15
X1885 a_27316_14020# a_4259_22596# a_27138_14020# uio_oe[0] sky130_fd_pr__nfet_01v8 ad=0.2436 pd=2.26 as=0.2436 ps=2.26 w=0.84 l=0.6
X1886 a_54693_35161# a_37361_41391# VDPWR VDPWR sky130_fd_pr__pfet_01v8_hvt ad=0.1176 pd=1.4 as=0.0693 ps=0.75 w=0.42 l=0.15
X1887 VDPWR a_38077_34837# a_38019_34863# VDPWR sky130_fd_pr__pfet_01v8_hvt ad=0.2279 pd=1.74 as=0.0609 ps=0.71 w=0.42 l=0.15
X1888 VDPWR a_53011_41365# a_52942_41391# VDPWR sky130_fd_pr__pfet_01v8_hvt ad=0.2184 pd=2.2 as=0.12915 ps=1.185 w=0.84 l=0.15
X1889 a_47283_40821# a_39947_42997# VDPWR VDPWR sky130_fd_pr__pfet_01v8_hvt ad=0.0567 pd=0.69 as=0.0819 ps=0.81 w=0.42 l=0.15
X1890 uio_oe[0] a_36847_39457# a_36808_39331# uio_oe[0] sky130_fd_pr__nfet_01v8 ad=0.0567 pd=0.69 as=0.1092 ps=1.36 w=0.42 l=0.15
X1891 a_41706_39215# a_40948_39331# a_41143_39189# VDPWR sky130_fd_pr__pfet_01v8_hvt ad=0.0651 pd=0.73 as=0.07245 ps=0.765 w=0.42 l=0.15
X1892 a_61341_34319# a_61297_34561# a_61175_34319# uio_oe[0] sky130_fd_pr__nfet_01v8 ad=0.0441 pd=0.63 as=0.1401 ps=1.1 w=0.42 l=0.15
X1893 a_39729_34347# a_37029_37583# uio_oe[0] uio_oe[0] sky130_fd_pr__nfet_01v8 ad=0.0567 pd=0.69 as=0.1118 ps=1.04 w=0.42 l=0.15
X1894 a_41131_37949# a_40507_37583# a_41023_37583# VDPWR sky130_fd_pr__pfet_01v8_hvt ad=0.1155 pd=0.97 as=0.07245 ps=0.765 w=0.42 l=0.15
X1895 a_25383_33551# a_17507_33198# a_25020_33417# uio_oe[0] sky130_fd_pr__nfet_01v8 ad=0.0693 pd=0.75 as=0.09975 ps=0.895 w=0.42 l=0.15
X1896 a_61753_40847# a_60563_40847# a_61644_40847# uio_oe[0] sky130_fd_pr__special_nfet_01v8 ad=0.0669 pd=0.75 as=0.0711 ps=0.755 w=0.36 l=0.15
X1897 VDPWR a_48511_39759# a_48677_39759# VDPWR sky130_fd_pr__pfet_01v8_hvt ad=0.135 pd=1.27 as=0.135 ps=1.27 w=1 l=0.15
X1898 a_57046_36747# a_57363_36637# a_57321_36495# uio_oe[0] sky130_fd_pr__special_nfet_01v8 ad=0.0711 pd=0.755 as=0.0669 ps=0.75 w=0.36 l=0.15
X1899 a_30123_36271# a_28651_35905# uio_oe[0] uio_oe[0] sky130_fd_pr__nfet_01v8 ad=0.1092 pd=1.36 as=0.1092 ps=1.36 w=0.42 l=0.15
X1900 VDPWR a_38532_39447# a_21252_34505# VDPWR sky130_fd_pr__pfet_01v8_hvt ad=0.15835 pd=1.395 as=0.26 ps=2.52 w=1 l=0.15
X1901 a_41453_39581# a_41074_39215# a_41381_39581# uio_oe[0] sky130_fd_pr__nfet_01v8 ad=0.1401 pd=1.1 as=0.0441 ps=0.63 w=0.42 l=0.15
X1902 a_41850_36495# a_40379_35551# uio_oe[0] uio_oe[0] sky130_fd_pr__nfet_01v8 ad=0.06405 pd=0.725 as=0.12495 ps=1.015 w=0.42 l=0.15
X1903 ua[5] a_28348_14376# a_31002_14020# uio_oe[0] sky130_fd_pr__nfet_01v8 ad=0.1885 pd=1.88 as=0.1885 ps=1.88 w=0.65 l=0.15
X1904 VDPWR a_36385_38127# a_39127_43023# VDPWR sky130_fd_pr__pfet_01v8_hvt ad=0.0864 pd=0.91 as=0.1664 ps=1.8 w=0.64 l=0.15
X1905 a_47108_43023# a_46193_43023# a_46761_43265# uio_oe[0] sky130_fd_pr__special_nfet_01v8 ad=0.0711 pd=0.755 as=0.0999 ps=0.985 w=0.36 l=0.15
X1906 a_39686_37405# a_37029_37583# uio_oe[0] uio_oe[0] sky130_fd_pr__nfet_01v8 ad=0.0693 pd=0.75 as=0.11285 ps=1.045 w=0.42 l=0.15
X1907 a_61192_37039# a_60416_37317# a_60584_37353# uio_oe[0] sky130_fd_pr__special_nfet_01v8 ad=0.0935 pd=0.965 as=0.072 ps=0.76 w=0.36 l=0.15
X1908 a_39544_42711# a_39752_42747# a_39686_42845# uio_oe[0] sky130_fd_pr__nfet_01v8 ad=0.09975 pd=0.895 as=0.0693 ps=0.75 w=0.42 l=0.15
X1909 a_42679_42857# a_42163_42485# a_42584_42845# uio_oe[0] sky130_fd_pr__special_nfet_01v8 ad=0.0594 pd=0.69 as=0.066 ps=0.745 w=0.36 l=0.15
X1910 a_56843_39733# a_57046_40011# VDPWR VDPWR sky130_fd_pr__pfet_01v8_hvt ad=0.0567 pd=0.69 as=0.1134 ps=1.38 w=0.42 l=0.15
X1911 ua[4] a_24484_10782# a_25746_14020# uio_oe[0] sky130_fd_pr__nfet_01v8 ad=0.1885 pd=1.88 as=0.1885 ps=1.88 w=0.65 l=0.15
X1912 uio_oe[0] a_48511_39759# a_48677_39759# uio_oe[0] sky130_fd_pr__nfet_01v8 ad=0.169 pd=1.82 as=0.08775 ps=0.92 w=0.65 l=0.15
X1913 a_49721_36495# a_49686_36747# a_49483_36469# uio_oe[0] sky130_fd_pr__nfet_01v8 ad=0.06405 pd=0.725 as=0.1092 ps=1.36 w=0.42 l=0.15
X1914 a_50722_42301# a_49964_42203# a_50159_42172# VDPWR sky130_fd_pr__pfet_01v8_hvt ad=0.0651 pd=0.73 as=0.07245 ps=0.765 w=0.42 l=0.15
X1915 a_19834_26464# a_16756_10782# ua[4] uio_oe[0] sky130_fd_pr__nfet_01v8 ad=0.1885 pd=1.88 as=0.1885 ps=1.88 w=0.65 l=0.15
X1916 a_45176_41769# a_44261_41397# a_44829_41365# uio_oe[0] sky130_fd_pr__special_nfet_01v8 ad=0.0711 pd=0.755 as=0.0999 ps=0.985 w=0.36 l=0.15
X1917 uio_oe[0] a_38961_37337# a_38895_37405# uio_oe[0] sky130_fd_pr__nfet_01v8 ad=0.1449 pd=1.11 as=0.0693 ps=0.75 w=0.42 l=0.15
X1918 a_59201_34293# a_48677_38127# VDPWR VDPWR sky130_fd_pr__pfet_01v8_hvt ad=0.1176 pd=1.4 as=0.0693 ps=0.75 w=0.42 l=0.15
X1919 a_52855_42721# a_37913_43023# VDPWR VDPWR sky130_fd_pr__pfet_01v8_hvt ad=0.1664 pd=1.8 as=0.0864 ps=0.91 w=0.64 l=0.15
X1920 VDPWR a_50003_39901# a_49964_40027# VDPWR sky130_fd_pr__pfet_01v8_hvt ad=0.0864 pd=0.91 as=0.1664 ps=1.8 w=0.64 l=0.15
X1921 uio_oe[0] a_46013_38823# a_45114_37735# uio_oe[0] sky130_fd_pr__nfet_01v8 ad=0.10025 pd=0.985 as=0.169 ps=1.82 w=0.65 l=0.15
X1922 a_51620_38645# a_54459_38645# uio_oe[0] uio_oe[0] sky130_fd_pr__nfet_01v8 ad=0.169 pd=1.82 as=0.2087 ps=2.02 w=0.65 l=0.15
X1923 a_37913_43023# a_37747_43023# VDPWR VDPWR sky130_fd_pr__pfet_01v8_hvt ad=0.135 pd=1.27 as=0.135 ps=1.27 w=1 l=0.15
X1924 ua[4] a_24484_18376# a_27138_18020# uio_oe[0] sky130_fd_pr__nfet_01v8 ad=0.1885 pd=1.88 as=0.1885 ps=1.88 w=0.65 l=0.15
X1925 a_47108_42857# a_46193_42485# a_46761_42453# uio_oe[0] sky130_fd_pr__special_nfet_01v8 ad=0.0711 pd=0.755 as=0.0999 ps=0.985 w=0.36 l=0.15
X1926 a_19834_26464# a_4259_22596# a_19538_24730# uio_oe[0] sky130_fd_pr__nfet_01v8 ad=0.2436 pd=2.26 as=0.2436 ps=2.26 w=0.84 l=0.6
X1927 a_51554_37405# a_48677_38127# uio_oe[0] uio_oe[0] sky130_fd_pr__nfet_01v8 ad=0.0693 pd=0.75 as=0.11285 ps=1.045 w=0.42 l=0.15
X1928 a_51412_42711# a_51620_42747# a_51554_42845# uio_oe[0] sky130_fd_pr__nfet_01v8 ad=0.09975 pd=0.895 as=0.0693 ps=0.75 w=0.42 l=0.15
X1929 a_45530_41757# a_39947_42997# uio_oe[0] uio_oe[0] sky130_fd_pr__nfet_01v8 ad=0.06405 pd=0.725 as=0.12495 ps=1.015 w=0.42 l=0.15
X1930 a_42743_38884# a_42643_37078# VDPWR VDPWR sky130_fd_pr__pfet_01v8_hvt ad=0.26 pd=2.52 as=0.15835 ps=1.395 w=1 l=0.15
X1931 ua[4] a_16756_14376# a_19410_22020# uio_oe[0] sky130_fd_pr__nfet_01v8 ad=0.1885 pd=1.88 as=0.1885 ps=1.88 w=0.65 l=0.15
X1932 VDPWR a_29804_33417# a_28908_33703# VDPWR sky130_fd_pr__pfet_01v8_hvt ad=0.15835 pd=1.395 as=0.26 ps=2.52 w=1 l=0.15
X1933 uio_oe[0] a_59201_38425# a_59135_38493# uio_oe[0] sky130_fd_pr__nfet_01v8 ad=0.1449 pd=1.11 as=0.0693 ps=0.75 w=0.42 l=0.15
X1934 a_43308_35657# a_41677_40847# uio_oe[0] uio_oe[0] sky130_fd_pr__nfet_01v8 ad=0.0567 pd=0.69 as=0.1092 ps=1.36 w=0.42 l=0.15
X1935 a_59201_34293# a_48677_38127# uio_oe[0] uio_oe[0] sky130_fd_pr__nfet_01v8 ad=0.1092 pd=1.36 as=0.1449 ps=1.11 w=0.42 l=0.15
X1936 a_58082_35773# a_57363_35549# a_57519_35644# uio_oe[0] sky130_fd_pr__special_nfet_01v8 ad=0.066 pd=0.745 as=0.0594 ps=0.69 w=0.36 l=0.15
X1937 uio_oe[0] a_56916_37271# a_39752_37307# uio_oe[0] sky130_fd_pr__nfet_01v8 ad=0.097 pd=0.975 as=0.169 ps=1.82 w=0.65 l=0.15
X1938 a_17751_35400# a_17500_33453# a_17292_35593# VDPWR sky130_fd_pr__pfet_01v8_hvt ad=0.0441 pd=0.63 as=0.1932 ps=1.34 w=0.42 l=0.15
X1939 a_50722_35773# a_50003_35549# a_50159_35644# uio_oe[0] sky130_fd_pr__special_nfet_01v8 ad=0.066 pd=0.745 as=0.0594 ps=0.69 w=0.36 l=0.15
X1940 a_39973_39733# a_38005_40847# VDPWR VDPWR sky130_fd_pr__pfet_01v8_hvt ad=0.1176 pd=1.4 as=0.0693 ps=0.75 w=0.42 l=0.15
X1941 a_36355_38101# uio_in[0] uio_oe[0] uio_oe[0] sky130_fd_pr__nfet_01v8 ad=0.169 pd=1.82 as=0.08775 ps=0.92 w=0.65 l=0.15
X1942 a_53574_37039# a_52816_37155# a_53011_37013# VDPWR sky130_fd_pr__pfet_01v8_hvt ad=0.0651 pd=0.73 as=0.07245 ps=0.765 w=0.42 l=0.15
X1943 a_61624_36183# a_54479_35964# a_61766_36317# uio_oe[0] sky130_fd_pr__nfet_01v8 ad=0.09975 pd=0.895 as=0.0693 ps=0.75 w=0.42 l=0.15
X1944 ua[5] a_24484_10782# a_25746_26020# uio_oe[0] sky130_fd_pr__nfet_01v8 ad=0.1885 pd=1.88 as=0.1885 ps=1.88 w=0.65 l=0.15
X1945 a_47462_42845# a_39947_42997# uio_oe[0] uio_oe[0] sky130_fd_pr__nfet_01v8 ad=0.06405 pd=0.725 as=0.12495 ps=1.015 w=0.42 l=0.15
X1946 a_61950_37078# a_37361_41391# VDPWR VDPWR sky130_fd_pr__pfet_01v8_hvt ad=0.07665 pd=0.785 as=0.15835 ps=1.395 w=0.42 l=0.15
X1947 VDPWR a_21156_33417# a_21107_33185# VDPWR sky130_fd_pr__pfet_01v8_hvt ad=0.15835 pd=1.395 as=0.26 ps=2.52 w=1 l=0.15
X1948 a_21335_34817# a_21107_34273# a_20972_34969# uio_oe[0] sky130_fd_pr__nfet_01v8 ad=0.0693 pd=0.75 as=0.09975 ps=0.895 w=0.42 l=0.15
X1949 VDPWR a_48125_43023# a_49483_42453# VDPWR sky130_fd_pr__pfet_01v8_hvt ad=0.0819 pd=0.81 as=0.0567 ps=0.69 w=0.42 l=0.15
X1950 uio_oe[0] a_57363_42077# a_57324_42203# uio_oe[0] sky130_fd_pr__nfet_01v8 ad=0.0567 pd=0.69 as=0.1092 ps=1.36 w=0.42 l=0.15
X1951 a_37859_37910# a_37829_37812# a_37787_37910# VDPWR sky130_fd_pr__pfet_01v8_hvt ad=0.1932 pd=1.34 as=0.0441 ps=0.63 w=0.42 l=0.15
X1952 a_31426_18464# a_28348_18782# ua[4] uio_oe[0] sky130_fd_pr__nfet_01v8 ad=0.1885 pd=1.88 as=0.1885 ps=1.88 w=0.65 l=0.15
X1953 a_22218_34639# a_21252_34505# uio_oe[0] uio_oe[0] sky130_fd_pr__nfet_01v8 ad=0.0693 pd=0.75 as=0.11285 ps=1.045 w=0.42 l=0.15
X1954 VDPWR a_18212_34505# a_17316_34791# VDPWR sky130_fd_pr__pfet_01v8_hvt ad=0.15835 pd=1.395 as=0.26 ps=2.52 w=1 l=0.15
X1955 a_41344_39037# a_40864_38671# VDPWR VDPWR sky130_fd_pr__pfet_01v8_hvt ad=0.0483 pd=0.65 as=0.0567 ps=0.69 w=0.42 l=0.15
X1956 a_59939_37583# a_59685_37910# uio_oe[0] uio_oe[0] sky130_fd_pr__nfet_01v8 ad=0.0693 pd=0.75 as=0.1449 ps=1.11 w=0.42 l=0.15
X1957 a_23698_22464# a_20620_14782# ua[4] uio_oe[0] sky130_fd_pr__nfet_01v8 ad=0.1885 pd=1.88 as=0.1885 ps=1.88 w=0.65 l=0.15
X1958 VDPWR a_44905_38671# a_57776_35229# VDPWR sky130_fd_pr__pfet_01v8_hvt ad=0.0798 pd=0.8 as=0.0567 ps=0.69 w=0.42 l=0.15
X1959 a_53624_35407# a_53005_35407# uio_oe[0] uio_oe[0] sky130_fd_pr__nfet_01v8 ad=0.066 pd=0.745 as=0.2205 ps=1.89 w=0.42 l=0.15
X1960 a_52538_41523# a_52855_41633# a_52813_41757# uio_oe[0] sky130_fd_pr__special_nfet_01v8 ad=0.0711 pd=0.755 as=0.0669 ps=0.75 w=0.36 l=0.15
X1961 a_43406_41213# a_42329_40847# a_43244_40847# VDPWR sky130_fd_pr__pfet_01v8_hvt ad=0.0567 pd=0.69 as=0.0588 ps=0.7 w=0.42 l=0.15
X1962 VDPWR a_43327_36647# a_37452_34953# VDPWR sky130_fd_pr__pfet_01v8_hvt ad=0.16655 pd=1.39 as=0.475 ps=2.95 w=1 l=0.15
X1963 a_43559_35407# a_43308_35657# uio_oe[0] uio_oe[0] sky130_fd_pr__nfet_01v8 ad=0.169 pd=1.82 as=0.10025 ps=0.985 w=0.65 l=0.15
X1964 a_29788_14020# a_16812_8642# uio_oe[0] uio_oe[0] sky130_fd_pr__nfet_01v8 ad=1.4703 pd=10.72 as=1.4703 ps=10.72 w=5.07 l=1
X1965 a_31426_18464# ua[0] a_31180_18020# uio_oe[0] sky130_fd_pr__nfet_01v8 ad=0.2436 pd=2.26 as=0.2436 ps=2.26 w=0.84 l=0.6
X1966 a_45176_42857# a_44095_42485# a_44829_42453# VDPWR sky130_fd_pr__pfet_01v8_hvt ad=0.0588 pd=0.7 as=0.12915 ps=1.185 w=0.42 l=0.15
X1967 a_58914_42845# a_48677_39759# uio_oe[0] uio_oe[0] sky130_fd_pr__nfet_01v8 ad=0.0693 pd=0.75 as=0.11285 ps=1.045 w=0.42 l=0.15
X1968 a_57858_41757# a_57640_41705# a_57776_41757# uio_oe[0] sky130_fd_pr__nfet_01v8 ad=0.0441 pd=0.63 as=0.1092 ps=1.36 w=0.42 l=0.15
X1969 a_46761_40277# a_46543_40681# VDPWR VDPWR sky130_fd_pr__pfet_01v8_hvt ad=0.12915 pd=1.185 as=0.2184 ps=2.2 w=0.84 l=0.15
X1970 a_42917_37557# a_38285_34863# uio_oe[0] uio_oe[0] sky130_fd_pr__nfet_01v8 ad=0.1092 pd=1.36 as=0.1449 ps=1.11 w=0.42 l=0.15
X1971 VDPWR a_59860_37271# a_54479_37052# VDPWR sky130_fd_pr__pfet_01v8_hvt ad=0.149 pd=1.325 as=0.26 ps=2.52 w=1 l=0.15
X1972 uio_oe[0] a_37913_43023# a_60563_41935# uio_oe[0] sky130_fd_pr__nfet_01v8 ad=0.0567 pd=0.69 as=0.1092 ps=1.36 w=0.42 l=0.15
X1973 VDPWR a_36661_41391# a_52325_40086# VDPWR sky130_fd_pr__pfet_01v8_hvt ad=0.0693 pd=0.75 as=0.1176 ps=1.4 w=0.42 l=0.15
X1974 a_23698_22464# a_4259_22596# a_23402_20730# uio_oe[0] sky130_fd_pr__nfet_01v8 ad=0.2436 pd=2.26 as=0.2436 ps=2.26 w=0.84 l=0.6
X1975 a_4259_22596# uio_oe[0] sky130_fd_pr__cap_mim_m3_1 l=22 w=22
X1976 uio_oe[0] a_50784_34568# a_50722_34685# uio_oe[0] sky130_fd_pr__nfet_01v8 ad=0.2205 pd=1.89 as=0.066 ps=0.745 w=0.42 l=0.15
X1977 uio_oe[0] uio_in[0] a_37747_41935# uio_oe[0] sky130_fd_pr__nfet_01v8 ad=0.08775 pd=0.92 as=0.169 ps=1.82 w=0.65 l=0.15
X1978 a_49920_42301# a_49483_41909# VDPWR VDPWR sky130_fd_pr__pfet_01v8_hvt ad=0.0567 pd=0.69 as=0.0819 ps=0.81 w=0.42 l=0.15
X1979 a_52772_39215# a_52335_39189# VDPWR VDPWR sky130_fd_pr__pfet_01v8_hvt ad=0.0567 pd=0.69 as=0.0819 ps=0.81 w=0.42 l=0.15
X1980 uio_oe[0] a_44905_38671# a_49721_35229# uio_oe[0] sky130_fd_pr__nfet_01v8 ad=0.12495 pd=1.015 as=0.06405 ps=0.725 w=0.42 l=0.15
X1981 a_57519_35644# a_57324_35675# a_57829_35407# uio_oe[0] sky130_fd_pr__special_nfet_01v8 ad=0.0594 pd=0.69 as=0.1401 ps=1.1 w=0.36 l=0.15
X1982 VDPWR a_60371_40277# a_60302_40303# VDPWR sky130_fd_pr__pfet_01v8_hvt ad=0.2184 pd=2.2 as=0.12915 ps=1.185 w=0.84 l=0.15
X1983 a_50722_35773# a_49964_35675# a_50159_35644# VDPWR sky130_fd_pr__pfet_01v8_hvt ad=0.0651 pd=0.73 as=0.07245 ps=0.765 w=0.42 l=0.15
X1984 a_42045_34319# a_41711_34569# a_41961_34569# VDPWR sky130_fd_pr__pfet_01v8_hvt ad=0.3 pd=2.6 as=0.26 ps=2.52 w=1 l=0.15
X1985 a_59956_39189# a_60500_39189# a_60458_39215# VDPWR sky130_fd_pr__pfet_01v8_hvt ad=0.0819 pd=0.81 as=0.0441 ps=0.63 w=0.42 l=0.15
X1986 a_37003_39996# a_36847_39901# a_37148_40125# VDPWR sky130_fd_pr__pfet_01v8_hvt ad=0.07245 pd=0.765 as=0.1155 ps=0.97 w=0.42 l=0.15
X1987 VDPWR a_49483_35381# a_39783_35409# VDPWR sky130_fd_pr__pfet_01v8_hvt ad=0.3012 pd=2.66 as=0.26 ps=2.52 w=1 l=0.15
X1988 a_57829_38493# a_57450_38127# a_57757_38493# uio_oe[0] sky130_fd_pr__nfet_01v8 ad=0.1401 pd=1.1 as=0.0441 ps=0.63 w=0.42 l=0.15
X1989 a_60160_34319# a_58980_34293# a_59939_34646# uio_oe[0] sky130_fd_pr__nfet_01v8 ad=0.0693 pd=0.75 as=0.09975 ps=0.895 w=0.42 l=0.15
X1990 a_43419_42783# a_39947_42997# VDPWR VDPWR sky130_fd_pr__pfet_01v8_hvt ad=0.0567 pd=0.69 as=0.0819 ps=0.81 w=0.42 l=0.15
X1991 VDPWR a_43408_37735# a_43359_37583# VDPWR sky130_fd_pr__pfet_01v8_hvt ad=0.15835 pd=1.395 as=0.26 ps=2.52 w=1 l=0.15
X1992 a_45176_40681# a_44261_40309# a_44829_40277# uio_oe[0] sky130_fd_pr__special_nfet_01v8 ad=0.0711 pd=0.755 as=0.0999 ps=0.985 w=0.36 l=0.15
X1993 uio_oe[0] uio_oe[0] uio_oe[0] uio_oe[0] sky130_fd_pr__nfet_01v8 ad=1.4703 pd=10.72 as=0 ps=0 w=5.07 l=1
X1994 VDPWR a_38483_43023# a_38649_43023# VDPWR sky130_fd_pr__pfet_01v8_hvt ad=0.135 pd=1.27 as=0.135 ps=1.27 w=1 l=0.15
X1995 VDPWR a_47283_41909# a_47270_42301# VDPWR sky130_fd_pr__pfet_01v8_hvt ad=0.0819 pd=0.81 as=0.0567 ps=0.69 w=0.42 l=0.15
X1996 a_46761_41089# a_46543_40847# VDPWR VDPWR sky130_fd_pr__pfet_01v8_hvt ad=0.12915 pd=1.185 as=0.2184 ps=2.2 w=0.84 l=0.15
X1997 uio_oe[0] a_36847_39901# a_36808_40027# uio_oe[0] sky130_fd_pr__nfet_01v8 ad=0.0567 pd=0.69 as=0.1092 ps=1.36 w=0.42 l=0.15
X1998 a_57081_38493# a_57046_38259# a_56843_38101# uio_oe[0] sky130_fd_pr__nfet_01v8 ad=0.06405 pd=0.725 as=0.1092 ps=1.36 w=0.42 l=0.15
X1999 a_41013_36317# a_40379_35551# uio_oe[0] uio_oe[0] sky130_fd_pr__nfet_01v8 ad=0.0441 pd=0.63 as=0.1346 ps=1.15 w=0.42 l=0.15
X2000 a_21585_35659# a_21252_35593# VDPWR VDPWR sky130_fd_pr__pfet_01v8_hvt ad=0.1176 pd=1.4 as=0.0693 ps=0.75 w=0.42 l=0.15
X2001 VDPWR a_54693_39513# a_54723_39254# VDPWR sky130_fd_pr__pfet_01v8_hvt ad=0.0693 pd=0.75 as=0.0441 ps=0.63 w=0.42 l=0.15
X2002 a_41453_39759# a_41074_40125# a_41381_39759# uio_oe[0] sky130_fd_pr__nfet_01v8 ad=0.1401 pd=1.1 as=0.0441 ps=0.63 w=0.42 l=0.15
X2003 a_43125_39581# a_43081_39189# a_42959_39593# uio_oe[0] sky130_fd_pr__nfet_01v8 ad=0.0441 pd=0.63 as=0.1401 ps=1.1 w=0.42 l=0.15
X2004 a_42467_40474# a_43419_40821# VDPWR VDPWR sky130_fd_pr__pfet_01v8_hvt ad=0.26 pd=2.52 as=0.3012 ps=2.66 w=1 l=0.15
X2005 uio_oe[0] a_44739_38671# a_44905_38671# uio_oe[0] sky130_fd_pr__nfet_01v8 ad=0.169 pd=1.82 as=0.08775 ps=0.92 w=0.65 l=0.15
X2006 a_22535_36488# a_18420_33453# a_22076_36681# VDPWR sky130_fd_pr__pfet_01v8_hvt ad=0.0441 pd=0.63 as=0.1932 ps=1.34 w=0.42 l=0.15
X2007 VDPWR a_46193_39759# a_53156_35951# VDPWR sky130_fd_pr__pfet_01v8_hvt ad=0.07035 pd=0.755 as=0.1092 ps=1.36 w=0.42 l=0.15
X2008 VDPWR a_26369_35659# a_26399_35400# VDPWR sky130_fd_pr__pfet_01v8_hvt ad=0.0693 pd=0.75 as=0.0441 ps=0.63 w=0.42 l=0.15
X2009 a_37410_34979# a_37310_34471# a_37328_34979# VDPWR sky130_fd_pr__pfet_01v8_hvt ad=0.0441 pd=0.63 as=0.1092 ps=1.36 w=0.42 l=0.15
X2010 VDPWR a_36607_39455# a_37148_40125# VDPWR sky130_fd_pr__pfet_01v8_hvt ad=0.07035 pd=0.755 as=0.1092 ps=1.36 w=0.42 l=0.15
X2011 a_25449_36747# a_25116_36681# VDPWR VDPWR sky130_fd_pr__pfet_01v8_hvt ad=0.1176 pd=1.4 as=0.0693 ps=0.75 w=0.42 l=0.15
X2012 a_54459_40821# a_48125_41935# VDPWR VDPWR sky130_fd_pr__pfet_01v8_hvt ad=0.0567 pd=0.69 as=0.0819 ps=0.81 w=0.42 l=0.15
X2013 a_59135_40847# a_38740_40821# a_58772_40999# uio_oe[0] sky130_fd_pr__nfet_01v8 ad=0.0693 pd=0.75 as=0.09975 ps=0.895 w=0.42 l=0.15
X2014 a_36327_35381# a_36503_35381# a_36455_35407# uio_oe[0] sky130_fd_pr__nfet_01v8 ad=0.1092 pd=1.36 as=0.0504 ps=0.66 w=0.42 l=0.15
X2015 uio_oe[0] a_49483_34293# a_39783_34321# uio_oe[0] sky130_fd_pr__nfet_01v8 ad=0.2087 pd=2.02 as=0.169 ps=1.82 w=0.65 l=0.15
X2016 a_57694_34863# a_57472_35141# a_57012_34837# VDPWR sky130_fd_pr__pfet_01v8_hvt ad=0.0483 pd=0.65 as=0.0819 ps=0.81 w=0.42 l=0.15
X2017 a_44399_41562# a_45351_41909# VDPWR VDPWR sky130_fd_pr__pfet_01v8_hvt ad=0.26 pd=2.52 as=0.3012 ps=2.66 w=1 l=0.15
X2018 VDPWR a_57363_42077# a_57324_42203# VDPWR sky130_fd_pr__pfet_01v8_hvt ad=0.0864 pd=0.91 as=0.1664 ps=1.8 w=0.64 l=0.15
X2019 a_44537_39535# a_36425_35381# uio_oe[0] uio_oe[0] sky130_fd_pr__nfet_01v8 ad=0.08775 pd=0.92 as=0.08775 ps=0.92 w=0.65 l=0.15
X2020 a_59231_38998# a_58980_38645# a_58772_38823# VDPWR sky130_fd_pr__pfet_01v8_hvt ad=0.0441 pd=0.63 as=0.1932 ps=1.34 w=0.42 l=0.15
X2021 a_18671_33224# a_18420_33453# a_18212_33417# VDPWR sky130_fd_pr__pfet_01v8_hvt ad=0.0441 pd=0.63 as=0.1932 ps=1.34 w=0.42 l=0.15
X2022 a_30233_34571# a_28980_34505# uio_oe[0] uio_oe[0] sky130_fd_pr__nfet_01v8 ad=0.1092 pd=1.36 as=0.1449 ps=1.11 w=0.42 l=0.15
X2023 VDPWR a_48125_43023# a_49483_41365# VDPWR sky130_fd_pr__pfet_01v8_hvt ad=0.0819 pd=0.81 as=0.0567 ps=0.69 w=0.42 l=0.15
X2024 a_42149_37039# a_41671_37343# uio_oe[0] uio_oe[0] sky130_fd_pr__nfet_01v8 ad=0.169 pd=1.82 as=0.2087 ps=2.02 w=0.65 l=0.15
X2025 a_54406_36317# a_37361_41391# uio_oe[0] uio_oe[0] sky130_fd_pr__nfet_01v8 ad=0.0693 pd=0.75 as=0.11285 ps=1.045 w=0.42 l=0.15
X2026 a_22218_33551# a_21252_33417# uio_oe[0] uio_oe[0] sky130_fd_pr__nfet_01v8 ad=0.0693 pd=0.75 as=0.11285 ps=1.045 w=0.42 l=0.15
X2027 a_17537_33703# a_17204_33881# uio_oe[0] uio_oe[0] sky130_fd_pr__nfet_01v8 ad=0.1092 pd=1.36 as=0.1449 ps=1.11 w=0.42 l=0.15
X2028 a_54264_41623# a_51620_41659# a_54406_41757# uio_oe[0] sky130_fd_pr__nfet_01v8 ad=0.09975 pd=0.895 as=0.0693 ps=0.75 w=0.42 l=0.15
X2029 a_38005_40847# a_37839_40847# VDPWR VDPWR sky130_fd_pr__pfet_01v8_hvt ad=0.135 pd=1.27 as=0.135 ps=1.27 w=1 l=0.15
X2030 a_38073_37910# a_37579_34863# a_37859_37910# VDPWR sky130_fd_pr__pfet_01v8_hvt ad=0.07665 pd=0.785 as=0.1932 ps=1.34 w=0.42 l=0.15
X2031 a_54693_35161# a_37361_41391# uio_oe[0] uio_oe[0] sky130_fd_pr__nfet_01v8 ad=0.1092 pd=1.36 as=0.1449 ps=1.11 w=0.42 l=0.15
X2032 VDPWR a_40379_35551# a_40920_35773# VDPWR sky130_fd_pr__pfet_01v8_hvt ad=0.07035 pd=0.755 as=0.1092 ps=1.36 w=0.42 l=0.15
X2033 a_59227_35229# a_39647_34877# a_58864_35095# uio_oe[0] sky130_fd_pr__nfet_01v8 ad=0.0693 pd=0.75 as=0.09975 ps=0.895 w=0.42 l=0.15
X2034 a_53937_35649# a_53719_35407# uio_oe[0] uio_oe[0] sky130_fd_pr__nfet_01v8 ad=0.0999 pd=0.985 as=0.1346 ps=1.15 w=0.64 l=0.15
X2035 a_57664_41213# a_57450_41213# VDPWR VDPWR sky130_fd_pr__pfet_01v8_hvt ad=0.1155 pd=0.97 as=0.07035 ps=0.755 w=0.42 l=0.15
X2036 a_52538_40435# a_52855_40545# a_52813_40669# uio_oe[0] sky130_fd_pr__special_nfet_01v8 ad=0.0711 pd=0.755 as=0.0669 ps=0.75 w=0.36 l=0.15
X2037 uio_oe[0] a_17689_32641# a_18801_34817# uio_oe[0] sky130_fd_pr__nfet_01v8 ad=0.1013 pd=0.99 as=0.0504 ps=0.66 w=0.42 l=0.15
X2038 a_60302_42479# a_60176_42595# a_59898_42611# uio_oe[0] sky130_fd_pr__special_nfet_01v8 ad=0.0999 pd=0.985 as=0.0711 ps=0.755 w=0.36 l=0.15
X2039 a_50469_40847# a_50090_41213# a_50397_40847# uio_oe[0] sky130_fd_pr__nfet_01v8 ad=0.1401 pd=1.1 as=0.0441 ps=0.63 w=0.42 l=0.15
X2040 uio_oe[0] a_17255_32793# a_36503_35169# uio_oe[0] sky130_fd_pr__nfet_01v8 ad=0.1092 pd=1.36 as=0.1092 ps=1.36 w=0.42 l=0.15
X2041 a_45176_41769# a_44095_41397# a_44829_41365# VDPWR sky130_fd_pr__pfet_01v8_hvt ad=0.0588 pd=0.7 as=0.12915 ps=1.185 w=0.42 l=0.15
X2042 a_60681_36317# a_60302_35951# a_60609_36317# uio_oe[0] sky130_fd_pr__nfet_01v8 ad=0.1401 pd=1.1 as=0.0441 ps=0.63 w=0.42 l=0.15
X2043 a_49920_35773# a_49483_35381# VDPWR VDPWR sky130_fd_pr__pfet_01v8_hvt ad=0.0567 pd=0.69 as=0.0819 ps=0.81 w=0.42 l=0.15
X2044 a_46193_40847# a_46027_40847# uio_oe[0] uio_oe[0] sky130_fd_pr__nfet_01v8 ad=0.1092 pd=1.36 as=0.0567 ps=0.69 w=0.42 l=0.15
X2045 a_37387_36745# a_37195_36501# uio_oe[0] uio_oe[0] sky130_fd_pr__nfet_01v8 ad=0.0567 pd=0.69 as=0.1575 ps=1.17 w=0.42 l=0.15
X2046 a_20972_36057# a_21180_35879# a_21114_35905# uio_oe[0] sky130_fd_pr__nfet_01v8 ad=0.09975 pd=0.895 as=0.0693 ps=0.75 w=0.42 l=0.15
X2047 VDPWR a_37913_43023# a_60563_41935# VDPWR sky130_fd_pr__pfet_01v8_hvt ad=0.0864 pd=0.91 as=0.1664 ps=1.8 w=0.64 l=0.15
X2048 a_40705_39581# a_40670_39347# a_40467_39189# uio_oe[0] sky130_fd_pr__nfet_01v8 ad=0.06405 pd=0.725 as=0.1092 ps=1.36 w=0.42 l=0.15
X2049 a_21519_36815# a_17507_33198# a_21156_36681# uio_oe[0] sky130_fd_pr__nfet_01v8 ad=0.0693 pd=0.75 as=0.09975 ps=0.895 w=0.42 l=0.15
X2050 VDPWR a_39973_39513# a_40003_39254# VDPWR sky130_fd_pr__pfet_01v8_hvt ad=0.0693 pd=0.75 as=0.0441 ps=0.63 w=0.42 l=0.15
X2051 a_25265_35879# a_24932_36057# VDPWR VDPWR sky130_fd_pr__pfet_01v8_hvt ad=0.1176 pd=1.4 as=0.0693 ps=0.75 w=0.42 l=0.15
X2052 VDPWR a_39783_35967# a_39555_36183# VDPWR sky130_fd_pr__pfet_01v8_hvt ad=0.1176 pd=1.4 as=0.0567 ps=0.69 w=0.42 l=0.15
X2053 a_26170_14464# a_24484_10376# ua[4] uio_oe[0] sky130_fd_pr__nfet_01v8 ad=0.1885 pd=1.88 as=0.1885 ps=1.88 w=0.65 l=0.15
X2054 ua[4] a_28348_10376# a_29610_22020# uio_oe[0] sky130_fd_pr__nfet_01v8 ad=0.1885 pd=1.88 as=0.1885 ps=1.88 w=0.65 l=0.15
X2055 a_38005_41391# a_37839_41391# VDPWR VDPWR sky130_fd_pr__pfet_01v8_hvt ad=0.135 pd=1.27 as=0.135 ps=1.27 w=1 l=0.15
X2056 a_22575_34095# a_22395_34095# VDPWR VDPWR sky130_fd_pr__pfet_01v8_hvt ad=0.0609 pd=0.71 as=0.0714 ps=0.76 w=0.42 l=0.15
X2057 a_48125_41935# a_47959_41935# uio_oe[0] uio_oe[0] sky130_fd_pr__nfet_01v8 ad=0.08775 pd=0.92 as=0.08775 ps=0.92 w=0.65 l=0.15
X2058 a_36455_35407# a_36425_35381# uio_oe[0] uio_oe[0] sky130_fd_pr__nfet_01v8 ad=0.0504 pd=0.66 as=0.1013 ps=0.99 w=0.42 l=0.15
X2059 VDPWR a_21553_32641# a_21875_35933# VDPWR sky130_fd_pr__pfet_01v8_hvt ad=0.16655 pd=1.39 as=0.0567 ps=0.69 w=0.42 l=0.15
X2060 a_43419_41695# a_39947_42997# VDPWR VDPWR sky130_fd_pr__pfet_01v8_hvt ad=0.0567 pd=0.69 as=0.0819 ps=0.81 w=0.42 l=0.15
X2061 a_52538_40435# a_52816_40419# a_52772_40303# VDPWR sky130_fd_pr__pfet_01v8_hvt ad=0.0588 pd=0.7 as=0.0567 ps=0.69 w=0.42 l=0.15
X2062 VDPWR a_44905_38671# a_49483_37557# VDPWR sky130_fd_pr__pfet_01v8_hvt ad=0.0819 pd=0.81 as=0.0567 ps=0.69 w=0.42 l=0.15
X2063 a_26170_14464# ua[1] a_25924_14020# uio_oe[0] sky130_fd_pr__nfet_01v8 ad=0.2436 pd=2.26 as=0.2436 ps=2.26 w=0.84 l=0.6
X2064 VDPWR a_36661_41391# a_59685_42262# VDPWR sky130_fd_pr__pfet_01v8_hvt ad=0.0693 pd=0.75 as=0.1176 ps=1.4 w=0.42 l=0.15
X2065 a_44516_43023# ui_in[0] uio_oe[0] uio_oe[0] sky130_fd_pr__nfet_01v8 ad=0.066 pd=0.745 as=0.2205 ps=1.89 w=0.42 l=0.15
X2066 a_39686_36822# a_37029_37583# VDPWR VDPWR sky130_fd_pr__pfet_01v8_hvt ad=0.07665 pd=0.785 as=0.15835 ps=1.395 w=0.42 l=0.15
X2067 a_52579_36822# a_51620_36469# a_52507_36822# VDPWR sky130_fd_pr__pfet_01v8_hvt ad=0.1932 pd=1.34 as=0.0441 ps=0.63 w=0.42 l=0.15
X2068 a_16812_8642# a_16812_8642# uio_oe[0] uio_oe[0] sky130_fd_pr__nfet_01v8 ad=2.32 pd=16.58 as=1.16 ps=8.29 w=8 l=1
X2069 a_40317_43023# a_39127_43023# a_40208_43023# uio_oe[0] sky130_fd_pr__special_nfet_01v8 ad=0.0669 pd=0.75 as=0.0711 ps=0.755 w=0.36 l=0.15
X2070 VDPWR a_44327_39447# a_44537_39215# VDPWR sky130_fd_pr__pfet_01v8_hvt ad=0.26 pd=2.52 as=0.135 ps=1.27 w=1 l=0.15
X2071 uio_oe[0] a_38532_37271# a_25116_34505# uio_oe[0] sky130_fd_pr__nfet_01v8 ad=0.11285 pd=1.045 as=0.169 ps=1.82 w=0.65 l=0.15
X2072 a_47283_40607# a_39947_42997# VDPWR VDPWR sky130_fd_pr__pfet_01v8_hvt ad=0.0567 pd=0.69 as=0.0819 ps=0.81 w=0.42 l=0.15
X2073 uio_oe[0] a_37913_43023# a_53203_39759# uio_oe[0] sky130_fd_pr__nfet_01v8 ad=0.0567 pd=0.69 as=0.1092 ps=1.36 w=0.42 l=0.15
X2074 uio_oe[0] a_50159_36732# a_50090_36861# uio_oe[0] sky130_fd_pr__nfet_01v8 ad=0.1346 pd=1.15 as=0.0999 ps=0.985 w=0.64 l=0.15
X2075 a_24778_14464# a_24484_14782# ua[5] uio_oe[0] sky130_fd_pr__nfet_01v8 ad=0.1885 pd=1.88 as=0.1885 ps=1.88 w=0.65 l=0.15
X2076 uio_oe[0] a_16812_8642# a_16754_24730# uio_oe[0] sky130_fd_pr__nfet_01v8 ad=1.4703 pd=10.72 as=1.4703 ps=10.72 w=5.07 l=1
X2077 uio_oe[0] a_37335_37557# a_37839_40847# uio_oe[0] sky130_fd_pr__nfet_01v8 ad=0.08775 pd=0.92 as=0.169 ps=1.82 w=0.65 l=0.15
X2078 a_54393_37583# a_53203_37583# a_54284_37583# uio_oe[0] sky130_fd_pr__special_nfet_01v8 ad=0.0669 pd=0.75 as=0.0711 ps=0.755 w=0.36 l=0.15
X2079 a_54459_34293# a_46193_39759# VDPWR VDPWR sky130_fd_pr__pfet_01v8_hvt ad=0.0567 pd=0.69 as=0.0819 ps=0.81 w=0.42 l=0.15
X2080 a_22218_34312# a_21252_34505# VDPWR VDPWR sky130_fd_pr__pfet_01v8_hvt ad=0.07665 pd=0.785 as=0.15835 ps=1.395 w=0.42 l=0.15
X2081 uio_oe[0] a_21553_32641# a_21961_37021# uio_oe[0] sky130_fd_pr__nfet_01v8 ad=0.1118 pd=1.04 as=0.0567 ps=0.69 w=0.42 l=0.15
X2082 a_22505_33483# a_21252_33417# VDPWR VDPWR sky130_fd_pr__pfet_01v8_hvt ad=0.1176 pd=1.4 as=0.0693 ps=0.75 w=0.42 l=0.15
X2083 a_53005_41935# a_52579_42262# uio_oe[0] uio_oe[0] sky130_fd_pr__nfet_01v8 ad=0.169 pd=1.82 as=0.11285 ps=1.045 w=0.65 l=0.15
X2084 a_61644_40847# a_60729_40847# a_61297_41089# uio_oe[0] sky130_fd_pr__special_nfet_01v8 ad=0.0711 pd=0.755 as=0.0999 ps=0.985 w=0.36 l=0.15
X2085 VDPWR a_58772_39911# a_58144_40008# VDPWR sky130_fd_pr__pfet_01v8_hvt ad=0.15835 pd=1.395 as=0.26 ps=2.52 w=1 l=0.15
X2086 uio_oe[0] a_60371_38101# a_60302_38127# uio_oe[0] sky130_fd_pr__nfet_01v8 ad=0.1346 pd=1.15 as=0.0999 ps=0.985 w=0.64 l=0.15
X2087 a_39907_37405# a_38285_37583# a_39544_37271# uio_oe[0] sky130_fd_pr__nfet_01v8 ad=0.0693 pd=0.75 as=0.09975 ps=0.895 w=0.42 l=0.15
X2088 a_38991_36822# a_38740_36469# a_38532_36647# VDPWR sky130_fd_pr__pfet_01v8_hvt ad=0.0441 pd=0.63 as=0.1932 ps=1.34 w=0.42 l=0.15
X2089 uio_oe[0] a_39973_42777# a_39907_42845# uio_oe[0] sky130_fd_pr__nfet_01v8 ad=0.1449 pd=1.11 as=0.0693 ps=0.75 w=0.42 l=0.15
X2090 a_53827_41213# a_48125_41935# VDPWR VDPWR sky130_fd_pr__pfet_01v8_hvt ad=0.1092 pd=1.36 as=0.07035 ps=0.755 w=0.42 l=0.15
X2091 VDPWR a_39973_38645# a_40003_38998# VDPWR sky130_fd_pr__pfet_01v8_hvt ad=0.0693 pd=0.75 as=0.0441 ps=0.63 w=0.42 l=0.15
X2092 a_26170_26464# a_24484_10376# ua[5] uio_oe[0] sky130_fd_pr__nfet_01v8 ad=0.1885 pd=1.88 as=0.1885 ps=1.88 w=0.65 l=0.15
X2093 a_29015_33007# a_28835_33007# VDPWR VDPWR sky130_fd_pr__pfet_01v8_hvt ad=0.0609 pd=0.71 as=0.0714 ps=0.76 w=0.42 l=0.15
X2094 uio_oe[0] a_37003_39996# a_36934_40125# uio_oe[0] sky130_fd_pr__nfet_01v8 ad=0.1346 pd=1.15 as=0.0999 ps=0.985 w=0.64 l=0.15
X2095 VDPWR a_37661_37052# a_38073_37910# VDPWR sky130_fd_pr__pfet_01v8_hvt ad=0.15835 pd=1.395 as=0.07665 ps=0.785 w=0.42 l=0.15
X2096 uio_oe[0] a_43275_37039# a_43609_37359# uio_oe[0] sky130_fd_pr__nfet_01v8 ad=0.208 pd=1.94 as=0.25025 ps=1.42 w=0.65 l=0.15
X2097 a_24971_33007# a_17255_32793# uio_oe[0] uio_oe[0] sky130_fd_pr__nfet_01v8 ad=0.1092 pd=1.36 as=0.1092 ps=1.36 w=0.42 l=0.15
X2098 a_39544_42087# a_39752_41909# a_39686_41935# uio_oe[0] sky130_fd_pr__nfet_01v8 ad=0.09975 pd=0.895 as=0.0693 ps=0.75 w=0.42 l=0.15
X2099 a_52579_42262# a_51620_42747# a_52579_41935# uio_oe[0] sky130_fd_pr__nfet_01v8 ad=0.09975 pd=0.895 as=0.0693 ps=0.75 w=0.42 l=0.15
X2100 uio_oe[0] a_45114_37735# a_44909_37735# uio_oe[0] sky130_fd_pr__nfet_01v8 ad=0.1092 pd=1.36 as=0.0567 ps=0.69 w=0.42 l=0.15
X2101 VDPWR a_57363_40545# a_57324_40419# VDPWR sky130_fd_pr__pfet_01v8_hvt ad=0.0864 pd=0.91 as=0.1664 ps=1.8 w=0.64 l=0.15
X2102 a_29026_36488# a_28980_36681# VDPWR VDPWR sky130_fd_pr__pfet_01v8_hvt ad=0.07665 pd=0.785 as=0.15835 ps=1.395 w=0.42 l=0.15
X2103 a_51554_36822# a_48677_38127# VDPWR VDPWR sky130_fd_pr__pfet_01v8_hvt ad=0.07665 pd=0.785 as=0.15835 ps=1.395 w=0.42 l=0.15
X2104 uio_oe[0] a_42028_36183# a_41400_35656# uio_oe[0] sky130_fd_pr__nfet_01v8 ad=0.11285 pd=1.045 as=0.169 ps=1.82 w=0.65 l=0.15
X2105 a_59898_36083# a_60176_36067# a_60132_35951# VDPWR sky130_fd_pr__pfet_01v8_hvt ad=0.0588 pd=0.7 as=0.0567 ps=0.69 w=0.42 l=0.15
X2106 VDPWR a_36447_40849# a_38077_34577# VDPWR sky130_fd_pr__pfet_01v8_hvt ad=0.26 pd=2.52 as=0.135 ps=1.27 w=1 l=0.15
X2107 a_30233_33483# a_28980_33417# uio_oe[0] uio_oe[0] sky130_fd_pr__nfet_01v8 ad=0.1092 pd=1.36 as=0.1449 ps=1.11 w=0.42 l=0.15
X2108 a_57664_34685# a_57450_34685# VDPWR VDPWR sky130_fd_pr__pfet_01v8_hvt ad=0.1155 pd=0.97 as=0.07035 ps=0.755 w=0.42 l=0.15
X2109 a_37913_43023# a_37747_43023# VDPWR VDPWR sky130_fd_pr__pfet_01v8_hvt ad=0.135 pd=1.27 as=0.135 ps=1.27 w=1 l=0.15
X2110 VDPWR a_61624_38359# a_60996_38101# VDPWR sky130_fd_pr__pfet_01v8_hvt ad=0.15835 pd=1.395 as=0.26 ps=2.52 w=1 l=0.15
X2111 a_57514_37039# a_57148_37039# VDPWR VDPWR sky130_fd_pr__pfet_01v8_hvt ad=0.0441 pd=0.63 as=0.1092 ps=1.36 w=0.42 l=0.15
X2112 a_37085_35951# a_36919_35951# uio_oe[0] uio_oe[0] sky130_fd_pr__nfet_01v8 ad=0.08775 pd=0.92 as=0.08775 ps=0.92 w=0.65 l=0.15
X2113 uio_oe[0] a_36999_37013# a_37029_37039# uio_oe[0] sky130_fd_pr__nfet_01v8 ad=0.08775 pd=0.92 as=0.08775 ps=0.92 w=0.65 l=0.15
X2114 a_19834_10464# a_16756_10376# ua[4] uio_oe[0] sky130_fd_pr__nfet_01v8 ad=0.1885 pd=1.88 as=0.1885 ps=1.88 w=0.65 l=0.15
X2115 a_51775_37405# a_38740_37307# a_51412_37271# uio_oe[0] sky130_fd_pr__nfet_01v8 ad=0.0693 pd=0.75 as=0.09975 ps=0.895 w=0.42 l=0.15
X2116 uio_oe[0] a_51841_42777# a_51775_42845# uio_oe[0] sky130_fd_pr__nfet_01v8 ad=0.1449 pd=1.11 as=0.0693 ps=0.75 w=0.42 l=0.15
X2117 a_43125_39759# a_43081_40001# a_42959_39759# uio_oe[0] sky130_fd_pr__nfet_01v8 ad=0.0441 pd=0.63 as=0.1401 ps=1.1 w=0.42 l=0.15
X2118 uio_oe[0] a_52335_38101# a_51620_38395# uio_oe[0] sky130_fd_pr__nfet_01v8 ad=0.2087 pd=2.02 as=0.169 ps=1.82 w=0.65 l=0.15
X2119 a_51841_41689# a_48677_39759# uio_oe[0] uio_oe[0] sky130_fd_pr__nfet_01v8 ad=0.1092 pd=1.36 as=0.1449 ps=1.11 w=0.42 l=0.15
X2120 a_53981_36495# a_53937_36737# a_53815_36495# uio_oe[0] sky130_fd_pr__nfet_01v8 ad=0.0441 pd=0.63 as=0.1401 ps=1.1 w=0.42 l=0.15
X2121 a_57280_42479# a_56843_42453# VDPWR VDPWR sky130_fd_pr__pfet_01v8_hvt ad=0.0567 pd=0.69 as=0.0819 ps=0.81 w=0.42 l=0.15
X2122 a_51412_42087# a_51620_41909# a_51554_41935# uio_oe[0] sky130_fd_pr__nfet_01v8 ad=0.09975 pd=0.895 as=0.0693 ps=0.75 w=0.42 l=0.15
X2123 a_46193_40847# a_46027_40847# VDPWR VDPWR sky130_fd_pr__pfet_01v8_hvt ad=0.1664 pd=1.8 as=0.0864 ps=0.91 w=0.64 l=0.15
X2124 uio_oe[0] a_16812_8642# a_20618_20730# uio_oe[0] sky130_fd_pr__nfet_01v8 ad=1.4703 pd=10.72 as=1.4703 ps=10.72 w=5.07 l=1
X2125 a_57776_41757# a_57640_41705# VDPWR VDPWR sky130_fd_pr__pfet_01v8_hvt ad=0.0567 pd=0.69 as=0.0567 ps=0.69 w=0.42 l=0.15
X2126 a_45530_40847# a_39947_42997# uio_oe[0] uio_oe[0] sky130_fd_pr__nfet_01v8 ad=0.06405 pd=0.725 as=0.12495 ps=1.015 w=0.42 l=0.15
X2127 uio_oe[0] a_59201_37557# a_59135_37583# uio_oe[0] sky130_fd_pr__nfet_01v8 ad=0.1449 pd=1.11 as=0.0693 ps=0.75 w=0.42 l=0.15
X2128 a_19834_10464# ua[3] a_19588_10020# uio_oe[0] sky130_fd_pr__nfet_01v8 ad=0.2436 pd=2.26 as=0.2436 ps=2.26 w=0.84 l=0.6
X2129 a_24482_24730# ua[1] a_24354_26020# uio_oe[0] sky130_fd_pr__nfet_01v8 ad=0.2436 pd=2.26 as=0.2436 ps=2.26 w=0.84 l=0.6
X2130 a_37375_35773# a_37195_35773# VDPWR VDPWR sky130_fd_pr__pfet_01v8_hvt ad=0.0609 pd=0.71 as=0.0714 ps=0.76 w=0.42 l=0.15
X2131 VDPWR a_57012_34837# a_57148_34863# VDPWR sky130_fd_pr__pfet_01v8_hvt ad=0.12285 pd=1.17 as=0.2184 ps=2.2 w=0.84 l=0.15
X2132 a_20620_18782# a_21875_34845# VDPWR VDPWR sky130_fd_pr__pfet_01v8_hvt ad=0.475 pd=2.95 as=0.16655 ps=1.39 w=1 l=0.15
X2133 a_53321_41757# a_52942_41391# a_53249_41757# uio_oe[0] sky130_fd_pr__nfet_01v8 ad=0.1401 pd=1.1 as=0.0441 ps=0.63 w=0.42 l=0.15
X2134 a_36393_40875# a_17500_33453# a_36307_40875# uio_oe[0] sky130_fd_pr__nfet_01v8 ad=0.0567 pd=0.69 as=0.1176 ps=1.4 w=0.42 l=0.15
X2135 uio_oe[0] a_54264_39447# a_53636_39189# uio_oe[0] sky130_fd_pr__nfet_01v8 ad=0.11285 pd=1.045 as=0.169 ps=1.82 w=0.65 l=0.15
X2136 a_17721_35659# a_17388_35593# uio_oe[0] uio_oe[0] sky130_fd_pr__nfet_01v8 ad=0.1092 pd=1.36 as=0.1449 ps=1.11 w=0.42 l=0.15
X2137 a_4259_22596# ua[0] uio_oe[0] sky130_fd_pr__res_xhigh_po_0p35 l=17.36
X2138 a_22395_34095# a_20923_33729# uio_oe[0] uio_oe[0] sky130_fd_pr__nfet_01v8 ad=0.1092 pd=1.36 as=0.1092 ps=1.36 w=0.42 l=0.15
X2139 a_61950_37405# a_37361_41391# uio_oe[0] uio_oe[0] sky130_fd_pr__nfet_01v8 ad=0.0693 pd=0.75 as=0.11285 ps=1.045 w=0.42 l=0.15
X2140 VDPWR a_46193_39759# a_60720_35229# VDPWR sky130_fd_pr__pfet_01v8_hvt ad=0.0798 pd=0.8 as=0.0567 ps=0.69 w=0.42 l=0.15
X2141 a_60988_39215# a_60720_39581# VDPWR VDPWR sky130_fd_pr__pfet_01v8_hvt ad=0.0945 pd=0.87 as=0.0798 ps=0.8 w=0.42 l=0.15
X2142 a_40987_38369# a_38005_41391# VDPWR VDPWR sky130_fd_pr__pfet_01v8_hvt ad=0.1664 pd=1.8 as=0.0864 ps=0.91 w=0.64 l=0.15
X2143 a_36447_40849# a_43419_42783# VDPWR VDPWR sky130_fd_pr__pfet_01v8_hvt ad=0.26 pd=2.52 as=0.3012 ps=2.66 w=1 l=0.15
X2144 a_47462_41935# a_39947_42997# uio_oe[0] uio_oe[0] sky130_fd_pr__nfet_01v8 ad=0.06405 pd=0.725 as=0.12495 ps=1.015 w=0.42 l=0.15
X2145 uio_oe[0] a_37029_42479# a_44095_40309# uio_oe[0] sky130_fd_pr__nfet_01v8 ad=0.0567 pd=0.69 as=0.1092 ps=1.36 w=0.42 l=0.15
X2146 a_39544_36647# a_39759_36777# a_39686_36822# VDPWR sky130_fd_pr__pfet_01v8_hvt ad=0.1932 pd=1.34 as=0.07665 ps=0.785 w=0.42 l=0.15
X2147 a_27562_18464# a_24484_18376# ua[5] uio_oe[0] sky130_fd_pr__nfet_01v8 ad=0.1885 pd=1.88 as=0.1885 ps=1.88 w=0.65 l=0.15
X2148 a_38019_34685# a_37839_34685# VDPWR VDPWR sky130_fd_pr__pfet_01v8_hvt ad=0.0609 pd=0.71 as=0.0714 ps=0.76 w=0.42 l=0.15
X2149 a_57450_41213# a_57363_40989# a_57046_41099# VDPWR sky130_fd_pr__pfet_01v8_hvt ad=0.12915 pd=1.185 as=0.0588 ps=0.7 w=0.42 l=0.15
X2150 uio_oe[0] a_16812_8642# a_22010_24730# uio_oe[0] sky130_fd_pr__nfet_01v8 ad=1.4703 pd=10.72 as=1.4703 ps=10.72 w=5.07 l=1
X2151 ua[5] a_24484_10376# a_25746_10020# uio_oe[0] sky130_fd_pr__nfet_01v8 ad=0.1885 pd=1.88 as=0.1885 ps=1.88 w=0.65 l=0.15
X2152 uio_oe[0] a_47283_42997# a_47217_43023# uio_oe[0] sky130_fd_pr__nfet_01v8 ad=0.12495 pd=1.015 as=0.0669 ps=0.75 w=0.42 l=0.15
X2153 VDPWR a_38005_41391# a_40415_36495# VDPWR sky130_fd_pr__pfet_01v8_hvt ad=0.0864 pd=0.91 as=0.1664 ps=1.8 w=0.64 l=0.15
X2154 a_18148_18782# a_18011_33757# uio_oe[0] uio_oe[0] sky130_fd_pr__nfet_01v8 ad=0.182 pd=1.86 as=0.1118 ps=1.04 w=0.65 l=0.15
X2155 a_60802_41757# a_60584_41705# a_60720_41757# uio_oe[0] sky130_fd_pr__nfet_01v8 ad=0.0441 pd=0.63 as=0.1092 ps=1.36 w=0.42 l=0.15
X2156 a_43406_40303# a_42329_40309# a_43244_40681# VDPWR sky130_fd_pr__pfet_01v8_hvt ad=0.0567 pd=0.69 as=0.0588 ps=0.7 w=0.42 l=0.15
X2157 a_51620_39733# a_54459_39733# VDPWR VDPWR sky130_fd_pr__pfet_01v8_hvt ad=0.26 pd=2.52 as=0.3012 ps=2.66 w=1 l=0.15
X2158 a_60609_38493# a_46193_39759# uio_oe[0] uio_oe[0] sky130_fd_pr__nfet_01v8 ad=0.0441 pd=0.63 as=0.1346 ps=1.15 w=0.42 l=0.15
X2159 a_19834_22464# a_16756_14376# ua[5] uio_oe[0] sky130_fd_pr__nfet_01v8 ad=0.1885 pd=1.88 as=0.1885 ps=1.88 w=0.65 l=0.15
X2160 VDPWR a_21553_32641# a_21875_34845# VDPWR sky130_fd_pr__pfet_01v8_hvt ad=0.16655 pd=1.39 as=0.0567 ps=0.69 w=0.42 l=0.15
X2161 VDPWR a_44905_38671# a_49483_36469# VDPWR sky130_fd_pr__pfet_01v8_hvt ad=0.0819 pd=0.81 as=0.0567 ps=0.69 w=0.42 l=0.15
X2162 a_29247_35727# a_17507_33198# a_28884_35593# uio_oe[0] sky130_fd_pr__nfet_01v8 ad=0.0693 pd=0.75 as=0.09975 ps=0.895 w=0.42 l=0.15
X2163 uio_oe[0] a_29129_33703# a_29063_33729# uio_oe[0] sky130_fd_pr__nfet_01v8 ad=0.1449 pd=1.11 as=0.0693 ps=0.75 w=0.42 l=0.15
X2164 a_50090_34685# a_49964_34587# a_49686_34571# uio_oe[0] sky130_fd_pr__special_nfet_01v8 ad=0.0999 pd=0.985 as=0.0711 ps=0.755 w=0.36 l=0.15
X2165 uio_oe[0] a_37029_42479# a_46027_41397# uio_oe[0] sky130_fd_pr__nfet_01v8 ad=0.0567 pd=0.69 as=0.1092 ps=1.36 w=0.42 l=0.15
X2166 uio_oe[0] a_37755_40303# a_38089_40623# uio_oe[0] sky130_fd_pr__nfet_01v8 ad=0.208 pd=1.94 as=0.25025 ps=1.42 w=0.65 l=0.15
X2167 a_44829_43265# a_44611_43023# uio_oe[0] uio_oe[0] sky130_fd_pr__nfet_01v8 ad=0.0999 pd=0.985 as=0.1346 ps=1.15 w=0.64 l=0.15
X2168 a_47270_43389# a_46193_43023# a_47108_43023# VDPWR sky130_fd_pr__pfet_01v8_hvt ad=0.0567 pd=0.69 as=0.0588 ps=0.7 w=0.42 l=0.15
X2169 VDPWR a_61819_40821# a_61806_41213# VDPWR sky130_fd_pr__pfet_01v8_hvt ad=0.0819 pd=0.81 as=0.0567 ps=0.69 w=0.42 l=0.15
X2170 a_43603_39733# a_40379_35551# VDPWR VDPWR sky130_fd_pr__pfet_01v8_hvt ad=0.0567 pd=0.69 as=0.0819 ps=0.81 w=0.42 l=0.15
X2171 uio_oe[0] a_38005_41391# a_40415_37045# uio_oe[0] sky130_fd_pr__nfet_01v8 ad=0.0567 pd=0.69 as=0.1092 ps=1.36 w=0.42 l=0.15
X2172 VDPWR a_57519_42453# a_57450_42479# VDPWR sky130_fd_pr__pfet_01v8_hvt ad=0.2184 pd=2.2 as=0.12915 ps=1.185 w=0.84 l=0.15
X2173 a_41074_38127# a_40948_38243# a_40670_38259# uio_oe[0] sky130_fd_pr__special_nfet_01v8 ad=0.0999 pd=0.985 as=0.0711 ps=0.755 w=0.36 l=0.15
X2174 a_41241_37825# a_41023_37583# VDPWR VDPWR sky130_fd_pr__pfet_01v8_hvt ad=0.12915 pd=1.185 as=0.2184 ps=2.2 w=0.84 l=0.15
X2175 VDPWR a_24787_33729# a_26259_34095# VDPWR sky130_fd_pr__pfet_01v8_hvt ad=0.0714 pd=0.76 as=0.1092 ps=1.36 w=0.42 l=0.15
X2176 a_58914_41935# a_48677_39759# uio_oe[0] uio_oe[0] sky130_fd_pr__nfet_01v8 ad=0.0693 pd=0.75 as=0.11285 ps=1.045 w=0.42 l=0.15
X2177 a_40705_39759# a_40670_40011# a_40467_39733# uio_oe[0] sky130_fd_pr__nfet_01v8 ad=0.06405 pd=0.725 as=0.1092 ps=1.36 w=0.42 l=0.15
X2178 uio_oe[0] a_37913_43023# a_53203_38671# uio_oe[0] sky130_fd_pr__nfet_01v8 ad=0.0567 pd=0.69 as=0.1092 ps=1.36 w=0.42 l=0.15
X2179 ua[5] a_24484_14376# a_27138_14020# uio_oe[0] sky130_fd_pr__nfet_01v8 ad=0.1885 pd=1.88 as=0.1885 ps=1.88 w=0.65 l=0.15
X2180 a_53827_34685# a_46193_39759# VDPWR VDPWR sky130_fd_pr__pfet_01v8_hvt ad=0.1092 pd=1.36 as=0.07035 ps=0.755 w=0.42 l=0.15
X2181 a_30233_34571# a_28980_34505# VDPWR VDPWR sky130_fd_pr__pfet_01v8_hvt ad=0.1176 pd=1.4 as=0.0693 ps=0.75 w=0.42 l=0.15
X2182 uio_oe[0] a_42919_38369# a_42880_38243# uio_oe[0] sky130_fd_pr__nfet_01v8 ad=0.0567 pd=0.69 as=0.1092 ps=1.36 w=0.42 l=0.15
X2183 a_41658_37039# a_40581_37045# a_41496_37417# VDPWR sky130_fd_pr__pfet_01v8_hvt ad=0.0567 pd=0.69 as=0.0588 ps=0.7 w=0.42 l=0.15
X2184 uio_oe[0] a_41309_34319# a_39759_39228# uio_oe[0] sky130_fd_pr__nfet_01v8 ad=0.169 pd=1.82 as=0.169 ps=1.82 w=0.65 l=0.15
X2185 a_51412_36647# a_39752_36469# a_51554_36822# VDPWR sky130_fd_pr__pfet_01v8_hvt ad=0.1932 pd=1.34 as=0.07665 ps=0.785 w=0.42 l=0.15
X2186 a_21961_33757# a_20923_33729# a_21875_33757# uio_oe[0] sky130_fd_pr__nfet_01v8 ad=0.0567 pd=0.69 as=0.1176 ps=1.4 w=0.42 l=0.15
X2187 uio_oe[0] a_44905_38671# a_49721_34319# uio_oe[0] sky130_fd_pr__nfet_01v8 ad=0.12495 pd=1.015 as=0.06405 ps=0.725 w=0.42 l=0.15
X2188 a_58914_35990# a_48677_38127# VDPWR VDPWR sky130_fd_pr__pfet_01v8_hvt ad=0.07665 pd=0.785 as=0.15835 ps=1.395 w=0.42 l=0.15
X2189 uio_oe[0] uio_oe[0] uio_oe[0] uio_oe[0] sky130_fd_pr__nfet_01v8 ad=0.1885 pd=1.88 as=0 ps=0 w=0.65 l=0.15
X2190 a_60365_34319# a_59939_34646# VDPWR VDPWR sky130_fd_pr__pfet_01v8_hvt ad=0.26 pd=2.52 as=0.15835 ps=1.395 w=1 l=0.15
X2191 a_50722_34863# a_49964_34979# a_50159_34837# VDPWR sky130_fd_pr__pfet_01v8_hvt ad=0.0651 pd=0.73 as=0.07245 ps=0.765 w=0.42 l=0.15
X2192 a_53369_40847# a_53203_40847# uio_oe[0] uio_oe[0] sky130_fd_pr__nfet_01v8 ad=0.1092 pd=1.36 as=0.0567 ps=0.69 w=0.42 l=0.15
X2193 a_43918_36041# a_45095_39733# VDPWR VDPWR sky130_fd_pr__pfet_01v8_hvt ad=0.135 pd=1.27 as=0.26 ps=2.52 w=1 l=0.15
X2194 a_52855_39457# a_37913_43023# uio_oe[0] uio_oe[0] sky130_fd_pr__nfet_01v8 ad=0.1092 pd=1.36 as=0.0567 ps=0.69 w=0.42 l=0.15
X2195 a_43173_38913# a_42955_38671# VDPWR VDPWR sky130_fd_pr__pfet_01v8_hvt ad=0.12915 pd=1.185 as=0.2184 ps=2.2 w=0.84 l=0.15
X2196 a_36329_36469# a_36427_36475# uio_oe[0] uio_oe[0] sky130_fd_pr__nfet_01v8 ad=0.0567 pd=0.69 as=0.10187 ps=0.99 w=0.42 l=0.15
X2197 a_39947_42997# a_41231_42997# uio_oe[0] uio_oe[0] sky130_fd_pr__nfet_01v8 ad=0.08775 pd=0.92 as=0.08775 ps=0.92 w=0.65 l=0.15
X2198 a_51841_42777# a_48677_39759# VDPWR VDPWR sky130_fd_pr__pfet_01v8_hvt ad=0.1176 pd=1.4 as=0.0693 ps=0.75 w=0.42 l=0.15
X2199 a_25874_16730# ua[1] a_25746_18020# uio_oe[0] sky130_fd_pr__nfet_01v8 ad=0.2436 pd=2.26 as=0.2436 ps=2.26 w=0.84 l=0.6
X2200 uio_oe[0] a_36631_41365# a_36661_41391# uio_oe[0] sky130_fd_pr__nfet_01v8 ad=0.08775 pd=0.92 as=0.08775 ps=0.92 w=0.65 l=0.15
X2201 a_57829_37583# a_57450_37949# a_57757_37583# uio_oe[0] sky130_fd_pr__nfet_01v8 ad=0.1401 pd=1.1 as=0.0441 ps=0.63 w=0.42 l=0.15
X2202 VDPWR a_48125_43023# a_50304_42301# VDPWR sky130_fd_pr__pfet_01v8_hvt ad=0.07035 pd=0.755 as=0.1092 ps=1.36 w=0.42 l=0.15
X2203 a_58772_39911# a_58980_39733# a_58914_39759# uio_oe[0] sky130_fd_pr__nfet_01v8 ad=0.09975 pd=0.895 as=0.0693 ps=0.75 w=0.42 l=0.15
X2204 uio_oe[0] a_16812_8642# a_23402_24730# uio_oe[0] sky130_fd_pr__nfet_01v8 ad=1.4703 pd=10.72 as=1.4703 ps=10.72 w=5.07 l=1
X2205 a_31426_14464# a_28348_14782# ua[5] uio_oe[0] sky130_fd_pr__nfet_01v8 ad=0.1885 pd=1.88 as=0.1885 ps=1.88 w=0.65 l=0.15
X2206 a_58980_35381# a_61819_35381# VDPWR VDPWR sky130_fd_pr__pfet_01v8_hvt ad=0.26 pd=2.52 as=0.3012 ps=2.66 w=1 l=0.15
X2207 VDPWR a_52335_42453# a_51620_42747# VDPWR sky130_fd_pr__pfet_01v8_hvt ad=0.3012 pd=2.66 as=0.26 ps=2.52 w=1 l=0.15
X2208 a_43063_39037# a_42439_38671# a_42955_38671# VDPWR sky130_fd_pr__pfet_01v8_hvt ad=0.1155 pd=0.97 as=0.07245 ps=0.765 w=0.42 l=0.15
X2209 a_50003_37725# a_41685_42479# VDPWR VDPWR sky130_fd_pr__pfet_01v8_hvt ad=0.1664 pd=1.8 as=0.0864 ps=0.91 w=0.64 l=0.15
X2210 VDPWR a_61297_42177# a_61187_42301# VDPWR sky130_fd_pr__pfet_01v8_hvt ad=0.07035 pd=0.755 as=0.1155 ps=0.97 w=0.42 l=0.15
X2211 a_28842_34817# a_28796_34969# uio_oe[0] uio_oe[0] sky130_fd_pr__nfet_01v8 ad=0.0693 pd=0.75 as=0.11285 ps=1.045 w=0.42 l=0.15
X2212 a_48677_39759# a_48511_39759# VDPWR VDPWR sky130_fd_pr__pfet_01v8_hvt ad=0.135 pd=1.27 as=0.135 ps=1.27 w=1 l=0.15
X2213 a_57081_37583# a_57046_37835# a_56843_37557# uio_oe[0] sky130_fd_pr__nfet_01v8 ad=0.06405 pd=0.725 as=0.1092 ps=1.36 w=0.42 l=0.15
X2214 VDPWR a_37661_38140# a_42389_37078# VDPWR sky130_fd_pr__pfet_01v8_hvt ad=0.0693 pd=0.75 as=0.1176 ps=1.4 w=0.42 l=0.15
X2215 a_57640_37353# a_57556_37013# a_58044_37405# uio_oe[0] sky130_fd_pr__special_nfet_01v8 ad=0.072 pd=0.76 as=0.06705 ps=0.75 w=0.36 l=0.15
X2216 a_25825_35933# a_24787_35905# a_25739_35933# uio_oe[0] sky130_fd_pr__nfet_01v8 ad=0.0567 pd=0.69 as=0.1176 ps=1.4 w=0.42 l=0.15
X2217 a_41013_35407# a_40379_35551# uio_oe[0] uio_oe[0] sky130_fd_pr__nfet_01v8 ad=0.0441 pd=0.63 as=0.1346 ps=1.15 w=0.42 l=0.15
X2218 uio_oe[0] uio_oe[0] uio_oe[0] uio_oe[0] sky130_fd_pr__nfet_01v8 ad=0.1885 pd=1.88 as=0 ps=0 w=0.65 l=0.15
X2219 uio_oe[0] a_16812_8642# a_16812_8642# uio_oe[0] sky130_fd_pr__nfet_01v8 ad=1.16 pd=8.29 as=1.16 ps=8.29 w=8 l=1
X2220 a_43419_41695# a_43244_41769# a_43598_41757# uio_oe[0] sky130_fd_pr__nfet_01v8 ad=0.1092 pd=1.36 as=0.06405 ps=0.725 w=0.42 l=0.15
X2221 VDPWR a_41768_40008# a_41706_40125# VDPWR sky130_fd_pr__pfet_01v8_hvt ad=0.1092 pd=1.36 as=0.0651 ps=0.73 w=0.42 l=0.15
X2222 VDPWR a_49483_35925# a_38771_35967# VDPWR sky130_fd_pr__pfet_01v8_hvt ad=0.3012 pd=2.66 as=0.26 ps=2.52 w=1 l=0.15
X2223 a_57354_37405# a_44905_38671# uio_oe[0] uio_oe[0] sky130_fd_pr__nfet_01v8 ad=0.0483 pd=0.65 as=0.1137 ps=1.01 w=0.42 l=0.15
X2224 VDPWR a_53011_35925# a_52942_35951# VDPWR sky130_fd_pr__pfet_01v8_hvt ad=0.2184 pd=2.2 as=0.12915 ps=1.185 w=0.84 l=0.15
X2225 uio_oe[0] a_41519_42479# a_41685_42479# uio_oe[0] sky130_fd_pr__nfet_01v8 ad=0.169 pd=1.82 as=0.08775 ps=0.92 w=0.65 l=0.15
X2226 uio_oe[0] a_22505_36747# a_22439_36815# uio_oe[0] sky130_fd_pr__nfet_01v8 ad=0.1449 pd=1.11 as=0.0693 ps=0.75 w=0.42 l=0.15
X2227 a_50159_42453# a_50003_42721# a_50304_42479# VDPWR sky130_fd_pr__pfet_01v8_hvt ad=0.07245 pd=0.765 as=0.1155 ps=0.97 w=0.42 l=0.15
X2228 a_36631_41365# uio_in[2] uio_oe[0] uio_oe[0] sky130_fd_pr__nfet_01v8 ad=0.169 pd=1.82 as=0.08775 ps=0.92 w=0.65 l=0.15
X2229 a_25449_36747# a_25116_36681# uio_oe[0] uio_oe[0] sky130_fd_pr__nfet_01v8 ad=0.1092 pd=1.36 as=0.1449 ps=1.11 w=0.42 l=0.15
X2230 a_17250_35905# a_17204_36057# uio_oe[0] uio_oe[0] sky130_fd_pr__nfet_01v8 ad=0.0693 pd=0.75 as=0.11285 ps=1.045 w=0.42 l=0.15
X2231 a_30167_35727# a_18427_33198# a_29804_35593# uio_oe[0] sky130_fd_pr__nfet_01v8 ad=0.0693 pd=0.75 as=0.09975 ps=0.895 w=0.42 l=0.15
X2232 a_57450_34685# a_57363_34461# a_57046_34571# VDPWR sky130_fd_pr__pfet_01v8_hvt ad=0.12915 pd=1.185 as=0.0588 ps=0.7 w=0.42 l=0.15
X2233 a_41143_39189# a_40948_39331# a_41453_39581# uio_oe[0] sky130_fd_pr__special_nfet_01v8 ad=0.0594 pd=0.69 as=0.1401 ps=1.1 w=0.36 l=0.15
X2234 a_49721_40669# a_49686_40435# a_49483_40277# uio_oe[0] sky130_fd_pr__nfet_01v8 ad=0.06405 pd=0.725 as=0.1092 ps=1.36 w=0.42 l=0.15
X2235 VDPWR a_46193_39759# a_53156_37039# VDPWR sky130_fd_pr__pfet_01v8_hvt ad=0.07035 pd=0.755 as=0.1092 ps=1.36 w=0.42 l=0.15
X2236 a_54627_36317# a_54479_35964# a_54264_36183# uio_oe[0] sky130_fd_pr__nfet_01v8 ad=0.0693 pd=0.75 as=0.09975 ps=0.895 w=0.42 l=0.15
X2237 uio_oe[0] uio_oe[0] uio_oe[0] uio_oe[0] sky130_fd_pr__nfet_01v8 ad=1.4703 pd=10.72 as=0 ps=0 w=5.07 l=1
X2238 VDPWR a_48511_39759# a_48677_39759# VDPWR sky130_fd_pr__pfet_01v8_hvt ad=0.26 pd=2.52 as=0.135 ps=1.27 w=1 l=0.15
X2239 a_36385_38127# a_36355_38101# uio_oe[0] uio_oe[0] sky130_fd_pr__nfet_01v8 ad=0.08775 pd=0.92 as=0.169 ps=1.82 w=0.65 l=0.15
X2240 a_58980_34293# a_61819_34293# uio_oe[0] uio_oe[0] sky130_fd_pr__nfet_01v8 ad=0.169 pd=1.82 as=0.2087 ps=2.02 w=0.65 l=0.15
X2241 a_41141_40316# a_43419_41695# VDPWR VDPWR sky130_fd_pr__pfet_01v8_hvt ad=0.26 pd=2.52 as=0.3012 ps=2.66 w=1 l=0.15
X2242 uio_oe[0] a_54693_41689# a_54627_41757# uio_oe[0] sky130_fd_pr__nfet_01v8 ad=0.1449 pd=1.11 as=0.0693 ps=0.75 w=0.42 l=0.15
X2243 a_52800_36495# a_51620_36469# a_52579_36822# uio_oe[0] sky130_fd_pr__nfet_01v8 ad=0.0693 pd=0.75 as=0.09975 ps=0.895 w=0.42 l=0.15
X2244 a_50397_36317# a_44905_38671# uio_oe[0] uio_oe[0] sky130_fd_pr__nfet_01v8 ad=0.0441 pd=0.63 as=0.1346 ps=1.15 w=0.42 l=0.15
X2245 a_57321_36317# a_56843_35925# uio_oe[0] uio_oe[0] sky130_fd_pr__nfet_01v8 ad=0.0669 pd=0.75 as=0.12495 ps=1.015 w=0.42 l=0.15
X2246 VDPWR uio_in[0] a_37747_43023# VDPWR sky130_fd_pr__pfet_01v8_hvt ad=0.135 pd=1.27 as=0.26 ps=2.52 w=1 l=0.15
X2247 a_58082_41213# a_57324_41115# a_57519_41084# VDPWR sky130_fd_pr__pfet_01v8_hvt ad=0.0651 pd=0.73 as=0.07245 ps=0.765 w=0.42 l=0.15
X2248 VDPWR a_53937_40001# a_53827_40125# VDPWR sky130_fd_pr__pfet_01v8_hvt ad=0.07035 pd=0.755 as=0.1155 ps=0.97 w=0.42 l=0.15
X2249 VDPWR a_61819_34293# a_61806_34685# VDPWR sky130_fd_pr__pfet_01v8_hvt ad=0.0819 pd=0.81 as=0.0567 ps=0.69 w=0.42 l=0.15
X2250 a_42685_36611# a_43603_39519# uio_oe[0] uio_oe[0] sky130_fd_pr__nfet_01v8 ad=0.169 pd=1.82 as=0.2087 ps=2.02 w=0.65 l=0.15
X2251 a_29804_35593# a_18427_33198# a_29946_35400# VDPWR sky130_fd_pr__pfet_01v8_hvt ad=0.1932 pd=1.34 as=0.07665 ps=0.785 w=0.42 l=0.15
X2252 a_37029_37039# a_36999_37013# uio_oe[0] uio_oe[0] sky130_fd_pr__nfet_01v8 ad=0.08775 pd=0.92 as=0.169 ps=1.82 w=0.65 l=0.15
X2253 a_31130_24730# ua[0] a_31002_26020# uio_oe[0] sky130_fd_pr__nfet_01v8 ad=0.2436 pd=2.26 as=0.2436 ps=2.26 w=0.84 l=0.6
X2254 a_57012_34837# a_44905_38671# VDPWR VDPWR sky130_fd_pr__pfet_01v8_hvt ad=0.1092 pd=1.36 as=0.12285 ps=1.17 w=0.42 l=0.15
X2255 a_44327_38359# a_47283_40607# VDPWR VDPWR sky130_fd_pr__pfet_01v8_hvt ad=0.26 pd=2.52 as=0.3012 ps=2.66 w=1 l=0.15
X2256 a_57664_40303# a_57450_40303# VDPWR VDPWR sky130_fd_pr__pfet_01v8_hvt ad=0.1155 pd=0.97 as=0.07035 ps=0.755 w=0.42 l=0.15
X2257 a_44369_40009# a_44339_39944# a_43432_35381# VDPWR sky130_fd_pr__pfet_01v8_hvt ad=0.26 pd=2.52 as=0.3 ps=2.6 w=1 l=0.15
X2258 uio_oe[0] a_40379_35551# a_43125_39581# uio_oe[0] sky130_fd_pr__nfet_01v8 ad=0.1346 pd=1.15 as=0.0441 ps=0.63 w=0.42 l=0.15
X2259 uio_oe[0] a_17255_32793# a_36503_34293# uio_oe[0] sky130_fd_pr__nfet_01v8 ad=0.1092 pd=1.36 as=0.1092 ps=1.36 w=0.42 l=0.15
X2260 uio_oe[0] a_48125_41935# a_61341_39759# uio_oe[0] sky130_fd_pr__nfet_01v8 ad=0.1346 pd=1.15 as=0.0441 ps=0.63 w=0.42 l=0.15
X2261 a_37169_38671# a_36835_38921# a_37085_38921# VDPWR sky130_fd_pr__pfet_01v8_hvt ad=0.3 pd=2.6 as=0.26 ps=2.52 w=1 l=0.15
X2262 VDPWR a_50003_34461# a_49964_34587# VDPWR sky130_fd_pr__pfet_01v8_hvt ad=0.0864 pd=0.91 as=0.1664 ps=1.8 w=0.64 l=0.15
X2263 a_49920_34863# a_49483_34837# VDPWR VDPWR sky130_fd_pr__pfet_01v8_hvt ad=0.0567 pd=0.69 as=0.0819 ps=0.81 w=0.42 l=0.15
X2264 a_58772_36183# a_39783_35967# a_58914_35990# VDPWR sky130_fd_pr__pfet_01v8_hvt ad=0.1932 pd=1.34 as=0.07665 ps=0.785 w=0.42 l=0.15
X2265 a_59898_42611# a_60215_42721# a_60173_42845# uio_oe[0] sky130_fd_pr__special_nfet_01v8 ad=0.0711 pd=0.755 as=0.0669 ps=0.75 w=0.36 l=0.15
X2266 VDPWR a_37452_34953# a_37410_34979# VDPWR sky130_fd_pr__pfet_01v8_hvt ad=0.14575 pd=1.335 as=0.0441 ps=0.63 w=0.42 l=0.15
X2267 a_38005_41391# a_37839_41391# VDPWR VDPWR sky130_fd_pr__pfet_01v8_hvt ad=0.135 pd=1.27 as=0.135 ps=1.27 w=1 l=0.15
X2268 VDPWR rst_n a_44739_38671# VDPWR sky130_fd_pr__pfet_01v8_hvt ad=0.135 pd=1.27 as=0.26 ps=2.52 w=1 l=0.15
X2269 a_16754_16730# ua[3] a_16626_18020# uio_oe[0] sky130_fd_pr__nfet_01v8 ad=0.2436 pd=2.26 as=0.2436 ps=2.26 w=0.84 l=0.6
X2270 a_61819_40821# a_61644_40847# a_61998_40847# uio_oe[0] sky130_fd_pr__nfet_01v8 ad=0.1092 pd=1.36 as=0.06405 ps=0.725 w=0.42 l=0.15
X2271 a_57280_37949# a_56843_37557# VDPWR VDPWR sky130_fd_pr__pfet_01v8_hvt ad=0.0567 pd=0.69 as=0.0819 ps=0.81 w=0.42 l=0.15
X2272 a_40836_36495# a_38285_38127# VDPWR VDPWR sky130_fd_pr__pfet_01v8_hvt ad=0.0651 pd=0.73 as=0.1092 ps=1.36 w=0.42 l=0.15
X2273 a_41108_35095# a_41316_35131# a_41250_35229# uio_oe[0] sky130_fd_pr__nfet_01v8 ad=0.09975 pd=0.895 as=0.0693 ps=0.75 w=0.42 l=0.15
X2274 uio_oe[0] a_50003_35105# a_49964_34979# uio_oe[0] sky130_fd_pr__nfet_01v8 ad=0.0567 pd=0.69 as=0.1092 ps=1.36 w=0.42 l=0.15
X2275 a_49483_42453# a_49686_42611# VDPWR VDPWR sky130_fd_pr__pfet_01v8_hvt ad=0.0567 pd=0.69 as=0.1134 ps=1.38 w=0.42 l=0.15
X2276 a_28884_36681# a_17500_33453# a_29026_36815# uio_oe[0] sky130_fd_pr__nfet_01v8 ad=0.09975 pd=0.895 as=0.0693 ps=0.75 w=0.42 l=0.15
X2277 VDPWR a_44905_38671# a_50304_35773# VDPWR sky130_fd_pr__pfet_01v8_hvt ad=0.07035 pd=0.755 as=0.1092 ps=1.36 w=0.42 l=0.15
X2278 a_43032_34569# a_43014_34471# uio_oe[0] uio_oe[0] sky130_fd_pr__nfet_01v8 ad=0.0567 pd=0.69 as=0.1092 ps=1.36 w=0.42 l=0.15
X2279 VDPWR a_21553_32641# a_22575_35183# VDPWR sky130_fd_pr__pfet_01v8_hvt ad=0.2279 pd=1.74 as=0.0609 ps=0.71 w=0.42 l=0.15
X2280 uio_oe[0] a_39544_42711# a_17204_37145# uio_oe[0] sky130_fd_pr__nfet_01v8 ad=0.11285 pd=1.045 as=0.169 ps=1.82 w=0.65 l=0.15
X2281 a_53369_40847# a_53203_40847# VDPWR VDPWR sky130_fd_pr__pfet_01v8_hvt ad=0.1664 pd=1.8 as=0.0864 ps=0.91 w=0.64 l=0.15
X2282 VDPWR a_18641_33483# a_18671_33224# VDPWR sky130_fd_pr__pfet_01v8_hvt ad=0.0693 pd=0.75 as=0.0441 ps=0.63 w=0.42 l=0.15
X2283 a_51841_41689# a_48677_39759# VDPWR VDPWR sky130_fd_pr__pfet_01v8_hvt ad=0.1176 pd=1.4 as=0.0693 ps=0.75 w=0.42 l=0.15
X2284 VDPWR a_39544_37735# a_24932_36057# VDPWR sky130_fd_pr__pfet_01v8_hvt ad=0.15835 pd=1.395 as=0.26 ps=2.52 w=1 l=0.15
X2285 a_61644_37583# a_60563_37583# a_61297_37825# VDPWR sky130_fd_pr__pfet_01v8_hvt ad=0.0588 pd=0.7 as=0.12915 ps=1.185 w=0.42 l=0.15
X2286 VDPWR a_61297_35649# a_61187_35773# VDPWR sky130_fd_pr__pfet_01v8_hvt ad=0.07035 pd=0.755 as=0.1155 ps=0.97 w=0.42 l=0.15
X2287 a_60371_40277# a_60215_40545# a_60516_40303# VDPWR sky130_fd_pr__pfet_01v8_hvt ad=0.07245 pd=0.765 as=0.1155 ps=0.97 w=0.42 l=0.15
X2288 a_59201_38425# a_48677_38127# uio_oe[0] uio_oe[0] sky130_fd_pr__nfet_01v8 ad=0.1092 pd=1.36 as=0.1449 ps=1.11 w=0.42 l=0.15
X2289 a_18801_35905# a_18531_36271# a_18711_36271# uio_oe[0] sky130_fd_pr__nfet_01v8 ad=0.0504 pd=0.66 as=0.1092 ps=1.36 w=0.42 l=0.15
X2290 uio_oe[0] a_43918_36041# a_43713_36183# uio_oe[0] sky130_fd_pr__nfet_01v8 ad=0.1092 pd=1.36 as=0.0567 ps=0.69 w=0.42 l=0.15
X2291 uio_oe[0] a_44905_38671# a_57081_36317# uio_oe[0] sky130_fd_pr__nfet_01v8 ad=0.12495 pd=1.015 as=0.06405 ps=0.725 w=0.42 l=0.15
X2292 a_53827_41213# a_53203_40847# a_53719_40847# VDPWR sky130_fd_pr__pfet_01v8_hvt ad=0.1155 pd=0.97 as=0.07245 ps=0.765 w=0.42 l=0.15
X2293 VDPWR a_50003_39457# a_49964_39331# VDPWR sky130_fd_pr__pfet_01v8_hvt ad=0.0864 pd=0.91 as=0.1664 ps=1.8 w=0.64 l=0.15
X2294 a_58772_38823# a_58980_38645# a_58914_38671# uio_oe[0] sky130_fd_pr__nfet_01v8 ad=0.09975 pd=0.895 as=0.0693 ps=0.75 w=0.42 l=0.15
X2295 a_54638_41935# a_48125_41935# uio_oe[0] uio_oe[0] sky130_fd_pr__nfet_01v8 ad=0.06405 pd=0.725 as=0.12495 ps=1.015 w=0.42 l=0.15
X2296 VDPWR a_52335_41365# a_51620_41659# VDPWR sky130_fd_pr__pfet_01v8_hvt ad=0.3012 pd=2.66 as=0.26 ps=2.52 w=1 l=0.15
X2297 a_17721_35659# a_17388_35593# VDPWR VDPWR sky130_fd_pr__pfet_01v8_hvt ad=0.1176 pd=1.4 as=0.0693 ps=0.75 w=0.42 l=0.15
X2298 a_60584_35177# a_60500_34837# a_60988_35229# uio_oe[0] sky130_fd_pr__special_nfet_01v8 ad=0.072 pd=0.76 as=0.06705 ps=0.75 w=0.36 l=0.15
X2299 a_57757_36495# a_44905_38671# uio_oe[0] uio_oe[0] sky130_fd_pr__nfet_01v8 ad=0.0441 pd=0.63 as=0.1346 ps=1.15 w=0.42 l=0.15
X2300 VDPWR a_60996_35925# a_60934_35951# VDPWR sky130_fd_pr__pfet_01v8_hvt ad=0.1092 pd=1.36 as=0.0651 ps=0.73 w=0.42 l=0.15
X2301 a_40208_43023# a_39293_43023# a_39861_43265# uio_oe[0] sky130_fd_pr__special_nfet_01v8 ad=0.0711 pd=0.755 as=0.0999 ps=0.985 w=0.36 l=0.15
X2302 a_54723_42518# a_51620_42747# a_54264_42711# VDPWR sky130_fd_pr__pfet_01v8_hvt ad=0.0441 pd=0.63 as=0.1932 ps=1.34 w=0.42 l=0.15
X2303 uio_oe[0] a_57472_35141# a_57556_34837# uio_oe[0] sky130_fd_pr__nfet_01v8 ad=0.0567 pd=0.69 as=0.1092 ps=1.36 w=0.42 l=0.15
X2304 a_60984_41935# a_60365_41935# uio_oe[0] uio_oe[0] sky130_fd_pr__nfet_01v8 ad=0.066 pd=0.745 as=0.2205 ps=1.89 w=0.42 l=0.15
X2305 a_43283_34319# a_43032_34569# uio_oe[0] uio_oe[0] sky130_fd_pr__nfet_01v8 ad=0.169 pd=1.82 as=0.10025 ps=0.985 w=0.65 l=0.15
X2306 uio_oe[0] a_51412_42711# a_50784_42453# uio_oe[0] sky130_fd_pr__nfet_01v8 ad=0.11285 pd=1.045 as=0.169 ps=1.82 w=0.65 l=0.15
X2307 uio_oe[0] a_57519_40277# a_57450_40303# uio_oe[0] sky130_fd_pr__nfet_01v8 ad=0.1346 pd=1.15 as=0.0999 ps=0.985 w=0.64 l=0.15
X2308 VDPWR a_40987_39901# a_40948_40027# VDPWR sky130_fd_pr__pfet_01v8_hvt ad=0.0864 pd=0.91 as=0.1664 ps=1.8 w=0.64 l=0.15
X2309 a_54284_37583# a_53369_37583# a_53937_37825# uio_oe[0] sky130_fd_pr__special_nfet_01v8 ad=0.0711 pd=0.755 as=0.0999 ps=0.985 w=0.36 l=0.15
X2310 uio_oe[0] a_20972_36057# a_20923_35905# uio_oe[0] sky130_fd_pr__nfet_01v8 ad=0.11285 pd=1.045 as=0.169 ps=1.82 w=0.65 l=0.15
X2311 uio_oe[0] a_39973_41909# a_39907_41935# uio_oe[0] sky130_fd_pr__nfet_01v8 ad=0.1449 pd=1.11 as=0.0693 ps=0.75 w=0.42 l=0.15
X2312 a_45338_41213# a_44261_40847# a_45176_40847# VDPWR sky130_fd_pr__pfet_01v8_hvt ad=0.0567 pd=0.69 as=0.0588 ps=0.7 w=0.42 l=0.15
X2313 VDPWR a_51412_37735# a_50784_37832# VDPWR sky130_fd_pr__pfet_01v8_hvt ad=0.15835 pd=1.395 as=0.26 ps=2.52 w=1 l=0.15
X2314 a_26082_36488# a_25116_36681# VDPWR VDPWR sky130_fd_pr__pfet_01v8_hvt ad=0.07665 pd=0.785 as=0.15835 ps=1.395 w=0.42 l=0.15
X2315 VDPWR a_37361_41391# a_52325_34646# VDPWR sky130_fd_pr__pfet_01v8_hvt ad=0.0693 pd=0.75 as=0.1176 ps=1.4 w=0.42 l=0.15
X2316 a_41567_34902# a_41316_35131# a_41108_35095# VDPWR sky130_fd_pr__pfet_01v8_hvt ad=0.0441 pd=0.63 as=0.1932 ps=1.34 w=0.42 l=0.15
X2317 a_46331_41562# a_47283_41909# uio_oe[0] uio_oe[0] sky130_fd_pr__nfet_01v8 ad=0.169 pd=1.82 as=0.2087 ps=2.02 w=0.65 l=0.15
X2318 uio_oe[0] a_36661_41391# a_52800_41935# uio_oe[0] sky130_fd_pr__nfet_01v8 ad=0.11285 pd=1.045 as=0.0693 ps=0.75 w=0.42 l=0.15
X2319 a_50159_41365# a_50003_41633# a_50304_41391# VDPWR sky130_fd_pr__pfet_01v8_hvt ad=0.07245 pd=0.765 as=0.1155 ps=0.97 w=0.42 l=0.15
X2320 a_36934_39215# a_36808_39331# a_36530_39347# uio_oe[0] sky130_fd_pr__special_nfet_01v8 ad=0.0999 pd=0.985 as=0.0711 ps=0.755 w=0.36 l=0.15
X2321 VDPWR a_57472_39493# a_57556_39189# VDPWR sky130_fd_pr__pfet_01v8_hvt ad=0.0864 pd=0.91 as=0.1664 ps=1.8 w=0.64 l=0.15
X2322 a_58082_34685# a_57324_34587# a_57519_34556# VDPWR sky130_fd_pr__pfet_01v8_hvt ad=0.0651 pd=0.73 as=0.07245 ps=0.765 w=0.42 l=0.15
X2323 a_29026_36815# a_28980_36681# uio_oe[0] uio_oe[0] sky130_fd_pr__nfet_01v8 ad=0.0693 pd=0.75 as=0.11285 ps=1.045 w=0.42 l=0.15
X2324 a_26170_10464# a_24484_10782# ua[5] uio_oe[0] sky130_fd_pr__nfet_01v8 ad=0.1885 pd=1.88 as=0.1885 ps=1.88 w=0.65 l=0.15
X2325 a_17537_33703# a_17204_33881# VDPWR VDPWR sky130_fd_pr__pfet_01v8_hvt ad=0.1176 pd=1.4 as=0.0693 ps=0.75 w=0.42 l=0.15
X2326 a_26369_34571# a_25116_34505# uio_oe[0] uio_oe[0] sky130_fd_pr__nfet_01v8 ad=0.1092 pd=1.36 as=0.1449 ps=1.11 w=0.42 l=0.15
X2327 a_38649_43023# a_38483_43023# VDPWR VDPWR sky130_fd_pr__pfet_01v8_hvt ad=0.135 pd=1.27 as=0.135 ps=1.27 w=1 l=0.15
X2328 a_57640_39529# a_57472_39493# a_58044_39215# VDPWR sky130_fd_pr__pfet_01v8_hvt ad=0.0567 pd=0.69 as=0.0945 ps=0.87 w=0.42 l=0.15
X2329 uio_oe[0] a_50784_38101# a_50722_38127# uio_oe[0] sky130_fd_pr__nfet_01v8 ad=0.2205 pd=1.89 as=0.066 ps=0.745 w=0.42 l=0.15
X2330 VDPWR a_54459_37557# a_54446_37949# VDPWR sky130_fd_pr__pfet_01v8_hvt ad=0.0819 pd=0.81 as=0.0567 ps=0.69 w=0.42 l=0.15
X2331 a_18196_14020# a_16812_8642# uio_oe[0] uio_oe[0] sky130_fd_pr__nfet_01v8 ad=1.4703 pd=10.72 as=1.4703 ps=10.72 w=5.07 l=1
X2332 VDPWR a_58772_40535# a_58144_40277# VDPWR sky130_fd_pr__pfet_01v8_hvt ad=0.15835 pd=1.395 as=0.26 ps=2.52 w=1 l=0.15
X2333 uio_oe[0] a_37361_41391# a_52325_34646# uio_oe[0] sky130_fd_pr__nfet_01v8 ad=0.1449 pd=1.11 as=0.1092 ps=1.36 w=0.42 l=0.15
X2334 a_48125_43023# a_47959_43023# VDPWR VDPWR sky130_fd_pr__pfet_01v8_hvt ad=0.135 pd=1.27 as=0.135 ps=1.27 w=1 l=0.15
X2335 uio_oe[0] a_49483_40277# a_38740_40571# uio_oe[0] sky130_fd_pr__nfet_01v8 ad=0.2087 pd=2.02 as=0.169 ps=1.82 w=0.65 l=0.15
X2336 a_16812_8642# a_16812_8642# uio_oe[0] uio_oe[0] sky130_fd_pr__nfet_01v8 ad=1.16 pd=8.29 as=1.16 ps=8.29 w=8 l=1
X2337 a_29740_18782# a_29603_33757# uio_oe[0] uio_oe[0] sky130_fd_pr__nfet_01v8 ad=0.182 pd=1.86 as=0.1118 ps=1.04 w=0.65 l=0.15
X2338 uio_oe[0] a_51841_41909# a_51775_41935# uio_oe[0] sky130_fd_pr__nfet_01v8 ad=0.1449 pd=1.11 as=0.0693 ps=0.75 w=0.42 l=0.15
X2339 a_53937_42177# a_53719_41935# VDPWR VDPWR sky130_fd_pr__pfet_01v8_hvt ad=0.12915 pd=1.185 as=0.2184 ps=2.2 w=0.84 l=0.15
X2340 a_51841_40821# a_48677_39759# uio_oe[0] uio_oe[0] sky130_fd_pr__nfet_01v8 ad=0.1092 pd=1.36 as=0.1449 ps=1.11 w=0.42 l=0.15
X2341 a_60542_37405# a_60500_37013# a_59956_37013# uio_oe[0] sky130_fd_pr__nfet_01v8 ad=0.0441 pd=0.63 as=0.0693 ps=0.75 w=0.42 l=0.15
X2342 uio_oe[0] a_48125_41935# a_61341_38671# uio_oe[0] sky130_fd_pr__nfet_01v8 ad=0.1346 pd=1.15 as=0.0441 ps=0.63 w=0.42 l=0.15
X2343 VDPWR a_41059_34863# a_41338_35951# VDPWR sky130_fd_pr__pfet_01v8_hvt ad=0.1092 pd=1.36 as=0.0651 ps=0.73 w=0.42 l=0.15
X2344 a_62053_36249# a_37361_41391# uio_oe[0] uio_oe[0] sky130_fd_pr__nfet_01v8 ad=0.1092 pd=1.36 as=0.1449 ps=1.11 w=0.42 l=0.15
X2345 VDPWR a_20923_36993# a_22395_37359# VDPWR sky130_fd_pr__pfet_01v8_hvt ad=0.0714 pd=0.76 as=0.1092 ps=1.36 w=0.42 l=0.15
X2346 uio_oe[0] uio_oe[0] uio_oe[0] uio_oe[0] sky130_fd_pr__nfet_01v8 ad=0.1885 pd=1.88 as=0 ps=0 w=0.65 l=0.15
X2347 VDPWR a_58298_39445# a_58248_39215# VDPWR sky130_fd_pr__pfet_01v8_hvt ad=0.2184 pd=2.2 as=0.12495 ps=1.175 w=0.84 l=0.15
X2348 VDPWR a_43359_37583# a_43638_38127# VDPWR sky130_fd_pr__pfet_01v8_hvt ad=0.1092 pd=1.36 as=0.0651 ps=0.73 w=0.42 l=0.15
X2349 a_51871_35990# a_51620_36219# a_51412_36183# VDPWR sky130_fd_pr__pfet_01v8_hvt ad=0.0441 pd=0.63 as=0.1932 ps=1.34 w=0.42 l=0.15
X2350 a_62237_41689# a_36661_41391# uio_oe[0] uio_oe[0] sky130_fd_pr__nfet_01v8 ad=0.1092 pd=1.36 as=0.1449 ps=1.11 w=0.42 l=0.15
X2351 a_42947_37910# a_42696_37557# a_42488_37735# VDPWR sky130_fd_pr__pfet_01v8_hvt ad=0.0441 pd=0.63 as=0.1932 ps=1.34 w=0.42 l=0.15
X2352 a_50159_37820# a_50003_37725# a_50304_37949# VDPWR sky130_fd_pr__pfet_01v8_hvt ad=0.07245 pd=0.765 as=0.1155 ps=0.97 w=0.42 l=0.15
X2353 a_57280_36861# a_56843_36469# VDPWR VDPWR sky130_fd_pr__pfet_01v8_hvt ad=0.0567 pd=0.69 as=0.0819 ps=0.81 w=0.42 l=0.15
X2354 a_24532_10020# a_4259_22596# a_24354_10020# uio_oe[0] sky130_fd_pr__nfet_01v8 ad=0.2436 pd=2.26 as=0.2436 ps=2.26 w=0.84 l=0.6
X2355 a_52813_35229# a_52335_34837# uio_oe[0] uio_oe[0] sky130_fd_pr__nfet_01v8 ad=0.0669 pd=0.75 as=0.12495 ps=1.015 w=0.42 l=0.15
X2356 a_49483_41365# a_49686_41523# VDPWR VDPWR sky130_fd_pr__pfet_01v8_hvt ad=0.0567 pd=0.69 as=0.1134 ps=1.38 w=0.42 l=0.15
X2357 VDPWR a_42897_42177# a_42787_42301# VDPWR sky130_fd_pr__pfet_01v8_hvt ad=0.07035 pd=0.755 as=0.1155 ps=0.97 w=0.42 l=0.15
X2358 VDPWR a_37839_40847# a_38005_40847# VDPWR sky130_fd_pr__pfet_01v8_hvt ad=0.135 pd=1.27 as=0.135 ps=1.27 w=1 l=0.15
X2359 VDPWR a_39555_35559# a_28796_36057# VDPWR sky130_fd_pr__pfet_01v8_hvt ad=0.16655 pd=1.39 as=0.475 ps=2.95 w=1 l=0.15
X2360 a_53827_34685# a_53203_34319# a_53719_34319# VDPWR sky130_fd_pr__pfet_01v8_hvt ad=0.1155 pd=0.97 as=0.07245 ps=0.765 w=0.42 l=0.15
X2361 a_57012_37013# a_57556_37013# a_57514_37039# VDPWR sky130_fd_pr__pfet_01v8_hvt ad=0.0819 pd=0.81 as=0.0441 ps=0.63 w=0.42 l=0.15
X2362 a_22076_35593# a_18427_33198# a_22218_35400# VDPWR sky130_fd_pr__pfet_01v8_hvt ad=0.1932 pd=1.34 as=0.07665 ps=0.785 w=0.42 l=0.15
X2363 VDPWR a_48125_41935# a_52335_42453# VDPWR sky130_fd_pr__pfet_01v8_hvt ad=0.0819 pd=0.81 as=0.0567 ps=0.69 w=0.42 l=0.15
X2364 a_57450_40303# a_57363_40545# a_57046_40435# VDPWR sky130_fd_pr__pfet_01v8_hvt ad=0.12915 pd=1.185 as=0.0588 ps=0.7 w=0.42 l=0.15
X2365 a_61644_36495# a_60563_36495# a_61297_36737# VDPWR sky130_fd_pr__pfet_01v8_hvt ad=0.0588 pd=0.7 as=0.12915 ps=1.185 w=0.42 l=0.15
X2366 a_57430_35229# a_57148_34863# a_57354_35229# uio_oe[0] sky130_fd_pr__nfet_01v8 ad=0.0441 pd=0.63 as=0.0483 ps=0.65 w=0.42 l=0.15
X2367 VDPWR a_57363_36637# a_57324_36763# VDPWR sky130_fd_pr__pfet_01v8_hvt ad=0.0864 pd=0.91 as=0.1664 ps=1.8 w=0.64 l=0.15
X2368 uio_oe[0] a_40379_35551# a_43125_39759# uio_oe[0] sky130_fd_pr__nfet_01v8 ad=0.1346 pd=1.15 as=0.0441 ps=0.63 w=0.42 l=0.15
X2369 uio_oe[0] a_54459_36469# a_54393_36495# uio_oe[0] sky130_fd_pr__nfet_01v8 ad=0.12495 pd=1.015 as=0.0669 ps=0.75 w=0.42 l=0.15
X2370 a_59006_34902# a_48677_38127# VDPWR VDPWR sky130_fd_pr__pfet_01v8_hvt ad=0.07665 pd=0.785 as=0.15835 ps=1.395 w=0.42 l=0.15
X2371 a_50003_35105# a_41685_42479# VDPWR VDPWR sky130_fd_pr__pfet_01v8_hvt ad=0.1664 pd=1.8 as=0.0864 ps=0.91 w=0.64 l=0.15
X2372 uio_oe[0] a_37029_42479# a_46027_40847# uio_oe[0] sky130_fd_pr__nfet_01v8 ad=0.0567 pd=0.69 as=0.1092 ps=1.36 w=0.42 l=0.15
X2373 uio_oe[0] a_56843_40821# a_38740_40821# uio_oe[0] sky130_fd_pr__nfet_01v8 ad=0.2087 pd=2.02 as=0.169 ps=1.82 w=0.65 l=0.15
X2374 VDPWR a_44905_38671# a_49483_35925# VDPWR sky130_fd_pr__pfet_01v8_hvt ad=0.0819 pd=0.81 as=0.0567 ps=0.69 w=0.42 l=0.15
X2375 a_47270_42479# a_46193_42485# a_47108_42857# VDPWR sky130_fd_pr__pfet_01v8_hvt ad=0.0567 pd=0.69 as=0.0588 ps=0.7 w=0.42 l=0.15
X2376 a_25940_36681# a_18427_33198# a_26082_36488# VDPWR sky130_fd_pr__pfet_01v8_hvt ad=0.1932 pd=1.34 as=0.07665 ps=0.785 w=0.42 l=0.15
X2377 a_49686_34571# a_50003_34461# a_49961_34319# uio_oe[0] sky130_fd_pr__special_nfet_01v8 ad=0.0711 pd=0.755 as=0.0669 ps=0.75 w=0.36 l=0.15
X2378 VDPWR a_41143_39189# a_41074_39215# VDPWR sky130_fd_pr__pfet_01v8_hvt ad=0.2184 pd=2.2 as=0.12915 ps=1.185 w=0.84 l=0.15
X2379 a_58044_37039# a_57776_37405# VDPWR VDPWR sky130_fd_pr__pfet_01v8_hvt ad=0.0945 pd=0.87 as=0.0798 ps=0.8 w=0.42 l=0.15
X2380 a_61766_42845# a_36661_41391# uio_oe[0] uio_oe[0] sky130_fd_pr__nfet_01v8 ad=0.0693 pd=0.75 as=0.11285 ps=1.045 w=0.42 l=0.15
X2381 a_50159_42172# a_49964_42203# a_50469_41935# uio_oe[0] sky130_fd_pr__special_nfet_01v8 ad=0.0594 pd=0.69 as=0.1401 ps=1.1 w=0.36 l=0.15
X2382 a_59201_38645# a_48677_39759# VDPWR VDPWR sky130_fd_pr__pfet_01v8_hvt ad=0.1176 pd=1.4 as=0.0693 ps=0.75 w=0.42 l=0.15
X2383 a_60984_38671# a_60365_38671# VDPWR VDPWR sky130_fd_pr__pfet_01v8_hvt ad=0.0651 pd=0.73 as=0.1092 ps=1.36 w=0.42 l=0.15
X2384 a_39555_36183# a_37029_37583# VDPWR VDPWR sky130_fd_pr__pfet_01v8_hvt ad=0.0567 pd=0.69 as=0.16655 ps=1.39 w=0.42 l=0.15
X2385 uio_oe[0] uio_oe[0] uio_oe[0] uio_oe[0] sky130_fd_pr__nfet_01v8 ad=1.4703 pd=10.72 as=0 ps=0 w=5.07 l=1
X2386 a_54723_41430# a_51620_41659# a_54264_41623# VDPWR sky130_fd_pr__pfet_01v8_hvt ad=0.0441 pd=0.63 as=0.1932 ps=1.34 w=0.42 l=0.15
X2387 a_40670_38259# a_40987_38369# a_40945_38493# uio_oe[0] sky130_fd_pr__special_nfet_01v8 ad=0.0711 pd=0.755 as=0.0669 ps=0.75 w=0.36 l=0.15
X2388 a_52942_35951# a_52816_36067# a_52538_36083# uio_oe[0] sky130_fd_pr__special_nfet_01v8 ad=0.0999 pd=0.985 as=0.0711 ps=0.755 w=0.36 l=0.15
X2389 uio_oe[0] a_58772_42087# a_58144_42184# uio_oe[0] sky130_fd_pr__nfet_01v8 ad=0.11285 pd=1.045 as=0.169 ps=1.82 w=0.65 l=0.15
X2390 a_61297_42177# a_61079_41935# uio_oe[0] uio_oe[0] sky130_fd_pr__nfet_01v8 ad=0.0999 pd=0.985 as=0.1346 ps=1.15 w=0.64 l=0.15
X2391 uio_oe[0] a_53636_42453# a_53574_42479# uio_oe[0] sky130_fd_pr__nfet_01v8 ad=0.2205 pd=1.89 as=0.066 ps=0.745 w=0.42 l=0.15
X2392 a_25479_33224# a_17500_33453# a_25020_33417# VDPWR sky130_fd_pr__pfet_01v8_hvt ad=0.0441 pd=0.63 as=0.1932 ps=1.34 w=0.42 l=0.15
X2393 uio_oe[0] a_46193_39759# a_52573_35229# uio_oe[0] sky130_fd_pr__nfet_01v8 ad=0.12495 pd=1.015 as=0.06405 ps=0.725 w=0.42 l=0.15
X2394 VDPWR a_37913_41935# a_60563_36495# VDPWR sky130_fd_pr__pfet_01v8_hvt ad=0.0864 pd=0.91 as=0.1664 ps=1.8 w=0.64 l=0.15
X2395 ua[4] a_24484_14782# a_24354_14020# uio_oe[0] sky130_fd_pr__nfet_01v8 ad=0.1885 pd=1.88 as=0.1885 ps=1.88 w=0.65 l=0.15
X2396 uio_oe[0] a_39555_34471# a_28796_33881# uio_oe[0] sky130_fd_pr__nfet_01v8 ad=0.1118 pd=1.04 as=0.182 ps=1.86 w=0.65 l=0.15
X2397 a_43590_39215# a_42513_39221# a_43428_39593# VDPWR sky130_fd_pr__pfet_01v8_hvt ad=0.0567 pd=0.69 as=0.0588 ps=0.7 w=0.42 l=0.15
X2398 a_53011_38101# a_52855_38369# a_53156_38127# VDPWR sky130_fd_pr__pfet_01v8_hvt ad=0.07245 pd=0.765 as=0.1155 ps=0.97 w=0.42 l=0.15
X2399 a_49483_37557# a_49686_37835# VDPWR VDPWR sky130_fd_pr__pfet_01v8_hvt ad=0.0567 pd=0.69 as=0.1134 ps=1.38 w=0.42 l=0.15
X2400 uio_oe[0] a_48125_41935# a_60802_41757# uio_oe[0] sky130_fd_pr__nfet_01v8 ad=0.0882 pd=0.84 as=0.0441 ps=0.63 w=0.42 l=0.15
X2401 a_58082_40125# a_57363_39901# a_57519_39996# uio_oe[0] sky130_fd_pr__special_nfet_01v8 ad=0.066 pd=0.745 as=0.0594 ps=0.69 w=0.36 l=0.15
X2402 uio_oe[0] a_58298_37269# a_58248_37039# uio_oe[0] sky130_fd_pr__nfet_01v8 ad=0.1664 pd=1.8 as=0.0935 ps=0.965 w=0.64 l=0.15
X2403 a_26369_33483# a_25116_33417# uio_oe[0] uio_oe[0] sky130_fd_pr__nfet_01v8 ad=0.1092 pd=1.36 as=0.1449 ps=1.11 w=0.42 l=0.15
X2404 a_44719_43389# a_44095_43023# a_44611_43023# VDPWR sky130_fd_pr__pfet_01v8_hvt ad=0.1155 pd=0.97 as=0.07245 ps=0.765 w=0.42 l=0.15
X2405 a_50722_40125# a_50003_39901# a_50159_39996# uio_oe[0] sky130_fd_pr__special_nfet_01v8 ad=0.066 pd=0.745 as=0.0594 ps=0.69 w=0.36 l=0.15
X2406 VDPWR a_28884_33417# a_28835_33185# VDPWR sky130_fd_pr__pfet_01v8_hvt ad=0.15835 pd=1.395 as=0.26 ps=2.52 w=1 l=0.15
X2407 uio_oe[0] a_36447_40849# a_36545_37405# uio_oe[0] sky130_fd_pr__nfet_01v8 ad=0.1013 pd=0.99 as=0.0504 ps=0.66 w=0.42 l=0.15
X2408 VDPWR a_54459_36469# a_54446_36861# VDPWR sky130_fd_pr__pfet_01v8_hvt ad=0.0819 pd=0.81 as=0.0567 ps=0.69 w=0.42 l=0.15
X2409 a_37901_37307# a_37795_40535# VDPWR VDPWR sky130_fd_pr__pfet_01v8_hvt ad=0.135 pd=1.27 as=0.26 ps=2.52 w=1 l=0.15
X2410 a_4259_22596# uio_oe[0] sky130_fd_pr__cap_mim_m3_1 l=22 w=22
X2411 uio_oe[0] a_29281_32641# a_30393_33729# uio_oe[0] sky130_fd_pr__nfet_01v8 ad=0.1013 pd=0.99 as=0.0504 ps=0.66 w=0.42 l=0.15
X2412 a_53937_35649# a_53719_35407# VDPWR VDPWR sky130_fd_pr__pfet_01v8_hvt ad=0.12915 pd=1.185 as=0.2184 ps=2.2 w=0.84 l=0.15
X2413 VDPWR a_50159_40277# a_50090_40303# VDPWR sky130_fd_pr__pfet_01v8_hvt ad=0.2184 pd=2.2 as=0.12915 ps=1.185 w=0.84 l=0.15
X2414 uio_oe[0] a_37661_38140# a_42389_37078# uio_oe[0] sky130_fd_pr__nfet_01v8 ad=0.1449 pd=1.11 as=0.1092 ps=1.36 w=0.42 l=0.15
X2415 uio_oe[0] a_18212_33417# a_17316_33703# uio_oe[0] sky130_fd_pr__nfet_01v8 ad=0.11285 pd=1.045 as=0.169 ps=1.82 w=0.65 l=0.15
X2416 uio_oe[0] a_42907_35951# a_42445_36469# uio_oe[0] sky130_fd_pr__nfet_01v8 ad=0.208 pd=1.94 as=0.25025 ps=1.42 w=0.65 l=0.15
X2417 a_43419_40821# a_43244_40847# a_43598_40847# uio_oe[0] sky130_fd_pr__nfet_01v8 ad=0.1092 pd=1.36 as=0.06405 ps=0.725 w=0.42 l=0.15
X2418 VDPWR a_37361_41391# a_59685_36822# VDPWR sky130_fd_pr__pfet_01v8_hvt ad=0.0693 pd=0.75 as=0.1176 ps=1.4 w=0.42 l=0.15
X2419 uio_oe[0] a_28700_34969# a_28651_34817# uio_oe[0] sky130_fd_pr__nfet_01v8 ad=0.11285 pd=1.045 as=0.169 ps=1.82 w=0.65 l=0.15
X2420 a_53624_39759# a_53005_39759# uio_oe[0] uio_oe[0] sky130_fd_pr__nfet_01v8 ad=0.066 pd=0.745 as=0.2205 ps=1.89 w=0.42 l=0.15
X2421 a_42513_39759# a_42347_39759# VDPWR VDPWR sky130_fd_pr__pfet_01v8_hvt ad=0.1664 pd=1.8 as=0.0864 ps=0.91 w=0.64 l=0.15
X2422 VDPWR a_25020_36681# a_24971_36449# VDPWR sky130_fd_pr__pfet_01v8_hvt ad=0.15835 pd=1.395 as=0.26 ps=2.52 w=1 l=0.15
X2423 a_16756_18782# a_18011_34845# VDPWR VDPWR sky130_fd_pr__pfet_01v8_hvt ad=0.475 pd=2.95 as=0.16655 ps=1.39 w=1 l=0.15
X2424 a_20620_10376# a_21875_37021# uio_oe[0] uio_oe[0] sky130_fd_pr__nfet_01v8 ad=0.182 pd=1.86 as=0.1118 ps=1.04 w=0.65 l=0.15
X2425 a_40379_35551# a_40495_42453# uio_oe[0] uio_oe[0] sky130_fd_pr__nfet_01v8 ad=0.08775 pd=0.92 as=0.08775 ps=0.92 w=0.65 l=0.15
X2426 VDPWR a_49483_37013# a_38740_37307# VDPWR sky130_fd_pr__pfet_01v8_hvt ad=0.3012 pd=2.66 as=0.26 ps=2.52 w=1 l=0.15
X2427 a_17471_35905# a_17243_35361# a_17108_36057# uio_oe[0] sky130_fd_pr__nfet_01v8 ad=0.0693 pd=0.75 as=0.09975 ps=0.895 w=0.42 l=0.15
X2428 VDPWR a_20923_35905# a_22395_36271# VDPWR sky130_fd_pr__pfet_01v8_hvt ad=0.0714 pd=0.76 as=0.1092 ps=1.36 w=0.42 l=0.15
X2429 VDPWR a_17292_34505# a_17243_34273# VDPWR sky130_fd_pr__pfet_01v8_hvt ad=0.15835 pd=1.395 as=0.26 ps=2.52 w=1 l=0.15
X2430 a_26439_35183# a_26259_35183# VDPWR VDPWR sky130_fd_pr__pfet_01v8_hvt ad=0.0609 pd=0.71 as=0.0714 ps=0.76 w=0.42 l=0.15
X2431 ua[5] a_24484_10782# a_24354_26020# uio_oe[0] sky130_fd_pr__nfet_01v8 ad=0.1885 pd=1.88 as=0.1885 ps=1.88 w=0.65 l=0.15
X2432 VDPWR a_56916_35095# a_39647_34877# VDPWR sky130_fd_pr__pfet_01v8_hvt ad=0.149 pd=1.325 as=0.26 ps=2.52 w=1 l=0.15
X2433 a_46448_43023# ui_in[1] uio_oe[0] uio_oe[0] sky130_fd_pr__nfet_01v8 ad=0.066 pd=0.745 as=0.2205 ps=1.89 w=0.42 l=0.15
X2434 uio_oe[0] a_48125_41935# a_59933_40669# uio_oe[0] sky130_fd_pr__nfet_01v8 ad=0.12495 pd=1.015 as=0.06405 ps=0.725 w=0.42 l=0.15
X2435 a_61341_37583# a_61297_37825# a_61175_37583# uio_oe[0] sky130_fd_pr__nfet_01v8 ad=0.0441 pd=0.63 as=0.1401 ps=1.1 w=0.42 l=0.15
X2436 a_40775_35925# a_40580_36067# a_41085_36317# uio_oe[0] sky130_fd_pr__special_nfet_01v8 ad=0.0594 pd=0.69 as=0.1401 ps=1.1 w=0.36 l=0.15
X2437 VDPWR a_53011_37013# a_52942_37039# VDPWR sky130_fd_pr__pfet_01v8_hvt ad=0.2184 pd=2.2 as=0.12915 ps=1.185 w=0.84 l=0.15
X2438 a_50159_36732# a_50003_36637# a_50304_36861# VDPWR sky130_fd_pr__pfet_01v8_hvt ad=0.07245 pd=0.765 as=0.1155 ps=0.97 w=0.42 l=0.15
X2439 a_61175_36495# a_60729_36495# a_61079_36495# uio_oe[0] sky130_fd_pr__special_nfet_01v8 ad=0.1401 pd=1.1 as=0.0594 ps=0.69 w=0.36 l=0.15
X2440 uio_oe[0] a_17108_36057# a_17059_35905# uio_oe[0] sky130_fd_pr__nfet_01v8 ad=0.11285 pd=1.045 as=0.169 ps=1.82 w=0.65 l=0.15
X2441 a_36503_36257# a_17255_32793# VDPWR VDPWR sky130_fd_pr__pfet_01v8_hvt ad=0.1092 pd=1.36 as=0.0714 ps=0.76 w=0.42 l=0.15
X2442 a_30034_18464# a_29740_18376# ua[4] uio_oe[0] sky130_fd_pr__nfet_01v8 ad=0.1885 pd=1.88 as=0.1885 ps=1.88 w=0.65 l=0.15
X2443 VDPWR a_50159_41084# a_50090_41213# VDPWR sky130_fd_pr__pfet_01v8_hvt ad=0.2184 pd=2.2 as=0.12915 ps=1.185 w=0.84 l=0.15
X2444 a_37029_37039# a_36999_37013# uio_oe[0] uio_oe[0] sky130_fd_pr__nfet_01v8 ad=0.08775 pd=0.92 as=0.08775 ps=0.92 w=0.65 l=0.15
X2445 VDPWR a_43713_36183# a_43504_37735# VDPWR sky130_fd_pr__pfet_01v8_hvt ad=0.14575 pd=1.335 as=0.34 ps=2.68 w=1 l=0.15
X2446 a_50397_35407# a_44905_38671# uio_oe[0] uio_oe[0] sky130_fd_pr__nfet_01v8 ad=0.0441 pd=0.63 as=0.1346 ps=1.15 w=0.42 l=0.15
X2447 a_57321_35407# a_56843_35381# uio_oe[0] uio_oe[0] sky130_fd_pr__nfet_01v8 ad=0.0669 pd=0.75 as=0.12495 ps=1.015 w=0.42 l=0.15
X2448 a_58082_40303# a_57324_40419# a_57519_40277# VDPWR sky130_fd_pr__pfet_01v8_hvt ad=0.0651 pd=0.73 as=0.07245 ps=0.765 w=0.42 l=0.15
X2449 a_57519_39996# a_57324_40027# a_57829_39759# uio_oe[0] sky130_fd_pr__special_nfet_01v8 ad=0.0594 pd=0.69 as=0.1401 ps=1.1 w=0.36 l=0.15
X2450 a_57363_38369# a_41685_42479# VDPWR VDPWR sky130_fd_pr__pfet_01v8_hvt ad=0.1664 pd=1.8 as=0.0864 ps=0.91 w=0.64 l=0.15
X2451 a_30393_33729# a_30123_34095# a_30303_34095# uio_oe[0] sky130_fd_pr__nfet_01v8 ad=0.0504 pd=0.66 as=0.1092 ps=1.36 w=0.42 l=0.15
X2452 a_29159_34056# a_28908_33703# a_28700_33881# VDPWR sky130_fd_pr__pfet_01v8_hvt ad=0.0441 pd=0.63 as=0.1932 ps=1.34 w=0.42 l=0.15
X2453 a_51620_41909# a_54459_41909# uio_oe[0] uio_oe[0] sky130_fd_pr__nfet_01v8 ad=0.169 pd=1.82 as=0.2087 ps=2.02 w=0.65 l=0.15
X2454 VDPWR a_48125_41935# a_52335_41365# VDPWR sky130_fd_pr__pfet_01v8_hvt ad=0.0819 pd=0.81 as=0.0567 ps=0.69 w=0.42 l=0.15
X2455 a_30034_18464# a_4259_22596# a_29738_16730# uio_oe[0] sky130_fd_pr__nfet_01v8 ad=0.2436 pd=2.26 as=0.2436 ps=2.26 w=0.84 l=0.6
X2456 VDPWR a_37029_42479# a_46027_40847# VDPWR sky130_fd_pr__pfet_01v8_hvt ad=0.0864 pd=0.91 as=0.1664 ps=1.8 w=0.64 l=0.15
X2457 a_28396_14020# a_16812_8642# uio_oe[0] uio_oe[0] sky130_fd_pr__nfet_01v8 ad=1.4703 pd=10.72 as=1.4703 ps=10.72 w=5.07 l=1
X2458 a_58914_42262# a_48677_39759# VDPWR VDPWR sky130_fd_pr__pfet_01v8_hvt ad=0.07665 pd=0.785 as=0.15835 ps=1.395 w=0.42 l=0.15
X2459 a_59135_36317# a_39783_35967# a_58772_36183# uio_oe[0] sky130_fd_pr__nfet_01v8 ad=0.0693 pd=0.75 as=0.09975 ps=0.895 w=0.42 l=0.15
X2460 a_38543_35559# a_38771_35409# a_38717_35435# uio_oe[0] sky130_fd_pr__nfet_01v8 ad=0.1176 pd=1.4 as=0.0567 ps=0.69 w=0.42 l=0.15
X2461 a_47270_41391# a_46193_41397# a_47108_41769# VDPWR sky130_fd_pr__pfet_01v8_hvt ad=0.0567 pd=0.69 as=0.0588 ps=0.7 w=0.42 l=0.15
X2462 a_61808_39447# a_54479_39228# a_61950_39581# uio_oe[0] sky130_fd_pr__nfet_01v8 ad=0.09975 pd=0.895 as=0.0693 ps=0.75 w=0.42 l=0.15
X2463 a_60934_38127# a_60215_38369# a_60371_38101# uio_oe[0] sky130_fd_pr__special_nfet_01v8 ad=0.066 pd=0.745 as=0.0594 ps=0.69 w=0.36 l=0.15
X2464 a_31180_10020# a_4259_22596# a_31002_10020# uio_oe[0] sky130_fd_pr__nfet_01v8 ad=0.2436 pd=2.26 as=0.2436 ps=2.26 w=0.84 l=0.6
X2465 a_26369_34571# a_25116_34505# VDPWR VDPWR sky130_fd_pr__pfet_01v8_hvt ad=0.1176 pd=1.4 as=0.0693 ps=0.75 w=0.42 l=0.15
X2466 a_42584_40847# ui_in[5] VDPWR VDPWR sky130_fd_pr__pfet_01v8_hvt ad=0.0651 pd=0.73 as=0.1092 ps=1.36 w=0.42 l=0.15
X2467 uio_oe[0] a_41537_35161# a_41471_35229# uio_oe[0] sky130_fd_pr__nfet_01v8 ad=0.1449 pd=1.11 as=0.0693 ps=0.75 w=0.42 l=0.15
X2468 a_38961_39513# a_38005_40847# uio_oe[0] uio_oe[0] sky130_fd_pr__nfet_01v8 ad=0.1092 pd=1.36 as=0.1449 ps=1.11 w=0.42 l=0.15
X2469 a_60720_35229# a_60584_35177# VDPWR VDPWR sky130_fd_pr__pfet_01v8_hvt ad=0.0567 pd=0.69 as=0.0567 ps=0.69 w=0.42 l=0.15
X2470 VDPWR a_42488_37735# a_41768_40008# VDPWR sky130_fd_pr__pfet_01v8_hvt ad=0.15835 pd=1.395 as=0.26 ps=2.52 w=1 l=0.15
X2471 a_17434_36488# a_17388_36681# VDPWR VDPWR sky130_fd_pr__pfet_01v8_hvt ad=0.07665 pd=0.785 as=0.15835 ps=1.395 w=0.42 l=0.15
X2472 a_52942_34863# a_52816_34979# a_52538_34995# uio_oe[0] sky130_fd_pr__special_nfet_01v8 ad=0.0999 pd=0.985 as=0.0711 ps=0.755 w=0.36 l=0.15
X2473 a_46761_41365# a_46543_41769# uio_oe[0] uio_oe[0] sky130_fd_pr__nfet_01v8 ad=0.0999 pd=0.985 as=0.1346 ps=1.15 w=0.64 l=0.15
X2474 uio_oe[0] a_50003_34461# a_49964_34587# uio_oe[0] sky130_fd_pr__nfet_01v8 ad=0.0567 pd=0.69 as=0.1092 ps=1.36 w=0.42 l=0.15
X2475 a_44516_41935# ui_in[3] VDPWR VDPWR sky130_fd_pr__pfet_01v8_hvt ad=0.0651 pd=0.73 as=0.1092 ps=1.36 w=0.42 l=0.15
X2476 a_40330_34902# a_37661_37052# VDPWR VDPWR sky130_fd_pr__pfet_01v8_hvt ad=0.07665 pd=0.785 as=0.15835 ps=1.395 w=0.42 l=0.15
X2477 a_50469_36317# a_50090_35951# a_50397_36317# uio_oe[0] sky130_fd_pr__nfet_01v8 ad=0.1401 pd=1.1 as=0.0441 ps=0.63 w=0.42 l=0.15
X2478 VDPWR a_44905_38671# a_50304_34863# VDPWR sky130_fd_pr__pfet_01v8_hvt ad=0.07035 pd=0.755 as=0.1092 ps=1.36 w=0.42 l=0.15
X2479 a_44516_40669# a_44399_40474# uio_oe[0] uio_oe[0] sky130_fd_pr__nfet_01v8 ad=0.066 pd=0.745 as=0.2205 ps=1.89 w=0.42 l=0.15
X2480 a_59939_40847# a_59685_41174# uio_oe[0] uio_oe[0] sky130_fd_pr__nfet_01v8 ad=0.0693 pd=0.75 as=0.1449 ps=1.11 w=0.42 l=0.15
X2481 a_37195_36501# a_36721_37583# VDPWR VDPWR sky130_fd_pr__pfet_01v8_hvt ad=0.1176 pd=1.4 as=0.1092 ps=1.36 w=0.42 l=0.15
X2482 a_49483_36469# a_49686_36747# VDPWR VDPWR sky130_fd_pr__pfet_01v8_hvt ad=0.0567 pd=0.69 as=0.1134 ps=1.38 w=0.42 l=0.15
X2483 uio_oe[0] a_16812_8642# a_19538_24730# uio_oe[0] sky130_fd_pr__nfet_01v8 ad=1.4703 pd=10.72 as=1.4703 ps=10.72 w=5.07 l=1
X2484 a_58864_35095# a_54479_34876# a_59006_35229# uio_oe[0] sky130_fd_pr__nfet_01v8 ad=0.09975 pd=0.895 as=0.0693 ps=0.75 w=0.42 l=0.15
X2485 uio_oe[0] a_44905_38671# a_57081_35407# uio_oe[0] sky130_fd_pr__nfet_01v8 ad=0.12495 pd=1.015 as=0.06405 ps=0.725 w=0.42 l=0.15
X2486 a_58082_39037# a_57363_38813# a_57519_38908# uio_oe[0] sky130_fd_pr__special_nfet_01v8 ad=0.066 pd=0.745 as=0.0594 ps=0.69 w=0.36 l=0.15
X2487 a_59201_37557# a_48677_38127# uio_oe[0] uio_oe[0] sky130_fd_pr__nfet_01v8 ad=0.1092 pd=1.36 as=0.1449 ps=1.11 w=0.42 l=0.15
X2488 a_28842_35144# a_28796_34969# VDPWR VDPWR sky130_fd_pr__pfet_01v8_hvt ad=0.07665 pd=0.785 as=0.15835 ps=1.395 w=0.42 l=0.15
X2489 a_61806_41213# a_60729_40847# a_61644_40847# VDPWR sky130_fd_pr__pfet_01v8_hvt ad=0.0567 pd=0.69 as=0.0588 ps=0.7 w=0.42 l=0.15
X2490 a_50722_39037# a_50003_38813# a_50159_38908# uio_oe[0] sky130_fd_pr__special_nfet_01v8 ad=0.066 pd=0.745 as=0.0594 ps=0.69 w=0.36 l=0.15
X2491 uio_oe[0] a_52855_36193# a_52816_36067# uio_oe[0] sky130_fd_pr__nfet_01v8 ad=0.0567 pd=0.69 as=0.1092 ps=1.36 w=0.42 l=0.15
X2492 a_21615_36488# a_17500_33453# a_21156_36681# VDPWR sky130_fd_pr__pfet_01v8_hvt ad=0.0441 pd=0.63 as=0.1932 ps=1.34 w=0.42 l=0.15
X2493 a_62237_41689# a_36661_41391# VDPWR VDPWR sky130_fd_pr__pfet_01v8_hvt ad=0.1176 pd=1.4 as=0.0693 ps=0.75 w=0.42 l=0.15
X2494 a_21156_36681# a_17500_33453# a_21298_36815# uio_oe[0] sky130_fd_pr__nfet_01v8 ad=0.09975 pd=0.895 as=0.0693 ps=0.75 w=0.42 l=0.15
X2495 a_40706_35773# a_40619_35549# a_40302_35659# VDPWR sky130_fd_pr__pfet_01v8_hvt ad=0.12915 pd=1.185 as=0.0588 ps=0.7 w=0.42 l=0.15
X2496 ua[4] a_28348_14782# a_31002_14020# uio_oe[0] sky130_fd_pr__nfet_01v8 ad=0.1885 pd=1.88 as=0.1885 ps=1.88 w=0.65 l=0.15
X2497 a_53937_40001# a_53719_39759# uio_oe[0] uio_oe[0] sky130_fd_pr__nfet_01v8 ad=0.0999 pd=0.985 as=0.1346 ps=1.15 w=0.64 l=0.15
X2498 a_53624_38671# a_53005_38671# uio_oe[0] uio_oe[0] sky130_fd_pr__nfet_01v8 ad=0.066 pd=0.745 as=0.2205 ps=1.89 w=0.42 l=0.15
X2499 VDPWR a_29313_36747# a_29343_36488# VDPWR sky130_fd_pr__pfet_01v8_hvt ad=0.0693 pd=0.75 as=0.0441 ps=0.63 w=0.42 l=0.15
X2500 a_50003_36637# a_41685_42479# uio_oe[0] uio_oe[0] sky130_fd_pr__nfet_01v8 ad=0.1092 pd=1.36 as=0.0567 ps=0.69 w=0.42 l=0.15
X2501 VDPWR a_25020_35593# a_24971_35361# VDPWR sky130_fd_pr__pfet_01v8_hvt ad=0.15835 pd=1.395 as=0.26 ps=2.52 w=1 l=0.15
X2502 a_37361_41391# a_37195_41391# uio_oe[0] uio_oe[0] sky130_fd_pr__nfet_01v8 ad=0.08775 pd=0.92 as=0.08775 ps=0.92 w=0.65 l=0.15
X2503 uio_oe[0] a_57640_41705# a_57598_41757# uio_oe[0] sky130_fd_pr__nfet_01v8 ad=0.1092 pd=1.36 as=0.0441 ps=0.63 w=0.42 l=0.15
X2504 a_45338_40303# a_44261_40309# a_45176_40681# VDPWR sky130_fd_pr__pfet_01v8_hvt ad=0.0567 pd=0.69 as=0.0588 ps=0.7 w=0.42 l=0.15
X2505 a_26082_36815# a_25116_36681# uio_oe[0] uio_oe[0] sky130_fd_pr__nfet_01v8 ad=0.0693 pd=0.75 as=0.11285 ps=1.045 w=0.42 l=0.15
X2506 a_17250_36232# a_17204_36057# VDPWR VDPWR sky130_fd_pr__pfet_01v8_hvt ad=0.07665 pd=0.785 as=0.15835 ps=1.395 w=0.42 l=0.15
X2507 a_4259_22596# ua[1] uio_oe[0] sky130_fd_pr__res_xhigh_po_0p35 l=17.36
X2508 a_42775_43023# a_42329_43023# a_42679_43023# uio_oe[0] sky130_fd_pr__special_nfet_01v8 ad=0.1401 pd=1.1 as=0.0594 ps=0.69 w=0.36 l=0.15
X2509 a_38285_38127# a_37859_38166# uio_oe[0] uio_oe[0] sky130_fd_pr__nfet_01v8 ad=0.169 pd=1.82 as=0.11285 ps=1.045 w=0.65 l=0.15
X2510 a_36585_40847# a_36307_40875# uio_oe[0] uio_oe[0] sky130_fd_pr__nfet_01v8 ad=0.182 pd=1.86 as=0.1118 ps=1.04 w=0.65 l=0.15
X2511 a_59231_42518# a_54479_42492# a_58772_42711# VDPWR sky130_fd_pr__pfet_01v8_hvt ad=0.0441 pd=0.63 as=0.1932 ps=1.34 w=0.42 l=0.15
X2512 a_52793_42262# a_51620_42747# a_52579_42262# VDPWR sky130_fd_pr__pfet_01v8_hvt ad=0.07665 pd=0.785 as=0.1932 ps=1.34 w=0.42 l=0.15
X2513 a_38005_40623# a_37851_36647# uio_oe[0] uio_oe[0] sky130_fd_pr__nfet_01v8 ad=0.08775 pd=0.92 as=0.08775 ps=0.92 w=0.65 l=0.15
X2514 a_36530_39347# a_36847_39457# a_36805_39581# uio_oe[0] sky130_fd_pr__special_nfet_01v8 ad=0.0711 pd=0.755 as=0.0669 ps=0.75 w=0.36 l=0.15
X2515 a_58864_39447# a_39752_39483# a_59006_39254# VDPWR sky130_fd_pr__pfet_01v8_hvt ad=0.1932 pd=1.34 as=0.07665 ps=0.785 w=0.42 l=0.15
X2516 a_37195_35773# a_17255_32793# uio_oe[0] uio_oe[0] sky130_fd_pr__nfet_01v8 ad=0.1092 pd=1.36 as=0.1092 ps=1.36 w=0.42 l=0.15
X2517 a_58772_42087# a_38740_41909# a_58914_42262# VDPWR sky130_fd_pr__pfet_01v8_hvt ad=0.1932 pd=1.34 as=0.07665 ps=0.785 w=0.42 l=0.15
X2518 a_57472_41669# a_38649_43023# uio_oe[0] uio_oe[0] sky130_fd_pr__nfet_01v8 ad=0.1092 pd=1.36 as=0.0567 ps=0.69 w=0.42 l=0.15
X2519 a_59867_41174# a_59685_41174# VDPWR VDPWR sky130_fd_pr__pfet_01v8_hvt ad=0.0441 pd=0.63 as=0.0693 ps=0.75 w=0.42 l=0.15
X2520 a_40673_37583# a_40507_37583# uio_oe[0] uio_oe[0] sky130_fd_pr__nfet_01v8 ad=0.1092 pd=1.36 as=0.0567 ps=0.69 w=0.42 l=0.15
X2521 uio_oe[0] a_50784_37832# a_50722_37949# uio_oe[0] sky130_fd_pr__nfet_01v8 ad=0.2205 pd=1.89 as=0.066 ps=0.745 w=0.42 l=0.15
X2522 a_37839_35951# a_37433_35665# uio_oe[0] uio_oe[0] sky130_fd_pr__nfet_01v8 ad=0.1092 pd=1.36 as=0.1092 ps=1.36 w=0.42 l=0.15
X2523 a_59323_34902# a_54479_34876# a_58864_35095# VDPWR sky130_fd_pr__pfet_01v8_hvt ad=0.0441 pd=0.63 as=0.1932 ps=1.34 w=0.42 l=0.15
X2524 a_59006_35229# a_48677_38127# uio_oe[0] uio_oe[0] sky130_fd_pr__nfet_01v8 ad=0.0693 pd=0.75 as=0.11285 ps=1.045 w=0.42 l=0.15
X2525 a_61753_35407# a_60563_35407# a_61644_35407# uio_oe[0] sky130_fd_pr__special_nfet_01v8 ad=0.0669 pd=0.75 as=0.0711 ps=0.755 w=0.36 l=0.15
X2526 VDPWR a_50159_39996# a_50090_40125# VDPWR sky130_fd_pr__pfet_01v8_hvt ad=0.2184 pd=2.2 as=0.12915 ps=1.185 w=0.84 l=0.15
X2527 a_43603_39519# a_43428_39593# a_43782_39581# uio_oe[0] sky130_fd_pr__nfet_01v8 ad=0.1092 pd=1.36 as=0.06405 ps=0.725 w=0.42 l=0.15
X2528 a_45015_39215# a_37639_36495# uio_oe[0] uio_oe[0] sky130_fd_pr__nfet_01v8 ad=0.1092 pd=1.36 as=0.1092 ps=1.36 w=0.42 l=0.15
X2529 a_57519_38908# a_57324_38939# a_57829_38671# uio_oe[0] sky130_fd_pr__special_nfet_01v8 ad=0.0594 pd=0.69 as=0.1401 ps=1.1 w=0.36 l=0.15
X2530 uio_oe[0] a_44905_38671# a_49721_38493# uio_oe[0] sky130_fd_pr__nfet_01v8 ad=0.12495 pd=1.015 as=0.06405 ps=0.725 w=0.42 l=0.15
X2531 a_27266_24730# ua[1] a_27138_26020# uio_oe[0] sky130_fd_pr__nfet_01v8 ad=0.2436 pd=2.26 as=0.2436 ps=2.26 w=0.84 l=0.6
X2532 VDPWR a_29281_32641# a_29603_35933# VDPWR sky130_fd_pr__pfet_01v8_hvt ad=0.16655 pd=1.39 as=0.0567 ps=0.69 w=0.42 l=0.15
X2533 a_42457_36249# a_37661_38140# uio_oe[0] uio_oe[0] sky130_fd_pr__nfet_01v8 ad=0.1092 pd=1.36 as=0.1449 ps=1.11 w=0.42 l=0.15
X2534 VDPWR a_54693_42777# a_54723_42518# VDPWR sky130_fd_pr__pfet_01v8_hvt ad=0.0693 pd=0.75 as=0.0441 ps=0.63 w=0.42 l=0.15
X2535 uio_oe[0] a_62053_42777# a_61987_42845# uio_oe[0] sky130_fd_pr__nfet_01v8 ad=0.1449 pd=1.11 as=0.0693 ps=0.75 w=0.42 l=0.15
X2536 a_40003_37078# a_39752_37307# a_39544_37271# VDPWR sky130_fd_pr__pfet_01v8_hvt ad=0.0441 pd=0.63 as=0.1932 ps=1.34 w=0.42 l=0.15
X2537 a_17292_36681# a_17507_33198# a_17434_36488# VDPWR sky130_fd_pr__pfet_01v8_hvt ad=0.1932 pd=1.34 as=0.07665 ps=0.785 w=0.42 l=0.15
X2538 uio_oe[0] a_37195_41391# a_37361_41391# uio_oe[0] sky130_fd_pr__nfet_01v8 ad=0.169 pd=1.82 as=0.08775 ps=0.92 w=0.65 l=0.15
X2539 a_42605_38671# a_42439_38671# uio_oe[0] uio_oe[0] sky130_fd_pr__nfet_01v8 ad=0.1092 pd=1.36 as=0.0567 ps=0.69 w=0.42 l=0.15
X2540 a_60160_37583# a_58980_37557# a_59939_37910# uio_oe[0] sky130_fd_pr__nfet_01v8 ad=0.0693 pd=0.75 as=0.09975 ps=0.895 w=0.42 l=0.15
X2541 a_39544_37271# a_39752_37307# a_39686_37405# uio_oe[0] sky130_fd_pr__nfet_01v8 ad=0.09975 pd=0.895 as=0.0693 ps=0.75 w=0.42 l=0.15
X2542 ua[5] a_28348_10782# a_31002_26020# uio_oe[0] sky130_fd_pr__nfet_01v8 ad=0.1885 pd=1.88 as=0.1885 ps=1.88 w=0.65 l=0.15
X2543 a_42775_42857# a_42329_42485# a_42679_42857# uio_oe[0] sky130_fd_pr__special_nfet_01v8 ad=0.1401 pd=1.1 as=0.0594 ps=0.69 w=0.36 l=0.15
X2544 a_37639_36495# a_37387_36745# VDPWR VDPWR sky130_fd_pr__pfet_01v8_hvt ad=0.27 pd=2.54 as=0.14825 ps=1.34 w=1 l=0.15
X2545 a_41338_35773# a_40619_35549# a_40775_35644# uio_oe[0] sky130_fd_pr__special_nfet_01v8 ad=0.066 pd=0.745 as=0.0594 ps=0.69 w=0.36 l=0.15
X2546 a_25417_32641# a_25151_33007# uio_oe[0] uio_oe[0] sky130_fd_pr__nfet_01v8 ad=0.169 pd=1.82 as=0.1013 ps=0.99 w=0.65 l=0.15
X2547 a_40188_35095# a_40403_34876# a_40330_34902# VDPWR sky130_fd_pr__pfet_01v8_hvt ad=0.1932 pd=1.34 as=0.07665 ps=0.785 w=0.42 l=0.15
X2548 a_60132_42479# a_59695_42453# VDPWR VDPWR sky130_fd_pr__pfet_01v8_hvt ad=0.0567 pd=0.69 as=0.0819 ps=0.81 w=0.42 l=0.15
X2549 VDPWR a_41537_35161# a_41567_34902# VDPWR sky130_fd_pr__pfet_01v8_hvt ad=0.0693 pd=0.75 as=0.0441 ps=0.63 w=0.42 l=0.15
X2550 a_18711_35183# a_18531_35183# VDPWR VDPWR sky130_fd_pr__pfet_01v8_hvt ad=0.0609 pd=0.71 as=0.0714 ps=0.76 w=0.42 l=0.15
X2551 VDPWR a_50003_41633# a_49964_41507# VDPWR sky130_fd_pr__pfet_01v8_hvt ad=0.0864 pd=0.91 as=0.1664 ps=1.8 w=0.64 l=0.15
X2552 a_53011_38101# a_52816_38243# a_53321_38493# uio_oe[0] sky130_fd_pr__special_nfet_01v8 ad=0.0594 pd=0.69 as=0.1401 ps=1.1 w=0.36 l=0.15
X2553 ua[4] a_24484_10376# a_25746_26020# uio_oe[0] sky130_fd_pr__nfet_01v8 ad=0.1885 pd=1.88 as=0.1885 ps=1.88 w=0.65 l=0.15
X2554 a_42787_43389# a_40379_35551# VDPWR VDPWR sky130_fd_pr__pfet_01v8_hvt ad=0.1092 pd=1.36 as=0.07035 ps=0.755 w=0.42 l=0.15
X2555 uio_oe[0] a_47283_40607# a_47217_40681# uio_oe[0] sky130_fd_pr__nfet_01v8 ad=0.12495 pd=1.015 as=0.0669 ps=0.75 w=0.42 l=0.15
X2556 VDPWR a_17689_32641# a_18011_37021# VDPWR sky130_fd_pr__pfet_01v8_hvt ad=0.16655 pd=1.39 as=0.0567 ps=0.69 w=0.42 l=0.15
X2557 uio_oe[0] a_29281_32641# a_29689_37021# uio_oe[0] sky130_fd_pr__nfet_01v8 ad=0.1118 pd=1.04 as=0.0567 ps=0.69 w=0.42 l=0.15
X2558 a_57280_35951# a_56843_35925# VDPWR VDPWR sky130_fd_pr__pfet_01v8_hvt ad=0.0567 pd=0.69 as=0.0819 ps=0.81 w=0.42 l=0.15
X2559 VDPWR a_17689_32641# a_18711_35183# VDPWR sky130_fd_pr__pfet_01v8_hvt ad=0.2279 pd=1.74 as=0.0609 ps=0.71 w=0.42 l=0.15
X2560 uio_oe[0] a_40383_42997# a_40317_43023# uio_oe[0] sky130_fd_pr__nfet_01v8 ad=0.12495 pd=1.015 as=0.0669 ps=0.75 w=0.42 l=0.15
X2561 a_52855_37281# a_37913_41935# VDPWR VDPWR sky130_fd_pr__pfet_01v8_hvt ad=0.1664 pd=1.8 as=0.0864 ps=0.91 w=0.64 l=0.15
X2562 ua[5] a_16756_18376# a_16626_18020# uio_oe[0] sky130_fd_pr__nfet_01v8 ad=0.1885 pd=1.88 as=0.1885 ps=1.88 w=0.65 l=0.15
X2563 a_28700_34969# a_28835_34273# a_28842_35144# VDPWR sky130_fd_pr__pfet_01v8_hvt ad=0.1932 pd=1.34 as=0.07665 ps=0.785 w=0.42 l=0.15
X2564 a_61806_34685# a_60729_34319# a_61644_34319# VDPWR sky130_fd_pr__pfet_01v8_hvt ad=0.0567 pd=0.69 as=0.0588 ps=0.7 w=0.42 l=0.15
X2565 a_51871_37078# a_51620_37307# a_51412_37271# VDPWR sky130_fd_pr__pfet_01v8_hvt ad=0.0441 pd=0.63 as=0.1932 ps=1.34 w=0.42 l=0.15
X2566 a_41685_42479# a_41519_42479# VDPWR VDPWR sky130_fd_pr__pfet_01v8_hvt ad=0.135 pd=1.27 as=0.135 ps=1.27 w=1 l=0.15
X2567 a_40370_43389# a_39293_43023# a_40208_43023# VDPWR sky130_fd_pr__pfet_01v8_hvt ad=0.0567 pd=0.69 as=0.0588 ps=0.7 w=0.42 l=0.15
X2568 VDPWR a_20972_37145# a_20923_36993# VDPWR sky130_fd_pr__pfet_01v8_hvt ad=0.15835 pd=1.395 as=0.26 ps=2.52 w=1 l=0.15
X2569 a_51412_37271# a_51620_37307# a_51554_37405# uio_oe[0] sky130_fd_pr__nfet_01v8 ad=0.09975 pd=0.895 as=0.0693 ps=0.75 w=0.42 l=0.15
X2570 VDPWR a_61644_39759# a_61819_39733# VDPWR sky130_fd_pr__pfet_01v8_hvt ad=0.1134 pd=1.38 as=0.0567 ps=0.69 w=0.42 l=0.15
X2571 uio_oe[0] a_25940_34505# a_25044_34791# uio_oe[0] sky130_fd_pr__nfet_01v8 ad=0.11285 pd=1.045 as=0.169 ps=1.82 w=0.65 l=0.15
X2572 a_42321_35183# a_37029_37583# a_42237_35183# uio_oe[0] sky130_fd_pr__nfet_01v8 ad=0.25025 pd=1.42 as=0.08775 ps=0.92 w=0.65 l=0.15
X2573 a_46331_42650# a_47283_42997# VDPWR VDPWR sky130_fd_pr__pfet_01v8_hvt ad=0.26 pd=2.52 as=0.3012 ps=2.66 w=1 l=0.15
X2574 uio_oe[0] a_49483_37557# a_39752_37557# uio_oe[0] sky130_fd_pr__nfet_01v8 ad=0.2087 pd=2.02 as=0.169 ps=1.82 w=0.65 l=0.15
X2575 a_25739_33757# a_24787_33729# VDPWR VDPWR sky130_fd_pr__pfet_01v8_hvt ad=0.0567 pd=0.69 as=0.1176 ps=1.4 w=0.42 l=0.15
X2576 VDPWR a_57472_41669# a_57556_41365# VDPWR sky130_fd_pr__pfet_01v8_hvt ad=0.0864 pd=0.91 as=0.1664 ps=1.8 w=0.64 l=0.15
X2577 a_17108_36057# a_17243_35361# a_17250_36232# VDPWR sky130_fd_pr__pfet_01v8_hvt ad=0.1932 pd=1.34 as=0.07665 ps=0.785 w=0.42 l=0.15
X2578 VDPWR a_39555_36183# a_28796_37145# VDPWR sky130_fd_pr__pfet_01v8_hvt ad=0.16655 pd=1.39 as=0.475 ps=2.95 w=1 l=0.15
X2579 uio_oe[0] a_38483_43023# a_38649_43023# uio_oe[0] sky130_fd_pr__nfet_01v8 ad=0.169 pd=1.82 as=0.08775 ps=0.92 w=0.65 l=0.15
X2580 a_61987_42845# uio_in[1] a_61624_42711# uio_oe[0] sky130_fd_pr__nfet_01v8 ad=0.0693 pd=0.75 as=0.09975 ps=0.895 w=0.42 l=0.15
X2581 VDPWR a_37839_41391# a_38005_41391# VDPWR sky130_fd_pr__pfet_01v8_hvt ad=0.135 pd=1.27 as=0.135 ps=1.27 w=1 l=0.15
X2582 a_20914_18464# a_20620_18782# ua[5] uio_oe[0] sky130_fd_pr__nfet_01v8 ad=0.1885 pd=1.88 as=0.1885 ps=1.88 w=0.65 l=0.15
X2583 a_38961_39733# a_38005_40847# uio_oe[0] uio_oe[0] sky130_fd_pr__nfet_01v8 ad=0.1092 pd=1.36 as=0.1449 ps=1.11 w=0.42 l=0.15
X2584 a_54406_39581# a_36661_41391# uio_oe[0] uio_oe[0] sky130_fd_pr__nfet_01v8 ad=0.0693 pd=0.75 as=0.11285 ps=1.045 w=0.42 l=0.15
X2585 a_17537_36967# a_17204_37145# uio_oe[0] uio_oe[0] sky130_fd_pr__nfet_01v8 ad=0.1092 pd=1.36 as=0.1449 ps=1.11 w=0.42 l=0.15
X2586 VDPWR a_59201_36249# a_59231_35990# VDPWR sky130_fd_pr__pfet_01v8_hvt ad=0.0693 pd=0.75 as=0.0441 ps=0.63 w=0.42 l=0.15
X2587 a_38285_42479# a_37859_42518# VDPWR VDPWR sky130_fd_pr__pfet_01v8_hvt ad=0.26 pd=2.52 as=0.15835 ps=1.395 w=1 l=0.15
X2588 a_61187_42301# a_60563_41935# a_61079_41935# VDPWR sky130_fd_pr__pfet_01v8_hvt ad=0.1155 pd=0.97 as=0.07245 ps=0.765 w=0.42 l=0.15
X2589 a_38674_38166# a_37029_37583# VDPWR VDPWR sky130_fd_pr__pfet_01v8_hvt ad=0.07665 pd=0.785 as=0.15835 ps=1.395 w=0.42 l=0.15
X2590 VDPWR a_44905_38671# a_49483_37013# VDPWR sky130_fd_pr__pfet_01v8_hvt ad=0.0819 pd=0.81 as=0.0567 ps=0.69 w=0.42 l=0.15
X2591 a_24484_14376# a_25739_35933# uio_oe[0] uio_oe[0] sky130_fd_pr__nfet_01v8 ad=0.182 pd=1.86 as=0.1118 ps=1.04 w=0.65 l=0.15
X2592 VDPWR a_51841_36249# a_51871_35990# VDPWR sky130_fd_pr__pfet_01v8_hvt ad=0.0693 pd=0.75 as=0.0441 ps=0.63 w=0.42 l=0.15
X2593 VDPWR ua[4] uio_oe[0] sky130_fd_pr__res_high_po_1p41 l=11.61
X2594 uio_oe[0] a_21401_34791# a_21335_34817# uio_oe[0] sky130_fd_pr__nfet_01v8 ad=0.1449 pd=1.11 as=0.0693 ps=0.75 w=0.42 l=0.15
X2595 VDPWR a_39973_42777# a_40003_42518# VDPWR sky130_fd_pr__pfet_01v8_hvt ad=0.0693 pd=0.75 as=0.0441 ps=0.63 w=0.42 l=0.15
X2596 a_40003_42262# a_39752_41909# a_39544_42087# VDPWR sky130_fd_pr__pfet_01v8_hvt ad=0.0441 pd=0.63 as=0.1932 ps=1.34 w=0.42 l=0.15
X2597 VDPWR a_36661_41391# a_52793_42262# VDPWR sky130_fd_pr__pfet_01v8_hvt ad=0.15835 pd=1.395 as=0.07665 ps=0.785 w=0.42 l=0.15
X2598 a_44611_40847# a_44261_40847# a_44516_40847# VDPWR sky130_fd_pr__pfet_01v8_hvt ad=0.07245 pd=0.765 as=0.0651 ps=0.73 w=0.42 l=0.15
X2599 a_53937_38913# a_53719_38671# uio_oe[0] uio_oe[0] sky130_fd_pr__nfet_01v8 ad=0.0999 pd=0.985 as=0.1346 ps=1.15 w=0.64 l=0.15
X2600 a_54693_38425# a_37361_41391# uio_oe[0] uio_oe[0] sky130_fd_pr__nfet_01v8 ad=0.1092 pd=1.36 as=0.1449 ps=1.11 w=0.42 l=0.15
X2601 a_22076_34505# a_18420_33453# a_22218_34639# uio_oe[0] sky130_fd_pr__nfet_01v8 ad=0.09975 pd=0.895 as=0.0693 ps=0.75 w=0.42 l=0.15
X2602 a_60416_35141# a_37913_41935# VDPWR VDPWR sky130_fd_pr__pfet_01v8_hvt ad=0.1664 pd=1.8 as=0.0864 ps=0.91 w=0.64 l=0.15
X2603 a_52538_36083# a_52855_36193# a_52813_36317# uio_oe[0] sky130_fd_pr__special_nfet_01v8 ad=0.0711 pd=0.755 as=0.0669 ps=0.75 w=0.36 l=0.15
X2604 VDPWR a_57519_35925# a_57450_35951# VDPWR sky130_fd_pr__pfet_01v8_hvt ad=0.2184 pd=2.2 as=0.12915 ps=1.185 w=0.84 l=0.15
X2605 VDPWR a_42445_36469# a_42389_36822# VDPWR sky130_fd_pr__pfet_01v8_hvt ad=0.0693 pd=0.75 as=0.1176 ps=1.4 w=0.42 l=0.15
X2606 VDPWR a_36425_35078# a_36917_38921# VDPWR sky130_fd_pr__pfet_01v8_hvt ad=0.135 pd=1.27 as=0.135 ps=1.27 w=1 l=0.15
X2607 a_43713_36183# a_42445_36469# uio_oe[0] uio_oe[0] sky130_fd_pr__nfet_01v8 ad=0.0567 pd=0.69 as=0.10025 ps=0.985 w=0.42 l=0.15
X2608 a_61766_35990# a_37361_41391# VDPWR VDPWR sky130_fd_pr__pfet_01v8_hvt ad=0.07665 pd=0.785 as=0.15835 ps=1.395 w=0.42 l=0.15
X2609 a_28348_18782# a_29603_34845# VDPWR VDPWR sky130_fd_pr__pfet_01v8_hvt ad=0.475 pd=2.95 as=0.16655 ps=1.39 w=1 l=0.15
X2610 VDPWR a_48125_43023# a_57664_39037# VDPWR sky130_fd_pr__pfet_01v8_hvt ad=0.07035 pd=0.755 as=0.1092 ps=1.36 w=0.42 l=0.15
X2611 a_54459_34293# a_54284_34319# a_54638_34319# uio_oe[0] sky130_fd_pr__nfet_01v8 ad=0.1092 pd=1.36 as=0.06405 ps=0.725 w=0.42 l=0.15
X2612 a_50304_42479# a_50090_42479# VDPWR VDPWR sky130_fd_pr__pfet_01v8_hvt ad=0.1155 pd=0.97 as=0.07035 ps=0.755 w=0.42 l=0.15
X2613 a_42329_43023# a_42163_43023# uio_oe[0] uio_oe[0] sky130_fd_pr__nfet_01v8 ad=0.1092 pd=1.36 as=0.0567 ps=0.69 w=0.42 l=0.15
X2614 a_44719_42479# a_44095_42485# a_44611_42857# VDPWR sky130_fd_pr__pfet_01v8_hvt ad=0.1155 pd=0.97 as=0.07245 ps=0.765 w=0.42 l=0.15
X2615 a_53369_35407# a_53203_35407# VDPWR VDPWR sky130_fd_pr__pfet_01v8_hvt ad=0.1664 pd=1.8 as=0.0864 ps=0.91 w=0.64 l=0.15
X2616 a_58772_42711# a_54479_42492# a_58914_42845# uio_oe[0] sky130_fd_pr__nfet_01v8 ad=0.09975 pd=0.895 as=0.0693 ps=0.75 w=0.42 l=0.15
X2617 a_57757_40669# a_48125_43023# uio_oe[0] uio_oe[0] sky130_fd_pr__nfet_01v8 ad=0.0441 pd=0.63 as=0.1346 ps=1.15 w=0.42 l=0.15
X2618 uio_oe[0] a_16812_8642# a_29738_24730# uio_oe[0] sky130_fd_pr__nfet_01v8 ad=1.4703 pd=10.72 as=1.4703 ps=10.72 w=5.07 l=1
X2619 a_51871_42262# a_51620_41909# a_51412_42087# VDPWR sky130_fd_pr__pfet_01v8_hvt ad=0.0441 pd=0.63 as=0.1932 ps=1.34 w=0.42 l=0.15
X2620 a_51841_40821# a_48677_39759# VDPWR VDPWR sky130_fd_pr__pfet_01v8_hvt ad=0.1176 pd=1.4 as=0.0693 ps=0.75 w=0.42 l=0.15
X2621 VDPWR a_29281_32641# a_29603_34845# VDPWR sky130_fd_pr__pfet_01v8_hvt ad=0.16655 pd=1.39 as=0.0567 ps=0.69 w=0.42 l=0.15
X2622 VDPWR a_54693_41689# a_54723_41430# VDPWR sky130_fd_pr__pfet_01v8_hvt ad=0.0693 pd=0.75 as=0.0441 ps=0.63 w=0.42 l=0.15
X2623 a_54393_40847# a_53203_40847# a_54284_40847# uio_oe[0] sky130_fd_pr__special_nfet_01v8 ad=0.0669 pd=0.75 as=0.0711 ps=0.755 w=0.36 l=0.15
X2624 VDPWR a_57519_36732# a_57450_36861# VDPWR sky130_fd_pr__pfet_01v8_hvt ad=0.2184 pd=2.2 as=0.12915 ps=1.185 w=0.84 l=0.15
X2625 VDPWR a_52335_35925# a_51620_36219# VDPWR sky130_fd_pr__pfet_01v8_hvt ad=0.3012 pd=2.66 as=0.26 ps=2.52 w=1 l=0.15
X2626 a_18531_35183# a_17059_34817# uio_oe[0] uio_oe[0] sky130_fd_pr__nfet_01v8 ad=0.1092 pd=1.36 as=0.1092 ps=1.36 w=0.42 l=0.15
X2627 uio_oe[0] a_41141_40316# a_43275_37039# uio_oe[0] sky130_fd_pr__nfet_01v8 ad=0.08775 pd=0.92 as=0.08775 ps=0.92 w=0.65 l=0.15
X2628 a_40330_35229# a_37661_37052# uio_oe[0] uio_oe[0] sky130_fd_pr__nfet_01v8 ad=0.0693 pd=0.75 as=0.11285 ps=1.045 w=0.42 l=0.15
X2629 VDPWR a_56843_41909# a_38740_41909# VDPWR sky130_fd_pr__pfet_01v8_hvt ad=0.3012 pd=2.66 as=0.26 ps=2.52 w=1 l=0.15
X2630 a_54446_37949# a_53369_37583# a_54284_37583# VDPWR sky130_fd_pr__pfet_01v8_hvt ad=0.0567 pd=0.69 as=0.0588 ps=0.7 w=0.42 l=0.15
X2631 a_52573_40669# a_52538_40435# a_52335_40277# uio_oe[0] sky130_fd_pr__nfet_01v8 ad=0.06405 pd=0.725 as=0.1092 ps=1.36 w=0.42 l=0.15
X2632 a_39973_38425# a_38005_40847# uio_oe[0] uio_oe[0] sky130_fd_pr__nfet_01v8 ad=0.1092 pd=1.36 as=0.1449 ps=1.11 w=0.42 l=0.15
X2633 a_50159_35925# a_50003_36193# a_50304_35951# VDPWR sky130_fd_pr__pfet_01v8_hvt ad=0.07245 pd=0.765 as=0.1155 ps=0.97 w=0.42 l=0.15
X2634 ua[5] a_24484_10376# a_24354_10020# uio_oe[0] sky130_fd_pr__nfet_01v8 ad=0.1885 pd=1.88 as=0.1885 ps=1.88 w=0.65 l=0.15
X2635 a_36329_36469# a_36499_36647# a_36457_36745# VDPWR sky130_fd_pr__pfet_01v8_hvt ad=0.1092 pd=1.36 as=0.0441 ps=0.63 w=0.42 l=0.15
X2636 a_41793_34569# a_41751_34471# a_41711_34569# VDPWR sky130_fd_pr__pfet_01v8_hvt ad=0.135 pd=1.27 as=0.26 ps=2.52 w=1 l=0.15
X2637 VDPWR a_60584_41705# a_60638_41391# VDPWR sky130_fd_pr__pfet_01v8_hvt ad=0.0567 pd=0.69 as=0.0483 ps=0.65 w=0.42 l=0.15
X2638 a_43603_39733# a_43428_39759# a_43782_39759# uio_oe[0] sky130_fd_pr__nfet_01v8 ad=0.1092 pd=1.36 as=0.06405 ps=0.725 w=0.42 l=0.15
X2639 a_54693_39513# a_36661_41391# VDPWR VDPWR sky130_fd_pr__pfet_01v8_hvt ad=0.1176 pd=1.4 as=0.0693 ps=0.75 w=0.42 l=0.15
X2640 a_60173_36317# a_59695_35925# uio_oe[0] uio_oe[0] sky130_fd_pr__nfet_01v8 ad=0.0669 pd=0.75 as=0.12495 ps=1.015 w=0.42 l=0.15
X2641 a_28700_33881# a_28908_33703# a_28842_33729# uio_oe[0] sky130_fd_pr__nfet_01v8 ad=0.09975 pd=0.895 as=0.0693 ps=0.75 w=0.42 l=0.15
X2642 a_36721_37039# a_36455_37039# VDPWR VDPWR sky130_fd_pr__pfet_01v8_hvt ad=0.26 pd=2.52 as=0.2279 ps=1.74 w=1 l=0.15
X2643 uio_oe[0] a_29073_32899# a_29105_32641# uio_oe[0] sky130_fd_pr__nfet_01v8 ad=0.1013 pd=0.99 as=0.0504 ps=0.66 w=0.42 l=0.15
X2644 a_61819_37557# a_46193_39759# VDPWR VDPWR sky130_fd_pr__pfet_01v8_hvt ad=0.0567 pd=0.69 as=0.0819 ps=0.81 w=0.42 l=0.15
X2645 uio_oe[0] a_62237_39513# a_62171_39581# uio_oe[0] sky130_fd_pr__nfet_01v8 ad=0.1449 pd=1.11 as=0.0693 ps=0.75 w=0.42 l=0.15
X2646 a_38532_38359# a_38089_40623# a_38674_38166# VDPWR sky130_fd_pr__pfet_01v8_hvt ad=0.1932 pd=1.34 as=0.07665 ps=0.785 w=0.42 l=0.15
X2647 a_61187_35773# a_60563_35407# a_61079_35407# VDPWR sky130_fd_pr__pfet_01v8_hvt ad=0.1155 pd=0.97 as=0.07245 ps=0.765 w=0.42 l=0.15
X2648 a_28348_18376# a_30303_35183# uio_oe[0] uio_oe[0] sky130_fd_pr__nfet_01v8 ad=0.169 pd=1.82 as=0.1013 ps=0.99 w=0.65 l=0.15
X2649 a_42959_39593# a_42513_39221# a_42863_39593# uio_oe[0] sky130_fd_pr__special_nfet_01v8 ad=0.1401 pd=1.1 as=0.0594 ps=0.69 w=0.36 l=0.15
X2650 a_59135_35407# a_38771_35409# a_58772_35559# uio_oe[0] sky130_fd_pr__nfet_01v8 ad=0.0693 pd=0.75 as=0.09975 ps=0.895 w=0.42 l=0.15
X2651 uio_oe[0] a_59201_40821# a_59135_40847# uio_oe[0] sky130_fd_pr__nfet_01v8 ad=0.1449 pd=1.11 as=0.0693 ps=0.75 w=0.42 l=0.15
X2652 a_42584_40669# a_42467_40474# VDPWR VDPWR sky130_fd_pr__pfet_01v8_hvt ad=0.0651 pd=0.73 as=0.1092 ps=1.36 w=0.42 l=0.15
X2653 VDPWR a_40987_39457# a_40948_39331# VDPWR sky130_fd_pr__pfet_01v8_hvt ad=0.0864 pd=0.91 as=0.1664 ps=1.8 w=0.64 l=0.15
X2654 a_61624_36183# a_58980_36469# a_61766_35990# VDPWR sky130_fd_pr__pfet_01v8_hvt ad=0.1932 pd=1.34 as=0.07665 ps=0.785 w=0.42 l=0.15
X2655 a_52772_34863# a_52335_34837# VDPWR VDPWR sky130_fd_pr__pfet_01v8_hvt ad=0.0567 pd=0.69 as=0.0819 ps=0.81 w=0.42 l=0.15
X2656 a_38961_38645# a_38005_40847# uio_oe[0] uio_oe[0] sky130_fd_pr__nfet_01v8 ad=0.1092 pd=1.36 as=0.1449 ps=1.11 w=0.42 l=0.15
X2657 a_29804_35593# a_18420_33453# a_29946_35727# uio_oe[0] sky130_fd_pr__nfet_01v8 ad=0.09975 pd=0.895 as=0.0693 ps=0.75 w=0.42 l=0.15
X2658 a_59956_34837# a_60500_34837# a_60458_34863# VDPWR sky130_fd_pr__pfet_01v8_hvt ad=0.0819 pd=0.81 as=0.0441 ps=0.63 w=0.42 l=0.15
X2659 a_17108_34969# a_17316_34791# a_17250_34817# uio_oe[0] sky130_fd_pr__nfet_01v8 ad=0.09975 pd=0.895 as=0.0693 ps=0.75 w=0.42 l=0.15
X2660 VDPWR a_53636_39189# a_53574_39215# VDPWR sky130_fd_pr__pfet_01v8_hvt ad=0.1092 pd=1.36 as=0.0651 ps=0.73 w=0.42 l=0.15
X2661 a_17434_36815# a_17388_36681# uio_oe[0] uio_oe[0] sky130_fd_pr__nfet_01v8 ad=0.0693 pd=0.75 as=0.11285 ps=1.045 w=0.42 l=0.15
X2662 a_46448_43023# ui_in[1] VDPWR VDPWR sky130_fd_pr__pfet_01v8_hvt ad=0.0651 pd=0.73 as=0.1092 ps=1.36 w=0.42 l=0.15
X2663 VDPWR a_39973_41689# a_40003_41430# VDPWR sky130_fd_pr__pfet_01v8_hvt ad=0.0693 pd=0.75 as=0.0441 ps=0.63 w=0.42 l=0.15
X2664 a_54264_36183# a_51620_36219# a_54406_36317# uio_oe[0] sky130_fd_pr__nfet_01v8 ad=0.09975 pd=0.895 as=0.0693 ps=0.75 w=0.42 l=0.15
X2665 a_22076_33417# a_18420_33453# a_22218_33551# uio_oe[0] sky130_fd_pr__nfet_01v8 ad=0.09975 pd=0.895 as=0.0693 ps=0.75 w=0.42 l=0.15
X2666 a_37183_40277# rst_n VDPWR VDPWR sky130_fd_pr__pfet_01v8_hvt ad=0.26 pd=2.52 as=0.135 ps=1.27 w=1 l=0.15
X2667 VDPWR a_28700_36057# a_28651_35905# VDPWR sky130_fd_pr__pfet_01v8_hvt ad=0.15835 pd=1.395 as=0.26 ps=2.52 w=1 l=0.15
X2668 a_52538_34995# a_52855_35105# a_52813_35229# uio_oe[0] sky130_fd_pr__special_nfet_01v8 ad=0.0711 pd=0.755 as=0.0669 ps=0.75 w=0.36 l=0.15
X2669 VDPWR a_48125_43023# a_56843_38645# VDPWR sky130_fd_pr__pfet_01v8_hvt ad=0.0819 pd=0.81 as=0.0567 ps=0.69 w=0.42 l=0.15
X2670 a_50469_35407# a_50090_35773# a_50397_35407# uio_oe[0] sky130_fd_pr__nfet_01v8 ad=0.1401 pd=1.1 as=0.0441 ps=0.63 w=0.42 l=0.15
X2671 uio_oe[0] a_59293_35161# a_59227_35229# uio_oe[0] sky130_fd_pr__nfet_01v8 ad=0.1449 pd=1.11 as=0.0693 ps=0.75 w=0.42 l=0.15
X2672 a_44611_41935# a_44095_41935# a_44516_41935# uio_oe[0] sky130_fd_pr__special_nfet_01v8 ad=0.0594 pd=0.69 as=0.066 ps=0.745 w=0.36 l=0.15
X2673 a_36999_42453# clk uio_oe[0] uio_oe[0] sky130_fd_pr__nfet_01v8 ad=0.169 pd=1.82 as=0.08775 ps=0.92 w=0.65 l=0.15
X2674 a_36999_37557# a_37335_37557# VDPWR VDPWR sky130_fd_pr__pfet_01v8_hvt ad=0.26 pd=2.52 as=0.135 ps=1.27 w=1 l=0.15
X2675 a_40836_37405# a_36956_35095# VDPWR VDPWR sky130_fd_pr__pfet_01v8_hvt ad=0.0651 pd=0.73 as=0.1092 ps=1.36 w=0.42 l=0.15
X2676 a_30034_14464# a_28348_10782# ua[5] uio_oe[0] sky130_fd_pr__nfet_01v8 ad=0.1885 pd=1.88 as=0.1885 ps=1.88 w=0.65 l=0.15
X2677 a_50304_41391# a_50090_41391# VDPWR VDPWR sky130_fd_pr__pfet_01v8_hvt ad=0.1155 pd=0.97 as=0.07035 ps=0.755 w=0.42 l=0.15
X2678 a_57776_37405# a_57640_37353# VDPWR VDPWR sky130_fd_pr__pfet_01v8_hvt ad=0.0567 pd=0.69 as=0.0567 ps=0.69 w=0.42 l=0.15
X2679 a_49483_35925# a_49686_36083# VDPWR VDPWR sky130_fd_pr__pfet_01v8_hvt ad=0.0567 pd=0.69 as=0.1134 ps=1.38 w=0.42 l=0.15
X2680 a_29105_32641# a_28835_33007# a_29015_33007# uio_oe[0] sky130_fd_pr__nfet_01v8 ad=0.0504 pd=0.66 as=0.1092 ps=1.36 w=0.42 l=0.15
X2681 uio_oe[0] a_25417_32641# a_26529_33729# uio_oe[0] sky130_fd_pr__nfet_01v8 ad=0.1013 pd=0.99 as=0.0504 ps=0.66 w=0.42 l=0.15
X2682 VDPWR a_47959_41935# a_48125_41935# VDPWR sky130_fd_pr__pfet_01v8_hvt ad=0.26 pd=2.52 as=0.135 ps=1.27 w=1 l=0.15
X2683 a_44719_41391# a_44095_41397# a_44611_41769# VDPWR sky130_fd_pr__pfet_01v8_hvt ad=0.1155 pd=0.97 as=0.07245 ps=0.765 w=0.42 l=0.15
X2684 a_22395_37359# a_20923_36993# uio_oe[0] uio_oe[0] sky130_fd_pr__nfet_01v8 ad=0.1092 pd=1.36 as=0.1092 ps=1.36 w=0.42 l=0.15
X2685 a_36875_38823# a_43419_40607# uio_oe[0] uio_oe[0] sky130_fd_pr__nfet_01v8 ad=0.169 pd=1.82 as=0.2087 ps=2.02 w=0.65 l=0.15
X2686 a_53005_37583# a_52579_37910# VDPWR VDPWR sky130_fd_pr__pfet_01v8_hvt ad=0.26 pd=2.52 as=0.15835 ps=1.395 w=1 l=0.15
X2687 uio_oe[0] a_21585_36747# a_21519_36815# uio_oe[0] sky130_fd_pr__nfet_01v8 ad=0.1449 pd=1.11 as=0.0693 ps=0.75 w=0.42 l=0.15
X2688 uio_oe[0] a_21553_32641# a_21961_33757# uio_oe[0] sky130_fd_pr__nfet_01v8 ad=0.1118 pd=1.04 as=0.0567 ps=0.69 w=0.42 l=0.15
X2689 a_48677_38127# a_48511_38127# VDPWR VDPWR sky130_fd_pr__pfet_01v8_hvt ad=0.135 pd=1.27 as=0.135 ps=1.27 w=1 l=0.15
X2690 a_24778_14464# a_24484_14376# ua[4] uio_oe[0] sky130_fd_pr__nfet_01v8 ad=0.1885 pd=1.88 as=0.1885 ps=1.88 w=0.65 l=0.15
X2691 a_39973_39513# a_38005_40847# VDPWR VDPWR sky130_fd_pr__pfet_01v8_hvt ad=0.1176 pd=1.4 as=0.0693 ps=0.75 w=0.42 l=0.15
X2692 VDPWR a_17108_37145# a_17059_36993# VDPWR sky130_fd_pr__pfet_01v8_hvt ad=0.15835 pd=1.395 as=0.26 ps=2.52 w=1 l=0.15
X2693 VDPWR a_44829_42177# a_44719_42301# VDPWR sky130_fd_pr__pfet_01v8_hvt ad=0.07035 pd=0.755 as=0.1155 ps=0.97 w=0.42 l=0.15
X2694 uio_oe[0] a_37913_43023# a_53203_41935# uio_oe[0] sky130_fd_pr__nfet_01v8 ad=0.0567 pd=0.69 as=0.1092 ps=1.36 w=0.42 l=0.15
X2695 a_26259_36271# a_24787_35905# uio_oe[0] uio_oe[0] sky130_fd_pr__nfet_01v8 ad=0.1092 pd=1.36 as=0.1092 ps=1.36 w=0.42 l=0.15
X2696 a_41316_41909# a_45351_41695# uio_oe[0] uio_oe[0] sky130_fd_pr__nfet_01v8 ad=0.169 pd=1.82 as=0.2087 ps=2.02 w=0.65 l=0.15
X2697 a_16756_10376# a_18011_37021# uio_oe[0] uio_oe[0] sky130_fd_pr__nfet_01v8 ad=0.182 pd=1.86 as=0.1118 ps=1.04 w=0.65 l=0.15
X2698 a_26303_36815# a_18427_33198# a_25940_36681# uio_oe[0] sky130_fd_pr__nfet_01v8 ad=0.0693 pd=0.75 as=0.09975 ps=0.895 w=0.42 l=0.15
X2699 a_50159_41365# a_49964_41507# a_50469_41757# uio_oe[0] sky130_fd_pr__special_nfet_01v8 ad=0.0594 pd=0.69 as=0.1401 ps=1.1 w=0.36 l=0.15
X2700 a_59860_37271# a_59956_37013# uio_oe[0] uio_oe[0] sky130_fd_pr__nfet_01v8 ad=0.1092 pd=1.36 as=0.097 ps=0.975 w=0.42 l=0.15
X2701 a_26170_26464# a_24484_10782# ua[4] uio_oe[0] sky130_fd_pr__nfet_01v8 ad=0.1885 pd=1.88 as=0.1885 ps=1.88 w=0.65 l=0.15
X2702 a_57598_35229# a_57556_34837# a_57012_34837# uio_oe[0] sky130_fd_pr__nfet_01v8 ad=0.0441 pd=0.63 as=0.0693 ps=0.75 w=0.42 l=0.15
X2703 a_29129_34791# a_28796_34969# uio_oe[0] uio_oe[0] sky130_fd_pr__nfet_01v8 ad=0.1092 pd=1.36 as=0.1449 ps=1.11 w=0.42 l=0.15
X2704 a_50090_42479# a_50003_42721# a_49686_42611# VDPWR sky130_fd_pr__pfet_01v8_hvt ad=0.12915 pd=1.185 as=0.0588 ps=0.7 w=0.42 l=0.15
X2705 uio_oe[0] a_60371_40277# a_60302_40303# uio_oe[0] sky130_fd_pr__nfet_01v8 ad=0.1346 pd=1.15 as=0.0999 ps=0.985 w=0.64 l=0.15
X2706 uio_oe[0] a_29129_36967# a_29063_36993# uio_oe[0] sky130_fd_pr__nfet_01v8 ad=0.1449 pd=1.11 as=0.0693 ps=0.75 w=0.42 l=0.15
X2707 a_17050_18464# a_16756_18782# ua[5] uio_oe[0] sky130_fd_pr__nfet_01v8 ad=0.1885 pd=1.88 as=0.1885 ps=1.88 w=0.65 l=0.15
X2708 a_52855_42721# a_37913_43023# uio_oe[0] uio_oe[0] sky130_fd_pr__nfet_01v8 ad=0.1092 pd=1.36 as=0.0567 ps=0.69 w=0.42 l=0.15
X2709 VDPWR a_40469_41909# a_40304_34293# VDPWR sky130_fd_pr__pfet_01v8_hvt ad=0.14825 pd=1.34 as=0.27 ps=2.54 w=1 l=0.15
X2710 a_40670_40011# a_40948_40027# a_40904_40125# VDPWR sky130_fd_pr__pfet_01v8_hvt ad=0.0588 pd=0.7 as=0.0567 ps=0.69 w=0.42 l=0.15
X2711 VDPWR a_39544_39447# a_21068_34969# VDPWR sky130_fd_pr__pfet_01v8_hvt ad=0.15835 pd=1.395 as=0.26 ps=2.52 w=1 l=0.15
X2712 a_50090_37949# a_49964_37851# a_49686_37835# uio_oe[0] sky130_fd_pr__special_nfet_01v8 ad=0.0999 pd=0.985 as=0.0711 ps=0.755 w=0.36 l=0.15
X2713 a_24778_14464# ua[1] a_24532_14020# uio_oe[0] sky130_fd_pr__nfet_01v8 ad=0.2436 pd=2.26 as=0.2436 ps=2.26 w=0.84 l=0.6
X2714 VDPWR a_50003_38813# a_49964_38939# VDPWR sky130_fd_pr__pfet_01v8_hvt ad=0.0864 pd=0.91 as=0.1664 ps=1.8 w=0.64 l=0.15
X2715 a_57829_40847# a_57450_41213# a_57757_40847# uio_oe[0] sky130_fd_pr__nfet_01v8 ad=0.1401 pd=1.1 as=0.0441 ps=0.63 w=0.42 l=0.15
X2716 uio_oe[0] a_60215_40545# a_60176_40419# uio_oe[0] sky130_fd_pr__nfet_01v8 ad=0.0567 pd=0.69 as=0.1092 ps=1.36 w=0.42 l=0.15
X2717 uio_oe[0] a_50159_39189# a_50090_39215# uio_oe[0] sky130_fd_pr__nfet_01v8 ad=0.1346 pd=1.15 as=0.0999 ps=0.985 w=0.64 l=0.15
X2718 a_54446_36861# a_53369_36495# a_54284_36495# VDPWR sky130_fd_pr__pfet_01v8_hvt ad=0.0567 pd=0.69 as=0.0588 ps=0.7 w=0.42 l=0.15
X2719 a_26170_26464# a_4259_22596# a_25874_24730# uio_oe[0] sky130_fd_pr__nfet_01v8 ad=0.2436 pd=2.26 as=0.2436 ps=2.26 w=0.84 l=0.6
X2720 a_37839_35773# a_37795_40535# uio_oe[0] uio_oe[0] sky130_fd_pr__nfet_01v8 ad=0.1092 pd=1.36 as=0.1092 ps=1.36 w=0.42 l=0.15
X2721 a_26529_33729# a_26259_34095# a_26439_34095# uio_oe[0] sky130_fd_pr__nfet_01v8 ad=0.0504 pd=0.66 as=0.1092 ps=1.36 w=0.42 l=0.15
X2722 a_50304_37949# a_50090_37949# VDPWR VDPWR sky130_fd_pr__pfet_01v8_hvt ad=0.1155 pd=0.97 as=0.07035 ps=0.755 w=0.42 l=0.15
X2723 VDPWR a_21585_36747# a_21615_36488# VDPWR sky130_fd_pr__pfet_01v8_hvt ad=0.0693 pd=0.75 as=0.0441 ps=0.63 w=0.42 l=0.15
X2724 VDPWR a_45176_40847# a_45351_40821# VDPWR sky130_fd_pr__pfet_01v8_hvt ad=0.1134 pd=1.38 as=0.0567 ps=0.69 w=0.42 l=0.15
X2725 VDPWR a_61624_40535# a_60996_40277# VDPWR sky130_fd_pr__pfet_01v8_hvt ad=0.15835 pd=1.395 as=0.26 ps=2.52 w=1 l=0.15
X2726 uio_oe[0] a_44905_38671# a_49721_37583# uio_oe[0] sky130_fd_pr__nfet_01v8 ad=0.12495 pd=1.015 as=0.06405 ps=0.725 w=0.42 l=0.15
X2727 a_38674_36495# a_37029_37583# uio_oe[0] uio_oe[0] sky130_fd_pr__nfet_01v8 ad=0.0693 pd=0.75 as=0.11285 ps=1.045 w=0.42 l=0.15
X2728 a_61644_35407# a_60729_35407# a_61297_35649# uio_oe[0] sky130_fd_pr__special_nfet_01v8 ad=0.0711 pd=0.755 as=0.0999 ps=0.985 w=0.36 l=0.15
X2729 a_42787_42301# a_42163_41935# a_42679_41935# VDPWR sky130_fd_pr__pfet_01v8_hvt ad=0.1155 pd=0.97 as=0.07245 ps=0.765 w=0.42 l=0.15
X2730 a_57081_40847# a_57046_41099# a_56843_40821# uio_oe[0] sky130_fd_pr__nfet_01v8 ad=0.06405 pd=0.725 as=0.1092 ps=1.36 w=0.42 l=0.15
X2731 a_43918_36041# a_45095_39733# uio_oe[0] uio_oe[0] sky130_fd_pr__nfet_01v8 ad=0.08775 pd=0.92 as=0.08775 ps=0.92 w=0.65 l=0.15
X2732 a_61187_37949# a_46193_39759# VDPWR VDPWR sky130_fd_pr__pfet_01v8_hvt ad=0.1092 pd=1.36 as=0.07035 ps=0.755 w=0.42 l=0.15
X2733 uio_oe[0] a_39973_37337# a_39907_37405# uio_oe[0] sky130_fd_pr__nfet_01v8 ad=0.1449 pd=1.11 as=0.0693 ps=0.75 w=0.42 l=0.15
X2734 VDPWR a_38005_41391# a_42347_39759# VDPWR sky130_fd_pr__pfet_01v8_hvt ad=0.0864 pd=0.91 as=0.1664 ps=1.8 w=0.64 l=0.15
X2735 uio_oe[0] a_36427_36475# a_37605_38998# uio_oe[0] sky130_fd_pr__nfet_01v8 ad=0.1449 pd=1.11 as=0.1092 ps=1.36 w=0.42 l=0.15
X2736 a_39973_38645# a_38005_40847# VDPWR VDPWR sky130_fd_pr__pfet_01v8_hvt ad=0.1176 pd=1.4 as=0.0693 ps=0.75 w=0.42 l=0.15
X2737 a_44537_38127# a_36425_36166# VDPWR VDPWR sky130_fd_pr__pfet_01v8_hvt ad=0.135 pd=1.27 as=0.135 ps=1.27 w=1 l=0.15
X2738 a_24978_37320# a_24932_37145# VDPWR VDPWR sky130_fd_pr__pfet_01v8_hvt ad=0.07665 pd=0.785 as=0.15835 ps=1.395 w=0.42 l=0.15
X2739 a_61819_36469# a_46193_39759# VDPWR VDPWR sky130_fd_pr__pfet_01v8_hvt ad=0.0567 pd=0.69 as=0.0819 ps=0.81 w=0.42 l=0.15
X2740 a_24778_26464# a_24484_10376# ua[5] uio_oe[0] sky130_fd_pr__nfet_01v8 ad=0.1885 pd=1.88 as=0.1885 ps=1.88 w=0.65 l=0.15
X2741 a_40188_35095# a_37310_34471# a_40330_35229# uio_oe[0] sky130_fd_pr__nfet_01v8 ad=0.09975 pd=0.895 as=0.0693 ps=0.75 w=0.42 l=0.15
X2742 a_53719_41935# a_53369_41935# a_53624_41935# VDPWR sky130_fd_pr__pfet_01v8_hvt ad=0.07245 pd=0.765 as=0.0651 ps=0.73 w=0.42 l=0.15
X2743 a_41099_40342# a_40917_40342# VDPWR VDPWR sky130_fd_pr__pfet_01v8_hvt ad=0.0441 pd=0.63 as=0.0693 ps=0.75 w=0.42 l=0.15
X2744 uio_oe[0] a_52335_40277# a_51620_40571# uio_oe[0] sky130_fd_pr__nfet_01v8 ad=0.2087 pd=2.02 as=0.169 ps=1.82 w=0.65 l=0.15
X2745 a_27316_10020# a_4259_22596# a_27138_10020# uio_oe[0] sky130_fd_pr__nfet_01v8 ad=0.2436 pd=2.26 as=0.2436 ps=2.26 w=0.84 l=0.6
X2746 uio_oe[0] a_40495_42453# a_40379_35551# uio_oe[0] sky130_fd_pr__nfet_01v8 ad=0.08775 pd=0.92 as=0.08775 ps=0.92 w=0.65 l=0.15
X2747 VDPWR a_51412_39447# a_50784_39189# VDPWR sky130_fd_pr__pfet_01v8_hvt ad=0.15835 pd=1.395 as=0.26 ps=2.52 w=1 l=0.15
X2748 VDPWR a_17721_33483# a_17751_33224# VDPWR sky130_fd_pr__pfet_01v8_hvt ad=0.0693 pd=0.75 as=0.0441 ps=0.63 w=0.42 l=0.15
X2749 a_28884_33417# a_17507_33198# a_29026_33224# VDPWR sky130_fd_pr__pfet_01v8_hvt ad=0.1932 pd=1.34 as=0.07665 ps=0.785 w=0.42 l=0.15
X2750 a_44261_41397# a_44095_41397# VDPWR VDPWR sky130_fd_pr__pfet_01v8_hvt ad=0.1664 pd=1.8 as=0.0864 ps=0.91 w=0.64 l=0.15
X2751 ua[5] a_28348_10376# a_31002_10020# uio_oe[0] sky130_fd_pr__nfet_01v8 ad=0.1885 pd=1.88 as=0.1885 ps=1.88 w=0.65 l=0.15
X2752 a_59933_42845# a_59898_42611# a_59695_42453# uio_oe[0] sky130_fd_pr__nfet_01v8 ad=0.06405 pd=0.725 as=0.1092 ps=1.36 w=0.42 l=0.15
X2753 a_60584_39529# a_60500_39189# a_60988_39581# uio_oe[0] sky130_fd_pr__special_nfet_01v8 ad=0.072 pd=0.76 as=0.06705 ps=0.75 w=0.36 l=0.15
X2754 a_62083_35990# a_54479_35964# a_61624_36183# VDPWR sky130_fd_pr__pfet_01v8_hvt ad=0.0441 pd=0.63 as=0.1932 ps=1.34 w=0.42 l=0.15
X2755 a_42787_42479# a_39947_42997# VDPWR VDPWR sky130_fd_pr__pfet_01v8_hvt ad=0.1092 pd=1.36 as=0.07035 ps=0.755 w=0.42 l=0.15
X2756 uio_oe[0] a_54264_41623# a_53636_41365# uio_oe[0] sky130_fd_pr__nfet_01v8 ad=0.11285 pd=1.045 as=0.169 ps=1.82 w=0.65 l=0.15
X2757 a_60298_39581# a_48125_41935# uio_oe[0] uio_oe[0] sky130_fd_pr__nfet_01v8 ad=0.0483 pd=0.65 as=0.1137 ps=1.01 w=0.42 l=0.15
X2758 a_48677_39759# a_48511_39759# uio_oe[0] uio_oe[0] sky130_fd_pr__nfet_01v8 ad=0.08775 pd=0.92 as=0.08775 ps=0.92 w=0.65 l=0.15
X2759 uio_oe[0] a_44909_37735# a_44511_38645# uio_oe[0] sky130_fd_pr__nfet_01v8 ad=0.10025 pd=0.985 as=0.169 ps=1.82 w=0.65 l=0.15
X2760 a_44126_37155# a_37639_36495# a_44044_37155# VDPWR sky130_fd_pr__pfet_01v8_hvt ad=0.0441 pd=0.63 as=0.1092 ps=1.36 w=0.42 l=0.15
X2761 a_61998_34319# a_46193_39759# uio_oe[0] uio_oe[0] sky130_fd_pr__nfet_01v8 ad=0.06405 pd=0.725 as=0.12495 ps=1.015 w=0.42 l=0.15
X2762 a_59939_41174# a_58980_40821# a_59867_41174# VDPWR sky130_fd_pr__pfet_01v8_hvt ad=0.1932 pd=1.34 as=0.0441 ps=0.63 w=0.42 l=0.15
X2763 a_27562_18464# a_24484_18782# ua[4] uio_oe[0] sky130_fd_pr__nfet_01v8 ad=0.1885 pd=1.88 as=0.1885 ps=1.88 w=0.65 l=0.15
X2764 ua[4] a_24484_10782# a_25746_10020# uio_oe[0] sky130_fd_pr__nfet_01v8 ad=0.1885 pd=1.88 as=0.1885 ps=1.88 w=0.65 l=0.15
X2765 a_18354_34639# a_17388_34505# uio_oe[0] uio_oe[0] sky130_fd_pr__nfet_01v8 ad=0.0693 pd=0.75 as=0.11285 ps=1.045 w=0.42 l=0.15
X2766 VDPWR a_59293_35161# a_59323_34902# VDPWR sky130_fd_pr__pfet_01v8_hvt ad=0.0693 pd=0.75 as=0.0441 ps=0.63 w=0.42 l=0.15
X2767 a_46193_42485# a_46027_42485# VDPWR VDPWR sky130_fd_pr__pfet_01v8_hvt ad=0.1664 pd=1.8 as=0.0864 ps=0.91 w=0.64 l=0.15
X2768 a_49686_39347# a_49964_39331# a_49920_39215# VDPWR sky130_fd_pr__pfet_01v8_hvt ad=0.0588 pd=0.7 as=0.0567 ps=0.69 w=0.42 l=0.15
X2769 uio_oe[0] a_51841_37337# a_51775_37405# uio_oe[0] sky130_fd_pr__nfet_01v8 ad=0.1449 pd=1.11 as=0.0693 ps=0.75 w=0.42 l=0.15
X2770 VDPWR a_22076_36681# a_21180_36967# VDPWR sky130_fd_pr__pfet_01v8_hvt ad=0.15835 pd=1.395 as=0.26 ps=2.52 w=1 l=0.15
X2771 a_51841_36249# a_48677_38127# uio_oe[0] uio_oe[0] sky130_fd_pr__nfet_01v8 ad=0.1092 pd=1.36 as=0.1449 ps=1.11 w=0.42 l=0.15
X2772 VDPWR a_36661_41391# a_52325_38998# VDPWR sky130_fd_pr__pfet_01v8_hvt ad=0.0693 pd=0.75 as=0.1176 ps=1.4 w=0.42 l=0.15
X2773 uio_oe[0] a_57519_36732# a_57450_36861# uio_oe[0] sky130_fd_pr__nfet_01v8 ad=0.1346 pd=1.15 as=0.0999 ps=0.985 w=0.64 l=0.15
X2774 a_19834_22464# a_16756_14782# ua[4] uio_oe[0] sky130_fd_pr__nfet_01v8 ad=0.1885 pd=1.88 as=0.1885 ps=1.88 w=0.65 l=0.15
X2775 VDPWR a_41751_34471# a_42499_34471# VDPWR sky130_fd_pr__pfet_01v8_hvt ad=0.1176 pd=1.4 as=0.0567 ps=0.69 w=0.42 l=0.15
X2776 VDPWR a_52855_42721# a_52816_42595# VDPWR sky130_fd_pr__pfet_01v8_hvt ad=0.0864 pd=0.91 as=0.1664 ps=1.8 w=0.64 l=0.15
X2777 a_60365_36495# a_59939_36822# uio_oe[0] uio_oe[0] sky130_fd_pr__nfet_01v8 ad=0.169 pd=1.82 as=0.11285 ps=1.045 w=0.65 l=0.15
X2778 VDPWR a_21401_35879# a_21431_36232# VDPWR sky130_fd_pr__pfet_01v8_hvt ad=0.0693 pd=0.75 as=0.0441 ps=0.63 w=0.42 l=0.15
X2779 a_40931_36495# a_40415_36495# a_40836_36495# uio_oe[0] sky130_fd_pr__special_nfet_01v8 ad=0.0594 pd=0.69 as=0.066 ps=0.745 w=0.36 l=0.15
X2780 a_38717_35435# a_37029_37583# uio_oe[0] uio_oe[0] sky130_fd_pr__nfet_01v8 ad=0.0567 pd=0.69 as=0.1118 ps=1.04 w=0.42 l=0.15
X2781 VDPWR a_40467_39189# a_37335_37557# VDPWR sky130_fd_pr__pfet_01v8_hvt ad=0.3012 pd=2.66 as=0.26 ps=2.52 w=1 l=0.15
X2782 a_53156_38127# a_52942_38127# VDPWR VDPWR sky130_fd_pr__pfet_01v8_hvt ad=0.1155 pd=0.97 as=0.07035 ps=0.755 w=0.42 l=0.15
X2783 a_27562_18464# ua[1] a_27316_18020# uio_oe[0] sky130_fd_pr__nfet_01v8 ad=0.2436 pd=2.26 as=0.2436 ps=2.26 w=0.84 l=0.6
X2784 VDPWR a_43437_35095# a_43014_34471# VDPWR sky130_fd_pr__pfet_01v8_hvt ad=0.14575 pd=1.335 as=0.34 ps=2.68 w=1 l=0.15
X2785 a_53321_36317# a_52942_35951# a_53249_36317# uio_oe[0] sky130_fd_pr__nfet_01v8 ad=0.1401 pd=1.1 as=0.0441 ps=0.63 w=0.42 l=0.15
X2786 VDPWR a_46193_39759# a_52335_35925# VDPWR sky130_fd_pr__pfet_01v8_hvt ad=0.0819 pd=0.81 as=0.0567 ps=0.69 w=0.42 l=0.15
X2787 a_37452_34293# a_38019_35773# VDPWR VDPWR sky130_fd_pr__pfet_01v8_hvt ad=0.26 pd=2.52 as=0.2279 ps=1.74 w=1 l=0.15
X2788 uio_oe[0] uio_oe[0] uio_oe[0] uio_oe[0] sky130_fd_pr__nfet_01v8 ad=0.1885 pd=1.88 as=0 ps=0 w=0.65 l=0.15
X2789 a_42513_39221# a_42347_39221# VDPWR VDPWR sky130_fd_pr__pfet_01v8_hvt ad=0.1664 pd=1.8 as=0.0864 ps=0.91 w=0.64 l=0.15
X2790 a_54627_39581# a_54479_39228# a_54264_39447# uio_oe[0] sky130_fd_pr__nfet_01v8 ad=0.0693 pd=0.75 as=0.09975 ps=0.895 w=0.42 l=0.15
X2791 a_59939_36822# a_51620_36469# a_59939_36495# uio_oe[0] sky130_fd_pr__nfet_01v8 ad=0.09975 pd=0.895 as=0.0693 ps=0.75 w=0.42 l=0.15
X2792 ua[4] a_24484_14782# a_27138_14020# uio_oe[0] sky130_fd_pr__nfet_01v8 ad=0.1885 pd=1.88 as=0.1885 ps=1.88 w=0.65 l=0.15
X2793 VDPWR a_37913_43023# a_53203_41935# VDPWR sky130_fd_pr__pfet_01v8_hvt ad=0.0864 pd=0.91 as=0.1664 ps=1.8 w=0.64 l=0.15
X2794 a_50397_39581# a_48125_43023# uio_oe[0] uio_oe[0] sky130_fd_pr__nfet_01v8 ad=0.0441 pd=0.63 as=0.1346 ps=1.15 w=0.42 l=0.15
X2795 a_58980_37557# a_61819_37557# uio_oe[0] uio_oe[0] sky130_fd_pr__nfet_01v8 ad=0.169 pd=1.82 as=0.2087 ps=2.02 w=0.65 l=0.15
X2796 a_19834_22464# a_4259_22596# a_19538_20730# uio_oe[0] sky130_fd_pr__nfet_01v8 ad=0.2436 pd=2.26 as=0.2436 ps=2.26 w=0.84 l=0.6
X2797 VDPWR a_58864_41623# a_58298_41621# VDPWR sky130_fd_pr__pfet_01v8_hvt ad=0.15835 pd=1.395 as=0.26 ps=2.52 w=1 l=0.15
X2798 a_58914_36822# a_48677_38127# VDPWR VDPWR sky130_fd_pr__pfet_01v8_hvt ad=0.07665 pd=0.785 as=0.15835 ps=1.395 w=0.42 l=0.15
X2799 a_44611_40681# a_44261_40309# a_44516_40669# VDPWR sky130_fd_pr__pfet_01v8_hvt ad=0.07245 pd=0.765 as=0.0651 ps=0.73 w=0.42 l=0.15
X2800 a_50159_40277# a_49964_40419# a_50469_40669# uio_oe[0] sky130_fd_pr__special_nfet_01v8 ad=0.0594 pd=0.69 as=0.1401 ps=1.1 w=0.36 l=0.15
X2801 a_50090_41391# a_50003_41633# a_49686_41523# VDPWR sky130_fd_pr__pfet_01v8_hvt ad=0.12915 pd=1.185 as=0.0588 ps=0.7 w=0.42 l=0.15
X2802 a_36721_37583# a_36455_37949# uio_oe[0] uio_oe[0] sky130_fd_pr__nfet_01v8 ad=0.169 pd=1.82 as=0.1013 ps=0.99 w=0.65 l=0.15
X2803 uio_oe[0] a_61819_34293# a_61753_34319# uio_oe[0] sky130_fd_pr__nfet_01v8 ad=0.12495 pd=1.015 as=0.0669 ps=0.75 w=0.42 l=0.15
X2804 VDPWR a_51841_37337# a_51871_37078# VDPWR sky130_fd_pr__pfet_01v8_hvt ad=0.0693 pd=0.75 as=0.0441 ps=0.63 w=0.42 l=0.15
X2805 VDPWR a_44905_38671# a_57664_38127# VDPWR sky130_fd_pr__pfet_01v8_hvt ad=0.07035 pd=0.755 as=0.1092 ps=1.36 w=0.42 l=0.15
X2806 uio_oe[0] a_29313_35659# a_29247_35727# uio_oe[0] sky130_fd_pr__nfet_01v8 ad=0.1449 pd=1.11 as=0.0693 ps=0.75 w=0.42 l=0.15
X2807 ua[5] a_24484_10782# a_25746_22020# uio_oe[0] sky130_fd_pr__nfet_01v8 ad=0.1885 pd=1.88 as=0.1885 ps=1.88 w=0.65 l=0.15
X2808 uio_oe[0] a_59695_38101# a_54479_38140# uio_oe[0] sky130_fd_pr__nfet_01v8 ad=0.2087 pd=2.02 as=0.169 ps=1.82 w=0.65 l=0.15
X2809 a_31426_14464# a_28348_14376# ua[4] uio_oe[0] sky130_fd_pr__nfet_01v8 ad=0.1885 pd=1.88 as=0.1885 ps=1.88 w=0.65 l=0.15
X2810 uio_oe[0] a_39947_42997# a_42941_42845# uio_oe[0] sky130_fd_pr__nfet_01v8 ad=0.1346 pd=1.15 as=0.0441 ps=0.63 w=0.42 l=0.15
X2811 a_58772_42087# a_58980_41909# a_58914_41935# uio_oe[0] sky130_fd_pr__nfet_01v8 ad=0.09975 pd=0.895 as=0.0693 ps=0.75 w=0.42 l=0.15
X2812 a_53719_35407# a_53369_35407# a_53624_35407# VDPWR sky130_fd_pr__pfet_01v8_hvt ad=0.07245 pd=0.765 as=0.0651 ps=0.73 w=0.42 l=0.15
X2813 a_57012_39189# a_57472_39493# a_57430_39581# uio_oe[0] sky130_fd_pr__nfet_01v8 ad=0.0693 pd=0.75 as=0.0441 ps=0.63 w=0.42 l=0.15
X2814 uio_oe[0] a_50003_38369# a_49964_38243# uio_oe[0] sky130_fd_pr__nfet_01v8 ad=0.0567 pd=0.69 as=0.1092 ps=1.36 w=0.42 l=0.15
X2815 a_50304_36861# a_50090_36861# VDPWR VDPWR sky130_fd_pr__pfet_01v8_hvt ad=0.1155 pd=0.97 as=0.07035 ps=0.755 w=0.42 l=0.15
X2816 a_37661_38140# a_38019_34685# uio_oe[0] uio_oe[0] sky130_fd_pr__nfet_01v8 ad=0.169 pd=1.82 as=0.1013 ps=0.99 w=0.65 l=0.15
X2817 a_40904_38127# a_40467_38101# VDPWR VDPWR sky130_fd_pr__pfet_01v8_hvt ad=0.0567 pd=0.69 as=0.0819 ps=0.81 w=0.42 l=0.15
X2818 a_61187_36861# a_46193_39759# VDPWR VDPWR sky130_fd_pr__pfet_01v8_hvt ad=0.1092 pd=1.36 as=0.07035 ps=0.755 w=0.42 l=0.15
X2819 ua[5] a_24484_10782# a_27138_26020# uio_oe[0] sky130_fd_pr__nfet_01v8 ad=0.1885 pd=1.88 as=0.1885 ps=1.88 w=0.65 l=0.15
X2820 a_31426_14464# ua[0] a_31180_14020# uio_oe[0] sky130_fd_pr__nfet_01v8 ad=0.2436 pd=2.26 as=0.2436 ps=2.26 w=0.84 l=0.6
X2821 VDPWR a_25449_34571# a_25479_34312# VDPWR sky130_fd_pr__pfet_01v8_hvt ad=0.0693 pd=0.75 as=0.0441 ps=0.63 w=0.42 l=0.15
X2822 a_53369_35407# a_53203_35407# uio_oe[0] uio_oe[0] sky130_fd_pr__nfet_01v8 ad=0.1092 pd=1.36 as=0.0567 ps=0.69 w=0.42 l=0.15
X2823 VDPWR a_58144_42453# a_58082_42479# VDPWR sky130_fd_pr__pfet_01v8_hvt ad=0.1092 pd=1.36 as=0.0651 ps=0.73 w=0.42 l=0.15
X2824 uio_oe[0] uio_in[2] a_37195_41391# uio_oe[0] sky130_fd_pr__nfet_01v8 ad=0.08775 pd=0.92 as=0.169 ps=1.82 w=0.65 l=0.15
X2825 a_46448_40669# a_46331_40474# uio_oe[0] uio_oe[0] sky130_fd_pr__nfet_01v8 ad=0.066 pd=0.745 as=0.2205 ps=1.89 w=0.42 l=0.15
X2826 a_50003_40545# a_38649_43023# uio_oe[0] uio_oe[0] sky130_fd_pr__nfet_01v8 ad=0.1092 pd=1.36 as=0.0567 ps=0.69 w=0.42 l=0.15
X2827 a_54284_40847# a_53369_40847# a_53937_41089# uio_oe[0] sky130_fd_pr__special_nfet_01v8 ad=0.0711 pd=0.755 as=0.0999 ps=0.985 w=0.36 l=0.15
X2828 uio_oe[0] a_53011_38101# a_52942_38127# uio_oe[0] sky130_fd_pr__nfet_01v8 ad=0.1346 pd=1.15 as=0.0999 ps=0.985 w=0.64 l=0.15
X2829 a_40551_35229# a_40403_34876# a_40188_35095# uio_oe[0] sky130_fd_pr__nfet_01v8 ad=0.0693 pd=0.75 as=0.09975 ps=0.895 w=0.42 l=0.15
X2830 a_60988_34863# a_60720_35229# VDPWR VDPWR sky130_fd_pr__pfet_01v8_hvt ad=0.0945 pd=0.87 as=0.0798 ps=0.8 w=0.42 l=0.15
X2831 VDPWR a_52335_37013# a_51620_37307# VDPWR sky130_fd_pr__pfet_01v8_hvt ad=0.3012 pd=2.66 as=0.26 ps=2.52 w=1 l=0.15
X2832 a_42679_43023# a_42329_43023# a_42584_43023# VDPWR sky130_fd_pr__pfet_01v8_hvt ad=0.07245 pd=0.765 as=0.0651 ps=0.73 w=0.42 l=0.15
X2833 a_42787_41391# a_39947_42997# VDPWR VDPWR sky130_fd_pr__pfet_01v8_hvt ad=0.1092 pd=1.36 as=0.07035 ps=0.755 w=0.42 l=0.15
X2834 uio_oe[0] a_38005_41391# a_40507_37583# uio_oe[0] sky130_fd_pr__nfet_01v8 ad=0.0567 pd=0.69 as=0.1092 ps=1.36 w=0.42 l=0.15
X2835 a_50090_37949# a_50003_37725# a_49686_37835# VDPWR sky130_fd_pr__pfet_01v8_hvt ad=0.12915 pd=1.185 as=0.0588 ps=0.7 w=0.42 l=0.15
X2836 a_57450_34685# a_57324_34587# a_57046_34571# uio_oe[0] sky130_fd_pr__special_nfet_01v8 ad=0.0999 pd=0.985 as=0.0711 ps=0.755 w=0.36 l=0.15
X2837 a_58044_41757# a_57776_41757# uio_oe[0] uio_oe[0] sky130_fd_pr__nfet_01v8 ad=0.06705 pd=0.75 as=0.0882 ps=0.84 w=0.42 l=0.15
X2838 a_45431_39733# a_45195_39215# uio_oe[0] uio_oe[0] sky130_fd_pr__nfet_01v8 ad=0.169 pd=1.82 as=0.1013 ps=0.99 w=0.65 l=0.15
X2839 a_39973_37557# a_37029_37583# uio_oe[0] uio_oe[0] sky130_fd_pr__nfet_01v8 ad=0.1092 pd=1.36 as=0.1449 ps=1.11 w=0.42 l=0.15
X2840 a_42571_37078# a_42389_37078# VDPWR VDPWR sky130_fd_pr__pfet_01v8_hvt ad=0.0441 pd=0.63 as=0.0693 ps=0.75 w=0.42 l=0.15
X2841 a_40577_36317# a_40099_35925# uio_oe[0] uio_oe[0] sky130_fd_pr__nfet_01v8 ad=0.0669 pd=0.75 as=0.12495 ps=1.015 w=0.42 l=0.15
X2842 uio_oe[0] a_50784_41365# a_50722_41391# uio_oe[0] sky130_fd_pr__nfet_01v8 ad=0.2205 pd=1.89 as=0.066 ps=0.745 w=0.42 l=0.15
X2843 a_24484_10376# a_25739_37021# VDPWR VDPWR sky130_fd_pr__pfet_01v8_hvt ad=0.475 pd=2.95 as=0.16655 ps=1.39 w=1 l=0.15
X2844 a_31426_26464# a_28348_10376# ua[5] uio_oe[0] sky130_fd_pr__nfet_01v8 ad=0.1885 pd=1.88 as=0.1885 ps=1.88 w=0.65 l=0.15
X2845 a_18354_33551# a_17388_33417# uio_oe[0] uio_oe[0] sky130_fd_pr__nfet_01v8 ad=0.0693 pd=0.75 as=0.11285 ps=1.045 w=0.42 l=0.15
X2846 VDPWR a_59201_41909# a_59231_42262# VDPWR sky130_fd_pr__pfet_01v8_hvt ad=0.0693 pd=0.75 as=0.0441 ps=0.63 w=0.42 l=0.15
X2847 VDPWR a_54264_38359# a_53636_38101# VDPWR sky130_fd_pr__pfet_01v8_hvt ad=0.15835 pd=1.395 as=0.26 ps=2.52 w=1 l=0.15
X2848 uio_oe[0] a_29804_36681# a_28908_36967# uio_oe[0] sky130_fd_pr__nfet_01v8 ad=0.11285 pd=1.045 as=0.169 ps=1.82 w=0.65 l=0.15
X2849 a_29603_35933# a_28651_35905# VDPWR VDPWR sky130_fd_pr__pfet_01v8_hvt ad=0.0567 pd=0.69 as=0.1176 ps=1.4 w=0.42 l=0.15
X2850 VDPWR a_22076_35593# a_21180_35879# VDPWR sky130_fd_pr__pfet_01v8_hvt ad=0.15835 pd=1.395 as=0.26 ps=2.52 w=1 l=0.15
X2851 VDPWR a_51841_41909# a_51871_42262# VDPWR sky130_fd_pr__pfet_01v8_hvt ad=0.0693 pd=0.75 as=0.0441 ps=0.63 w=0.42 l=0.15
X2852 a_52793_36822# a_51620_37307# a_52579_36822# VDPWR sky130_fd_pr__pfet_01v8_hvt ad=0.07665 pd=0.785 as=0.1932 ps=1.34 w=0.42 l=0.15
X2853 uio_oe[0] a_58144_36744# a_58082_36861# uio_oe[0] sky130_fd_pr__nfet_01v8 ad=0.2205 pd=1.89 as=0.066 ps=0.745 w=0.42 l=0.15
X2854 uio_oe[0] a_46193_39759# a_53981_34319# uio_oe[0] sky130_fd_pr__nfet_01v8 ad=0.1346 pd=1.15 as=0.0441 ps=0.63 w=0.42 l=0.15
X2855 uio_oe[0] a_37747_41935# a_37913_41935# uio_oe[0] sky130_fd_pr__nfet_01v8 ad=0.08775 pd=0.92 as=0.08775 ps=0.92 w=0.65 l=0.15
X2856 a_37361_41391# a_37195_41391# uio_oe[0] uio_oe[0] sky130_fd_pr__nfet_01v8 ad=0.08775 pd=0.92 as=0.08775 ps=0.92 w=0.65 l=0.15
X2857 a_60215_38369# a_37913_41935# VDPWR VDPWR sky130_fd_pr__pfet_01v8_hvt ad=0.1664 pd=1.8 as=0.0864 ps=0.91 w=0.64 l=0.15
X2858 a_50159_37013# a_50003_37281# a_50304_37039# VDPWR sky130_fd_pr__pfet_01v8_hvt ad=0.07245 pd=0.765 as=0.1155 ps=0.97 w=0.42 l=0.15
X2859 a_59867_35734# a_59685_35734# VDPWR VDPWR sky130_fd_pr__pfet_01v8_hvt ad=0.0441 pd=0.63 as=0.0693 ps=0.75 w=0.42 l=0.15
X2860 a_58772_36647# a_38740_36469# a_58914_36822# VDPWR sky130_fd_pr__pfet_01v8_hvt ad=0.1932 pd=1.34 as=0.07665 ps=0.785 w=0.42 l=0.15
X2861 VDPWR a_50159_34556# a_50090_34685# VDPWR sky130_fd_pr__pfet_01v8_hvt ad=0.2184 pd=2.2 as=0.12915 ps=1.185 w=0.84 l=0.15
X2862 a_39643_43023# a_39127_43023# a_39548_43023# uio_oe[0] sky130_fd_pr__special_nfet_01v8 ad=0.0594 pd=0.69 as=0.066 ps=0.745 w=0.36 l=0.15
X2863 uio_oe[0] a_48125_41935# a_61341_41935# uio_oe[0] sky130_fd_pr__nfet_01v8 ad=0.1346 pd=1.15 as=0.0441 ps=0.63 w=0.42 l=0.15
X2864 uio_oe[0] a_21156_36681# a_21107_36449# uio_oe[0] sky130_fd_pr__nfet_01v8 ad=0.11285 pd=1.045 as=0.169 ps=1.82 w=0.65 l=0.15
X2865 uio_oe[0] a_30233_35659# a_30167_35727# uio_oe[0] sky130_fd_pr__nfet_01v8 ad=0.1449 pd=1.11 as=0.0693 ps=0.75 w=0.42 l=0.15
X2866 a_42715_34863# a_42347_38127# uio_oe[0] uio_oe[0] sky130_fd_pr__nfet_01v8 ad=0.1092 pd=1.36 as=0.1092 ps=1.36 w=0.42 l=0.15
X2867 a_21431_35144# a_21180_34791# a_20972_34969# VDPWR sky130_fd_pr__pfet_01v8_hvt ad=0.0441 pd=0.63 as=0.1932 ps=1.34 w=0.42 l=0.15
X2868 uio_oe[0] clk a_38483_43023# uio_oe[0] sky130_fd_pr__nfet_01v8 ad=0.08775 pd=0.92 as=0.169 ps=1.82 w=0.65 l=0.15
X2869 a_59201_42777# a_48677_39759# VDPWR VDPWR sky130_fd_pr__pfet_01v8_hvt ad=0.1176 pd=1.4 as=0.0693 ps=0.75 w=0.42 l=0.15
X2870 a_41706_39215# a_40987_39457# a_41143_39189# uio_oe[0] sky130_fd_pr__special_nfet_01v8 ad=0.066 pd=0.745 as=0.0594 ps=0.69 w=0.36 l=0.15
X2871 a_17655_36815# a_17507_33198# a_17292_36681# uio_oe[0] sky130_fd_pr__nfet_01v8 ad=0.0693 pd=0.75 as=0.09975 ps=0.895 w=0.42 l=0.15
X2872 a_49721_35229# a_49686_34995# a_49483_34837# uio_oe[0] sky130_fd_pr__nfet_01v8 ad=0.06405 pd=0.725 as=0.1092 ps=1.36 w=0.42 l=0.15
X2873 uio_oe[0] a_17537_34791# a_17471_34817# uio_oe[0] sky130_fd_pr__nfet_01v8 ad=0.1449 pd=1.11 as=0.0693 ps=0.75 w=0.42 l=0.15
X2874 a_36764_39215# a_36327_39189# VDPWR VDPWR sky130_fd_pr__pfet_01v8_hvt ad=0.0567 pd=0.69 as=0.0819 ps=0.81 w=0.42 l=0.15
X2875 a_18011_37021# a_17059_36993# VDPWR VDPWR sky130_fd_pr__pfet_01v8_hvt ad=0.0567 pd=0.69 as=0.1176 ps=1.4 w=0.42 l=0.15
X2876 a_29689_37021# a_28651_36993# a_29603_37021# uio_oe[0] sky130_fd_pr__nfet_01v8 ad=0.0567 pd=0.69 as=0.1176 ps=1.4 w=0.42 l=0.15
X2877 uio_oe[0] a_54693_36249# a_54627_36317# uio_oe[0] sky130_fd_pr__nfet_01v8 ad=0.1449 pd=1.11 as=0.0693 ps=0.75 w=0.42 l=0.15
X2878 uio_oe[0] a_21345_32899# a_21377_32641# uio_oe[0] sky130_fd_pr__nfet_01v8 ad=0.1013 pd=0.99 as=0.0504 ps=0.66 w=0.42 l=0.15
X2879 uio_oe[0] a_37361_41391# a_52325_37910# uio_oe[0] sky130_fd_pr__nfet_01v8 ad=0.1449 pd=1.11 as=0.1092 ps=1.36 w=0.42 l=0.15
X2880 a_25199_33729# a_24971_33185# a_24836_33881# uio_oe[0] sky130_fd_pr__nfet_01v8 ad=0.0693 pd=0.75 as=0.09975 ps=0.895 w=0.42 l=0.15
X2881 a_46448_42845# a_46331_42650# VDPWR VDPWR sky130_fd_pr__pfet_01v8_hvt ad=0.0651 pd=0.73 as=0.1092 ps=1.36 w=0.42 l=0.15
X2882 VDPWR a_59695_42453# a_54479_42492# VDPWR sky130_fd_pr__pfet_01v8_hvt ad=0.3012 pd=2.66 as=0.26 ps=2.52 w=1 l=0.15
X2883 a_57363_37725# a_41685_42479# VDPWR VDPWR sky130_fd_pr__pfet_01v8_hvt ad=0.1664 pd=1.8 as=0.0864 ps=0.91 w=0.64 l=0.15
X2884 a_28348_10376# a_29603_37021# uio_oe[0] uio_oe[0] sky130_fd_pr__nfet_01v8 ad=0.182 pd=1.86 as=0.1118 ps=1.04 w=0.65 l=0.15
X2885 a_43327_36647# a_37851_36647# a_43501_36523# uio_oe[0] sky130_fd_pr__nfet_01v8 ad=0.1176 pd=1.4 as=0.0567 ps=0.69 w=0.42 l=0.15
X2886 uio_oe[0] a_17292_33417# a_17243_33185# uio_oe[0] sky130_fd_pr__nfet_01v8 ad=0.11285 pd=1.045 as=0.169 ps=1.82 w=0.65 l=0.15
X2887 VDPWR a_29129_34791# a_29159_35144# VDPWR sky130_fd_pr__pfet_01v8_hvt ad=0.0693 pd=0.75 as=0.0441 ps=0.63 w=0.42 l=0.15
X2888 a_41027_36495# a_40581_36495# a_40931_36495# uio_oe[0] sky130_fd_pr__special_nfet_01v8 ad=0.1401 pd=1.1 as=0.0594 ps=0.69 w=0.36 l=0.15
X2889 VDPWR a_50003_36193# a_49964_36067# VDPWR sky130_fd_pr__pfet_01v8_hvt ad=0.0864 pd=0.91 as=0.1664 ps=1.8 w=0.64 l=0.15
X2890 VDPWR a_44905_38671# a_56843_38101# VDPWR sky130_fd_pr__pfet_01v8_hvt ad=0.0819 pd=0.81 as=0.0567 ps=0.69 w=0.42 l=0.15
X2891 a_36425_35078# a_41671_36469# uio_oe[0] uio_oe[0] sky130_fd_pr__nfet_01v8 ad=0.169 pd=1.82 as=0.2087 ps=2.02 w=0.65 l=0.15
X2892 a_29946_33224# a_28980_33417# VDPWR VDPWR sky130_fd_pr__pfet_01v8_hvt ad=0.07665 pd=0.785 as=0.15835 ps=1.395 w=0.42 l=0.15
X2893 uio_oe[0] a_40639_42087# a_40469_41909# uio_oe[0] sky130_fd_pr__nfet_01v8 ad=0.1575 pd=1.17 as=0.0567 ps=0.69 w=0.42 l=0.15
X2894 a_25295_37320# a_25044_36967# a_24836_37145# VDPWR sky130_fd_pr__pfet_01v8_hvt ad=0.0441 pd=0.63 as=0.1932 ps=1.34 w=0.42 l=0.15
X2895 uio_oe[0] a_37851_36647# a_37310_34471# uio_oe[0] sky130_fd_pr__nfet_01v8 ad=0.169 pd=1.82 as=0.08775 ps=0.92 w=0.65 l=0.15
X2896 a_38649_43023# a_38483_43023# uio_oe[0] uio_oe[0] sky130_fd_pr__nfet_01v8 ad=0.08775 pd=0.92 as=0.08775 ps=0.92 w=0.65 l=0.15
X2897 uio_oe[0] a_41059_41935# a_41706_39215# uio_oe[0] sky130_fd_pr__nfet_01v8 ad=0.2205 pd=1.89 as=0.066 ps=0.745 w=0.42 l=0.15
X2898 a_42768_39581# a_42651_39386# VDPWR VDPWR sky130_fd_pr__pfet_01v8_hvt ad=0.0651 pd=0.73 as=0.1092 ps=1.36 w=0.42 l=0.15
X2899 a_52813_38493# a_52335_38101# uio_oe[0] uio_oe[0] sky130_fd_pr__nfet_01v8 ad=0.0669 pd=0.75 as=0.12495 ps=1.015 w=0.42 l=0.15
X2900 a_44719_43389# a_40379_35551# VDPWR VDPWR sky130_fd_pr__pfet_01v8_hvt ad=0.1092 pd=1.36 as=0.07035 ps=0.755 w=0.42 l=0.15
X2901 a_21298_33224# a_21252_33417# VDPWR VDPWR sky130_fd_pr__pfet_01v8_hvt ad=0.07665 pd=0.785 as=0.15835 ps=1.395 w=0.42 l=0.15
X2902 a_61819_35381# a_61644_35407# a_61998_35407# uio_oe[0] sky130_fd_pr__nfet_01v8 ad=0.1092 pd=1.36 as=0.06405 ps=0.725 w=0.42 l=0.15
X2903 a_50397_39759# a_48125_43023# uio_oe[0] uio_oe[0] sky130_fd_pr__nfet_01v8 ad=0.0441 pd=0.63 as=0.1346 ps=1.15 w=0.42 l=0.15
X2904 a_60729_37583# a_60563_37583# VDPWR VDPWR sky130_fd_pr__pfet_01v8_hvt ad=0.1664 pd=1.8 as=0.0864 ps=0.91 w=0.64 l=0.15
X2905 a_49483_37013# a_49686_37171# VDPWR VDPWR sky130_fd_pr__pfet_01v8_hvt ad=0.0567 pd=0.69 as=0.1134 ps=1.38 w=0.42 l=0.15
X2906 a_56916_37271# a_57012_37013# uio_oe[0] uio_oe[0] sky130_fd_pr__nfet_01v8 ad=0.1092 pd=1.36 as=0.097 ps=0.975 w=0.42 l=0.15
X2907 a_42696_37557# a_47283_42783# uio_oe[0] uio_oe[0] sky130_fd_pr__nfet_01v8 ad=0.169 pd=1.82 as=0.2087 ps=2.02 w=0.65 l=0.15
X2908 a_42941_41757# a_42897_41365# a_42775_41769# uio_oe[0] sky130_fd_pr__nfet_01v8 ad=0.0441 pd=0.63 as=0.1401 ps=1.1 w=0.42 l=0.15
X2909 a_57321_39759# a_56843_39733# uio_oe[0] uio_oe[0] sky130_fd_pr__nfet_01v8 ad=0.0669 pd=0.75 as=0.12495 ps=1.015 w=0.42 l=0.15
X2910 a_18354_34312# a_17388_34505# VDPWR VDPWR sky130_fd_pr__pfet_01v8_hvt ad=0.07665 pd=0.785 as=0.15835 ps=1.395 w=0.42 l=0.15
X2911 VDPWR a_60416_35141# a_60500_34837# VDPWR sky130_fd_pr__pfet_01v8_hvt ad=0.0864 pd=0.91 as=0.1664 ps=1.8 w=0.64 l=0.15
X2912 uio_oe[0] a_39544_37271# a_24932_34969# uio_oe[0] sky130_fd_pr__nfet_01v8 ad=0.11285 pd=1.045 as=0.169 ps=1.82 w=0.65 l=0.15
X2913 a_21377_32641# a_21107_33007# a_21287_33007# uio_oe[0] sky130_fd_pr__nfet_01v8 ad=0.0504 pd=0.66 as=0.1092 ps=1.36 w=0.42 l=0.15
X2914 uio_oe[0] rst_n a_47959_41935# uio_oe[0] sky130_fd_pr__nfet_01v8 ad=0.08775 pd=0.92 as=0.169 ps=1.82 w=0.65 l=0.15
X2915 a_36917_38921# a_36875_38823# a_36835_38921# VDPWR sky130_fd_pr__pfet_01v8_hvt ad=0.135 pd=1.27 as=0.26 ps=2.52 w=1 l=0.15
X2916 uio_oe[0] a_53011_37013# a_52942_37039# uio_oe[0] sky130_fd_pr__nfet_01v8 ad=0.1346 pd=1.15 as=0.0999 ps=0.985 w=0.64 l=0.15
X2917 VDPWR a_29281_32641# a_30303_34095# VDPWR sky130_fd_pr__pfet_01v8_hvt ad=0.2279 pd=1.74 as=0.0609 ps=0.71 w=0.42 l=0.15
X2918 a_44873_42845# a_44829_42453# a_44707_42857# uio_oe[0] sky130_fd_pr__nfet_01v8 ad=0.0441 pd=0.63 as=0.1401 ps=1.1 w=0.42 l=0.15
X2919 uio_oe[0] a_41108_35095# a_41059_34863# uio_oe[0] sky130_fd_pr__nfet_01v8 ad=0.11285 pd=1.045 as=0.169 ps=1.82 w=0.65 l=0.15
X2920 a_40003_36822# a_39752_36469# a_39544_36647# VDPWR sky130_fd_pr__pfet_01v8_hvt ad=0.0441 pd=0.63 as=0.1932 ps=1.34 w=0.42 l=0.15
X2921 VDPWR a_37361_41391# a_52793_36822# VDPWR sky130_fd_pr__pfet_01v8_hvt ad=0.15835 pd=1.395 as=0.07665 ps=0.785 w=0.42 l=0.15
X2922 a_26170_10464# a_24484_10376# ua[4] uio_oe[0] sky130_fd_pr__nfet_01v8 ad=0.1885 pd=1.88 as=0.1885 ps=1.88 w=0.65 l=0.15
X2923 a_60934_38127# a_60176_38243# a_60371_38101# VDPWR sky130_fd_pr__pfet_01v8_hvt ad=0.0651 pd=0.73 as=0.07245 ps=0.765 w=0.42 l=0.15
X2924 a_49686_37835# a_50003_37725# a_49961_37583# uio_oe[0] sky130_fd_pr__special_nfet_01v8 ad=0.0711 pd=0.755 as=0.0669 ps=0.75 w=0.36 l=0.15
X2925 a_28348_14782# a_30303_36271# VDPWR VDPWR sky130_fd_pr__pfet_01v8_hvt ad=0.26 pd=2.52 as=0.2279 ps=1.74 w=1 l=0.15
X2926 a_36327_35925# a_36425_36166# VDPWR VDPWR sky130_fd_pr__pfet_01v8_hvt ad=0.0609 pd=0.71 as=0.2279 ps=1.74 w=0.42 l=0.15
X2927 a_45351_42997# a_45176_43023# a_45530_43023# uio_oe[0] sky130_fd_pr__nfet_01v8 ad=0.1092 pd=1.36 as=0.06405 ps=0.725 w=0.42 l=0.15
X2928 VDPWR a_50784_38920# a_50722_39037# VDPWR sky130_fd_pr__pfet_01v8_hvt ad=0.1092 pd=1.36 as=0.0651 ps=0.73 w=0.42 l=0.15
X2929 a_50090_36861# a_50003_36637# a_49686_36747# VDPWR sky130_fd_pr__pfet_01v8_hvt ad=0.12915 pd=1.185 as=0.0588 ps=0.7 w=0.42 l=0.15
X2930 a_52942_39215# a_52816_39331# a_52538_39347# uio_oe[0] sky130_fd_pr__special_nfet_01v8 ad=0.0999 pd=0.985 as=0.0711 ps=0.755 w=0.36 l=0.15
X2931 a_38895_36495# a_37851_36647# a_38532_36647# uio_oe[0] sky130_fd_pr__nfet_01v8 ad=0.0693 pd=0.75 as=0.09975 ps=0.895 w=0.42 l=0.15
X2932 a_43437_35095# a_37169_38671# uio_oe[0] uio_oe[0] sky130_fd_pr__nfet_01v8 ad=0.0567 pd=0.69 as=0.10025 ps=0.985 w=0.42 l=0.15
X2933 a_21401_34791# a_21068_34969# uio_oe[0] uio_oe[0] sky130_fd_pr__nfet_01v8 ad=0.1092 pd=1.36 as=0.1449 ps=1.11 w=0.42 l=0.15
X2934 uio_oe[0] a_42685_36611# a_42907_35951# uio_oe[0] sky130_fd_pr__nfet_01v8 ad=0.08775 pd=0.92 as=0.08775 ps=0.92 w=0.65 l=0.15
X2935 uio_oe[0] a_29804_35593# a_28908_35879# uio_oe[0] sky130_fd_pr__nfet_01v8 ad=0.11285 pd=1.045 as=0.169 ps=1.82 w=0.65 l=0.15
X2936 VDPWR a_45176_40681# a_45351_40607# VDPWR sky130_fd_pr__pfet_01v8_hvt ad=0.1134 pd=1.38 as=0.0567 ps=0.69 w=0.42 l=0.15
X2937 VDPWR a_40379_35551# a_40467_39189# VDPWR sky130_fd_pr__pfet_01v8_hvt ad=0.0819 pd=0.81 as=0.0567 ps=0.69 w=0.42 l=0.15
X2938 uio_oe[0] a_51412_37271# a_50784_37013# uio_oe[0] sky130_fd_pr__nfet_01v8 ad=0.11285 pd=1.045 as=0.169 ps=1.82 w=0.65 l=0.15
X2939 a_26170_10464# ua[1] a_25924_10020# uio_oe[0] sky130_fd_pr__nfet_01v8 ad=0.2436 pd=2.26 as=0.2436 ps=2.26 w=0.84 l=0.6
X2940 a_29603_34845# a_28651_34817# VDPWR VDPWR sky130_fd_pr__pfet_01v8_hvt ad=0.0567 pd=0.69 as=0.1176 ps=1.4 w=0.42 l=0.15
X2941 a_46543_40847# a_46193_40847# a_46448_40847# VDPWR sky130_fd_pr__pfet_01v8_hvt ad=0.07245 pd=0.765 as=0.0651 ps=0.73 w=0.42 l=0.15
X2942 uio_oe[0] a_46193_39759# a_52573_38493# uio_oe[0] sky130_fd_pr__nfet_01v8 ad=0.12495 pd=1.015 as=0.06405 ps=0.725 w=0.42 l=0.15
X2943 a_45893_39553# a_36447_40849# uio_oe[0] uio_oe[0] sky130_fd_pr__nfet_01v8 ad=0.0567 pd=0.69 as=0.1118 ps=1.04 w=0.42 l=0.15
X2944 uio_oe[0] a_38532_36647# a_25116_33417# uio_oe[0] sky130_fd_pr__nfet_01v8 ad=0.11285 pd=1.045 as=0.169 ps=1.82 w=0.65 l=0.15
X2945 uio_oe[0] a_16812_8642# a_24482_16730# uio_oe[0] sky130_fd_pr__nfet_01v8 ad=1.4703 pd=10.72 as=1.4703 ps=10.72 w=5.07 l=1
X2946 a_48125_41935# a_47959_41935# uio_oe[0] uio_oe[0] sky130_fd_pr__nfet_01v8 ad=0.08775 pd=0.92 as=0.08775 ps=0.92 w=0.65 l=0.15
X2947 a_59231_41174# a_58980_40821# a_58772_40999# VDPWR sky130_fd_pr__pfet_01v8_hvt ad=0.0441 pd=0.63 as=0.1932 ps=1.34 w=0.42 l=0.15
X2948 a_43275_37039# a_37661_37052# uio_oe[0] uio_oe[0] sky130_fd_pr__nfet_01v8 ad=0.08775 pd=0.92 as=0.169 ps=1.82 w=0.65 l=0.15
X2949 uio_oe[0] a_48125_43023# a_57081_39759# uio_oe[0] sky130_fd_pr__nfet_01v8 ad=0.12495 pd=1.015 as=0.06405 ps=0.725 w=0.42 l=0.15
X2950 a_51871_36822# a_51620_36469# a_51412_36647# VDPWR sky130_fd_pr__pfet_01v8_hvt ad=0.0441 pd=0.63 as=0.1932 ps=1.34 w=0.42 l=0.15
X2951 a_42487_35990# a_42236_36219# a_42028_36183# VDPWR sky130_fd_pr__pfet_01v8_hvt ad=0.0441 pd=0.63 as=0.1932 ps=1.34 w=0.42 l=0.15
X2952 a_29343_35400# a_17500_33453# a_28884_35593# VDPWR sky130_fd_pr__pfet_01v8_hvt ad=0.0441 pd=0.63 as=0.1932 ps=1.34 w=0.42 l=0.15
X2953 a_51841_35381# a_48677_38127# VDPWR VDPWR sky130_fd_pr__pfet_01v8_hvt ad=0.1176 pd=1.4 as=0.0693 ps=0.75 w=0.42 l=0.15
X2954 uio_oe[0] a_16812_8642# a_16754_20730# uio_oe[0] sky130_fd_pr__nfet_01v8 ad=1.4703 pd=10.72 as=1.4703 ps=10.72 w=5.07 l=1
X2955 uio_oe[0] a_21156_35593# a_21107_35361# uio_oe[0] sky130_fd_pr__nfet_01v8 ad=0.11285 pd=1.045 as=0.169 ps=1.82 w=0.65 l=0.15
X2956 a_25940_35593# a_18420_33453# a_26082_35727# uio_oe[0] sky130_fd_pr__nfet_01v8 ad=0.09975 pd=0.895 as=0.0693 ps=0.75 w=0.42 l=0.15
X2957 a_24778_10464# a_24484_10782# ua[5] uio_oe[0] sky130_fd_pr__nfet_01v8 ad=0.1885 pd=1.88 as=0.1885 ps=1.88 w=0.65 l=0.15
X2958 uio_oe[0] a_29281_32641# a_30393_36993# uio_oe[0] sky130_fd_pr__nfet_01v8 ad=0.1013 pd=0.99 as=0.0504 ps=0.66 w=0.42 l=0.15
X2959 uio_oe[0] a_36999_38101# a_37029_38127# uio_oe[0] sky130_fd_pr__nfet_01v8 ad=0.08775 pd=0.92 as=0.08775 ps=0.92 w=0.65 l=0.15
X2960 VDPWR a_58144_37832# a_58082_37949# VDPWR sky130_fd_pr__pfet_01v8_hvt ad=0.1092 pd=1.36 as=0.0651 ps=0.73 w=0.42 l=0.15
X2961 a_61079_34319# a_60563_34319# a_60984_34319# uio_oe[0] sky130_fd_pr__special_nfet_01v8 ad=0.0594 pd=0.69 as=0.066 ps=0.745 w=0.36 l=0.15
X2962 a_61341_40847# a_61297_41089# a_61175_40847# uio_oe[0] sky130_fd_pr__nfet_01v8 ad=0.0441 pd=0.63 as=0.1401 ps=1.1 w=0.42 l=0.15
X2963 a_26170_22464# a_24484_10376# ua[5] uio_oe[0] sky130_fd_pr__nfet_01v8 ad=0.1885 pd=1.88 as=0.1885 ps=1.88 w=0.65 l=0.15
X2964 a_18575_34639# a_18427_33198# a_18212_34505# uio_oe[0] sky130_fd_pr__nfet_01v8 ad=0.0693 pd=0.75 as=0.09975 ps=0.895 w=0.42 l=0.15
X2965 a_46448_41757# a_46331_41562# VDPWR VDPWR sky130_fd_pr__pfet_01v8_hvt ad=0.0651 pd=0.73 as=0.1092 ps=1.36 w=0.42 l=0.15
X2966 a_60132_35951# a_59695_35925# VDPWR VDPWR sky130_fd_pr__pfet_01v8_hvt ad=0.0567 pd=0.69 as=0.0819 ps=0.81 w=0.42 l=0.15
X2967 VDPWR a_61808_39447# a_61242_39445# VDPWR sky130_fd_pr__pfet_01v8_hvt ad=0.15835 pd=1.395 as=0.26 ps=2.52 w=1 l=0.15
X2968 a_40864_38671# a_40415_38671# a_40769_38671# uio_oe[0] sky130_fd_pr__special_nfet_01v8 ad=0.072 pd=0.76 as=0.0935 ps=0.965 w=0.36 l=0.15
X2969 VDPWR a_56843_36469# a_38740_36469# VDPWR sky130_fd_pr__pfet_01v8_hvt ad=0.3012 pd=2.66 as=0.26 ps=2.52 w=1 l=0.15
X2970 uio_oe[0] a_16812_8642# a_18146_24730# uio_oe[0] sky130_fd_pr__nfet_01v8 ad=1.4703 pd=10.72 as=1.4703 ps=10.72 w=5.07 l=1
X2971 a_51841_35381# a_48677_38127# uio_oe[0] uio_oe[0] sky130_fd_pr__nfet_01v8 ad=0.1092 pd=1.36 as=0.1449 ps=1.11 w=0.42 l=0.15
X2972 a_36956_35095# a_40383_42997# VDPWR VDPWR sky130_fd_pr__pfet_01v8_hvt ad=0.26 pd=2.52 as=0.3012 ps=2.66 w=1 l=0.15
X2973 uio_oe[0] a_59860_39447# a_54479_39228# uio_oe[0] sky130_fd_pr__nfet_01v8 ad=0.097 pd=0.975 as=0.169 ps=1.82 w=0.65 l=0.15
X2974 a_38674_37910# a_37029_37583# VDPWR VDPWR sky130_fd_pr__pfet_01v8_hvt ad=0.07665 pd=0.785 as=0.15835 ps=1.395 w=0.42 l=0.15
X2975 a_43609_37359# a_37661_37052# a_43525_37359# uio_oe[0] sky130_fd_pr__nfet_01v8 ad=0.25025 pd=1.42 as=0.08775 ps=0.92 w=0.65 l=0.15
X2976 a_18212_34505# a_18427_33198# a_18354_34312# VDPWR sky130_fd_pr__pfet_01v8_hvt ad=0.1932 pd=1.34 as=0.07665 ps=0.785 w=0.42 l=0.15
X2977 uio_oe[0] a_58772_42711# a_58144_42453# uio_oe[0] sky130_fd_pr__nfet_01v8 ad=0.11285 pd=1.045 as=0.169 ps=1.82 w=0.65 l=0.15
X2978 VDPWR a_58772_37735# a_58144_37832# VDPWR sky130_fd_pr__pfet_01v8_hvt ad=0.15835 pd=1.395 as=0.26 ps=2.52 w=1 l=0.15
X2979 uio_oe[0] a_37361_41391# a_60160_36495# uio_oe[0] sky130_fd_pr__nfet_01v8 ad=0.11285 pd=1.045 as=0.0693 ps=0.75 w=0.42 l=0.15
X2980 VDPWR a_38961_38425# a_38991_38166# VDPWR sky130_fd_pr__pfet_01v8_hvt ad=0.0693 pd=0.75 as=0.0441 ps=0.63 w=0.42 l=0.15
X2981 uio_oe[0] a_42399_38101# a_42347_38127# uio_oe[0] sky130_fd_pr__nfet_01v8 ad=0.2087 pd=2.02 as=0.169 ps=1.82 w=0.65 l=0.15
X2982 a_61753_39759# a_60563_39759# a_61644_39759# uio_oe[0] sky130_fd_pr__special_nfet_01v8 ad=0.0669 pd=0.75 as=0.0711 ps=0.755 w=0.36 l=0.15
X2983 a_50397_38671# a_48125_43023# uio_oe[0] uio_oe[0] sky130_fd_pr__nfet_01v8 ad=0.0441 pd=0.63 as=0.1346 ps=1.15 w=0.42 l=0.15
X2984 a_29129_34791# a_28796_34969# VDPWR VDPWR sky130_fd_pr__pfet_01v8_hvt ad=0.1176 pd=1.4 as=0.0693 ps=0.75 w=0.42 l=0.15
X2985 a_38961_42777# a_38005_40847# uio_oe[0] uio_oe[0] sky130_fd_pr__nfet_01v8 ad=0.1092 pd=1.36 as=0.1449 ps=1.11 w=0.42 l=0.15
X2986 a_60984_40847# a_60365_40847# VDPWR VDPWR sky130_fd_pr__pfet_01v8_hvt ad=0.0651 pd=0.73 as=0.1092 ps=1.36 w=0.42 l=0.15
X2987 a_57321_38671# a_56843_38645# uio_oe[0] uio_oe[0] sky130_fd_pr__nfet_01v8 ad=0.0669 pd=0.75 as=0.12495 ps=1.015 w=0.42 l=0.15
X2988 VDPWR a_62053_36249# a_62083_35990# VDPWR sky130_fd_pr__pfet_01v8_hvt ad=0.0693 pd=0.75 as=0.0441 ps=0.63 w=0.42 l=0.15
X2989 VDPWR a_48125_43023# a_49483_39733# VDPWR sky130_fd_pr__pfet_01v8_hvt ad=0.0819 pd=0.81 as=0.0567 ps=0.69 w=0.42 l=0.15
X2990 a_60365_38671# a_59939_38998# VDPWR VDPWR sky130_fd_pr__pfet_01v8_hvt ad=0.26 pd=2.52 as=0.15835 ps=1.395 w=1 l=0.15
X2991 a_30393_36993# a_30123_37359# a_30303_37359# uio_oe[0] sky130_fd_pr__nfet_01v8 ad=0.0504 pd=0.66 as=0.1092 ps=1.36 w=0.42 l=0.15
X2992 VDPWR a_46193_39759# a_52335_37013# VDPWR sky130_fd_pr__pfet_01v8_hvt ad=0.0819 pd=0.81 as=0.0567 ps=0.69 w=0.42 l=0.15
X2993 a_24482_20730# ua[1] a_24354_22020# uio_oe[0] sky130_fd_pr__nfet_01v8 ad=0.2436 pd=2.26 as=0.2436 ps=2.26 w=0.84 l=0.6
X2994 a_56843_38645# a_57046_38923# VDPWR VDPWR sky130_fd_pr__pfet_01v8_hvt ad=0.0567 pd=0.69 as=0.1134 ps=1.38 w=0.42 l=0.15
X2995 VDPWR a_43161_34863# a_44126_37155# VDPWR sky130_fd_pr__pfet_01v8_hvt ad=0.14575 pd=1.335 as=0.0441 ps=0.63 w=0.42 l=0.15
X2996 a_37085_35951# a_36919_35951# uio_oe[0] uio_oe[0] sky130_fd_pr__nfet_01v8 ad=0.08775 pd=0.92 as=0.08775 ps=0.92 w=0.65 l=0.15
X2997 a_42329_40309# a_42163_40309# uio_oe[0] uio_oe[0] sky130_fd_pr__nfet_01v8 ad=0.1092 pd=1.36 as=0.0567 ps=0.69 w=0.42 l=0.15
X2998 a_57640_35177# a_57472_35141# a_58044_34863# VDPWR sky130_fd_pr__pfet_01v8_hvt ad=0.0567 pd=0.69 as=0.0945 ps=0.87 w=0.42 l=0.15
X2999 a_38077_34837# a_38019_35951# VDPWR VDPWR sky130_fd_pr__pfet_01v8_hvt ad=0.26 pd=2.52 as=0.2279 ps=1.74 w=1 l=0.15
X3000 uio_oe[0] a_56843_35381# a_38771_35409# uio_oe[0] sky130_fd_pr__nfet_01v8 ad=0.2087 pd=2.02 as=0.169 ps=1.82 w=0.65 l=0.15
X3001 a_53011_40277# a_52855_40545# a_53156_40303# VDPWR sky130_fd_pr__pfet_01v8_hvt ad=0.07245 pd=0.765 as=0.1155 ps=0.97 w=0.42 l=0.15
X3002 a_30263_35400# a_18420_33453# a_29804_35593# VDPWR sky130_fd_pr__pfet_01v8_hvt ad=0.0441 pd=0.63 as=0.1932 ps=1.34 w=0.42 l=0.15
X3003 a_58082_42301# a_57363_42077# a_57519_42172# uio_oe[0] sky130_fd_pr__special_nfet_01v8 ad=0.066 pd=0.745 as=0.0594 ps=0.69 w=0.36 l=0.15
X3004 a_59201_40821# a_48677_39759# uio_oe[0] uio_oe[0] sky130_fd_pr__nfet_01v8 ad=0.1092 pd=1.36 as=0.1449 ps=1.11 w=0.42 l=0.15
X3005 a_42613_36724# a_43603_39733# uio_oe[0] uio_oe[0] sky130_fd_pr__nfet_01v8 ad=0.169 pd=1.82 as=0.2087 ps=2.02 w=0.65 l=0.15
X3006 uio_oe[0] a_16812_8642# a_22010_20730# uio_oe[0] sky130_fd_pr__nfet_01v8 ad=1.4703 pd=10.72 as=1.4703 ps=10.72 w=5.07 l=1
X3007 a_27562_14464# a_24484_14782# ua[5] uio_oe[0] sky130_fd_pr__nfet_01v8 ad=0.1885 pd=1.88 as=0.1885 ps=1.88 w=0.65 l=0.15
X3008 VDPWR a_45351_42997# a_45338_43389# VDPWR sky130_fd_pr__pfet_01v8_hvt ad=0.0819 pd=0.81 as=0.0567 ps=0.69 w=0.42 l=0.15
X3009 uio_oe[0] a_39947_42997# a_42941_41935# uio_oe[0] sky130_fd_pr__nfet_01v8 ad=0.1346 pd=1.15 as=0.0441 ps=0.63 w=0.42 l=0.15
X3010 a_50722_42301# a_50003_42077# a_50159_42172# uio_oe[0] sky130_fd_pr__special_nfet_01v8 ad=0.066 pd=0.745 as=0.0594 ps=0.69 w=0.36 l=0.15
X3011 a_44611_41769# a_44095_41397# a_44516_41757# uio_oe[0] sky130_fd_pr__special_nfet_01v8 ad=0.0594 pd=0.69 as=0.066 ps=0.745 w=0.36 l=0.15
X3012 VDPWR a_39973_40821# a_40003_41174# VDPWR sky130_fd_pr__pfet_01v8_hvt ad=0.0693 pd=0.75 as=0.0441 ps=0.63 w=0.42 l=0.15
X3013 a_61624_42711# a_54479_42492# a_61766_42845# uio_oe[0] sky130_fd_pr__nfet_01v8 ad=0.09975 pd=0.895 as=0.0693 ps=0.75 w=0.42 l=0.15
X3014 uio_oe[0] a_41768_40008# a_41706_40125# uio_oe[0] sky130_fd_pr__nfet_01v8 ad=0.2205 pd=1.89 as=0.066 ps=0.745 w=0.42 l=0.15
X3015 VDPWR a_40617_35161# a_40647_34902# VDPWR sky130_fd_pr__pfet_01v8_hvt ad=0.0693 pd=0.75 as=0.0441 ps=0.63 w=0.42 l=0.15
X3016 a_47108_40847# a_46027_40847# a_46761_41089# VDPWR sky130_fd_pr__pfet_01v8_hvt ad=0.0588 pd=0.7 as=0.12915 ps=1.185 w=0.42 l=0.15
X3017 a_36607_39455# a_37183_40277# uio_oe[0] uio_oe[0] sky130_fd_pr__nfet_01v8 ad=0.08775 pd=0.92 as=0.169 ps=1.82 w=0.65 l=0.15
X3018 a_46289_39447# a_44621_38447# uio_oe[0] uio_oe[0] sky130_fd_pr__nfet_01v8 ad=0.0567 pd=0.69 as=0.10025 ps=0.985 w=0.42 l=0.15
X3019 a_42953_34837# a_44511_38645# a_44469_38921# VDPWR sky130_fd_pr__pfet_01v8_hvt ad=0.26 pd=2.52 as=0.105 ps=1.21 w=1 l=0.15
X3020 uio_oe[0] a_50003_37725# a_49964_37851# uio_oe[0] sky130_fd_pr__nfet_01v8 ad=0.0567 pd=0.69 as=0.1092 ps=1.36 w=0.42 l=0.15
X3021 uio_oe[0] a_53636_37013# a_53574_37039# uio_oe[0] sky130_fd_pr__nfet_01v8 ad=0.2205 pd=1.89 as=0.066 ps=0.745 w=0.42 l=0.15
X3022 uio_oe[0] a_51412_36183# a_50784_35925# uio_oe[0] sky130_fd_pr__nfet_01v8 ad=0.11285 pd=1.045 as=0.169 ps=1.82 w=0.65 l=0.15
X3023 a_50304_35951# a_50090_35951# VDPWR VDPWR sky130_fd_pr__pfet_01v8_hvt ad=0.1155 pd=0.97 as=0.07035 ps=0.755 w=0.42 l=0.15
X3024 a_50469_39581# a_50090_39215# a_50397_39581# uio_oe[0] sky130_fd_pr__nfet_01v8 ad=0.1401 pd=1.1 as=0.0441 ps=0.63 w=0.42 l=0.15
X3025 a_49961_36495# a_49483_36469# uio_oe[0] uio_oe[0] sky130_fd_pr__nfet_01v8 ad=0.0669 pd=0.75 as=0.12495 ps=1.015 w=0.42 l=0.15
X3026 a_61079_37583# a_60729_37583# a_60984_37583# VDPWR sky130_fd_pr__pfet_01v8_hvt ad=0.07245 pd=0.765 as=0.0651 ps=0.73 w=0.42 l=0.15
X3027 VDPWR a_36999_42453# a_37029_42479# VDPWR sky130_fd_pr__pfet_01v8_hvt ad=0.135 pd=1.27 as=0.135 ps=1.27 w=1 l=0.15
X3028 a_53624_41935# a_53005_41935# uio_oe[0] uio_oe[0] sky130_fd_pr__nfet_01v8 ad=0.066 pd=0.745 as=0.2205 ps=1.89 w=0.42 l=0.15
X3029 uio_oe[0] a_41420_39037# a_41990_38671# uio_oe[0] sky130_fd_pr__nfet_01v8 ad=0.097 pd=0.975 as=0.1092 ps=1.36 w=0.42 l=0.15
X3030 VDPWR a_58298_35093# a_58248_34863# VDPWR sky130_fd_pr__pfet_01v8_hvt ad=0.2184 pd=2.2 as=0.12495 ps=1.175 w=0.84 l=0.15
X3031 a_46543_41935# a_46027_41935# a_46448_41935# uio_oe[0] sky130_fd_pr__special_nfet_01v8 ad=0.0594 pd=0.69 as=0.066 ps=0.745 w=0.36 l=0.15
X3032 uio_oe[0] a_48125_43023# a_57081_38671# uio_oe[0] sky130_fd_pr__nfet_01v8 ad=0.12495 pd=1.015 as=0.06405 ps=0.725 w=0.42 l=0.15
X3033 ua[5] a_24484_10376# a_27138_10020# uio_oe[0] sky130_fd_pr__nfet_01v8 ad=0.1885 pd=1.88 as=0.1885 ps=1.88 w=0.65 l=0.15
X3034 uio_oe[0] clk a_37839_41391# uio_oe[0] sky130_fd_pr__nfet_01v8 ad=0.08775 pd=0.92 as=0.169 ps=1.82 w=0.65 l=0.15
X3035 a_38089_40623# a_37795_40535# a_38005_40623# uio_oe[0] sky130_fd_pr__nfet_01v8 ad=0.25025 pd=1.42 as=0.08775 ps=0.92 w=0.65 l=0.15
X3036 uio_oe[0] a_52855_39457# a_52816_39331# uio_oe[0] sky130_fd_pr__nfet_01v8 ad=0.0567 pd=0.69 as=0.1092 ps=1.36 w=0.42 l=0.15
X3037 VDPWR a_41420_39037# a_41990_38671# VDPWR sky130_fd_pr__pfet_01v8_hvt ad=0.149 pd=1.325 as=0.1664 ps=1.8 w=0.64 l=0.15
X3038 VDPWR a_48125_41935# a_59695_42453# VDPWR sky130_fd_pr__pfet_01v8_hvt ad=0.0819 pd=0.81 as=0.0567 ps=0.69 w=0.42 l=0.15
X3039 a_41671_36469# a_40379_35551# VDPWR VDPWR sky130_fd_pr__pfet_01v8_hvt ad=0.0567 pd=0.69 as=0.0819 ps=0.81 w=0.42 l=0.15
X3040 ua[4] a_24484_10376# a_24354_26020# uio_oe[0] sky130_fd_pr__nfet_01v8 ad=0.1885 pd=1.88 as=0.1885 ps=1.88 w=0.65 l=0.15
X3041 uio_oe[0] a_41231_42997# a_39947_42997# uio_oe[0] sky130_fd_pr__nfet_01v8 ad=0.08775 pd=0.92 as=0.08775 ps=0.92 w=0.65 l=0.15
X3042 a_38532_37735# a_37851_36647# a_38674_37910# VDPWR sky130_fd_pr__pfet_01v8_hvt ad=0.1932 pd=1.34 as=0.07665 ps=0.785 w=0.42 l=0.15
X3043 a_51620_37557# a_54459_37557# VDPWR VDPWR sky130_fd_pr__pfet_01v8_hvt ad=0.26 pd=2.52 as=0.3012 ps=2.66 w=1 l=0.15
X3044 uio_oe[0] a_44905_38671# a_57858_37405# uio_oe[0] sky130_fd_pr__nfet_01v8 ad=0.0882 pd=0.84 as=0.0441 ps=0.63 w=0.42 l=0.15
X3045 VDPWR a_58144_36744# a_58082_36861# VDPWR sky130_fd_pr__pfet_01v8_hvt ad=0.1092 pd=1.36 as=0.0651 ps=0.73 w=0.42 l=0.15
X3046 a_18575_33551# a_18427_33198# a_18212_33417# uio_oe[0] sky130_fd_pr__nfet_01v8 ad=0.0693 pd=0.75 as=0.09975 ps=0.895 w=0.42 l=0.15
X3047 a_42679_42857# a_42329_42485# a_42584_42845# VDPWR sky130_fd_pr__pfet_01v8_hvt ad=0.07245 pd=0.765 as=0.0651 ps=0.73 w=0.42 l=0.15
X3048 VDPWR a_38543_35559# a_28980_35593# VDPWR sky130_fd_pr__pfet_01v8_hvt ad=0.16655 pd=1.39 as=0.475 ps=2.95 w=1 l=0.15
X3049 a_40577_35407# a_40099_35381# uio_oe[0] uio_oe[0] sky130_fd_pr__nfet_01v8 ad=0.0669 pd=0.75 as=0.12495 ps=1.015 w=0.42 l=0.15
X3050 a_25924_14020# a_4259_22596# a_25746_14020# uio_oe[0] sky130_fd_pr__nfet_01v8 ad=0.2436 pd=2.26 as=0.2436 ps=2.26 w=0.84 l=0.6
X3051 uio_oe[0] a_37747_41935# a_37913_41935# uio_oe[0] sky130_fd_pr__nfet_01v8 ad=0.169 pd=1.82 as=0.08775 ps=0.92 w=0.65 l=0.15
X3052 uio_oe[0] a_50784_41096# a_50722_41213# uio_oe[0] sky130_fd_pr__nfet_01v8 ad=0.2205 pd=1.89 as=0.066 ps=0.745 w=0.42 l=0.15
X3053 a_61297_37825# a_61079_37583# VDPWR VDPWR sky130_fd_pr__pfet_01v8_hvt ad=0.12915 pd=1.185 as=0.2184 ps=2.2 w=0.84 l=0.15
X3054 a_57046_34571# a_57363_34461# a_57321_34319# uio_oe[0] sky130_fd_pr__special_nfet_01v8 ad=0.0711 pd=0.755 as=0.0669 ps=0.75 w=0.36 l=0.15
X3055 a_57519_42172# a_57324_42203# a_57829_41935# uio_oe[0] sky130_fd_pr__special_nfet_01v8 ad=0.0594 pd=0.69 as=0.1401 ps=1.1 w=0.36 l=0.15
X3056 uio_oe[0] a_48125_43023# a_49721_41757# uio_oe[0] sky130_fd_pr__nfet_01v8 ad=0.12495 pd=1.015 as=0.06405 ps=0.725 w=0.42 l=0.15
X3057 a_38674_40669# a_38005_40847# uio_oe[0] uio_oe[0] sky130_fd_pr__nfet_01v8 ad=0.0693 pd=0.75 as=0.11285 ps=1.045 w=0.42 l=0.15
X3058 uio_oe[0] a_45095_39733# a_43918_36041# uio_oe[0] sky130_fd_pr__nfet_01v8 ad=0.08775 pd=0.92 as=0.08775 ps=0.92 w=0.65 l=0.15
X3059 uio_oe[0] a_16812_8642# a_23402_20730# uio_oe[0] sky130_fd_pr__nfet_01v8 ad=1.4703 pd=10.72 as=1.4703 ps=10.72 w=5.07 l=1
X3060 a_31426_10464# a_28348_10782# ua[5] uio_oe[0] sky130_fd_pr__nfet_01v8 ad=0.1885 pd=1.88 as=0.1885 ps=1.88 w=0.65 l=0.15
X3061 uio_oe[0] a_37085_35951# a_37605_42518# uio_oe[0] sky130_fd_pr__nfet_01v8 ad=0.1449 pd=1.11 as=0.1092 ps=1.36 w=0.42 l=0.15
X3062 a_43918_36041# a_45095_39733# VDPWR VDPWR sky130_fd_pr__pfet_01v8_hvt ad=0.135 pd=1.27 as=0.135 ps=1.27 w=1 l=0.15
X3063 VDPWR a_43897_36647# a_37829_37812# VDPWR sky130_fd_pr__pfet_01v8_hvt ad=0.14575 pd=1.335 as=0.34 ps=2.68 w=1 l=0.15
X3064 uio_oe[0] uio_oe[0] uio_oe[0] uio_oe[0] sky130_fd_pr__nfet_01v8 ad=0.1885 pd=1.88 as=0 ps=0 w=0.65 l=0.15
X3065 a_60984_34319# a_60365_34319# VDPWR VDPWR sky130_fd_pr__pfet_01v8_hvt ad=0.0651 pd=0.73 as=0.1092 ps=1.36 w=0.42 l=0.15
X3066 a_60160_40847# a_58980_40821# a_59939_41174# uio_oe[0] sky130_fd_pr__nfet_01v8 ad=0.0693 pd=0.75 as=0.09975 ps=0.895 w=0.42 l=0.15
X3067 VDPWR a_54284_37583# a_54459_37557# VDPWR sky130_fd_pr__pfet_01v8_hvt ad=0.1134 pd=1.38 as=0.0567 ps=0.69 w=0.42 l=0.15
X3068 a_41231_42997# rst_n uio_oe[0] uio_oe[0] sky130_fd_pr__nfet_01v8 ad=0.169 pd=1.82 as=0.08775 ps=0.92 w=0.65 l=0.15
X3069 a_43353_41935# a_42163_41935# a_43244_41935# uio_oe[0] sky130_fd_pr__special_nfet_01v8 ad=0.0669 pd=0.75 as=0.0711 ps=0.755 w=0.36 l=0.15
X3070 VDPWR a_37029_42479# a_44095_41397# VDPWR sky130_fd_pr__pfet_01v8_hvt ad=0.0864 pd=0.91 as=0.1664 ps=1.8 w=0.64 l=0.15
X3071 a_61753_38671# a_60563_38671# a_61644_38671# uio_oe[0] sky130_fd_pr__special_nfet_01v8 ad=0.0669 pd=0.75 as=0.0711 ps=0.755 w=0.36 l=0.15
X3072 a_49721_34319# a_49686_34571# a_49483_34293# uio_oe[0] sky130_fd_pr__nfet_01v8 ad=0.06405 pd=0.725 as=0.1092 ps=1.36 w=0.42 l=0.15
X3073 VDPWR a_28651_34817# a_30123_35183# VDPWR sky130_fd_pr__pfet_01v8_hvt ad=0.0714 pd=0.76 as=0.1092 ps=1.36 w=0.42 l=0.15
X3074 a_37787_38998# a_37605_38998# VDPWR VDPWR sky130_fd_pr__pfet_01v8_hvt ad=0.0441 pd=0.63 as=0.0693 ps=0.75 w=0.42 l=0.15
X3075 VDPWR a_36447_40849# a_39127_34319# VDPWR sky130_fd_pr__pfet_01v8_hvt ad=0.26 pd=2.52 as=0.135 ps=1.27 w=1 l=0.15
X3076 VDPWR a_47108_40847# a_47283_40821# VDPWR sky130_fd_pr__pfet_01v8_hvt ad=0.1134 pd=1.38 as=0.0567 ps=0.69 w=0.42 l=0.15
X3077 a_36847_39457# a_37029_37039# uio_oe[0] uio_oe[0] sky130_fd_pr__nfet_01v8 ad=0.1092 pd=1.36 as=0.0567 ps=0.69 w=0.42 l=0.15
X3078 VDPWR a_37029_42479# a_46027_42485# VDPWR sky130_fd_pr__pfet_01v8_hvt ad=0.0864 pd=0.91 as=0.1664 ps=1.8 w=0.64 l=0.15
X3079 a_52855_40545# a_37913_43023# VDPWR VDPWR sky130_fd_pr__pfet_01v8_hvt ad=0.1664 pd=1.8 as=0.0864 ps=0.91 w=0.64 l=0.15
X3080 a_42643_37078# a_42613_37052# a_42571_37078# VDPWR sky130_fd_pr__pfet_01v8_hvt ad=0.1932 pd=1.34 as=0.0441 ps=0.63 w=0.42 l=0.15
X3081 a_48677_39759# a_48511_39759# VDPWR VDPWR sky130_fd_pr__pfet_01v8_hvt ad=0.135 pd=1.27 as=0.135 ps=1.27 w=1 l=0.15
X3082 uio_oe[0] uio_oe[0] uio_oe[0] uio_oe[0] sky130_fd_pr__nfet_01v8 ad=0.1885 pd=1.88 as=0 ps=0 w=0.65 l=0.15
X3083 uio_oe[0] a_38543_34471# a_28980_33417# uio_oe[0] sky130_fd_pr__nfet_01v8 ad=0.1118 pd=1.04 as=0.182 ps=1.86 w=0.65 l=0.15
X3084 uio_oe[0] a_59201_36249# a_59135_36317# uio_oe[0] sky130_fd_pr__nfet_01v8 ad=0.1449 pd=1.11 as=0.0693 ps=0.75 w=0.42 l=0.15
X3085 a_59939_35734# a_58980_35381# a_59867_35734# VDPWR sky130_fd_pr__pfet_01v8_hvt ad=0.1932 pd=1.34 as=0.0441 ps=0.63 w=0.42 l=0.15
X3086 a_43598_41757# a_39947_42997# uio_oe[0] uio_oe[0] sky130_fd_pr__nfet_01v8 ad=0.06405 pd=0.725 as=0.12495 ps=1.015 w=0.42 l=0.15
X3087 a_44611_40681# a_44095_40309# a_44516_40669# uio_oe[0] sky130_fd_pr__special_nfet_01v8 ad=0.0594 pd=0.69 as=0.066 ps=0.745 w=0.36 l=0.15
X3088 a_46452_39331# a_44621_38447# VDPWR VDPWR sky130_fd_pr__pfet_01v8_hvt ad=0.0441 pd=0.63 as=0.14575 ps=1.335 w=0.42 l=0.15
X3089 uio_oe[0] a_16812_8642# a_28346_24730# uio_oe[0] sky130_fd_pr__nfet_01v8 ad=1.4703 pd=10.72 as=1.4703 ps=10.72 w=5.07 l=1
X3090 uio_oe[0] a_49483_40821# a_39752_40821# uio_oe[0] sky130_fd_pr__nfet_01v8 ad=0.2087 pd=2.02 as=0.169 ps=1.82 w=0.65 l=0.15
X3091 a_36327_39733# a_36530_40011# VDPWR VDPWR sky130_fd_pr__pfet_01v8_hvt ad=0.0567 pd=0.69 as=0.1134 ps=1.38 w=0.42 l=0.15
X3092 VDPWR a_38005_41391# a_42347_39221# VDPWR sky130_fd_pr__pfet_01v8_hvt ad=0.0864 pd=0.91 as=0.1664 ps=1.8 w=0.64 l=0.15
X3093 VDPWR a_42953_34837# a_42895_34863# VDPWR sky130_fd_pr__pfet_01v8_hvt ad=0.2279 pd=1.74 as=0.0609 ps=0.71 w=0.42 l=0.15
X3094 a_44719_42479# a_39947_42997# VDPWR VDPWR sky130_fd_pr__pfet_01v8_hvt ad=0.1092 pd=1.36 as=0.07035 ps=0.755 w=0.42 l=0.15
X3095 a_41250_41935# a_38285_34863# uio_oe[0] uio_oe[0] sky130_fd_pr__nfet_01v8 ad=0.0693 pd=0.75 as=0.11285 ps=1.045 w=0.42 l=0.15
X3096 a_43537_39759# a_42347_39759# a_43428_39759# uio_oe[0] sky130_fd_pr__special_nfet_01v8 ad=0.0669 pd=0.75 as=0.0711 ps=0.755 w=0.36 l=0.15
X3097 a_31130_20730# ua[0] a_31002_22020# uio_oe[0] sky130_fd_pr__nfet_01v8 ad=0.2436 pd=2.26 as=0.2436 ps=2.26 w=0.84 l=0.6
X3098 a_41309_34319# a_40975_34569# a_41225_34569# VDPWR sky130_fd_pr__pfet_01v8_hvt ad=0.3 pd=2.6 as=0.26 ps=2.52 w=1 l=0.15
X3099 uio_oe[0] a_41143_39189# a_41074_39215# uio_oe[0] sky130_fd_pr__nfet_01v8 ad=0.1346 pd=1.15 as=0.0999 ps=0.985 w=0.64 l=0.15
X3100 a_54406_42845# a_36661_41391# uio_oe[0] uio_oe[0] sky130_fd_pr__nfet_01v8 ad=0.0693 pd=0.75 as=0.11285 ps=1.045 w=0.42 l=0.15
X3101 a_42941_40847# a_42897_41089# a_42775_40847# uio_oe[0] sky130_fd_pr__nfet_01v8 ad=0.0441 pd=0.63 as=0.1401 ps=1.1 w=0.42 l=0.15
X3102 a_61079_36495# a_60729_36495# a_60984_36495# VDPWR sky130_fd_pr__pfet_01v8_hvt ad=0.07245 pd=0.765 as=0.0651 ps=0.73 w=0.42 l=0.15
X3103 a_22012_18376# a_22575_34095# uio_oe[0] uio_oe[0] sky130_fd_pr__nfet_01v8 ad=0.169 pd=1.82 as=0.1013 ps=0.99 w=0.65 l=0.15
X3104 uio_oe[0] a_45719_39447# a_42236_36219# uio_oe[0] sky130_fd_pr__nfet_01v8 ad=0.1118 pd=1.04 as=0.182 ps=1.86 w=0.65 l=0.15
X3105 a_37085_38921# a_36425_35078# VDPWR VDPWR sky130_fd_pr__pfet_01v8_hvt ad=0.135 pd=1.27 as=0.135 ps=1.27 w=1 l=0.15
X3106 a_36385_38127# a_36355_38101# uio_oe[0] uio_oe[0] sky130_fd_pr__nfet_01v8 ad=0.08775 pd=0.92 as=0.08775 ps=0.92 w=0.65 l=0.15
X3107 a_53937_42177# a_53719_41935# uio_oe[0] uio_oe[0] sky130_fd_pr__nfet_01v8 ad=0.0999 pd=0.985 as=0.1346 ps=1.15 w=0.64 l=0.15
X3108 a_54693_41689# a_36661_41391# uio_oe[0] uio_oe[0] sky130_fd_pr__nfet_01v8 ad=0.1092 pd=1.36 as=0.1449 ps=1.11 w=0.42 l=0.15
X3109 a_50003_39901# a_38649_43023# VDPWR VDPWR sky130_fd_pr__pfet_01v8_hvt ad=0.1664 pd=1.8 as=0.0864 ps=0.91 w=0.64 l=0.15
X3110 a_59939_35407# a_59685_35734# uio_oe[0] uio_oe[0] sky130_fd_pr__nfet_01v8 ad=0.0693 pd=0.75 as=0.1449 ps=1.11 w=0.42 l=0.15
X3111 VDPWR a_37747_43023# a_37913_43023# VDPWR sky130_fd_pr__pfet_01v8_hvt ad=0.135 pd=1.27 as=0.135 ps=1.27 w=1 l=0.15
X3112 a_59227_41757# a_39752_41659# a_58864_41623# uio_oe[0] sky130_fd_pr__nfet_01v8 ad=0.0693 pd=0.75 as=0.09975 ps=0.895 w=0.42 l=0.15
X3113 VDPWR a_37913_41935# a_53203_36495# VDPWR sky130_fd_pr__pfet_01v8_hvt ad=0.0864 pd=0.91 as=0.1664 ps=1.8 w=0.64 l=0.15
X3114 a_16804_14020# a_4259_22596# a_16626_14020# uio_oe[0] sky130_fd_pr__nfet_01v8 ad=0.2436 pd=2.26 as=0.2436 ps=2.26 w=0.84 l=0.6
X3115 a_60681_42845# a_60302_42479# a_60609_42845# uio_oe[0] sky130_fd_pr__nfet_01v8 ad=0.1401 pd=1.1 as=0.0441 ps=0.63 w=0.42 l=0.15
X3116 a_44873_41935# a_44829_42177# a_44707_41935# uio_oe[0] sky130_fd_pr__nfet_01v8 ad=0.0441 pd=0.63 as=0.1401 ps=1.1 w=0.42 l=0.15
X3117 a_44707_40847# a_44261_40847# a_44611_40847# uio_oe[0] sky130_fd_pr__special_nfet_01v8 ad=0.1401 pd=1.1 as=0.0594 ps=0.69 w=0.36 l=0.15
X3118 a_59135_39759# a_38740_39733# a_58772_39911# uio_oe[0] sky130_fd_pr__nfet_01v8 ad=0.0693 pd=0.75 as=0.09975 ps=0.895 w=0.42 l=0.15
X3119 a_59006_39254# a_48677_39759# VDPWR VDPWR sky130_fd_pr__pfet_01v8_hvt ad=0.07665 pd=0.785 as=0.15835 ps=1.395 w=0.42 l=0.15
X3120 VDPWR a_50784_38101# a_50722_38127# VDPWR sky130_fd_pr__pfet_01v8_hvt ad=0.1092 pd=1.36 as=0.0651 ps=0.73 w=0.42 l=0.15
X3121 a_50090_35951# a_50003_36193# a_49686_36083# VDPWR sky130_fd_pr__pfet_01v8_hvt ad=0.12915 pd=1.185 as=0.0588 ps=0.7 w=0.42 l=0.15
X3122 uio_oe[0] a_54264_35095# a_53636_34837# uio_oe[0] sky130_fd_pr__nfet_01v8 ad=0.11285 pd=1.045 as=0.169 ps=1.82 w=0.65 l=0.15
X3123 a_42679_41769# a_42329_41397# a_42584_41757# VDPWR sky130_fd_pr__pfet_01v8_hvt ad=0.07245 pd=0.765 as=0.0651 ps=0.73 w=0.42 l=0.15
X3124 a_58864_41623# a_39752_41659# a_59006_41430# VDPWR sky130_fd_pr__pfet_01v8_hvt ad=0.1932 pd=1.34 as=0.07665 ps=0.785 w=0.42 l=0.15
X3125 a_38080_38671# a_36721_37583# a_37859_38998# uio_oe[0] sky130_fd_pr__nfet_01v8 ad=0.0693 pd=0.75 as=0.09975 ps=0.895 w=0.42 l=0.15
X3126 VDPWR a_25265_36967# a_25295_37320# VDPWR sky130_fd_pr__pfet_01v8_hvt ad=0.0693 pd=0.75 as=0.0441 ps=0.63 w=0.42 l=0.15
X3127 uio_oe[0] a_43419_41695# a_43353_41769# uio_oe[0] sky130_fd_pr__nfet_01v8 ad=0.12495 pd=1.015 as=0.0669 ps=0.75 w=0.42 l=0.15
X3128 a_24484_14782# a_26439_36271# uio_oe[0] uio_oe[0] sky130_fd_pr__nfet_01v8 ad=0.169 pd=1.82 as=0.1013 ps=0.99 w=0.65 l=0.15
X3129 a_18146_16730# ua[3] a_18018_18020# uio_oe[0] sky130_fd_pr__nfet_01v8 ad=0.2436 pd=2.26 as=0.2436 ps=2.26 w=0.84 l=0.6
X3130 uio_oe[0] a_60584_35177# a_60542_35229# uio_oe[0] sky130_fd_pr__nfet_01v8 ad=0.1092 pd=1.36 as=0.0441 ps=0.63 w=0.42 l=0.15
X3131 a_46543_40681# a_46193_40309# a_46448_40669# VDPWR sky130_fd_pr__pfet_01v8_hvt ad=0.07245 pd=0.765 as=0.0651 ps=0.73 w=0.42 l=0.15
X3132 a_52538_39347# a_52855_39457# a_52813_39581# uio_oe[0] sky130_fd_pr__special_nfet_01v8 ad=0.0711 pd=0.755 as=0.0669 ps=0.75 w=0.36 l=0.15
X3133 a_53624_37583# a_53005_37583# VDPWR VDPWR sky130_fd_pr__pfet_01v8_hvt ad=0.0651 pd=0.73 as=0.1092 ps=1.36 w=0.42 l=0.15
X3134 a_50469_39759# a_50090_40125# a_50397_39759# uio_oe[0] sky130_fd_pr__nfet_01v8 ad=0.1401 pd=1.1 as=0.0441 ps=0.63 w=0.42 l=0.15
X3135 a_29313_36747# a_28980_36681# VDPWR VDPWR sky130_fd_pr__pfet_01v8_hvt ad=0.1176 pd=1.4 as=0.0693 ps=0.75 w=0.42 l=0.15
X3136 a_54459_37557# a_54284_37583# a_54638_37583# uio_oe[0] sky130_fd_pr__nfet_01v8 ad=0.1092 pd=1.36 as=0.06405 ps=0.725 w=0.42 l=0.15
X3137 uio_oe[0] a_26369_35659# a_26303_35727# uio_oe[0] sky130_fd_pr__nfet_01v8 ad=0.1449 pd=1.11 as=0.0693 ps=0.75 w=0.42 l=0.15
X3138 a_16804_10020# a_16812_8642# uio_oe[0] uio_oe[0] sky130_fd_pr__nfet_01v8 ad=1.4703 pd=10.72 as=1.4703 ps=10.72 w=5.07 l=1
X3139 uio_oe[0] uio_oe[0] uio_oe[0] uio_oe[0] sky130_fd_pr__nfet_01v8 ad=1.4703 pd=10.72 as=0 ps=0 w=5.07 l=1
X3140 ua[4] a_28348_10376# a_31002_26020# uio_oe[0] sky130_fd_pr__nfet_01v8 ad=0.1885 pd=1.88 as=0.1885 ps=1.88 w=0.65 l=0.15
X3141 a_17567_35144# a_17316_34791# a_17108_34969# VDPWR sky130_fd_pr__pfet_01v8_hvt ad=0.0441 pd=0.63 as=0.1932 ps=1.34 w=0.42 l=0.15
X3142 a_46193_39759# a_46027_39759# uio_oe[0] uio_oe[0] sky130_fd_pr__nfet_01v8 ad=0.08775 pd=0.92 as=0.08775 ps=0.92 w=0.65 l=0.15
X3143 VDPWR a_54284_36495# a_54459_36469# VDPWR sky130_fd_pr__pfet_01v8_hvt ad=0.1134 pd=1.38 as=0.0567 ps=0.69 w=0.42 l=0.15
X3144 ua[5] a_22012_18376# a_21882_18020# uio_oe[0] sky130_fd_pr__nfet_01v8 ad=0.1885 pd=1.88 as=0.1885 ps=1.88 w=0.65 l=0.15
X3145 a_57858_39581# a_57640_39529# a_57776_39581# uio_oe[0] sky130_fd_pr__nfet_01v8 ad=0.0441 pd=0.63 as=0.1092 ps=1.36 w=0.42 l=0.15
X3146 a_60153_37910# a_51620_37557# a_59939_37910# VDPWR sky130_fd_pr__pfet_01v8_hvt ad=0.07665 pd=0.785 as=0.1932 ps=1.34 w=0.42 l=0.15
X3147 a_41149_36737# a_40931_36495# VDPWR VDPWR sky130_fd_pr__pfet_01v8_hvt ad=0.12915 pd=1.185 as=0.2184 ps=2.2 w=0.84 l=0.15
X3148 a_57829_36317# a_57450_35951# a_57757_36317# uio_oe[0] sky130_fd_pr__nfet_01v8 ad=0.1401 pd=1.1 as=0.0441 ps=0.63 w=0.42 l=0.15
X3149 uio_oe[0] a_29281_32641# a_29689_33757# uio_oe[0] sky130_fd_pr__nfet_01v8 ad=0.1118 pd=1.04 as=0.0567 ps=0.69 w=0.42 l=0.15
X3150 uio_oe[0] a_61808_37271# a_61242_37269# uio_oe[0] sky130_fd_pr__nfet_01v8 ad=0.11285 pd=1.045 as=0.169 ps=1.82 w=0.65 l=0.15
X3151 uio_oe[0] a_39947_42997# a_44873_42845# uio_oe[0] sky130_fd_pr__nfet_01v8 ad=0.1346 pd=1.15 as=0.0441 ps=0.63 w=0.42 l=0.15
X3152 a_36934_40125# a_36847_39901# a_36530_40011# VDPWR sky130_fd_pr__pfet_01v8_hvt ad=0.12915 pd=1.185 as=0.0588 ps=0.7 w=0.42 l=0.15
X3153 VDPWR a_59956_39189# a_60092_39215# VDPWR sky130_fd_pr__pfet_01v8_hvt ad=0.12285 pd=1.17 as=0.2184 ps=2.2 w=0.84 l=0.15
X3154 a_40536_35951# a_40099_35925# VDPWR VDPWR sky130_fd_pr__pfet_01v8_hvt ad=0.0567 pd=0.69 as=0.0819 ps=0.81 w=0.42 l=0.15
X3155 ua[4] a_16756_18782# a_16626_18020# uio_oe[0] sky130_fd_pr__nfet_01v8 ad=0.1885 pd=1.88 as=0.1885 ps=1.88 w=0.65 l=0.15
X3156 VDPWR a_38532_38823# a_21252_33417# VDPWR sky130_fd_pr__pfet_01v8_hvt ad=0.15835 pd=1.395 as=0.26 ps=2.52 w=1 l=0.15
X3157 a_57081_36317# a_57046_36083# a_56843_35925# uio_oe[0] sky130_fd_pr__nfet_01v8 ad=0.06405 pd=0.725 as=0.1092 ps=1.36 w=0.42 l=0.15
X3158 VDPWR a_20972_33881# a_20923_33729# VDPWR sky130_fd_pr__pfet_01v8_hvt ad=0.15835 pd=1.395 as=0.26 ps=2.52 w=1 l=0.15
X3159 a_21156_34505# a_17507_33198# a_21298_34312# VDPWR sky130_fd_pr__pfet_01v8_hvt ad=0.1932 pd=1.34 as=0.07665 ps=0.785 w=0.42 l=0.15
X3160 a_39973_41689# a_38005_40847# uio_oe[0] uio_oe[0] sky130_fd_pr__nfet_01v8 ad=0.1092 pd=1.36 as=0.1449 ps=1.11 w=0.42 l=0.15
X3161 a_42836_38127# a_42399_38101# VDPWR VDPWR sky130_fd_pr__pfet_01v8_hvt ad=0.0567 pd=0.69 as=0.0819 ps=0.81 w=0.42 l=0.15
X3162 VDPWR a_22505_34571# a_22535_34312# VDPWR sky130_fd_pr__pfet_01v8_hvt ad=0.0693 pd=0.75 as=0.0441 ps=0.63 w=0.42 l=0.15
X3163 a_40945_39581# a_40467_39189# uio_oe[0] uio_oe[0] sky130_fd_pr__nfet_01v8 ad=0.0669 pd=0.75 as=0.12495 ps=1.015 w=0.42 l=0.15
X3164 a_40928_37583# a_40811_37796# uio_oe[0] uio_oe[0] sky130_fd_pr__nfet_01v8 ad=0.066 pd=0.745 as=0.2205 ps=1.89 w=0.42 l=0.15
X3165 a_54693_42777# a_36661_41391# VDPWR VDPWR sky130_fd_pr__pfet_01v8_hvt ad=0.1176 pd=1.4 as=0.0693 ps=0.75 w=0.42 l=0.15
X3166 a_49686_42187# a_49964_42203# a_49920_42301# VDPWR sky130_fd_pr__pfet_01v8_hvt ad=0.0588 pd=0.7 as=0.0567 ps=0.69 w=0.42 l=0.15
X3167 a_43081_39189# a_42863_39593# uio_oe[0] uio_oe[0] sky130_fd_pr__nfet_01v8 ad=0.0999 pd=0.985 as=0.1346 ps=1.15 w=0.64 l=0.15
X3168 a_52538_39347# a_52816_39331# a_52772_39215# VDPWR sky130_fd_pr__pfet_01v8_hvt ad=0.0588 pd=0.7 as=0.0567 ps=0.69 w=0.42 l=0.15
X3169 uio_oe[0] a_17689_32641# a_18097_34845# uio_oe[0] sky130_fd_pr__nfet_01v8 ad=0.1118 pd=1.04 as=0.0567 ps=0.69 w=0.42 l=0.15
X3170 VDPWR rst_n a_47959_43023# VDPWR sky130_fd_pr__pfet_01v8_hvt ad=0.135 pd=1.27 as=0.26 ps=2.52 w=1 l=0.15
X3171 uio_oe[0] a_58144_40277# a_58082_40303# uio_oe[0] sky130_fd_pr__nfet_01v8 ad=0.2205 pd=1.89 as=0.066 ps=0.745 w=0.42 l=0.15
X3172 a_57280_40125# a_56843_39733# VDPWR VDPWR sky130_fd_pr__pfet_01v8_hvt ad=0.0567 pd=0.69 as=0.0819 ps=0.81 w=0.42 l=0.15
X3173 a_18641_36747# a_17388_36681# VDPWR VDPWR sky130_fd_pr__pfet_01v8_hvt ad=0.1176 pd=1.4 as=0.0693 ps=0.75 w=0.42 l=0.15
X3174 a_43520_38671# a_42605_38671# a_43173_38913# uio_oe[0] sky130_fd_pr__special_nfet_01v8 ad=0.0711 pd=0.755 as=0.0999 ps=0.985 w=0.36 l=0.15
X3175 VDPWR a_59201_36469# a_59231_36822# VDPWR sky130_fd_pr__pfet_01v8_hvt ad=0.0693 pd=0.75 as=0.0441 ps=0.63 w=0.42 l=0.15
X3176 a_57363_36637# a_41685_42479# uio_oe[0] uio_oe[0] sky130_fd_pr__nfet_01v8 ad=0.1092 pd=1.36 as=0.0567 ps=0.69 w=0.42 l=0.15
X3177 a_41537_35161# a_37661_38140# VDPWR VDPWR sky130_fd_pr__pfet_01v8_hvt ad=0.1176 pd=1.4 as=0.0693 ps=0.75 w=0.42 l=0.15
X3178 VDPWR a_42457_36249# a_42487_35990# VDPWR sky130_fd_pr__pfet_01v8_hvt ad=0.0693 pd=0.75 as=0.0441 ps=0.63 w=0.42 l=0.15
X3179 a_44719_41391# a_39947_42997# VDPWR VDPWR sky130_fd_pr__pfet_01v8_hvt ad=0.1092 pd=1.36 as=0.07035 ps=0.755 w=0.42 l=0.15
X3180 a_53574_38127# a_52855_38369# a_53011_38101# uio_oe[0] sky130_fd_pr__special_nfet_01v8 ad=0.066 pd=0.745 as=0.0594 ps=0.69 w=0.36 l=0.15
X3181 VDPWR a_51841_36469# a_51871_36822# VDPWR sky130_fd_pr__pfet_01v8_hvt ad=0.0693 pd=0.75 as=0.0441 ps=0.63 w=0.42 l=0.15
X3182 a_20914_18464# a_20620_18376# ua[4] uio_oe[0] sky130_fd_pr__nfet_01v8 ad=0.1885 pd=1.88 as=0.1885 ps=1.88 w=0.65 l=0.15
X3183 a_61644_39759# a_60563_39759# a_61297_40001# VDPWR sky130_fd_pr__pfet_01v8_hvt ad=0.0588 pd=0.7 as=0.12915 ps=1.185 w=0.42 l=0.15
X3184 uio_oe[0] uio_oe[0] uio_oe[0] uio_oe[0] sky130_fd_pr__nfet_01v8 ad=0.1885 pd=1.88 as=0 ps=0 w=0.65 l=0.15
X3185 a_38961_41909# a_38005_40847# uio_oe[0] uio_oe[0] sky130_fd_pr__nfet_01v8 ad=0.1092 pd=1.36 as=0.1449 ps=1.11 w=0.42 l=0.15
X3186 a_28700_37145# a_28908_36967# a_28842_36993# uio_oe[0] sky130_fd_pr__nfet_01v8 ad=0.09975 pd=0.895 as=0.0693 ps=0.75 w=0.42 l=0.15
X3187 a_38674_40342# a_38005_40847# VDPWR VDPWR sky130_fd_pr__pfet_01v8_hvt ad=0.07665 pd=0.785 as=0.15835 ps=1.395 w=0.42 l=0.15
X3188 a_61644_39759# a_60729_39759# a_61297_40001# uio_oe[0] sky130_fd_pr__special_nfet_01v8 ad=0.0711 pd=0.755 as=0.0999 ps=0.985 w=0.36 l=0.15
X3189 uio_oe[0] a_40987_38369# a_40948_38243# uio_oe[0] sky130_fd_pr__nfet_01v8 ad=0.0567 pd=0.69 as=0.1092 ps=1.36 w=0.42 l=0.15
X3190 VDPWR a_60584_37353# a_60638_37039# VDPWR sky130_fd_pr__pfet_01v8_hvt ad=0.0567 pd=0.69 as=0.0483 ps=0.65 w=0.42 l=0.15
X3191 VDPWR a_25417_32641# a_26439_34095# VDPWR sky130_fd_pr__pfet_01v8_hvt ad=0.2279 pd=1.74 as=0.0609 ps=0.71 w=0.42 l=0.15
X3192 a_36847_39901# a_37029_42479# uio_oe[0] uio_oe[0] sky130_fd_pr__nfet_01v8 ad=0.1092 pd=1.36 as=0.0567 ps=0.69 w=0.42 l=0.15
X3193 a_56843_38101# a_57046_38259# VDPWR VDPWR sky130_fd_pr__pfet_01v8_hvt ad=0.0567 pd=0.69 as=0.1134 ps=1.38 w=0.42 l=0.15
X3194 a_42651_39386# a_42643_36822# VDPWR VDPWR sky130_fd_pr__pfet_01v8_hvt ad=0.26 pd=2.52 as=0.15835 ps=1.395 w=1 l=0.15
X3195 a_20914_18464# a_4259_22596# a_20618_16730# uio_oe[0] sky130_fd_pr__nfet_01v8 ad=0.2436 pd=2.26 as=0.2436 ps=2.26 w=0.84 l=0.6
X3196 VDPWR a_51412_34471# a_50784_34568# VDPWR sky130_fd_pr__pfet_01v8_hvt ad=0.15835 pd=1.395 as=0.26 ps=2.52 w=1 l=0.15
X3197 a_48125_43023# a_47959_43023# VDPWR VDPWR sky130_fd_pr__pfet_01v8_hvt ad=0.135 pd=1.27 as=0.135 ps=1.27 w=1 l=0.15
X3198 a_41074_40125# a_40948_40027# a_40670_40011# uio_oe[0] sky130_fd_pr__special_nfet_01v8 ad=0.0999 pd=0.985 as=0.0711 ps=0.755 w=0.36 l=0.15
X3199 a_53719_36495# a_53203_36495# a_53624_36495# uio_oe[0] sky130_fd_pr__special_nfet_01v8 ad=0.0594 pd=0.69 as=0.066 ps=0.745 w=0.36 l=0.15
X3200 a_60729_36495# a_60563_36495# uio_oe[0] uio_oe[0] sky130_fd_pr__nfet_01v8 ad=0.1092 pd=1.36 as=0.0567 ps=0.69 w=0.42 l=0.15
X3201 VDPWR a_48125_43023# a_57664_41213# VDPWR sky130_fd_pr__pfet_01v8_hvt ad=0.07035 pd=0.755 as=0.1092 ps=1.36 w=0.42 l=0.15
X3202 a_59135_38671# a_38740_38645# a_58772_38823# uio_oe[0] sky130_fd_pr__nfet_01v8 ad=0.0693 pd=0.75 as=0.09975 ps=0.895 w=0.42 l=0.15
X3203 a_40469_41909# a_37851_36647# uio_oe[0] uio_oe[0] sky130_fd_pr__nfet_01v8 ad=0.0567 pd=0.69 as=0.10187 ps=0.99 w=0.42 l=0.15
X3204 a_37310_34471# a_37795_40535# uio_oe[0] uio_oe[0] sky130_fd_pr__nfet_01v8 ad=0.08775 pd=0.92 as=0.169 ps=1.82 w=0.65 l=0.15
X3205 a_21401_34791# a_21068_34969# VDPWR VDPWR sky130_fd_pr__pfet_01v8_hvt ad=0.1176 pd=1.4 as=0.0693 ps=0.75 w=0.42 l=0.15
X3206 a_37859_38493# a_37605_38166# uio_oe[0] uio_oe[0] sky130_fd_pr__nfet_01v8 ad=0.0693 pd=0.75 as=0.1449 ps=1.11 w=0.42 l=0.15
X3207 a_38285_37039# a_37859_37078# VDPWR VDPWR sky130_fd_pr__pfet_01v8_hvt ad=0.26 pd=2.52 as=0.15835 ps=1.395 w=1 l=0.15
X3208 uio_oe[0] a_41987_34863# a_42321_35183# uio_oe[0] sky130_fd_pr__nfet_01v8 ad=0.208 pd=1.94 as=0.25025 ps=1.42 w=0.65 l=0.15
X3209 VDPWR a_45351_42783# a_45338_42479# VDPWR sky130_fd_pr__pfet_01v8_hvt ad=0.0819 pd=0.81 as=0.0567 ps=0.69 w=0.42 l=0.15
X3210 a_42863_39759# a_42513_39759# a_42768_39759# VDPWR sky130_fd_pr__pfet_01v8_hvt ad=0.07245 pd=0.765 as=0.0651 ps=0.73 w=0.42 l=0.15
X3211 a_54264_39447# a_51620_39483# a_54406_39581# uio_oe[0] sky130_fd_pr__nfet_01v8 ad=0.09975 pd=0.895 as=0.0693 ps=0.75 w=0.42 l=0.15
X3212 VDPWR a_17500_33453# a_36275_37949# VDPWR sky130_fd_pr__pfet_01v8_hvt ad=0.0714 pd=0.76 as=0.1092 ps=1.36 w=0.42 l=0.15
X3213 VDPWR a_37361_41391# a_60153_37910# VDPWR sky130_fd_pr__pfet_01v8_hvt ad=0.15835 pd=1.395 as=0.07665 ps=0.785 w=0.42 l=0.15
X3214 a_24836_34969# a_24971_34273# a_24978_35144# VDPWR sky130_fd_pr__pfet_01v8_hvt ad=0.1932 pd=1.34 as=0.07665 ps=0.785 w=0.42 l=0.15
X3215 a_37661_37052# a_41763_37557# VDPWR VDPWR sky130_fd_pr__pfet_01v8_hvt ad=0.26 pd=2.52 as=0.3012 ps=2.66 w=1 l=0.15
X3216 a_39973_42777# a_37029_38127# VDPWR VDPWR sky130_fd_pr__pfet_01v8_hvt ad=0.1176 pd=1.4 as=0.0693 ps=0.75 w=0.42 l=0.15
X3217 a_47108_40681# a_46027_40309# a_46761_40277# VDPWR sky130_fd_pr__pfet_01v8_hvt ad=0.0588 pd=0.7 as=0.12915 ps=1.185 w=0.42 l=0.15
X3218 a_50469_38671# a_50090_39037# a_50397_38671# uio_oe[0] sky130_fd_pr__nfet_01v8 ad=0.1401 pd=1.1 as=0.0441 ps=0.63 w=0.42 l=0.15
X3219 a_53624_36495# a_53005_36495# VDPWR VDPWR sky130_fd_pr__pfet_01v8_hvt ad=0.0651 pd=0.73 as=0.1092 ps=1.36 w=0.42 l=0.15
X3220 VDPWR a_37839_40847# a_38005_40847# VDPWR sky130_fd_pr__pfet_01v8_hvt ad=0.26 pd=2.52 as=0.135 ps=1.27 w=1 l=0.15
X3221 VDPWR a_54459_39733# a_54446_40125# VDPWR sky130_fd_pr__pfet_01v8_hvt ad=0.0819 pd=0.81 as=0.0567 ps=0.69 w=0.42 l=0.15
X3222 a_42571_36822# a_42389_36822# VDPWR VDPWR sky130_fd_pr__pfet_01v8_hvt ad=0.0441 pd=0.63 as=0.0693 ps=0.75 w=0.42 l=0.15
X3223 uio_oe[0] a_25417_32641# a_26529_36993# uio_oe[0] sky130_fd_pr__nfet_01v8 ad=0.1013 pd=0.99 as=0.0504 ps=0.66 w=0.42 l=0.15
X3224 a_50304_37039# a_50090_37039# VDPWR VDPWR sky130_fd_pr__pfet_01v8_hvt ad=0.1155 pd=0.97 as=0.07035 ps=0.755 w=0.42 l=0.15
X3225 a_36425_35381# a_43695_38645# VDPWR VDPWR sky130_fd_pr__pfet_01v8_hvt ad=0.26 pd=2.52 as=0.3012 ps=2.66 w=1 l=0.15
X3226 a_50090_41213# a_49964_41115# a_49686_41099# uio_oe[0] sky130_fd_pr__special_nfet_01v8 ad=0.0999 pd=0.985 as=0.0711 ps=0.755 w=0.36 l=0.15
X3227 a_37566_40125# a_36808_40027# a_37003_39996# VDPWR sky130_fd_pr__pfet_01v8_hvt ad=0.0651 pd=0.73 as=0.07245 ps=0.765 w=0.42 l=0.15
X3228 a_41149_37013# a_40931_37417# uio_oe[0] uio_oe[0] sky130_fd_pr__nfet_01v8 ad=0.0999 pd=0.985 as=0.1346 ps=1.15 w=0.64 l=0.15
X3229 VDPWR a_58144_35925# a_58082_35951# VDPWR sky130_fd_pr__pfet_01v8_hvt ad=0.1092 pd=1.36 as=0.0651 ps=0.73 w=0.42 l=0.15
X3230 a_49686_35659# a_49964_35675# a_49920_35773# VDPWR sky130_fd_pr__pfet_01v8_hvt ad=0.0588 pd=0.7 as=0.0567 ps=0.69 w=0.42 l=0.15
X3231 VDPWR a_30233_35659# a_30263_35400# VDPWR sky130_fd_pr__pfet_01v8_hvt ad=0.0693 pd=0.75 as=0.0441 ps=0.63 w=0.42 l=0.15
X3232 a_38895_40669# a_37795_40535# a_38532_40535# uio_oe[0] sky130_fd_pr__nfet_01v8 ad=0.0693 pd=0.75 as=0.09975 ps=0.895 w=0.42 l=0.15
X3233 ua[4] a_24484_10782# a_24354_10020# uio_oe[0] sky130_fd_pr__nfet_01v8 ad=0.1885 pd=1.88 as=0.1885 ps=1.88 w=0.65 l=0.15
X3234 VDPWR a_36425_35381# a_44369_39215# VDPWR sky130_fd_pr__pfet_01v8_hvt ad=0.135 pd=1.27 as=0.135 ps=1.27 w=1 l=0.15
X3235 uio_oe[0] a_50159_34556# a_50090_34685# uio_oe[0] sky130_fd_pr__nfet_01v8 ad=0.1346 pd=1.15 as=0.0999 ps=0.985 w=0.64 l=0.15
X3236 a_54393_35407# a_53203_35407# a_54284_35407# uio_oe[0] sky130_fd_pr__special_nfet_01v8 ad=0.0669 pd=0.75 as=0.0711 ps=0.755 w=0.36 l=0.15
X3237 a_41241_37825# a_41023_37583# uio_oe[0] uio_oe[0] sky130_fd_pr__nfet_01v8 ad=0.0999 pd=0.985 as=0.1346 ps=1.15 w=0.64 l=0.15
X3238 a_54693_41689# a_36661_41391# VDPWR VDPWR sky130_fd_pr__pfet_01v8_hvt ad=0.1176 pd=1.4 as=0.0693 ps=0.75 w=0.42 l=0.15
X3239 uio_oe[0] a_48125_43023# a_49721_40847# uio_oe[0] sky130_fd_pr__nfet_01v8 ad=0.12495 pd=1.015 as=0.06405 ps=0.725 w=0.42 l=0.15
X3240 a_60458_39215# a_60092_39215# VDPWR VDPWR sky130_fd_pr__pfet_01v8_hvt ad=0.0441 pd=0.63 as=0.1092 ps=1.36 w=0.42 l=0.15
X3241 uio_oe[0] a_47959_41935# a_48125_41935# uio_oe[0] sky130_fd_pr__nfet_01v8 ad=0.08775 pd=0.92 as=0.08775 ps=0.92 w=0.65 l=0.15
X3242 a_50159_39996# a_50003_39901# a_50304_40125# VDPWR sky130_fd_pr__pfet_01v8_hvt ad=0.07245 pd=0.765 as=0.1155 ps=0.97 w=0.42 l=0.15
X3243 a_25449_33483# a_25116_33417# VDPWR VDPWR sky130_fd_pr__pfet_01v8_hvt ad=0.1176 pd=1.4 as=0.0693 ps=0.75 w=0.42 l=0.15
X3244 a_22535_33224# a_18420_33453# a_22076_33417# VDPWR sky130_fd_pr__pfet_01v8_hvt ad=0.0441 pd=0.63 as=0.1932 ps=1.34 w=0.42 l=0.15
X3245 a_38532_40535# a_37795_40535# a_38674_40342# VDPWR sky130_fd_pr__pfet_01v8_hvt ad=0.1932 pd=1.34 as=0.07665 ps=0.785 w=0.42 l=0.15
X3246 a_21875_37021# a_20923_36993# VDPWR VDPWR sky130_fd_pr__pfet_01v8_hvt ad=0.0567 pd=0.69 as=0.1176 ps=1.4 w=0.42 l=0.15
X3247 VDPWR a_38543_36183# a_28980_36681# VDPWR sky130_fd_pr__pfet_01v8_hvt ad=0.16655 pd=1.39 as=0.475 ps=2.95 w=1 l=0.15
X3248 a_28346_16730# ua[0] a_28218_18020# uio_oe[0] sky130_fd_pr__nfet_01v8 ad=0.2436 pd=2.26 as=0.2436 ps=2.26 w=0.84 l=0.6
X3249 a_47283_42997# a_47108_43023# a_47462_43023# uio_oe[0] sky130_fd_pr__nfet_01v8 ad=0.1092 pd=1.36 as=0.06405 ps=0.725 w=0.42 l=0.15
X3250 uio_oe[0] a_40099_35925# a_36425_34293# uio_oe[0] sky130_fd_pr__nfet_01v8 ad=0.2087 pd=2.02 as=0.169 ps=1.82 w=0.65 l=0.15
X3251 a_43244_41935# a_42329_41935# a_42897_42177# uio_oe[0] sky130_fd_pr__special_nfet_01v8 ad=0.0711 pd=0.755 as=0.0999 ps=0.985 w=0.36 l=0.15
X3252 a_26529_36993# a_26259_37359# a_26439_37359# uio_oe[0] sky130_fd_pr__nfet_01v8 ad=0.0504 pd=0.66 as=0.1092 ps=1.36 w=0.42 l=0.15
X3253 a_39555_35559# a_39783_35409# a_39729_35435# uio_oe[0] sky130_fd_pr__nfet_01v8 ad=0.1176 pd=1.4 as=0.0567 ps=0.69 w=0.42 l=0.15
X3254 VDPWR a_25940_33417# a_25044_33703# VDPWR sky130_fd_pr__pfet_01v8_hvt ad=0.15835 pd=1.395 as=0.26 ps=2.52 w=1 l=0.15
X3255 a_52573_35229# a_52538_34995# a_52335_34837# uio_oe[0] sky130_fd_pr__nfet_01v8 ad=0.06405 pd=0.725 as=0.1092 ps=1.36 w=0.42 l=0.15
X3256 a_59231_35734# a_58980_35381# a_58772_35559# VDPWR sky130_fd_pr__pfet_01v8_hvt ad=0.0441 pd=0.63 as=0.1932 ps=1.34 w=0.42 l=0.15
X3257 a_61644_38671# a_60729_38671# a_61297_38913# uio_oe[0] sky130_fd_pr__special_nfet_01v8 ad=0.0711 pd=0.755 as=0.0999 ps=0.985 w=0.36 l=0.15
X3258 VDPWR a_40379_35551# a_43220_38127# VDPWR sky130_fd_pr__pfet_01v8_hvt ad=0.07035 pd=0.755 as=0.1092 ps=1.36 w=0.42 l=0.15
X3259 VDPWR a_44905_38671# a_57664_34685# VDPWR sky130_fd_pr__pfet_01v8_hvt ad=0.07035 pd=0.755 as=0.1092 ps=1.36 w=0.42 l=0.15
X3260 VDPWR a_47108_40681# a_47283_40607# VDPWR sky130_fd_pr__pfet_01v8_hvt ad=0.1134 pd=1.38 as=0.0567 ps=0.69 w=0.42 l=0.15
X3261 a_53369_39759# a_53203_39759# uio_oe[0] uio_oe[0] sky130_fd_pr__nfet_01v8 ad=0.1092 pd=1.36 as=0.0567 ps=0.69 w=0.42 l=0.15
X3262 a_59323_39254# a_54479_39228# a_58864_39447# VDPWR sky130_fd_pr__pfet_01v8_hvt ad=0.0441 pd=0.63 as=0.1932 ps=1.34 w=0.42 l=0.15
X3263 a_42643_37405# a_42389_37078# uio_oe[0] uio_oe[0] sky130_fd_pr__nfet_01v8 ad=0.0693 pd=0.75 as=0.1449 ps=1.11 w=0.42 l=0.15
X3264 a_38005_40847# a_37839_40847# uio_oe[0] uio_oe[0] sky130_fd_pr__nfet_01v8 ad=0.08775 pd=0.92 as=0.08775 ps=0.92 w=0.65 l=0.15
X3265 VDPWR a_36327_35381# a_21345_32899# VDPWR sky130_fd_pr__pfet_01v8_hvt ad=0.2279 pd=1.74 as=0.26 ps=2.52 w=1 l=0.15
X3266 ua[5] a_24484_14782# a_24354_22020# uio_oe[0] sky130_fd_pr__nfet_01v8 ad=0.1885 pd=1.88 as=0.1885 ps=1.88 w=0.65 l=0.15
X3267 VDPWR a_48125_43023# a_56843_40821# VDPWR sky130_fd_pr__pfet_01v8_hvt ad=0.0819 pd=0.81 as=0.0567 ps=0.69 w=0.42 l=0.15
X3268 a_59201_40821# a_48677_39759# VDPWR VDPWR sky130_fd_pr__pfet_01v8_hvt ad=0.1176 pd=1.4 as=0.0693 ps=0.75 w=0.42 l=0.15
X3269 a_40945_39759# a_40467_39733# uio_oe[0] uio_oe[0] sky130_fd_pr__nfet_01v8 ad=0.0669 pd=0.75 as=0.12495 ps=1.015 w=0.42 l=0.15
X3270 a_26399_35400# a_18420_33453# a_25940_35593# VDPWR sky130_fd_pr__pfet_01v8_hvt ad=0.0441 pd=0.63 as=0.1932 ps=1.34 w=0.42 l=0.15
X3271 a_30034_14464# a_28348_10376# ua[4] uio_oe[0] sky130_fd_pr__nfet_01v8 ad=0.1885 pd=1.88 as=0.1885 ps=1.88 w=0.65 l=0.15
X3272 VDPWR a_57363_38369# a_57324_38243# VDPWR sky130_fd_pr__pfet_01v8_hvt ad=0.0864 pd=0.91 as=0.1664 ps=1.8 w=0.64 l=0.15
X3273 a_53981_34319# a_53937_34561# a_53815_34319# uio_oe[0] sky130_fd_pr__nfet_01v8 ad=0.0441 pd=0.63 as=0.1401 ps=1.1 w=0.42 l=0.15
X3274 VDPWR a_59695_35925# a_54479_35964# VDPWR sky130_fd_pr__pfet_01v8_hvt ad=0.3012 pd=2.66 as=0.26 ps=2.52 w=1 l=0.15
X3275 VDPWR a_17108_33881# a_17059_33729# VDPWR sky130_fd_pr__pfet_01v8_hvt ad=0.15835 pd=1.395 as=0.26 ps=2.52 w=1 l=0.15
X3276 a_41471_41935# a_37029_38127# a_41108_42087# uio_oe[0] sky130_fd_pr__nfet_01v8 ad=0.0693 pd=0.75 as=0.09975 ps=0.895 w=0.42 l=0.15
X3277 uio_oe[0] a_59201_35381# a_59135_35407# uio_oe[0] sky130_fd_pr__nfet_01v8 ad=0.1449 pd=1.11 as=0.0693 ps=0.75 w=0.42 l=0.15
X3278 a_40495_42453# rst_n uio_oe[0] uio_oe[0] sky130_fd_pr__nfet_01v8 ad=0.169 pd=1.82 as=0.08775 ps=0.92 w=0.65 l=0.15
X3279 a_43598_40847# a_39947_42997# uio_oe[0] uio_oe[0] sky130_fd_pr__nfet_01v8 ad=0.06405 pd=0.725 as=0.12495 ps=1.015 w=0.42 l=0.15
X3280 a_17751_36488# a_17500_33453# a_17292_36681# VDPWR sky130_fd_pr__pfet_01v8_hvt ad=0.0441 pd=0.63 as=0.1932 ps=1.34 w=0.42 l=0.15
X3281 VDPWR a_45351_41695# a_45338_41391# VDPWR sky130_fd_pr__pfet_01v8_hvt ad=0.0819 pd=0.81 as=0.0567 ps=0.69 w=0.42 l=0.15
X3282 a_43428_39759# a_42347_39759# a_43081_40001# VDPWR sky130_fd_pr__pfet_01v8_hvt ad=0.0588 pd=0.7 as=0.12915 ps=1.185 w=0.42 l=0.15
X3283 a_50090_38127# a_49964_38243# a_49686_38259# uio_oe[0] sky130_fd_pr__special_nfet_01v8 ad=0.0999 pd=0.985 as=0.0711 ps=0.755 w=0.36 l=0.15
X3284 a_61998_37583# a_46193_39759# uio_oe[0] uio_oe[0] sky130_fd_pr__nfet_01v8 ad=0.06405 pd=0.725 as=0.12495 ps=1.015 w=0.42 l=0.15
X3285 a_17292_36681# a_17500_33453# a_17434_36815# uio_oe[0] sky130_fd_pr__nfet_01v8 ad=0.09975 pd=0.895 as=0.0693 ps=0.75 w=0.42 l=0.15
X3286 a_54627_42845# a_54479_42492# a_54264_42711# uio_oe[0] sky130_fd_pr__nfet_01v8 ad=0.0693 pd=0.75 as=0.09975 ps=0.895 w=0.42 l=0.15
X3287 a_30034_14464# ua[0] a_29788_14020# uio_oe[0] sky130_fd_pr__nfet_01v8 ad=0.2436 pd=2.26 as=0.2436 ps=2.26 w=0.84 l=0.6
X3288 a_50397_42845# a_48125_43023# uio_oe[0] uio_oe[0] sky130_fd_pr__nfet_01v8 ad=0.0441 pd=0.63 as=0.1346 ps=1.15 w=0.42 l=0.15
X3289 a_57321_42845# a_56843_42453# uio_oe[0] uio_oe[0] sky130_fd_pr__nfet_01v8 ad=0.0669 pd=0.75 as=0.12495 ps=1.015 w=0.42 l=0.15
X3290 uio_oe[0] a_41108_42087# a_41059_41935# uio_oe[0] sky130_fd_pr__nfet_01v8 ad=0.11285 pd=1.045 as=0.169 ps=1.82 w=0.65 l=0.15
X3291 a_39973_41689# a_38005_40847# VDPWR VDPWR sky130_fd_pr__pfet_01v8_hvt ad=0.1176 pd=1.4 as=0.0693 ps=0.75 w=0.42 l=0.15
X3292 a_58980_40821# a_61819_40821# uio_oe[0] uio_oe[0] sky130_fd_pr__nfet_01v8 ad=0.169 pd=1.82 as=0.2087 ps=2.02 w=0.65 l=0.15
X3293 a_49483_39733# a_49686_40011# VDPWR VDPWR sky130_fd_pr__pfet_01v8_hvt ad=0.0567 pd=0.69 as=0.1134 ps=1.38 w=0.42 l=0.15
X3294 a_51841_39513# a_48677_39759# uio_oe[0] uio_oe[0] sky130_fd_pr__nfet_01v8 ad=0.1092 pd=1.36 as=0.1449 ps=1.11 w=0.42 l=0.15
X3295 a_37859_38998# a_36721_37583# a_37787_38998# VDPWR sky130_fd_pr__pfet_01v8_hvt ad=0.1932 pd=1.34 as=0.0441 ps=0.63 w=0.42 l=0.15
X3296 VDPWR a_37747_43023# a_37913_43023# VDPWR sky130_fd_pr__pfet_01v8_hvt ad=0.26 pd=2.52 as=0.135 ps=1.27 w=1 l=0.15
X3297 a_59860_39447# a_59956_39189# VDPWR VDPWR sky130_fd_pr__pfet_01v8_hvt ad=0.1664 pd=1.8 as=0.149 ps=1.325 w=0.64 l=0.15
X3298 uio_oe[0] a_36919_35951# a_37085_35951# uio_oe[0] sky130_fd_pr__nfet_01v8 ad=0.08775 pd=0.92 as=0.08775 ps=0.92 w=0.65 l=0.15
X3299 a_25162_35727# a_25116_35593# uio_oe[0] uio_oe[0] sky130_fd_pr__nfet_01v8 ad=0.0693 pd=0.75 as=0.11285 ps=1.045 w=0.42 l=0.15
X3300 a_24836_33881# a_25044_33703# a_24978_33729# uio_oe[0] sky130_fd_pr__nfet_01v8 ad=0.09975 pd=0.895 as=0.0693 ps=0.75 w=0.42 l=0.15
X3301 a_42897_40277# a_42679_40681# VDPWR VDPWR sky130_fd_pr__pfet_01v8_hvt ad=0.12915 pd=1.185 as=0.2184 ps=2.2 w=0.84 l=0.15
X3302 a_36999_37013# clk uio_oe[0] uio_oe[0] sky130_fd_pr__nfet_01v8 ad=0.169 pd=1.82 as=0.08775 ps=0.92 w=0.65 l=0.15
X3303 a_45351_40607# a_45176_40681# a_45530_40669# uio_oe[0] sky130_fd_pr__nfet_01v8 ad=0.1092 pd=1.36 as=0.06405 ps=0.725 w=0.42 l=0.15
X3304 VDPWR a_50159_38908# a_50090_39037# VDPWR sky130_fd_pr__pfet_01v8_hvt ad=0.2184 pd=2.2 as=0.12915 ps=1.185 w=0.84 l=0.15
X3305 uio_oe[0] a_28884_36681# a_28835_36449# uio_oe[0] sky130_fd_pr__nfet_01v8 ad=0.11285 pd=1.045 as=0.169 ps=1.82 w=0.65 l=0.15
X3306 a_17050_18464# a_16756_18376# ua[4] uio_oe[0] sky130_fd_pr__nfet_01v8 ad=0.1885 pd=1.88 as=0.1885 ps=1.88 w=0.65 l=0.15
X3307 a_60609_36317# a_46193_39759# uio_oe[0] uio_oe[0] sky130_fd_pr__nfet_01v8 ad=0.0441 pd=0.63 as=0.1346 ps=1.15 w=0.42 l=0.15
X3308 a_53321_39581# a_52942_39215# a_53249_39581# uio_oe[0] sky130_fd_pr__nfet_01v8 ad=0.1401 pd=1.1 as=0.0441 ps=0.63 w=0.42 l=0.15
X3309 a_54406_35990# a_37361_41391# VDPWR VDPWR sky130_fd_pr__pfet_01v8_hvt ad=0.07665 pd=0.785 as=0.15835 ps=1.395 w=0.42 l=0.15
X3310 uio_oe[0] a_36327_34293# a_29073_32899# uio_oe[0] sky130_fd_pr__nfet_01v8 ad=0.1013 pd=0.99 as=0.169 ps=1.82 w=0.65 l=0.15
X3311 a_57046_42611# a_57324_42595# a_57280_42479# VDPWR sky130_fd_pr__pfet_01v8_hvt ad=0.0588 pd=0.7 as=0.0567 ps=0.69 w=0.42 l=0.15
X3312 VDPWR a_48125_43023# a_57776_41757# VDPWR sky130_fd_pr__pfet_01v8_hvt ad=0.0798 pd=0.8 as=0.0567 ps=0.69 w=0.42 l=0.15
X3313 a_30034_26464# a_28348_10376# ua[5] uio_oe[0] sky130_fd_pr__nfet_01v8 ad=0.1885 pd=1.88 as=0.1885 ps=1.88 w=0.65 l=0.15
X3314 uio_oe[0] a_50159_41365# a_50090_41391# uio_oe[0] sky130_fd_pr__nfet_01v8 ad=0.1346 pd=1.15 as=0.0999 ps=0.985 w=0.64 l=0.15
X3315 uio_oe[0] a_36447_40849# a_36393_40875# uio_oe[0] sky130_fd_pr__nfet_01v8 ad=0.1118 pd=1.04 as=0.0567 ps=0.69 w=0.42 l=0.15
X3316 a_37148_39215# a_36934_39215# VDPWR VDPWR sky130_fd_pr__pfet_01v8_hvt ad=0.1155 pd=0.97 as=0.07035 ps=0.755 w=0.42 l=0.15
X3317 a_43609_37359# a_43275_37039# a_43525_37039# VDPWR sky130_fd_pr__pfet_01v8_hvt ad=0.3 pd=2.6 as=0.26 ps=2.52 w=1 l=0.15
X3318 a_17050_18464# a_4259_22596# a_16754_16730# uio_oe[0] sky130_fd_pr__nfet_01v8 ad=0.2436 pd=2.26 as=0.2436 ps=2.26 w=0.84 l=0.6
X3319 a_42613_36724# a_43603_39733# VDPWR VDPWR sky130_fd_pr__pfet_01v8_hvt ad=0.26 pd=2.52 as=0.3012 ps=2.66 w=1 l=0.15
X3320 VDPWR a_53937_38913# a_53827_39037# VDPWR sky130_fd_pr__pfet_01v8_hvt ad=0.07035 pd=0.755 as=0.1155 ps=0.97 w=0.42 l=0.15
X3321 a_41149_37013# a_40931_37417# VDPWR VDPWR sky130_fd_pr__pfet_01v8_hvt ad=0.12915 pd=1.185 as=0.2184 ps=2.2 w=0.84 l=0.15
X3322 VDPWR a_58864_37271# a_58298_37269# VDPWR sky130_fd_pr__pfet_01v8_hvt ad=0.15835 pd=1.395 as=0.26 ps=2.52 w=1 l=0.15
X3323 a_42445_36469# a_42907_35951# a_43157_35951# VDPWR sky130_fd_pr__pfet_01v8_hvt ad=0.3 pd=2.6 as=0.26 ps=2.52 w=1 l=0.15
X3324 uio_oe[0] a_16812_8642# a_19538_20730# uio_oe[0] sky130_fd_pr__nfet_01v8 ad=1.4703 pd=10.72 as=1.4703 ps=10.72 w=5.07 l=1
X3325 a_41537_35161# a_37661_38140# uio_oe[0] uio_oe[0] sky130_fd_pr__nfet_01v8 ad=0.1092 pd=1.36 as=0.1449 ps=1.11 w=0.42 l=0.15
X3326 uio_oe[0] a_50003_41633# a_49964_41507# uio_oe[0] sky130_fd_pr__nfet_01v8 ad=0.0567 pd=0.69 as=0.1092 ps=1.36 w=0.42 l=0.15
X3327 uio_oe[0] a_43419_40821# a_43353_40847# uio_oe[0] sky130_fd_pr__nfet_01v8 ad=0.12495 pd=1.015 as=0.0669 ps=0.75 w=0.42 l=0.15
X3328 a_50159_35925# a_49964_36067# a_50469_36317# uio_oe[0] sky130_fd_pr__special_nfet_01v8 ad=0.0594 pd=0.69 as=0.1401 ps=1.1 w=0.36 l=0.15
X3329 a_16812_8642# uio_oe[0] sky130_fd_pr__cap_mim_m3_1 l=22 w=22
X3330 a_60802_39581# a_60584_39529# a_60720_39581# uio_oe[0] sky130_fd_pr__nfet_01v8 ad=0.0441 pd=0.63 as=0.1092 ps=1.36 w=0.42 l=0.15
X3331 a_24778_26464# a_24484_10782# ua[4] uio_oe[0] sky130_fd_pr__nfet_01v8 ad=0.1885 pd=1.88 as=0.1885 ps=1.88 w=0.65 l=0.15
X3332 VDPWR a_43419_41909# a_43406_42301# VDPWR sky130_fd_pr__pfet_01v8_hvt ad=0.0819 pd=0.81 as=0.0567 ps=0.69 w=0.42 l=0.15
X3333 a_50722_41391# a_50003_41633# a_50159_41365# uio_oe[0] sky130_fd_pr__special_nfet_01v8 ad=0.066 pd=0.745 as=0.0594 ps=0.69 w=0.36 l=0.15
X3334 a_49961_40669# a_49483_40277# uio_oe[0] uio_oe[0] sky130_fd_pr__nfet_01v8 ad=0.0669 pd=0.75 as=0.12495 ps=1.015 w=0.42 l=0.15
X3335 uio_oe[0] a_61819_37557# a_61753_37583# uio_oe[0] sky130_fd_pr__nfet_01v8 ad=0.12495 pd=1.015 as=0.0669 ps=0.75 w=0.42 l=0.15
X3336 a_50090_37039# a_50003_37281# a_49686_37171# VDPWR sky130_fd_pr__pfet_01v8_hvt ad=0.12915 pd=1.185 as=0.0588 ps=0.7 w=0.42 l=0.15
X3337 a_29313_36747# a_28980_36681# uio_oe[0] uio_oe[0] sky130_fd_pr__nfet_01v8 ad=0.1092 pd=1.36 as=0.1449 ps=1.11 w=0.42 l=0.15
X3338 a_42897_41089# a_42679_40847# VDPWR VDPWR sky130_fd_pr__pfet_01v8_hvt ad=0.12915 pd=1.185 as=0.2184 ps=2.2 w=0.84 l=0.15
X3339 a_52855_37281# a_37913_41935# uio_oe[0] uio_oe[0] sky130_fd_pr__nfet_01v8 ad=0.1092 pd=1.36 as=0.0567 ps=0.69 w=0.42 l=0.15
X3340 uio_oe[0] a_48125_43023# a_57081_42845# uio_oe[0] sky130_fd_pr__nfet_01v8 ad=0.12495 pd=1.015 as=0.06405 ps=0.725 w=0.42 l=0.15
X3341 a_54284_41935# a_53203_41935# a_53937_42177# VDPWR sky130_fd_pr__pfet_01v8_hvt ad=0.0588 pd=0.7 as=0.12915 ps=1.185 w=0.42 l=0.15
X3342 a_29026_33224# a_28980_33417# VDPWR VDPWR sky130_fd_pr__pfet_01v8_hvt ad=0.07665 pd=0.785 as=0.15835 ps=1.395 w=0.42 l=0.15
X3343 a_24978_33729# a_24932_33881# uio_oe[0] uio_oe[0] sky130_fd_pr__nfet_01v8 ad=0.0693 pd=0.75 as=0.11285 ps=1.045 w=0.42 l=0.15
X3344 VDPWR a_53636_34837# a_53574_34863# VDPWR sky130_fd_pr__pfet_01v8_hvt ad=0.1092 pd=1.36 as=0.0651 ps=0.73 w=0.42 l=0.15
X3345 a_57829_35407# a_57450_35773# a_57757_35407# uio_oe[0] sky130_fd_pr__nfet_01v8 ad=0.1401 pd=1.1 as=0.0441 ps=0.63 w=0.42 l=0.15
X3346 a_24778_26464# a_4259_22596# a_24482_24730# uio_oe[0] sky130_fd_pr__nfet_01v8 ad=0.2436 pd=2.26 as=0.2436 ps=2.26 w=0.84 l=0.6
X3347 ua[4] a_28348_10782# a_31002_10020# uio_oe[0] sky130_fd_pr__nfet_01v8 ad=0.1885 pd=1.88 as=0.1885 ps=1.88 w=0.65 l=0.15
X3348 VDPWR a_47283_42997# a_47270_43389# VDPWR sky130_fd_pr__pfet_01v8_hvt ad=0.0819 pd=0.81 as=0.0567 ps=0.69 w=0.42 l=0.15
X3349 uio_oe[0] a_39947_42997# a_44873_41935# uio_oe[0] sky130_fd_pr__nfet_01v8 ad=0.1346 pd=1.15 as=0.0441 ps=0.63 w=0.42 l=0.15
X3350 VDPWR a_49483_41909# a_39752_41909# VDPWR sky130_fd_pr__pfet_01v8_hvt ad=0.3012 pd=2.66 as=0.26 ps=2.52 w=1 l=0.15
X3351 a_46543_41769# a_46027_41397# a_46448_41757# uio_oe[0] sky130_fd_pr__special_nfet_01v8 ad=0.0594 pd=0.69 as=0.066 ps=0.745 w=0.36 l=0.15
X3352 a_61819_39733# a_61644_39759# a_61998_39759# uio_oe[0] sky130_fd_pr__nfet_01v8 ad=0.1092 pd=1.36 as=0.06405 ps=0.725 w=0.42 l=0.15
X3353 VDPWR a_43428_39759# a_43603_39733# VDPWR sky130_fd_pr__pfet_01v8_hvt ad=0.1134 pd=1.38 as=0.0567 ps=0.69 w=0.42 l=0.15
X3354 a_38285_37583# a_37859_37910# uio_oe[0] uio_oe[0] sky130_fd_pr__nfet_01v8 ad=0.169 pd=1.82 as=0.11285 ps=1.045 w=0.65 l=0.15
X3355 uio_oe[0] uio_oe[0] uio_oe[0] uio_oe[0] sky130_fd_pr__nfet_01v8 ad=1.4703 pd=10.72 as=0 ps=0 w=5.07 l=1
X3356 VDPWR a_44905_38671# a_56843_34293# VDPWR sky130_fd_pr__pfet_01v8_hvt ad=0.0819 pd=0.81 as=0.0567 ps=0.69 w=0.42 l=0.15
X3357 VDPWR a_38961_37557# a_38991_37910# VDPWR sky130_fd_pr__pfet_01v8_hvt ad=0.0693 pd=0.75 as=0.0441 ps=0.63 w=0.42 l=0.15
X3358 a_40931_37417# a_40415_37045# a_40836_37405# uio_oe[0] sky130_fd_pr__special_nfet_01v8 ad=0.0594 pd=0.69 as=0.066 ps=0.745 w=0.36 l=0.15
X3359 a_21585_36747# a_21252_36681# VDPWR VDPWR sky130_fd_pr__pfet_01v8_hvt ad=0.1176 pd=1.4 as=0.0693 ps=0.75 w=0.42 l=0.15
X3360 a_38532_36647# a_38740_36469# a_38674_36495# uio_oe[0] sky130_fd_pr__nfet_01v8 ad=0.09975 pd=0.895 as=0.0693 ps=0.75 w=0.42 l=0.15
X3361 uio_oe[0] a_57472_41669# a_57556_41365# uio_oe[0] sky130_fd_pr__nfet_01v8 ad=0.0567 pd=0.69 as=0.1092 ps=1.36 w=0.42 l=0.15
X3362 a_39973_40821# a_38005_40847# uio_oe[0] uio_oe[0] sky130_fd_pr__nfet_01v8 ad=0.1092 pd=1.36 as=0.1449 ps=1.11 w=0.42 l=0.15
X3363 a_53369_38671# a_53203_38671# uio_oe[0] uio_oe[0] sky130_fd_pr__nfet_01v8 ad=0.1092 pd=1.36 as=0.0567 ps=0.69 w=0.42 l=0.15
X3364 uio_oe[0] a_37661_38140# a_38080_38493# uio_oe[0] sky130_fd_pr__nfet_01v8 ad=0.11285 pd=1.045 as=0.0693 ps=0.75 w=0.42 l=0.15
X3365 a_43327_36647# a_37795_40535# VDPWR VDPWR sky130_fd_pr__pfet_01v8_hvt ad=0.0567 pd=0.69 as=0.16655 ps=1.39 w=0.42 l=0.15
X3366 a_40775_35644# a_40619_35549# a_40920_35773# VDPWR sky130_fd_pr__pfet_01v8_hvt ad=0.07245 pd=0.765 as=0.1155 ps=0.97 w=0.42 l=0.15
X3367 a_57081_35407# a_57046_35659# a_56843_35381# uio_oe[0] sky130_fd_pr__nfet_01v8 ad=0.06405 pd=0.725 as=0.1092 ps=1.36 w=0.42 l=0.15
X3368 a_57519_42172# a_57363_42077# a_57664_42301# VDPWR sky130_fd_pr__pfet_01v8_hvt ad=0.07245 pd=0.765 as=0.1155 ps=0.97 w=0.42 l=0.15
X3369 a_20620_18376# a_22575_35183# VDPWR VDPWR sky130_fd_pr__pfet_01v8_hvt ad=0.26 pd=2.52 as=0.2279 ps=1.74 w=1 l=0.15
X3370 a_18641_36747# a_17388_36681# uio_oe[0] uio_oe[0] sky130_fd_pr__nfet_01v8 ad=0.1092 pd=1.36 as=0.1449 ps=1.11 w=0.42 l=0.15
X3371 VDPWR a_26369_36747# a_26399_36488# VDPWR sky130_fd_pr__pfet_01v8_hvt ad=0.0693 pd=0.75 as=0.0441 ps=0.63 w=0.42 l=0.15
X3372 a_45285_43023# a_44095_43023# a_45176_43023# uio_oe[0] sky130_fd_pr__special_nfet_01v8 ad=0.0669 pd=0.75 as=0.0711 ps=0.755 w=0.36 l=0.15
X3373 a_41250_42262# a_38285_34863# VDPWR VDPWR sky130_fd_pr__pfet_01v8_hvt ad=0.07665 pd=0.785 as=0.15835 ps=1.395 w=0.42 l=0.15
X3374 VDPWR a_45095_39733# a_43918_36041# VDPWR sky130_fd_pr__pfet_01v8_hvt ad=0.135 pd=1.27 as=0.135 ps=1.27 w=1 l=0.15
X3375 a_19588_10020# a_16812_8642# uio_oe[0] uio_oe[0] sky130_fd_pr__nfet_01v8 ad=1.4703 pd=10.72 as=1.4703 ps=10.72 w=5.07 l=1
X3376 VDPWR a_17255_32793# a_17243_33007# VDPWR sky130_fd_pr__pfet_01v8_hvt ad=0.0714 pd=0.76 as=0.1092 ps=1.36 w=0.42 l=0.15
X3377 VDPWR a_37795_40535# a_38019_36861# VDPWR sky130_fd_pr__pfet_01v8_hvt ad=0.2279 pd=1.74 as=0.0609 ps=0.71 w=0.42 l=0.15
X3378 a_27266_20730# ua[1] a_27138_22020# uio_oe[0] sky130_fd_pr__nfet_01v8 ad=0.2436 pd=2.26 as=0.2436 ps=2.26 w=0.84 l=0.6
X3379 VDPWR a_17537_34791# a_17567_35144# VDPWR sky130_fd_pr__pfet_01v8_hvt ad=0.0693 pd=0.75 as=0.0441 ps=0.63 w=0.42 l=0.15
X3380 uio_oe[0] a_61624_42711# a_60996_42453# uio_oe[0] sky130_fd_pr__nfet_01v8 ad=0.11285 pd=1.045 as=0.169 ps=1.82 w=0.65 l=0.15
X3381 a_53156_40303# a_52942_40303# VDPWR VDPWR sky130_fd_pr__pfet_01v8_hvt ad=0.1155 pd=0.97 as=0.07035 ps=0.755 w=0.42 l=0.15
X3382 a_45443_38823# a_36875_38823# a_45617_38699# uio_oe[0] sky130_fd_pr__nfet_01v8 ad=0.1176 pd=1.4 as=0.0567 ps=0.69 w=0.42 l=0.15
X3383 a_57450_37949# a_57324_37851# a_57046_37835# uio_oe[0] sky130_fd_pr__special_nfet_01v8 ad=0.0999 pd=0.985 as=0.0711 ps=0.755 w=0.36 l=0.15
X3384 uio_oe[0] a_40188_35095# a_39759_38140# uio_oe[0] sky130_fd_pr__nfet_01v8 ad=0.11285 pd=1.045 as=0.169 ps=1.82 w=0.65 l=0.15
X3385 a_18148_18376# a_18711_34095# uio_oe[0] uio_oe[0] sky130_fd_pr__nfet_01v8 ad=0.169 pd=1.82 as=0.1013 ps=0.99 w=0.65 l=0.15
X3386 a_43428_39593# a_42513_39221# a_43081_39189# uio_oe[0] sky130_fd_pr__special_nfet_01v8 ad=0.0711 pd=0.755 as=0.0999 ps=0.985 w=0.36 l=0.15
X3387 a_54264_36183# a_54479_35964# a_54406_35990# VDPWR sky130_fd_pr__pfet_01v8_hvt ad=0.1932 pd=1.34 as=0.07665 ps=0.785 w=0.42 l=0.15
X3388 a_39127_34319# a_38285_38671# VDPWR VDPWR sky130_fd_pr__pfet_01v8_hvt ad=0.135 pd=1.27 as=0.26 ps=2.52 w=1 l=0.15
X3389 a_43353_41769# a_42163_41397# a_43244_41769# uio_oe[0] sky130_fd_pr__special_nfet_01v8 ad=0.0669 pd=0.75 as=0.0711 ps=0.755 w=0.36 l=0.15
X3390 a_38089_40623# a_37755_40303# a_38005_40303# VDPWR sky130_fd_pr__pfet_01v8_hvt ad=0.3 pd=2.6 as=0.26 ps=2.52 w=1 l=0.15
X3391 ua[5] a_28348_14782# a_31002_22020# uio_oe[0] sky130_fd_pr__nfet_01v8 ad=0.1885 pd=1.88 as=0.1885 ps=1.88 w=0.65 l=0.15
X3392 uio_oe[0] a_36661_41391# a_52325_41174# uio_oe[0] sky130_fd_pr__nfet_01v8 ad=0.1449 pd=1.11 as=0.1092 ps=1.36 w=0.42 l=0.15
X3393 a_38073_38998# a_37433_35665# a_37859_38998# VDPWR sky130_fd_pr__pfet_01v8_hvt ad=0.07665 pd=0.785 as=0.1932 ps=1.34 w=0.42 l=0.15
X3394 uio_oe[0] a_46193_39759# a_53981_37583# uio_oe[0] sky130_fd_pr__nfet_01v8 ad=0.1346 pd=1.15 as=0.0441 ps=0.63 w=0.42 l=0.15
X3395 a_24484_10782# a_26439_37359# VDPWR VDPWR sky130_fd_pr__pfet_01v8_hvt ad=0.26 pd=2.52 as=0.2279 ps=1.74 w=1 l=0.15
X3396 a_52800_34319# a_51620_34293# a_52579_34646# uio_oe[0] sky130_fd_pr__nfet_01v8 ad=0.0693 pd=0.75 as=0.09975 ps=0.895 w=0.42 l=0.15
X3397 a_18212_34505# a_18420_33453# a_18354_34639# uio_oe[0] sky130_fd_pr__nfet_01v8 ad=0.09975 pd=0.895 as=0.0693 ps=0.75 w=0.42 l=0.15
X3398 a_59293_35161# a_48677_38127# VDPWR VDPWR sky130_fd_pr__pfet_01v8_hvt ad=0.1176 pd=1.4 as=0.0693 ps=0.75 w=0.42 l=0.15
X3399 a_57694_41391# a_57472_41669# a_57012_41365# VDPWR sky130_fd_pr__pfet_01v8_hvt ad=0.0483 pd=0.65 as=0.0819 ps=0.81 w=0.42 l=0.15
X3400 a_21114_37320# a_21068_37145# VDPWR VDPWR sky130_fd_pr__pfet_01v8_hvt ad=0.07665 pd=0.785 as=0.15835 ps=1.395 w=0.42 l=0.15
X3401 VDPWR a_52855_37281# a_52816_37155# VDPWR sky130_fd_pr__pfet_01v8_hvt ad=0.0864 pd=0.91 as=0.1664 ps=1.8 w=0.64 l=0.15
X3402 uio_oe[0] a_25417_32641# a_25825_35933# uio_oe[0] sky130_fd_pr__nfet_01v8 ad=0.1118 pd=1.04 as=0.0567 ps=0.69 w=0.42 l=0.15
X3403 a_39686_38166# a_38005_40847# VDPWR VDPWR sky130_fd_pr__pfet_01v8_hvt ad=0.07665 pd=0.785 as=0.15835 ps=1.395 w=0.42 l=0.15
X3404 VDPWR a_56843_38101# a_39752_38395# VDPWR sky130_fd_pr__pfet_01v8_hvt ad=0.3012 pd=2.66 as=0.26 ps=2.52 w=1 l=0.15
X3405 uio_oe[0] a_28884_35593# a_28835_35361# uio_oe[0] sky130_fd_pr__nfet_01v8 ad=0.11285 pd=1.045 as=0.169 ps=1.82 w=0.65 l=0.15
X3406 ua[4] a_24484_10376# a_25746_22020# uio_oe[0] sky130_fd_pr__nfet_01v8 ad=0.1885 pd=1.88 as=0.1885 ps=1.88 w=0.65 l=0.15
X3407 a_45285_42857# a_44095_42485# a_45176_42857# uio_oe[0] sky130_fd_pr__special_nfet_01v8 ad=0.0669 pd=0.75 as=0.0711 ps=0.755 w=0.36 l=0.15
X3408 a_62053_42777# a_36661_41391# uio_oe[0] uio_oe[0] sky130_fd_pr__nfet_01v8 ad=0.1092 pd=1.36 as=0.1449 ps=1.11 w=0.42 l=0.15
X3409 a_44327_39447# a_45351_40607# VDPWR VDPWR sky130_fd_pr__pfet_01v8_hvt ad=0.26 pd=2.52 as=0.3012 ps=2.66 w=1 l=0.15
X3410 ua[5] a_16756_14376# a_16626_14020# uio_oe[0] sky130_fd_pr__nfet_01v8 ad=0.1885 pd=1.88 as=0.1885 ps=1.88 w=0.65 l=0.15
X3411 VDPWR a_48125_43023# a_57664_40303# VDPWR sky130_fd_pr__pfet_01v8_hvt ad=0.07035 pd=0.755 as=0.1092 ps=1.36 w=0.42 l=0.15
X3412 a_40670_40011# a_40987_39901# a_40945_39759# uio_oe[0] sky130_fd_pr__special_nfet_01v8 ad=0.0711 pd=0.755 as=0.0669 ps=0.75 w=0.36 l=0.15
X3413 a_43782_39581# a_40379_35551# uio_oe[0] uio_oe[0] sky130_fd_pr__nfet_01v8 ad=0.06405 pd=0.725 as=0.12495 ps=1.015 w=0.42 l=0.15
X3414 a_49721_38493# a_49686_38259# a_49483_38101# uio_oe[0] sky130_fd_pr__nfet_01v8 ad=0.06405 pd=0.725 as=0.1092 ps=1.36 w=0.42 l=0.15
X3415 uio_oe[0] uio_oe[0] uio_oe[0] uio_oe[0] sky130_fd_pr__nfet_01v8 ad=0.1885 pd=1.88 as=0 ps=0 w=0.65 l=0.15
X3416 uio_oe[0] a_59695_40277# a_54479_40316# uio_oe[0] sky130_fd_pr__nfet_01v8 ad=0.2087 pd=2.02 as=0.169 ps=1.82 w=0.65 l=0.15
X3417 VDPWR a_43081_40001# a_42971_40125# VDPWR sky130_fd_pr__pfet_01v8_hvt ad=0.07035 pd=0.755 as=0.1155 ps=0.97 w=0.42 l=0.15
X3418 a_37859_37583# a_37605_37910# uio_oe[0] uio_oe[0] sky130_fd_pr__nfet_01v8 ad=0.0693 pd=0.75 as=0.1449 ps=1.11 w=0.42 l=0.15
X3419 uio_oe[0] a_54693_39513# a_54627_39581# uio_oe[0] sky130_fd_pr__nfet_01v8 ad=0.1449 pd=1.11 as=0.0693 ps=0.75 w=0.42 l=0.15
X3420 a_38991_38166# a_38740_38395# a_38532_38359# VDPWR sky130_fd_pr__pfet_01v8_hvt ad=0.0441 pd=0.63 as=0.1932 ps=1.34 w=0.42 l=0.15
X3421 a_25199_36993# a_24971_36449# a_24836_37145# uio_oe[0] sky130_fd_pr__nfet_01v8 ad=0.0693 pd=0.75 as=0.09975 ps=0.895 w=0.42 l=0.15
X3422 a_52813_41757# a_52335_41365# uio_oe[0] uio_oe[0] sky130_fd_pr__nfet_01v8 ad=0.0669 pd=0.75 as=0.12495 ps=1.015 w=0.42 l=0.15
X3423 a_38961_37337# a_37029_37583# VDPWR VDPWR sky130_fd_pr__pfet_01v8_hvt ad=0.1176 pd=1.4 as=0.0693 ps=0.75 w=0.42 l=0.15
X3424 a_58082_40303# a_57363_40545# a_57519_40277# uio_oe[0] sky130_fd_pr__special_nfet_01v8 ad=0.066 pd=0.745 as=0.0594 ps=0.69 w=0.36 l=0.15
X3425 uio_oe[0] a_16812_8642# a_16812_8642# uio_oe[0] sky130_fd_pr__nfet_01v8 ad=1.16 pd=8.29 as=2.32 ps=16.58 w=8 l=1
X3426 VDPWR a_51412_35095# a_50784_34837# VDPWR sky130_fd_pr__pfet_01v8_hvt ad=0.15835 pd=1.395 as=0.26 ps=2.52 w=1 l=0.15
X3427 a_50159_34837# a_49964_34979# a_50469_35229# uio_oe[0] sky130_fd_pr__special_nfet_01v8 ad=0.0594 pd=0.69 as=0.1401 ps=1.1 w=0.36 l=0.15
X3428 a_54284_35407# a_53203_35407# a_53937_35649# VDPWR sky130_fd_pr__pfet_01v8_hvt ad=0.0588 pd=0.7 as=0.12915 ps=1.185 w=0.42 l=0.15
X3429 uio_oe[0] a_49483_39189# a_38740_39483# uio_oe[0] sky130_fd_pr__nfet_01v8 ad=0.2087 pd=2.02 as=0.169 ps=1.82 w=0.65 l=0.15
X3430 uio_oe[0] a_36355_38101# a_36385_38127# uio_oe[0] sky130_fd_pr__nfet_01v8 ad=0.08775 pd=0.92 as=0.08775 ps=0.92 w=0.65 l=0.15
X3431 ua[4] a_24484_10376# a_27138_26020# uio_oe[0] sky130_fd_pr__nfet_01v8 ad=0.1885 pd=1.88 as=0.1885 ps=1.88 w=0.65 l=0.15
X3432 a_50722_40303# a_50003_40545# a_50159_40277# uio_oe[0] sky130_fd_pr__special_nfet_01v8 ad=0.066 pd=0.745 as=0.0594 ps=0.69 w=0.36 l=0.15
X3433 a_51841_39733# a_48677_39759# uio_oe[0] uio_oe[0] sky130_fd_pr__nfet_01v8 ad=0.1092 pd=1.36 as=0.1449 ps=1.11 w=0.42 l=0.15
X3434 a_29063_35905# a_28835_35361# a_28700_36057# uio_oe[0] sky130_fd_pr__nfet_01v8 ad=0.0693 pd=0.75 as=0.09975 ps=0.895 w=0.42 l=0.15
X3435 uio_oe[0] uio_oe[0] uio_oe[0] uio_oe[0] sky130_fd_pr__nfet_01v8 ad=1.4703 pd=10.72 as=0 ps=0 w=5.07 l=1
X3436 ua[5] a_18148_18376# a_18018_18020# uio_oe[0] sky130_fd_pr__nfet_01v8 ad=0.1885 pd=1.88 as=0.1885 ps=1.88 w=0.65 l=0.15
X3437 a_51554_38166# a_48677_38127# VDPWR VDPWR sky130_fd_pr__pfet_01v8_hvt ad=0.07665 pd=0.785 as=0.15835 ps=1.395 w=0.42 l=0.15
X3438 a_46805_43023# a_46761_43265# a_46639_43023# uio_oe[0] sky130_fd_pr__nfet_01v8 ad=0.0441 pd=0.63 as=0.1401 ps=1.1 w=0.42 l=0.15
X3439 a_57430_41757# a_57148_41391# a_57354_41757# uio_oe[0] sky130_fd_pr__nfet_01v8 ad=0.0441 pd=0.63 as=0.0483 ps=0.65 w=0.42 l=0.15
X3440 a_20914_14464# a_20620_14782# ua[5] uio_oe[0] sky130_fd_pr__nfet_01v8 ad=0.1885 pd=1.88 as=0.1885 ps=1.88 w=0.65 l=0.15
X3441 a_41685_42479# a_41519_42479# VDPWR VDPWR sky130_fd_pr__pfet_01v8_hvt ad=0.135 pd=1.27 as=0.135 ps=1.27 w=1 l=0.15
X3442 uio_oe[0] a_53011_40277# a_52942_40303# uio_oe[0] sky130_fd_pr__nfet_01v8 ad=0.1346 pd=1.15 as=0.0999 ps=0.985 w=0.64 l=0.15
X3443 a_59201_36249# a_48677_38127# uio_oe[0] uio_oe[0] sky130_fd_pr__nfet_01v8 ad=0.1092 pd=1.36 as=0.1449 ps=1.11 w=0.42 l=0.15
X3444 a_25876_18782# a_25739_33757# VDPWR VDPWR sky130_fd_pr__pfet_01v8_hvt ad=0.475 pd=2.95 as=0.16655 ps=1.39 w=1 l=0.15
X3445 a_46543_40681# a_46027_40309# a_46448_40669# uio_oe[0] sky130_fd_pr__special_nfet_01v8 ad=0.0594 pd=0.69 as=0.066 ps=0.745 w=0.36 l=0.15
X3446 a_61819_38645# a_61644_38671# a_61998_38671# uio_oe[0] sky130_fd_pr__nfet_01v8 ad=0.1092 pd=1.36 as=0.06405 ps=0.725 w=0.42 l=0.15
X3447 a_50003_34461# a_41685_42479# VDPWR VDPWR sky130_fd_pr__pfet_01v8_hvt ad=0.1664 pd=1.8 as=0.0864 ps=0.91 w=0.64 l=0.15
X3448 a_49686_34995# a_49964_34979# a_49920_34863# VDPWR sky130_fd_pr__pfet_01v8_hvt ad=0.0588 pd=0.7 as=0.0567 ps=0.69 w=0.42 l=0.15
X3449 a_57519_35644# a_57363_35549# a_57664_35773# VDPWR sky130_fd_pr__pfet_01v8_hvt ad=0.07245 pd=0.765 as=0.1155 ps=0.97 w=0.42 l=0.15
X3450 a_49686_41099# a_50003_40989# a_49961_40847# uio_oe[0] sky130_fd_pr__special_nfet_01v8 ad=0.0711 pd=0.755 as=0.0669 ps=0.75 w=0.36 l=0.15
X3451 a_57757_34319# a_44905_38671# uio_oe[0] uio_oe[0] sky130_fd_pr__nfet_01v8 ad=0.0441 pd=0.63 as=0.1346 ps=1.15 w=0.42 l=0.15
X3452 uio_oe[0] a_38005_41391# a_42163_43023# uio_oe[0] sky130_fd_pr__nfet_01v8 ad=0.0567 pd=0.69 as=0.1092 ps=1.36 w=0.42 l=0.15
X3453 a_41108_42087# a_37029_38127# a_41250_42262# VDPWR sky130_fd_pr__pfet_01v8_hvt ad=0.1932 pd=1.34 as=0.07665 ps=0.785 w=0.42 l=0.15
X3454 a_31426_26464# a_28348_10782# ua[4] uio_oe[0] sky130_fd_pr__nfet_01v8 ad=0.1885 pd=1.88 as=0.1885 ps=1.88 w=0.65 l=0.15
X3455 a_38080_42845# a_37042_34863# a_37859_42518# uio_oe[0] sky130_fd_pr__nfet_01v8 ad=0.0693 pd=0.75 as=0.09975 ps=0.895 w=0.42 l=0.15
X3456 a_52942_42479# a_52816_42595# a_52538_42611# uio_oe[0] sky130_fd_pr__special_nfet_01v8 ad=0.0999 pd=0.985 as=0.0711 ps=0.755 w=0.36 l=0.15
X3457 VDPWR a_37839_41391# a_38005_41391# VDPWR sky130_fd_pr__pfet_01v8_hvt ad=0.26 pd=2.52 as=0.135 ps=1.27 w=1 l=0.15
X3458 uio_oe[0] a_43603_39519# a_43537_39593# uio_oe[0] sky130_fd_pr__nfet_01v8 ad=0.12495 pd=1.015 as=0.0669 ps=0.75 w=0.42 l=0.15
X3459 a_44905_38671# a_44739_38671# VDPWR VDPWR sky130_fd_pr__pfet_01v8_hvt ad=0.135 pd=1.27 as=0.135 ps=1.27 w=1 l=0.15
X3460 a_41671_37343# a_40379_35551# VDPWR VDPWR sky130_fd_pr__pfet_01v8_hvt ad=0.0567 pd=0.69 as=0.0819 ps=0.81 w=0.42 l=0.15
X3461 VDPWR a_46193_39759# a_59695_35925# VDPWR sky130_fd_pr__pfet_01v8_hvt ad=0.0819 pd=0.81 as=0.0567 ps=0.69 w=0.42 l=0.15
X3462 a_22306_18464# a_22012_18782# ua[5] uio_oe[0] sky130_fd_pr__nfet_01v8 ad=0.1885 pd=1.88 as=0.1885 ps=1.88 w=0.65 l=0.15
X3463 VDPWR a_40096_34471# a_39759_41129# VDPWR sky130_fd_pr__pfet_01v8_hvt ad=0.15835 pd=1.395 as=0.26 ps=2.52 w=1 l=0.15
X3464 a_57046_37835# a_57324_37851# a_57280_37949# VDPWR sky130_fd_pr__pfet_01v8_hvt ad=0.0588 pd=0.7 as=0.0567 ps=0.69 w=0.42 l=0.15
X3465 a_25162_35400# a_25116_35593# VDPWR VDPWR sky130_fd_pr__pfet_01v8_hvt ad=0.07665 pd=0.785 as=0.15835 ps=1.395 w=0.42 l=0.15
X3466 a_42467_40474# a_43419_40821# uio_oe[0] uio_oe[0] sky130_fd_pr__nfet_01v8 ad=0.169 pd=1.82 as=0.2087 ps=2.02 w=0.65 l=0.15
X3467 a_46761_41089# a_46543_40847# uio_oe[0] uio_oe[0] sky130_fd_pr__nfet_01v8 ad=0.0999 pd=0.985 as=0.1346 ps=1.15 w=0.64 l=0.15
X3468 VDPWR a_54264_40535# a_53636_40277# VDPWR sky130_fd_pr__pfet_01v8_hvt ad=0.15835 pd=1.395 as=0.26 ps=2.52 w=1 l=0.15
X3469 a_50003_35105# a_41685_42479# uio_oe[0] uio_oe[0] sky130_fd_pr__nfet_01v8 ad=0.1092 pd=1.36 as=0.0567 ps=0.69 w=0.42 l=0.15
X3470 a_54284_35407# a_53369_35407# a_53937_35649# uio_oe[0] sky130_fd_pr__special_nfet_01v8 ad=0.0711 pd=0.755 as=0.0999 ps=0.985 w=0.36 l=0.15
X3471 uio_oe[0] a_48125_41935# a_52573_41757# uio_oe[0] sky130_fd_pr__nfet_01v8 ad=0.12495 pd=1.015 as=0.06405 ps=0.725 w=0.42 l=0.15
X3472 uio_oe[0] a_43156_34293# a_43032_34569# uio_oe[0] sky130_fd_pr__nfet_01v8 ad=0.10025 pd=0.985 as=0.0567 ps=0.69 w=0.42 l=0.15
X3473 uio_oe[0] rst_n a_46027_39759# uio_oe[0] sky130_fd_pr__nfet_01v8 ad=0.08775 pd=0.92 as=0.169 ps=1.82 w=0.65 l=0.15
X3474 uio_oe[0] a_56843_39733# a_38740_39733# uio_oe[0] sky130_fd_pr__nfet_01v8 ad=0.2087 pd=2.02 as=0.169 ps=1.82 w=0.65 l=0.15
X3475 VDPWR a_36427_36475# a_38073_38998# VDPWR sky130_fd_pr__pfet_01v8_hvt ad=0.15835 pd=1.395 as=0.07665 ps=0.785 w=0.42 l=0.15
X3476 a_31426_26464# a_4259_22596# a_31130_24730# uio_oe[0] sky130_fd_pr__nfet_01v8 ad=0.2436 pd=2.26 as=0.2436 ps=2.26 w=0.84 l=0.6
X3477 uio_oe[0] a_16812_8642# a_29738_20730# uio_oe[0] sky130_fd_pr__nfet_01v8 ad=1.4703 pd=10.72 as=1.4703 ps=10.72 w=5.07 l=1
X3478 a_42897_40277# a_42679_40681# uio_oe[0] uio_oe[0] sky130_fd_pr__nfet_01v8 ad=0.0999 pd=0.985 as=0.1346 ps=1.15 w=0.64 l=0.15
X3479 a_57519_40277# a_57324_40419# a_57829_40669# uio_oe[0] sky130_fd_pr__special_nfet_01v8 ad=0.0594 pd=0.69 as=0.1401 ps=1.1 w=0.36 l=0.15
X3480 a_42643_36822# a_42613_36724# a_42571_36822# VDPWR sky130_fd_pr__pfet_01v8_hvt ad=0.1932 pd=1.34 as=0.0441 ps=0.63 w=0.42 l=0.15
X3481 uio_oe[0] a_21553_32641# a_22665_35905# uio_oe[0] sky130_fd_pr__nfet_01v8 ad=0.1013 pd=0.99 as=0.0504 ps=0.66 w=0.42 l=0.15
X3482 a_29689_33757# a_28651_33729# a_29603_33757# uio_oe[0] sky130_fd_pr__nfet_01v8 ad=0.0567 pd=0.69 as=0.1176 ps=1.4 w=0.42 l=0.15
X3483 a_44399_41562# a_45351_41909# uio_oe[0] uio_oe[0] sky130_fd_pr__nfet_01v8 ad=0.169 pd=1.82 as=0.2087 ps=2.02 w=0.65 l=0.15
X3484 a_46639_40847# a_46193_40847# a_46543_40847# uio_oe[0] sky130_fd_pr__special_nfet_01v8 ad=0.1401 pd=1.1 as=0.0594 ps=0.69 w=0.36 l=0.15
X3485 a_41171_40342# a_37661_37052# a_41171_40669# uio_oe[0] sky130_fd_pr__nfet_01v8 ad=0.09975 pd=0.895 as=0.0693 ps=0.75 w=0.42 l=0.15
X3486 a_20972_37145# a_21107_36449# a_21114_37320# VDPWR sky130_fd_pr__pfet_01v8_hvt ad=0.1932 pd=1.34 as=0.07665 ps=0.785 w=0.42 l=0.15
X3487 a_41027_37417# a_40581_37045# a_40931_37417# uio_oe[0] sky130_fd_pr__special_nfet_01v8 ad=0.1401 pd=1.1 as=0.0594 ps=0.69 w=0.36 l=0.15
X3488 a_50722_42479# a_49964_42595# a_50159_42453# VDPWR sky130_fd_pr__pfet_01v8_hvt ad=0.0651 pd=0.73 as=0.07245 ps=0.765 w=0.42 l=0.15
X3489 a_38961_41909# a_38005_40847# VDPWR VDPWR sky130_fd_pr__pfet_01v8_hvt ad=0.1176 pd=1.4 as=0.0693 ps=0.75 w=0.42 l=0.15
X3490 a_46193_39759# a_46027_39759# VDPWR VDPWR sky130_fd_pr__pfet_01v8_hvt ad=0.135 pd=1.27 as=0.135 ps=1.27 w=1 l=0.15
X3491 a_39544_38359# a_39759_38140# a_39686_38166# VDPWR sky130_fd_pr__pfet_01v8_hvt ad=0.1932 pd=1.34 as=0.07665 ps=0.785 w=0.42 l=0.15
X3492 a_50003_39457# a_38649_43023# VDPWR VDPWR sky130_fd_pr__pfet_01v8_hvt ad=0.1664 pd=1.8 as=0.0864 ps=0.91 w=0.64 l=0.15
X3493 a_41420_39037# a_40415_38671# a_41344_39037# VDPWR sky130_fd_pr__pfet_01v8_hvt ad=0.0819 pd=0.81 as=0.0483 ps=0.65 w=0.42 l=0.15
X3494 uio_oe[0] a_50784_35925# a_50722_35951# uio_oe[0] sky130_fd_pr__nfet_01v8 ad=0.2205 pd=1.89 as=0.066 ps=0.745 w=0.42 l=0.15
X3495 a_43353_40681# a_42163_40309# a_43244_40681# uio_oe[0] sky130_fd_pr__special_nfet_01v8 ad=0.0669 pd=0.75 as=0.0711 ps=0.755 w=0.36 l=0.15
X3496 a_44829_41365# a_44611_41769# uio_oe[0] uio_oe[0] sky130_fd_pr__nfet_01v8 ad=0.0999 pd=0.985 as=0.1346 ps=1.15 w=0.64 l=0.15
X3497 a_38005_40847# a_37839_40847# uio_oe[0] uio_oe[0] sky130_fd_pr__nfet_01v8 ad=0.08775 pd=0.92 as=0.08775 ps=0.92 w=0.65 l=0.15
X3498 a_42864_37405# a_42613_37052# a_42643_37078# uio_oe[0] sky130_fd_pr__nfet_01v8 ad=0.0693 pd=0.75 as=0.09975 ps=0.895 w=0.42 l=0.15
X3499 a_37641_35407# a_37375_35773# uio_oe[0] uio_oe[0] sky130_fd_pr__nfet_01v8 ad=0.169 pd=1.82 as=0.1013 ps=0.99 w=0.65 l=0.15
X3500 a_18212_33417# a_18420_33453# a_18354_33551# uio_oe[0] sky130_fd_pr__nfet_01v8 ad=0.09975 pd=0.895 as=0.0693 ps=0.75 w=0.42 l=0.15
X3501 VDPWR a_37661_37052# a_37605_37078# VDPWR sky130_fd_pr__pfet_01v8_hvt ad=0.0693 pd=0.75 as=0.1176 ps=1.4 w=0.42 l=0.15
X3502 VDPWR a_36503_35381# a_36327_35381# VDPWR sky130_fd_pr__pfet_01v8_hvt ad=0.0714 pd=0.76 as=0.0609 ps=0.71 w=0.42 l=0.15
X3503 a_20618_16730# ua[2] a_20490_18020# uio_oe[0] sky130_fd_pr__nfet_01v8 ad=0.2436 pd=2.26 as=0.2436 ps=2.26 w=0.84 l=0.6
X3504 a_18097_34845# a_17059_34817# a_18011_34845# uio_oe[0] sky130_fd_pr__nfet_01v8 ad=0.0567 pd=0.69 as=0.1176 ps=1.4 w=0.42 l=0.15
X3505 VDPWR a_48125_43023# a_56843_40277# VDPWR sky130_fd_pr__pfet_01v8_hvt ad=0.0819 pd=0.81 as=0.0567 ps=0.69 w=0.42 l=0.15
X3506 a_40987_39901# a_38005_41391# VDPWR VDPWR sky130_fd_pr__pfet_01v8_hvt ad=0.1664 pd=1.8 as=0.0864 ps=0.91 w=0.64 l=0.15
X3507 a_41750_37949# a_40673_37583# a_41588_37583# VDPWR sky130_fd_pr__pfet_01v8_hvt ad=0.0567 pd=0.69 as=0.0588 ps=0.7 w=0.42 l=0.15
X3508 a_57363_40545# a_38649_43023# uio_oe[0] uio_oe[0] sky130_fd_pr__nfet_01v8 ad=0.1092 pd=1.36 as=0.0567 ps=0.69 w=0.42 l=0.15
X3509 a_51412_38359# a_38740_38395# a_51554_38166# VDPWR sky130_fd_pr__pfet_01v8_hvt ad=0.1932 pd=1.34 as=0.07665 ps=0.785 w=0.42 l=0.15
X3510 VDPWR a_50159_39189# a_50090_39215# VDPWR sky130_fd_pr__pfet_01v8_hvt ad=0.2184 pd=2.2 as=0.12915 ps=1.185 w=0.84 l=0.15
X3511 a_61079_37583# a_60563_37583# a_60984_37583# uio_oe[0] sky130_fd_pr__special_nfet_01v8 ad=0.0594 pd=0.69 as=0.066 ps=0.745 w=0.36 l=0.15
X3512 uio_oe[0] a_17721_36747# a_17655_36815# uio_oe[0] sky130_fd_pr__nfet_01v8 ad=0.1449 pd=1.11 as=0.0693 ps=0.75 w=0.42 l=0.15
X3513 a_40581_36495# a_40415_36495# uio_oe[0] uio_oe[0] sky130_fd_pr__nfet_01v8 ad=0.1092 pd=1.36 as=0.0567 ps=0.69 w=0.42 l=0.15
X3514 a_56916_39447# a_57012_39189# VDPWR VDPWR sky130_fd_pr__pfet_01v8_hvt ad=0.1664 pd=1.8 as=0.149 ps=1.325 w=0.64 l=0.15
X3515 a_52335_38101# a_52538_38259# VDPWR VDPWR sky130_fd_pr__pfet_01v8_hvt ad=0.0567 pd=0.69 as=0.1134 ps=1.38 w=0.42 l=0.15
X3516 a_22665_35905# a_22395_36271# a_22575_36271# uio_oe[0] sky130_fd_pr__nfet_01v8 ad=0.0504 pd=0.66 as=0.1092 ps=1.36 w=0.42 l=0.15
X3517 a_58248_39215# a_57556_39189# a_57640_39529# VDPWR sky130_fd_pr__pfet_01v8_hvt ad=0.12495 pd=1.175 as=0.0567 ps=0.69 w=0.42 l=0.15
X3518 VDPWR a_40967_41391# a_41706_38127# VDPWR sky130_fd_pr__pfet_01v8_hvt ad=0.1092 pd=1.36 as=0.0651 ps=0.73 w=0.42 l=0.15
X3519 a_43550_37910# a_43504_37735# VDPWR VDPWR sky130_fd_pr__pfet_01v8_hvt ad=0.07665 pd=0.785 as=0.15835 ps=1.395 w=0.42 l=0.15
X3520 VDPWR a_36327_35925# a_17481_32899# VDPWR sky130_fd_pr__pfet_01v8_hvt ad=0.2279 pd=1.74 as=0.26 ps=2.52 w=1 l=0.15
X3521 a_25383_35727# a_17507_33198# a_25020_35593# uio_oe[0] sky130_fd_pr__nfet_01v8 ad=0.0693 pd=0.75 as=0.09975 ps=0.895 w=0.42 l=0.15
X3522 uio_oe[0] a_25265_33703# a_25199_33729# uio_oe[0] sky130_fd_pr__nfet_01v8 ad=0.1449 pd=1.11 as=0.0693 ps=0.75 w=0.42 l=0.15
X3523 a_50397_41935# a_48125_43023# uio_oe[0] uio_oe[0] sky130_fd_pr__nfet_01v8 ad=0.0441 pd=0.63 as=0.1346 ps=1.15 w=0.42 l=0.15
X3524 VDPWR a_57012_41365# a_57148_41391# VDPWR sky130_fd_pr__pfet_01v8_hvt ad=0.12285 pd=1.17 as=0.2184 ps=2.2 w=0.84 l=0.15
X3525 a_49686_38259# a_50003_38369# a_49961_38493# uio_oe[0] sky130_fd_pr__special_nfet_01v8 ad=0.0711 pd=0.755 as=0.0669 ps=0.75 w=0.36 l=0.15
X3526 a_57321_41935# a_56843_41909# uio_oe[0] uio_oe[0] sky130_fd_pr__nfet_01v8 ad=0.0669 pd=0.75 as=0.12495 ps=1.015 w=0.42 l=0.15
X3527 a_51841_38645# a_48677_39759# uio_oe[0] uio_oe[0] sky130_fd_pr__nfet_01v8 ad=0.1092 pd=1.36 as=0.1449 ps=1.11 w=0.42 l=0.15
X3528 a_37433_35665# a_44044_37155# VDPWR VDPWR sky130_fd_pr__pfet_01v8_hvt ad=0.34 pd=2.68 as=0.14575 ps=1.335 w=1 l=0.15
X3529 a_41961_34569# a_36425_34293# VDPWR VDPWR sky130_fd_pr__pfet_01v8_hvt ad=0.135 pd=1.27 as=0.135 ps=1.27 w=1 l=0.15
X3530 VDPWR a_47959_43023# a_48125_43023# VDPWR sky130_fd_pr__pfet_01v8_hvt ad=0.135 pd=1.27 as=0.135 ps=1.27 w=1 l=0.15
X3531 VDPWR a_48125_41935# a_60720_41757# VDPWR sky130_fd_pr__pfet_01v8_hvt ad=0.0798 pd=0.8 as=0.0567 ps=0.69 w=0.42 l=0.15
X3532 VDPWR a_59293_39513# a_59323_39254# VDPWR sky130_fd_pr__pfet_01v8_hvt ad=0.0693 pd=0.75 as=0.0441 ps=0.63 w=0.42 l=0.15
X3533 a_25020_35593# a_17507_33198# a_25162_35400# VDPWR sky130_fd_pr__pfet_01v8_hvt ad=0.1932 pd=1.34 as=0.07665 ps=0.785 w=0.42 l=0.15
X3534 uio_oe[0] a_54459_34293# a_54393_34319# uio_oe[0] sky130_fd_pr__nfet_01v8 ad=0.12495 pd=1.015 as=0.0669 ps=0.75 w=0.42 l=0.15
X3535 a_18196_10020# a_16812_8642# uio_oe[0] uio_oe[0] sky130_fd_pr__nfet_01v8 ad=1.4703 pd=10.72 as=1.4703 ps=10.72 w=5.07 l=1
X3536 uio_oe[0] uio_oe[0] uio_oe[0] uio_oe[0] sky130_fd_pr__nfet_01v8 ad=1.4703 pd=10.72 as=0 ps=0 w=5.07 l=1
X3537 a_59135_42845# a_39752_42747# a_58772_42711# uio_oe[0] sky130_fd_pr__nfet_01v8 ad=0.0693 pd=0.75 as=0.09975 ps=0.895 w=0.42 l=0.15
X3538 a_43782_39759# a_40379_35551# uio_oe[0] uio_oe[0] sky130_fd_pr__nfet_01v8 ad=0.06405 pd=0.725 as=0.12495 ps=1.015 w=0.42 l=0.15
X3539 a_62237_39513# a_36661_41391# uio_oe[0] uio_oe[0] sky130_fd_pr__nfet_01v8 ad=0.1092 pd=1.36 as=0.1449 ps=1.11 w=0.42 l=0.15
X3540 a_60934_40303# a_60176_40419# a_60371_40277# VDPWR sky130_fd_pr__pfet_01v8_hvt ad=0.0651 pd=0.73 as=0.07245 ps=0.765 w=0.42 l=0.15
X3541 uio_oe[0] a_46289_39447# a_43156_34293# uio_oe[0] sky130_fd_pr__nfet_01v8 ad=0.10025 pd=0.985 as=0.169 ps=1.82 w=0.65 l=0.15
X3542 a_22010_16730# ua[2] a_21882_18020# uio_oe[0] sky130_fd_pr__nfet_01v8 ad=0.2436 pd=2.26 as=0.2436 ps=2.26 w=0.84 l=0.6
X3543 a_38543_35095# a_38771_34879# a_38717_35201# uio_oe[0] sky130_fd_pr__nfet_01v8 ad=0.1176 pd=1.4 as=0.0567 ps=0.69 w=0.42 l=0.15
X3544 VDPWR a_50784_41096# a_50722_41213# VDPWR sky130_fd_pr__pfet_01v8_hvt ad=0.1092 pd=1.36 as=0.0651 ps=0.73 w=0.42 l=0.15
X3545 a_38674_40086# a_38005_40847# VDPWR VDPWR sky130_fd_pr__pfet_01v8_hvt ad=0.07665 pd=0.785 as=0.15835 ps=1.395 w=0.42 l=0.15
X3546 a_44261_41397# a_44095_41397# uio_oe[0] uio_oe[0] sky130_fd_pr__nfet_01v8 ad=0.1092 pd=1.36 as=0.0567 ps=0.69 w=0.42 l=0.15
X3547 a_54406_37078# a_37361_41391# VDPWR VDPWR sky130_fd_pr__pfet_01v8_hvt ad=0.07665 pd=0.785 as=0.15835 ps=1.395 w=0.42 l=0.15
X3548 a_49920_42479# a_49483_42453# VDPWR VDPWR sky130_fd_pr__pfet_01v8_hvt ad=0.0567 pd=0.69 as=0.0819 ps=0.81 w=0.42 l=0.15
X3549 a_57046_36747# a_57324_36763# a_57280_36861# VDPWR sky130_fd_pr__pfet_01v8_hvt ad=0.0588 pd=0.7 as=0.0567 ps=0.69 w=0.42 l=0.15
X3550 a_30034_10464# a_28348_10782# ua[5] uio_oe[0] sky130_fd_pr__nfet_01v8 ad=0.1885 pd=1.88 as=0.1885 ps=1.88 w=0.65 l=0.15
X3551 uio_oe[0] a_50003_40989# a_49964_41115# uio_oe[0] sky130_fd_pr__nfet_01v8 ad=0.0567 pd=0.69 as=0.1092 ps=1.36 w=0.42 l=0.15
X3552 a_50469_42845# a_50090_42479# a_50397_42845# uio_oe[0] sky130_fd_pr__nfet_01v8 ad=0.1401 pd=1.1 as=0.0441 ps=0.63 w=0.42 l=0.15
X3553 a_54446_40125# a_53369_39759# a_54284_39759# VDPWR sky130_fd_pr__pfet_01v8_hvt ad=0.0567 pd=0.69 as=0.0588 ps=0.7 w=0.42 l=0.15
X3554 a_39686_36495# a_37029_37583# uio_oe[0] uio_oe[0] sky130_fd_pr__nfet_01v8 ad=0.0693 pd=0.75 as=0.11285 ps=1.045 w=0.42 l=0.15
X3555 a_26082_33224# a_25116_33417# VDPWR VDPWR sky130_fd_pr__pfet_01v8_hvt ad=0.07665 pd=0.785 as=0.15835 ps=1.395 w=0.42 l=0.15
X3556 uio_oe[0] a_56843_38645# a_38740_38645# uio_oe[0] sky130_fd_pr__nfet_01v8 ad=0.2087 pd=2.02 as=0.169 ps=1.82 w=0.65 l=0.15
X3557 a_52579_36495# a_52325_36822# uio_oe[0] uio_oe[0] sky130_fd_pr__nfet_01v8 ad=0.0693 pd=0.75 as=0.1449 ps=1.11 w=0.42 l=0.15
X3558 a_46193_42485# a_46027_42485# uio_oe[0] uio_oe[0] sky130_fd_pr__nfet_01v8 ad=0.1092 pd=1.36 as=0.0567 ps=0.69 w=0.42 l=0.15
X3559 a_58864_41623# a_54479_41404# a_59006_41757# uio_oe[0] sky130_fd_pr__nfet_01v8 ad=0.09975 pd=0.895 as=0.0693 ps=0.75 w=0.42 l=0.15
X3560 a_52507_37910# a_52325_37910# VDPWR VDPWR sky130_fd_pr__pfet_01v8_hvt ad=0.0441 pd=0.63 as=0.0693 ps=0.75 w=0.42 l=0.15
X3561 a_24778_10464# a_24484_10376# ua[4] uio_oe[0] sky130_fd_pr__nfet_01v8 ad=0.1885 pd=1.88 as=0.1885 ps=1.88 w=0.65 l=0.15
X3562 a_59293_35161# a_48677_38127# uio_oe[0] uio_oe[0] sky130_fd_pr__nfet_01v8 ad=0.1092 pd=1.36 as=0.1449 ps=1.11 w=0.42 l=0.15
X3563 uio_oe[0] a_48125_43023# a_57081_41935# uio_oe[0] sky130_fd_pr__nfet_01v8 ad=0.12495 pd=1.015 as=0.06405 ps=0.725 w=0.42 l=0.15
X3564 a_60365_40847# a_59939_41174# VDPWR VDPWR sky130_fd_pr__pfet_01v8_hvt ad=0.26 pd=2.52 as=0.15835 ps=1.395 w=1 l=0.15
X3565 a_37787_42518# a_37605_42518# VDPWR VDPWR sky130_fd_pr__pfet_01v8_hvt ad=0.0441 pd=0.63 as=0.0693 ps=0.75 w=0.42 l=0.15
X3566 uio_oe[0] a_52855_42721# a_52816_42595# uio_oe[0] sky130_fd_pr__nfet_01v8 ad=0.0567 pd=0.69 as=0.1092 ps=1.36 w=0.42 l=0.15
X3567 a_50722_41391# a_49964_41507# a_50159_41365# VDPWR sky130_fd_pr__pfet_01v8_hvt ad=0.0651 pd=0.73 as=0.07245 ps=0.765 w=0.42 l=0.15
X3568 VDPWR a_36585_40847# a_37566_39215# VDPWR sky130_fd_pr__pfet_01v8_hvt ad=0.1092 pd=1.36 as=0.0651 ps=0.73 w=0.42 l=0.15
X3569 ua[5] a_28348_18376# a_28218_18020# uio_oe[0] sky130_fd_pr__nfet_01v8 ad=0.1885 pd=1.88 as=0.1885 ps=1.88 w=0.65 l=0.15
X3570 a_26170_22464# a_24484_10782# ua[4] uio_oe[0] sky130_fd_pr__nfet_01v8 ad=0.1885 pd=1.88 as=0.1885 ps=1.88 w=0.65 l=0.15
X3571 uio_oe[0] a_24836_33881# a_24787_33729# uio_oe[0] sky130_fd_pr__nfet_01v8 ad=0.11285 pd=1.045 as=0.169 ps=1.82 w=0.65 l=0.15
X3572 VDPWR a_47283_42783# a_47270_42479# VDPWR sky130_fd_pr__pfet_01v8_hvt ad=0.0819 pd=0.81 as=0.0567 ps=0.69 w=0.42 l=0.15
X3573 a_61819_39733# a_48125_41935# VDPWR VDPWR sky130_fd_pr__pfet_01v8_hvt ad=0.0567 pd=0.69 as=0.0819 ps=0.81 w=0.42 l=0.15
X3574 a_52942_38127# a_52855_38369# a_52538_38259# VDPWR sky130_fd_pr__pfet_01v8_hvt ad=0.12915 pd=1.185 as=0.0588 ps=0.7 w=0.42 l=0.15
X3575 uio_oe[0] a_38961_36469# a_38895_36495# uio_oe[0] sky130_fd_pr__nfet_01v8 ad=0.1449 pd=1.11 as=0.0693 ps=0.75 w=0.42 l=0.15
X3576 a_42956_35657# a_37851_36647# VDPWR VDPWR sky130_fd_pr__pfet_01v8_hvt ad=0.0441 pd=0.63 as=0.14575 ps=1.335 w=0.42 l=0.15
X3577 a_44369_39215# a_44327_39447# a_44287_39215# VDPWR sky130_fd_pr__pfet_01v8_hvt ad=0.135 pd=1.27 as=0.26 ps=2.52 w=1 l=0.15
X3578 a_41184_38671# a_40379_35551# uio_oe[0] uio_oe[0] sky130_fd_pr__nfet_01v8 ad=0.0441 pd=0.63 as=0.0882 ps=0.84 w=0.42 l=0.15
X3579 a_21585_36747# a_21252_36681# uio_oe[0] uio_oe[0] sky130_fd_pr__nfet_01v8 ad=0.1092 pd=1.36 as=0.1449 ps=1.11 w=0.42 l=0.15
X3580 a_24778_10464# ua[1] a_24532_10020# uio_oe[0] sky130_fd_pr__nfet_01v8 ad=0.2436 pd=2.26 as=0.2436 ps=2.26 w=0.84 l=0.6
X3581 a_17050_14464# a_16756_14782# ua[5] uio_oe[0] sky130_fd_pr__nfet_01v8 ad=0.1885 pd=1.88 as=0.1885 ps=1.88 w=0.65 l=0.15
X3582 a_58980_41909# a_61819_41909# VDPWR VDPWR sky130_fd_pr__pfet_01v8_hvt ad=0.26 pd=2.52 as=0.3012 ps=2.66 w=1 l=0.15
X3583 uio_oe[0] a_43603_39733# a_43537_39759# uio_oe[0] sky130_fd_pr__nfet_01v8 ad=0.12495 pd=1.015 as=0.0669 ps=0.75 w=0.42 l=0.15
X3584 uio_oe[0] a_37661_37052# a_38080_37583# uio_oe[0] sky130_fd_pr__nfet_01v8 ad=0.11285 pd=1.045 as=0.0693 ps=0.75 w=0.42 l=0.15
X3585 VDPWR a_18212_36681# a_17316_36967# VDPWR sky130_fd_pr__pfet_01v8_hvt ad=0.15835 pd=1.395 as=0.26 ps=2.52 w=1 l=0.15
X3586 a_45351_40821# a_39947_42997# VDPWR VDPWR sky130_fd_pr__pfet_01v8_hvt ad=0.0567 pd=0.69 as=0.0819 ps=0.81 w=0.42 l=0.15
X3587 a_59939_39759# a_59685_40086# uio_oe[0] uio_oe[0] sky130_fd_pr__nfet_01v8 ad=0.0693 pd=0.75 as=0.1449 ps=1.11 w=0.42 l=0.15
X3588 a_43408_37735# a_42347_38127# a_43550_37910# VDPWR sky130_fd_pr__pfet_01v8_hvt ad=0.1932 pd=1.34 as=0.07665 ps=0.785 w=0.42 l=0.15
X3589 a_51554_36495# a_48677_38127# uio_oe[0] uio_oe[0] sky130_fd_pr__nfet_01v8 ad=0.0693 pd=0.75 as=0.11285 ps=1.045 w=0.42 l=0.15
X3590 uio_oe[0] a_59860_41623# a_54479_41404# uio_oe[0] sky130_fd_pr__nfet_01v8 ad=0.097 pd=0.975 as=0.169 ps=1.82 w=0.65 l=0.15
X3591 uio_oe[0] a_48125_41935# a_60802_39581# uio_oe[0] sky130_fd_pr__nfet_01v8 ad=0.0882 pd=0.84 as=0.0441 ps=0.63 w=0.42 l=0.15
X3592 a_26170_22464# a_4259_22596# a_25874_20730# uio_oe[0] sky130_fd_pr__nfet_01v8 ad=0.2436 pd=2.26 as=0.2436 ps=2.26 w=0.84 l=0.6
X3593 uio_oe[0] a_60996_40277# a_60934_40303# uio_oe[0] sky130_fd_pr__nfet_01v8 ad=0.2205 pd=1.89 as=0.066 ps=0.745 w=0.42 l=0.15
X3594 a_46176_38921# a_43609_37359# VDPWR VDPWR sky130_fd_pr__pfet_01v8_hvt ad=0.0441 pd=0.63 as=0.14575 ps=1.335 w=0.42 l=0.15
X3595 a_20620_18782# a_21875_34845# uio_oe[0] uio_oe[0] sky130_fd_pr__nfet_01v8 ad=0.182 pd=1.86 as=0.1118 ps=1.04 w=0.65 l=0.15
X3596 VDPWR a_43603_39519# a_43590_39215# VDPWR sky130_fd_pr__pfet_01v8_hvt ad=0.0819 pd=0.81 as=0.0567 ps=0.69 w=0.42 l=0.15
X3597 a_39293_43023# a_39127_43023# uio_oe[0] uio_oe[0] sky130_fd_pr__nfet_01v8 ad=0.1092 pd=1.36 as=0.0567 ps=0.69 w=0.42 l=0.15
X3598 VDPWR a_38961_40601# a_38991_40342# VDPWR sky130_fd_pr__pfet_01v8_hvt ad=0.0693 pd=0.75 as=0.0441 ps=0.63 w=0.42 l=0.15
X3599 VDPWR a_36447_40849# a_38019_35951# VDPWR sky130_fd_pr__pfet_01v8_hvt ad=0.2279 pd=1.74 as=0.0609 ps=0.71 w=0.42 l=0.15
X3600 a_45176_43023# a_44261_43023# a_44829_43265# uio_oe[0] sky130_fd_pr__special_nfet_01v8 ad=0.0711 pd=0.755 as=0.0999 ps=0.985 w=0.36 l=0.15
X3601 a_47283_41909# a_39947_42997# VDPWR VDPWR sky130_fd_pr__pfet_01v8_hvt ad=0.0567 pd=0.69 as=0.0819 ps=0.81 w=0.42 l=0.15
X3602 a_39729_35435# a_37029_37583# uio_oe[0] uio_oe[0] sky130_fd_pr__nfet_01v8 ad=0.0567 pd=0.69 as=0.1118 ps=1.04 w=0.42 l=0.15
X3603 a_24778_22464# a_24484_14376# ua[5] uio_oe[0] sky130_fd_pr__nfet_01v8 ad=0.1885 pd=1.88 as=0.1885 ps=1.88 w=0.65 l=0.15
X3604 ua[4] uio_oe[0] sky130_fd_pr__cap_mim_m3_1 l=4.2 w=4.2
X3605 a_61175_34319# a_60729_34319# a_61079_34319# uio_oe[0] sky130_fd_pr__special_nfet_01v8 ad=0.1401 pd=1.1 as=0.0594 ps=0.69 w=0.36 l=0.15
X3606 a_53005_34319# a_52579_34646# VDPWR VDPWR sky130_fd_pr__pfet_01v8_hvt ad=0.26 pd=2.52 as=0.15835 ps=1.395 w=1 l=0.15
X3607 a_61341_35407# a_61297_35649# a_61175_35407# uio_oe[0] sky130_fd_pr__nfet_01v8 ad=0.0441 pd=0.63 as=0.1401 ps=1.1 w=0.42 l=0.15
X3608 a_61753_41935# a_60563_41935# a_61644_41935# uio_oe[0] sky130_fd_pr__special_nfet_01v8 ad=0.0669 pd=0.75 as=0.0711 ps=0.755 w=0.36 l=0.15
X3609 a_59006_41757# a_48677_39759# uio_oe[0] uio_oe[0] sky130_fd_pr__nfet_01v8 ad=0.0693 pd=0.75 as=0.11285 ps=1.045 w=0.42 l=0.15
X3610 uio_oe[0] a_18641_34571# a_18575_34639# uio_oe[0] sky130_fd_pr__nfet_01v8 ad=0.1449 pd=1.11 as=0.0693 ps=0.75 w=0.42 l=0.15
X3611 a_57046_37835# a_57363_37725# a_57321_37583# uio_oe[0] sky130_fd_pr__special_nfet_01v8 ad=0.0711 pd=0.755 as=0.0669 ps=0.75 w=0.36 l=0.15
X3612 VDPWR a_37851_36647# a_37901_37307# VDPWR sky130_fd_pr__pfet_01v8_hvt ad=0.26 pd=2.52 as=0.135 ps=1.27 w=1 l=0.15
X3613 a_38532_39911# a_37795_40535# a_38674_40086# VDPWR sky130_fd_pr__pfet_01v8_hvt ad=0.1932 pd=1.34 as=0.07665 ps=0.785 w=0.42 l=0.15
X3614 a_50722_37949# a_49964_37851# a_50159_37820# VDPWR sky130_fd_pr__pfet_01v8_hvt ad=0.0651 pd=0.73 as=0.07245 ps=0.765 w=0.42 l=0.15
X3615 a_29804_36681# a_18427_33198# a_29946_36488# VDPWR sky130_fd_pr__pfet_01v8_hvt ad=0.1932 pd=1.34 as=0.07665 ps=0.785 w=0.42 l=0.15
X3616 VDPWR a_37641_35407# a_37839_34685# VDPWR sky130_fd_pr__pfet_01v8_hvt ad=0.0714 pd=0.76 as=0.1092 ps=1.36 w=0.42 l=0.15
X3617 a_43244_41769# a_42329_41397# a_42897_41365# uio_oe[0] sky130_fd_pr__special_nfet_01v8 ad=0.0711 pd=0.755 as=0.0999 ps=0.985 w=0.36 l=0.15
X3618 a_56843_40821# a_57046_41099# VDPWR VDPWR sky130_fd_pr__pfet_01v8_hvt ad=0.0567 pd=0.69 as=0.1134 ps=1.38 w=0.42 l=0.15
X3619 VDPWR a_50784_34568# a_50722_34685# VDPWR sky130_fd_pr__pfet_01v8_hvt ad=0.1092 pd=1.36 as=0.0651 ps=0.73 w=0.42 l=0.15
X3620 a_45095_39733# a_45431_39733# uio_oe[0] uio_oe[0] sky130_fd_pr__nfet_01v8 ad=0.169 pd=1.82 as=0.08775 ps=0.92 w=0.65 l=0.15
X3621 uio_oe[0] a_46193_39759# a_59933_38493# uio_oe[0] sky130_fd_pr__nfet_01v8 ad=0.12495 pd=1.015 as=0.06405 ps=0.725 w=0.42 l=0.15
X3622 a_54264_37271# a_54479_37052# a_54406_37078# VDPWR sky130_fd_pr__pfet_01v8_hvt ad=0.1932 pd=1.34 as=0.07665 ps=0.785 w=0.42 l=0.15
X3623 a_62267_37078# a_54479_37052# a_61808_37271# VDPWR sky130_fd_pr__pfet_01v8_hvt ad=0.0441 pd=0.63 as=0.1932 ps=1.34 w=0.42 l=0.15
X3624 a_49721_37583# a_49686_37835# a_49483_37557# uio_oe[0] sky130_fd_pr__nfet_01v8 ad=0.06405 pd=0.725 as=0.1092 ps=1.36 w=0.42 l=0.15
X3625 a_61808_37271# a_54479_37052# a_61950_37405# uio_oe[0] sky130_fd_pr__nfet_01v8 ad=0.09975 pd=0.895 as=0.0693 ps=0.75 w=0.42 l=0.15
X3626 a_27562_14464# a_24484_14376# ua[4] uio_oe[0] sky130_fd_pr__nfet_01v8 ad=0.1885 pd=1.88 as=0.1885 ps=1.88 w=0.65 l=0.15
X3627 uio_oe[0] a_40495_42453# a_40379_35551# uio_oe[0] sky130_fd_pr__nfet_01v8 ad=0.08775 pd=0.92 as=0.08775 ps=0.92 w=0.65 l=0.15
X3628 a_45176_42857# a_44261_42485# a_44829_42453# uio_oe[0] sky130_fd_pr__special_nfet_01v8 ad=0.0711 pd=0.755 as=0.0999 ps=0.985 w=0.36 l=0.15
X3629 a_40920_35951# a_40706_35951# VDPWR VDPWR sky130_fd_pr__pfet_01v8_hvt ad=0.1155 pd=0.97 as=0.07035 ps=0.755 w=0.42 l=0.15
X3630 a_25940_33417# a_18427_33198# a_26082_33224# VDPWR sky130_fd_pr__pfet_01v8_hvt ad=0.1932 pd=1.34 as=0.07665 ps=0.785 w=0.42 l=0.15
X3631 a_57012_41365# a_48125_43023# VDPWR VDPWR sky130_fd_pr__pfet_01v8_hvt ad=0.1092 pd=1.36 as=0.12285 ps=1.17 w=0.42 l=0.15
X3632 a_38961_37337# a_37029_37583# uio_oe[0] uio_oe[0] sky130_fd_pr__nfet_01v8 ad=0.1092 pd=1.36 as=0.1449 ps=1.11 w=0.42 l=0.15
X3633 a_59201_35381# a_48677_38127# VDPWR VDPWR sky130_fd_pr__pfet_01v8_hvt ad=0.1176 pd=1.4 as=0.0693 ps=0.75 w=0.42 l=0.15
X3634 uio_oe[0] a_39719_34953# a_39549_34837# uio_oe[0] sky130_fd_pr__nfet_01v8 ad=0.1575 pd=1.17 as=0.0567 ps=0.69 w=0.42 l=0.15
X3635 a_49920_41391# a_49483_41365# VDPWR VDPWR sky130_fd_pr__pfet_01v8_hvt ad=0.0567 pd=0.69 as=0.0819 ps=0.81 w=0.42 l=0.15
X3636 VDPWR a_50003_40989# a_49964_41115# VDPWR sky130_fd_pr__pfet_01v8_hvt ad=0.0864 pd=0.91 as=0.1664 ps=1.8 w=0.64 l=0.15
X3637 a_43220_38127# a_43006_38127# VDPWR VDPWR sky130_fd_pr__pfet_01v8_hvt ad=0.1155 pd=0.97 as=0.07035 ps=0.755 w=0.42 l=0.15
X3638 a_62053_36249# a_37361_41391# VDPWR VDPWR sky130_fd_pr__pfet_01v8_hvt ad=0.1176 pd=1.4 as=0.0693 ps=0.75 w=0.42 l=0.15
X3639 VDPWR a_40379_35551# a_40099_35381# VDPWR sky130_fd_pr__pfet_01v8_hvt ad=0.0819 pd=0.81 as=0.0567 ps=0.69 w=0.42 l=0.15
X3640 a_27562_14464# ua[1] a_27316_14020# uio_oe[0] sky130_fd_pr__nfet_01v8 ad=0.2436 pd=2.26 as=0.2436 ps=2.26 w=0.84 l=0.6
X3641 a_24978_34056# a_24932_33881# VDPWR VDPWR sky130_fd_pr__pfet_01v8_hvt ad=0.07665 pd=0.785 as=0.15835 ps=1.395 w=0.42 l=0.15
X3642 VDPWR a_29804_34505# a_28908_34791# VDPWR sky130_fd_pr__pfet_01v8_hvt ad=0.15835 pd=1.395 as=0.26 ps=2.52 w=1 l=0.15
X3643 a_45530_42845# a_39947_42997# uio_oe[0] uio_oe[0] sky130_fd_pr__nfet_01v8 ad=0.06405 pd=0.725 as=0.12495 ps=1.015 w=0.42 l=0.15
X3644 a_40706_35773# a_40580_35675# a_40302_35659# uio_oe[0] sky130_fd_pr__special_nfet_01v8 ad=0.0999 pd=0.985 as=0.0711 ps=0.755 w=0.36 l=0.15
X3645 ua[4] a_24484_10782# a_27138_10020# uio_oe[0] sky130_fd_pr__nfet_01v8 ad=0.1885 pd=1.88 as=0.1885 ps=1.88 w=0.65 l=0.15
X3646 a_41143_39996# a_40987_39901# a_41288_40125# VDPWR sky130_fd_pr__pfet_01v8_hvt ad=0.07245 pd=0.765 as=0.1155 ps=0.97 w=0.42 l=0.15
X3647 a_50304_40125# a_50090_40125# VDPWR VDPWR sky130_fd_pr__pfet_01v8_hvt ad=0.1155 pd=0.97 as=0.07035 ps=0.755 w=0.42 l=0.15
X3648 a_59201_35381# a_48677_38127# uio_oe[0] uio_oe[0] sky130_fd_pr__nfet_01v8 ad=0.1092 pd=1.36 as=0.1449 ps=1.11 w=0.42 l=0.15
X3649 a_61187_40125# a_48125_41935# VDPWR VDPWR sky130_fd_pr__pfet_01v8_hvt ad=0.1092 pd=1.36 as=0.07035 ps=0.755 w=0.42 l=0.15
X3650 VDPWR a_61808_35095# a_61242_35093# VDPWR sky130_fd_pr__pfet_01v8_hvt ad=0.15835 pd=1.395 as=0.26 ps=2.52 w=1 l=0.15
X3651 a_17721_36747# a_17388_36681# VDPWR VDPWR sky130_fd_pr__pfet_01v8_hvt ad=0.1176 pd=1.4 as=0.0693 ps=0.75 w=0.42 l=0.15
X3652 VDPWR a_47283_41695# a_47270_41391# VDPWR sky130_fd_pr__pfet_01v8_hvt ad=0.0819 pd=0.81 as=0.0567 ps=0.69 w=0.42 l=0.15
X3653 a_39973_40821# a_38005_40847# VDPWR VDPWR sky130_fd_pr__pfet_01v8_hvt ad=0.1176 pd=1.4 as=0.0693 ps=0.75 w=0.42 l=0.15
X3654 a_44905_38671# a_44739_38671# VDPWR VDPWR sky130_fd_pr__pfet_01v8_hvt ad=0.135 pd=1.27 as=0.135 ps=1.27 w=1 l=0.15
X3655 a_53574_38127# a_52816_38243# a_53011_38101# VDPWR sky130_fd_pr__pfet_01v8_hvt ad=0.0651 pd=0.73 as=0.07245 ps=0.765 w=0.42 l=0.15
X3656 a_21335_35905# a_21107_35361# a_20972_36057# uio_oe[0] sky130_fd_pr__nfet_01v8 ad=0.0693 pd=0.75 as=0.09975 ps=0.895 w=0.42 l=0.15
X3657 VDPWR a_21156_34505# a_21107_34273# VDPWR sky130_fd_pr__pfet_01v8_hvt ad=0.15835 pd=1.395 as=0.26 ps=2.52 w=1 l=0.15
X3658 a_40617_35161# a_37661_37052# VDPWR VDPWR sky130_fd_pr__pfet_01v8_hvt ad=0.1176 pd=1.4 as=0.0693 ps=0.75 w=0.42 l=0.15
X3659 a_16756_18376# a_18711_35183# VDPWR VDPWR sky130_fd_pr__pfet_01v8_hvt ad=0.26 pd=2.52 as=0.2279 ps=1.74 w=1 l=0.15
X3660 a_20620_10782# a_22575_37359# uio_oe[0] uio_oe[0] sky130_fd_pr__nfet_01v8 ad=0.169 pd=1.82 as=0.1013 ps=0.99 w=0.65 l=0.15
X3661 a_22218_35727# a_21252_35593# uio_oe[0] uio_oe[0] sky130_fd_pr__nfet_01v8 ad=0.0693 pd=0.75 as=0.11285 ps=1.045 w=0.42 l=0.15
X3662 a_27562_26464# a_24484_10376# ua[5] uio_oe[0] sky130_fd_pr__nfet_01v8 ad=0.1885 pd=1.88 as=0.1885 ps=1.88 w=0.65 l=0.15
X3663 VDPWR a_36999_37013# a_37029_37039# VDPWR sky130_fd_pr__pfet_01v8_hvt ad=0.135 pd=1.27 as=0.135 ps=1.27 w=1 l=0.15
X3664 VDPWR a_18212_35593# a_17316_35879# VDPWR sky130_fd_pr__pfet_01v8_hvt ad=0.15835 pd=1.395 as=0.26 ps=2.52 w=1 l=0.15
X3665 a_22505_34571# a_21252_34505# uio_oe[0] uio_oe[0] sky130_fd_pr__nfet_01v8 ad=0.1092 pd=1.36 as=0.1449 ps=1.11 w=0.42 l=0.15
X3666 a_43406_42301# a_42329_41935# a_43244_41935# VDPWR sky130_fd_pr__pfet_01v8_hvt ad=0.0567 pd=0.69 as=0.0588 ps=0.7 w=0.42 l=0.15
X3667 a_44829_40277# a_44611_40681# VDPWR VDPWR sky130_fd_pr__pfet_01v8_hvt ad=0.12915 pd=1.185 as=0.2184 ps=2.2 w=0.84 l=0.15
X3668 a_59939_38671# a_59685_38998# uio_oe[0] uio_oe[0] sky130_fd_pr__nfet_01v8 ad=0.0693 pd=0.75 as=0.1449 ps=1.11 w=0.42 l=0.15
X3669 VDPWR a_61644_38671# a_61819_38645# VDPWR sky130_fd_pr__pfet_01v8_hvt ad=0.1134 pd=1.38 as=0.0567 ps=0.69 w=0.42 l=0.15
X3670 a_31426_10464# a_28348_10376# ua[4] uio_oe[0] sky130_fd_pr__nfet_01v8 ad=0.1885 pd=1.88 as=0.1885 ps=1.88 w=0.65 l=0.15
X3671 a_50003_34461# a_41685_42479# uio_oe[0] uio_oe[0] sky130_fd_pr__nfet_01v8 ad=0.1092 pd=1.36 as=0.0567 ps=0.69 w=0.42 l=0.15
X3672 a_52538_42611# a_52855_42721# a_52813_42845# uio_oe[0] sky130_fd_pr__special_nfet_01v8 ad=0.0711 pd=0.755 as=0.0669 ps=0.75 w=0.36 l=0.15
X3673 a_47283_40607# a_47108_40681# a_47462_40669# uio_oe[0] sky130_fd_pr__nfet_01v8 ad=0.1092 pd=1.36 as=0.06405 ps=0.725 w=0.42 l=0.15
X3674 a_37913_43023# a_37747_43023# uio_oe[0] uio_oe[0] sky130_fd_pr__nfet_01v8 ad=0.08775 pd=0.92 as=0.08775 ps=0.92 w=0.65 l=0.15
X3675 uio_oe[0] a_38285_34863# a_41392_40669# uio_oe[0] sky130_fd_pr__nfet_01v8 ad=0.11285 pd=1.045 as=0.0693 ps=0.75 w=0.42 l=0.15
X3676 uio_oe[0] a_17500_33453# a_18420_33453# uio_oe[0] sky130_fd_pr__nfet_01v8 ad=0.169 pd=1.82 as=0.169 ps=1.82 w=0.65 l=0.15
X3677 a_40383_42997# a_40208_43023# a_40562_43023# uio_oe[0] sky130_fd_pr__nfet_01v8 ad=0.1092 pd=1.36 as=0.06405 ps=0.725 w=0.42 l=0.15
X3678 a_54459_40821# a_54284_40847# a_54638_40847# uio_oe[0] sky130_fd_pr__nfet_01v8 ad=0.1092 pd=1.36 as=0.06405 ps=0.725 w=0.42 l=0.15
X3679 a_49920_37949# a_49483_37557# VDPWR VDPWR sky130_fd_pr__pfet_01v8_hvt ad=0.0567 pd=0.69 as=0.0819 ps=0.81 w=0.42 l=0.15
X3680 uio_oe[0] a_40379_35551# a_46805_43023# uio_oe[0] sky130_fd_pr__nfet_01v8 ad=0.1346 pd=1.15 as=0.0441 ps=0.63 w=0.42 l=0.15
X3681 VDPWR a_40379_35551# a_41288_40125# VDPWR sky130_fd_pr__pfet_01v8_hvt ad=0.07035 pd=0.755 as=0.1092 ps=1.36 w=0.42 l=0.15
X3682 VDPWR a_36661_41391# a_52325_41174# VDPWR sky130_fd_pr__pfet_01v8_hvt ad=0.0693 pd=0.75 as=0.1176 ps=1.4 w=0.42 l=0.15
X3683 ua[5] a_24484_14782# a_27138_22020# uio_oe[0] sky130_fd_pr__nfet_01v8 ad=0.1885 pd=1.88 as=0.1885 ps=1.88 w=0.65 l=0.15
X3684 a_31426_10464# ua[0] a_31180_10020# uio_oe[0] sky130_fd_pr__nfet_01v8 ad=0.2436 pd=2.26 as=0.2436 ps=2.26 w=0.84 l=0.6
X3685 uio_oe[0] a_18641_33483# a_18575_33551# uio_oe[0] sky130_fd_pr__nfet_01v8 ad=0.1449 pd=1.11 as=0.0693 ps=0.75 w=0.42 l=0.15
X3686 a_56843_34293# a_57046_34571# VDPWR VDPWR sky130_fd_pr__pfet_01v8_hvt ad=0.0567 pd=0.69 as=0.1134 ps=1.38 w=0.42 l=0.15
X3687 a_60416_35141# a_37913_41935# uio_oe[0] uio_oe[0] sky130_fd_pr__nfet_01v8 ad=0.1092 pd=1.36 as=0.0567 ps=0.69 w=0.42 l=0.15
X3688 a_37755_40303# a_37795_40535# uio_oe[0] uio_oe[0] sky130_fd_pr__nfet_01v8 ad=0.08775 pd=0.92 as=0.169 ps=1.82 w=0.65 l=0.15
X3689 uio_oe[0] a_50784_35656# a_50722_35773# uio_oe[0] sky130_fd_pr__nfet_01v8 ad=0.2205 pd=1.89 as=0.066 ps=0.745 w=0.42 l=0.15
X3690 a_60516_42479# a_60302_42479# VDPWR VDPWR sky130_fd_pr__pfet_01v8_hvt ad=0.1155 pd=0.97 as=0.07035 ps=0.755 w=0.42 l=0.15
X3691 uio_oe[0] a_44905_38671# a_49721_36317# uio_oe[0] sky130_fd_pr__nfet_01v8 ad=0.12495 pd=1.015 as=0.06405 ps=0.725 w=0.42 l=0.15
X3692 a_38532_40535# a_38740_40571# a_38674_40669# uio_oe[0] sky130_fd_pr__nfet_01v8 ad=0.09975 pd=0.895 as=0.0693 ps=0.75 w=0.42 l=0.15
X3693 uio_oe[0] a_57640_39529# a_57598_39581# uio_oe[0] sky130_fd_pr__nfet_01v8 ad=0.1092 pd=1.36 as=0.0441 ps=0.63 w=0.42 l=0.15
X3694 a_50722_36861# a_49964_36763# a_50159_36732# VDPWR sky130_fd_pr__pfet_01v8_hvt ad=0.0651 pd=0.73 as=0.07245 ps=0.765 w=0.42 l=0.15
X3695 a_43244_40681# a_42329_40309# a_42897_40277# uio_oe[0] sky130_fd_pr__special_nfet_01v8 ad=0.0711 pd=0.755 as=0.0999 ps=0.985 w=0.36 l=0.15
X3696 uio_oe[0] a_37661_37052# a_37605_37078# uio_oe[0] sky130_fd_pr__nfet_01v8 ad=0.1449 pd=1.11 as=0.1092 ps=1.36 w=0.42 l=0.15
X3697 a_25874_24730# ua[1] a_25746_26020# uio_oe[0] sky130_fd_pr__nfet_01v8 ad=0.2436 pd=2.26 as=0.2436 ps=2.26 w=0.84 l=0.6
X3698 VDPWR a_36503_35169# a_36327_34837# VDPWR sky130_fd_pr__pfet_01v8_hvt ad=0.0714 pd=0.76 as=0.0609 ps=0.71 w=0.42 l=0.15
X3699 a_44829_41089# a_44611_40847# VDPWR VDPWR sky130_fd_pr__pfet_01v8_hvt ad=0.12915 pd=1.185 as=0.2184 ps=2.2 w=0.84 l=0.15
X3700 a_60416_39493# a_37913_43023# VDPWR VDPWR sky130_fd_pr__pfet_01v8_hvt ad=0.1664 pd=1.8 as=0.0864 ps=0.91 w=0.64 l=0.15
X3701 VDPWR a_49483_36469# a_39752_36469# VDPWR sky130_fd_pr__pfet_01v8_hvt ad=0.3012 pd=2.66 as=0.26 ps=2.52 w=1 l=0.15
X3702 uio_oe[0] a_58772_36183# a_58144_35925# uio_oe[0] sky130_fd_pr__nfet_01v8 ad=0.11285 pd=1.045 as=0.169 ps=1.82 w=0.65 l=0.15
X3703 a_60160_35407# a_58980_35381# a_59939_35734# uio_oe[0] sky130_fd_pr__nfet_01v8 ad=0.0693 pd=0.75 as=0.09975 ps=0.895 w=0.42 l=0.15
X3704 uio_oe[0] a_37195_41391# a_37361_41391# uio_oe[0] sky130_fd_pr__nfet_01v8 ad=0.08775 pd=0.92 as=0.08775 ps=0.92 w=0.65 l=0.15
X3705 a_61192_39215# a_60500_39189# a_60584_39529# VDPWR sky130_fd_pr__pfet_01v8_hvt ad=0.12495 pd=1.175 as=0.0567 ps=0.69 w=0.42 l=0.15
X3706 a_31426_22464# a_28348_14376# ua[5] uio_oe[0] sky130_fd_pr__nfet_01v8 ad=0.1885 pd=1.88 as=0.1885 ps=1.88 w=0.65 l=0.15
X3707 uio_oe[0] a_39549_34837# a_28796_34969# uio_oe[0] sky130_fd_pr__nfet_01v8 ad=0.10187 pd=0.99 as=0.1755 ps=1.84 w=0.65 l=0.15
X3708 a_57472_39493# a_38649_43023# uio_oe[0] uio_oe[0] sky130_fd_pr__nfet_01v8 ad=0.1092 pd=1.36 as=0.0567 ps=0.69 w=0.42 l=0.15
X3709 a_45617_38699# a_36447_40849# uio_oe[0] uio_oe[0] sky130_fd_pr__nfet_01v8 ad=0.0567 pd=0.69 as=0.1118 ps=1.04 w=0.42 l=0.15
X3710 uio_oe[0] a_50159_34837# a_50090_34863# uio_oe[0] sky130_fd_pr__nfet_01v8 ad=0.1346 pd=1.15 as=0.0999 ps=0.985 w=0.64 l=0.15
X3711 a_46761_42177# a_46543_41935# VDPWR VDPWR sky130_fd_pr__pfet_01v8_hvt ad=0.12915 pd=1.185 as=0.2184 ps=2.2 w=0.84 l=0.15
X3712 a_17434_33224# a_17388_33417# VDPWR VDPWR sky130_fd_pr__pfet_01v8_hvt ad=0.07665 pd=0.785 as=0.15835 ps=1.395 w=0.42 l=0.15
X3713 a_42860_38671# a_42743_38884# uio_oe[0] uio_oe[0] sky130_fd_pr__nfet_01v8 ad=0.066 pd=0.745 as=0.2205 ps=1.89 w=0.42 l=0.15
X3714 VDPWR a_42897_43265# a_42787_43389# VDPWR sky130_fd_pr__pfet_01v8_hvt ad=0.07035 pd=0.755 as=0.1155 ps=0.97 w=0.42 l=0.15
X3715 a_54393_39759# a_53203_39759# a_54284_39759# uio_oe[0] sky130_fd_pr__special_nfet_01v8 ad=0.0669 pd=0.75 as=0.0711 ps=0.755 w=0.36 l=0.15
X3716 a_60153_40086# a_51620_39733# a_59939_40086# VDPWR sky130_fd_pr__pfet_01v8_hvt ad=0.07665 pd=0.785 as=0.1932 ps=1.34 w=0.42 l=0.15
X3717 VDPWR uio_in[2] a_36919_35951# VDPWR sky130_fd_pr__pfet_01v8_hvt ad=0.135 pd=1.27 as=0.26 ps=2.52 w=1 l=0.15
X3718 a_22076_36681# a_18427_33198# a_22218_36488# VDPWR sky130_fd_pr__pfet_01v8_hvt ad=0.1932 pd=1.34 as=0.07665 ps=0.785 w=0.42 l=0.15
X3719 a_60173_42845# a_59695_42453# uio_oe[0] uio_oe[0] sky130_fd_pr__nfet_01v8 ad=0.0669 pd=0.75 as=0.12495 ps=1.015 w=0.42 l=0.15
X3720 a_42467_41562# a_43419_41909# VDPWR VDPWR sky130_fd_pr__pfet_01v8_hvt ad=0.26 pd=2.52 as=0.3012 ps=2.66 w=1 l=0.15
X3721 VDPWR a_57363_37725# a_57324_37851# VDPWR sky130_fd_pr__pfet_01v8_hvt ad=0.0864 pd=0.91 as=0.1664 ps=1.8 w=0.64 l=0.15
X3722 VDPWR a_18427_33198# a_36275_37039# VDPWR sky130_fd_pr__pfet_01v8_hvt ad=0.0714 pd=0.76 as=0.1092 ps=1.36 w=0.42 l=0.15
X3723 a_54459_41909# a_48125_41935# VDPWR VDPWR sky130_fd_pr__pfet_01v8_hvt ad=0.0567 pd=0.69 as=0.0819 ps=0.81 w=0.42 l=0.15
X3724 VDPWR a_38532_40999# a_17388_33417# VDPWR sky130_fd_pr__pfet_01v8_hvt ad=0.15835 pd=1.395 as=0.26 ps=2.52 w=1 l=0.15
X3725 uio_oe[0] a_49483_35381# a_39783_35409# uio_oe[0] sky130_fd_pr__nfet_01v8 ad=0.2087 pd=2.02 as=0.169 ps=1.82 w=0.65 l=0.15
X3726 a_17243_33007# a_17255_32793# uio_oe[0] uio_oe[0] sky130_fd_pr__nfet_01v8 ad=0.1092 pd=1.36 as=0.1092 ps=1.36 w=0.42 l=0.15
X3727 a_59135_41935# a_38740_41909# a_58772_42087# uio_oe[0] sky130_fd_pr__nfet_01v8 ad=0.0693 pd=0.75 as=0.09975 ps=0.895 w=0.42 l=0.15
X3728 a_21615_33224# a_17500_33453# a_21156_33417# VDPWR sky130_fd_pr__pfet_01v8_hvt ad=0.0441 pd=0.63 as=0.1932 ps=1.34 w=0.42 l=0.15
X3729 a_44399_42650# a_45351_42997# VDPWR VDPWR sky130_fd_pr__pfet_01v8_hvt ad=0.26 pd=2.52 as=0.3012 ps=2.66 w=1 l=0.15
X3730 uio_oe[0] a_41316_41909# a_41987_34863# uio_oe[0] sky130_fd_pr__nfet_01v8 ad=0.08775 pd=0.92 as=0.08775 ps=0.92 w=0.65 l=0.15
X3731 a_59006_41430# a_48677_39759# VDPWR VDPWR sky130_fd_pr__pfet_01v8_hvt ad=0.07665 pd=0.785 as=0.15835 ps=1.395 w=0.42 l=0.15
X3732 VDPWR a_37851_36647# a_37837_40303# VDPWR sky130_fd_pr__pfet_01v8_hvt ad=0.135 pd=1.27 as=0.135 ps=1.27 w=1 l=0.15
X3733 VDPWR a_50784_40277# a_50722_40303# VDPWR sky130_fd_pr__pfet_01v8_hvt ad=0.1092 pd=1.36 as=0.0651 ps=0.73 w=0.42 l=0.15
X3734 a_30233_35659# a_28980_35593# uio_oe[0] uio_oe[0] sky130_fd_pr__nfet_01v8 ad=0.1092 pd=1.36 as=0.1449 ps=1.11 w=0.42 l=0.15
X3735 a_18671_34312# a_18420_33453# a_18212_34505# VDPWR sky130_fd_pr__pfet_01v8_hvt ad=0.0441 pd=0.63 as=0.1932 ps=1.34 w=0.42 l=0.15
X3736 uio_oe[0] a_38483_43023# a_38649_43023# uio_oe[0] sky130_fd_pr__nfet_01v8 ad=0.08775 pd=0.92 as=0.08775 ps=0.92 w=0.65 l=0.15
X3737 a_50003_41633# a_38649_43023# VDPWR VDPWR sky130_fd_pr__pfet_01v8_hvt ad=0.1664 pd=1.8 as=0.0864 ps=0.91 w=0.64 l=0.15
X3738 a_54406_37405# a_37361_41391# uio_oe[0] uio_oe[0] sky130_fd_pr__nfet_01v8 ad=0.0693 pd=0.75 as=0.11285 ps=1.045 w=0.42 l=0.15
X3739 a_17537_34791# a_17204_34969# uio_oe[0] uio_oe[0] sky130_fd_pr__nfet_01v8 ad=0.1092 pd=1.36 as=0.1449 ps=1.11 w=0.42 l=0.15
X3740 a_54264_42711# a_51620_42747# a_54406_42845# uio_oe[0] sky130_fd_pr__nfet_01v8 ad=0.09975 pd=0.895 as=0.0693 ps=0.75 w=0.42 l=0.15
X3741 a_44261_40847# a_44095_40847# uio_oe[0] uio_oe[0] sky130_fd_pr__nfet_01v8 ad=0.1092 pd=1.36 as=0.0567 ps=0.69 w=0.42 l=0.15
X3742 a_41385_40342# a_37661_37052# a_41171_40342# VDPWR sky130_fd_pr__pfet_01v8_hvt ad=0.07665 pd=0.785 as=0.1932 ps=1.34 w=0.42 l=0.15
X3743 a_45072_37833# a_42321_35183# VDPWR VDPWR sky130_fd_pr__pfet_01v8_hvt ad=0.0441 pd=0.63 as=0.14575 ps=1.335 w=0.42 l=0.15
X3744 a_54693_36249# a_37361_41391# uio_oe[0] uio_oe[0] sky130_fd_pr__nfet_01v8 ad=0.1092 pd=1.36 as=0.1449 ps=1.11 w=0.42 l=0.15
X3745 a_57046_36083# a_57324_36067# a_57280_35951# VDPWR sky130_fd_pr__pfet_01v8_hvt ad=0.0588 pd=0.7 as=0.0567 ps=0.69 w=0.42 l=0.15
X3746 a_22505_33483# a_21252_33417# uio_oe[0] uio_oe[0] sky130_fd_pr__nfet_01v8 ad=0.1092 pd=1.36 as=0.1449 ps=1.11 w=0.42 l=0.15
X3747 a_39907_36495# a_39759_36777# a_39544_36647# uio_oe[0] sky130_fd_pr__nfet_01v8 ad=0.0693 pd=0.75 as=0.09975 ps=0.895 w=0.42 l=0.15
X3748 uio_oe[0] a_17689_32641# a_18801_35905# uio_oe[0] sky130_fd_pr__nfet_01v8 ad=0.1013 pd=0.99 as=0.0504 ps=0.66 w=0.42 l=0.15
X3749 uio_oe[0] uio_oe[0] uio_oe[0] uio_oe[0] sky130_fd_pr__nfet_01v8 ad=1.4703 pd=10.72 as=0 ps=0 w=5.07 l=1
X3750 a_50469_41935# a_50090_42301# a_50397_41935# uio_oe[0] sky130_fd_pr__nfet_01v8 ad=0.1401 pd=1.1 as=0.0441 ps=0.63 w=0.42 l=0.15
X3751 a_57664_42301# a_57450_42301# VDPWR VDPWR sky130_fd_pr__pfet_01v8_hvt ad=0.1155 pd=0.97 as=0.07035 ps=0.755 w=0.42 l=0.15
X3752 uio_oe[0] a_59293_41689# a_59227_41757# uio_oe[0] sky130_fd_pr__nfet_01v8 ad=0.1449 pd=1.11 as=0.0693 ps=0.75 w=0.42 l=0.15
X3753 a_53249_40669# a_48125_41935# uio_oe[0] uio_oe[0] sky130_fd_pr__nfet_01v8 ad=0.0441 pd=0.63 as=0.1346 ps=1.15 w=0.42 l=0.15
X3754 a_50090_40125# a_50003_39901# a_49686_40011# VDPWR sky130_fd_pr__pfet_01v8_hvt ad=0.12915 pd=1.185 as=0.0588 ps=0.7 w=0.42 l=0.15
X3755 VDPWR a_37913_41935# a_60563_37583# VDPWR sky130_fd_pr__pfet_01v8_hvt ad=0.0864 pd=0.91 as=0.1664 ps=1.8 w=0.64 l=0.15
X3756 uio_oe[0] a_17255_32793# a_36503_36257# uio_oe[0] sky130_fd_pr__nfet_01v8 ad=0.1092 pd=1.36 as=0.1092 ps=1.36 w=0.42 l=0.15
X3757 VDPWR a_29313_33483# a_29343_33224# VDPWR sky130_fd_pr__pfet_01v8_hvt ad=0.0693 pd=0.75 as=0.0441 ps=0.63 w=0.42 l=0.15
X3758 ua[4] a_22012_18782# a_21882_18020# uio_oe[0] sky130_fd_pr__nfet_01v8 ad=0.1885 pd=1.88 as=0.1885 ps=1.88 w=0.65 l=0.15
X3759 a_25020_34505# a_17500_33453# a_25162_34639# uio_oe[0] sky130_fd_pr__nfet_01v8 ad=0.09975 pd=0.895 as=0.0693 ps=0.75 w=0.42 l=0.15
X3760 a_46193_43023# a_46027_43023# VDPWR VDPWR sky130_fd_pr__pfet_01v8_hvt ad=0.1664 pd=1.8 as=0.0864 ps=0.91 w=0.64 l=0.15
X3761 VDPWR a_41519_42479# a_41685_42479# VDPWR sky130_fd_pr__pfet_01v8_hvt ad=0.135 pd=1.27 as=0.135 ps=1.27 w=1 l=0.15
X3762 a_49920_36861# a_49483_36469# VDPWR VDPWR sky130_fd_pr__pfet_01v8_hvt ad=0.0567 pd=0.69 as=0.0819 ps=0.81 w=0.42 l=0.15
X3763 VDPWR a_40383_42997# a_40370_43389# VDPWR sky130_fd_pr__pfet_01v8_hvt ad=0.0819 pd=0.81 as=0.0567 ps=0.69 w=0.42 l=0.15
X3764 a_46193_41935# a_46027_41935# uio_oe[0] uio_oe[0] sky130_fd_pr__nfet_01v8 ad=0.1092 pd=1.36 as=0.0567 ps=0.69 w=0.42 l=0.15
X3765 uio_oe[0] a_59201_39733# a_59135_39759# uio_oe[0] sky130_fd_pr__nfet_01v8 ad=0.1449 pd=1.11 as=0.0693 ps=0.75 w=0.42 l=0.15
X3766 uio_oe[0] a_39544_36647# a_24932_33881# uio_oe[0] sky130_fd_pr__nfet_01v8 ad=0.11285 pd=1.045 as=0.169 ps=1.82 w=0.65 l=0.15
X3767 a_42971_40125# a_40379_35551# VDPWR VDPWR sky130_fd_pr__pfet_01v8_hvt ad=0.1092 pd=1.36 as=0.07035 ps=0.755 w=0.42 l=0.15
X3768 a_16754_24730# ua[3] a_16626_26020# uio_oe[0] sky130_fd_pr__nfet_01v8 ad=0.2436 pd=2.26 as=0.2436 ps=2.26 w=0.84 l=0.6
X3769 VDPWR a_48125_43023# a_50304_42479# VDPWR sky130_fd_pr__pfet_01v8_hvt ad=0.07035 pd=0.755 as=0.1092 ps=1.36 w=0.42 l=0.15
X3770 VDPWR a_25417_32641# a_25739_33757# VDPWR sky130_fd_pr__pfet_01v8_hvt ad=0.16655 pd=1.39 as=0.0567 ps=0.69 w=0.42 l=0.15
X3771 a_25265_36967# a_24932_37145# VDPWR VDPWR sky130_fd_pr__pfet_01v8_hvt ad=0.1176 pd=1.4 as=0.0693 ps=0.75 w=0.42 l=0.15
X3772 a_40337_36317# a_40302_36083# a_40099_35925# uio_oe[0] sky130_fd_pr__nfet_01v8 ad=0.06405 pd=0.725 as=0.1092 ps=1.36 w=0.42 l=0.15
X3773 a_22575_35183# a_22395_35183# VDPWR VDPWR sky130_fd_pr__pfet_01v8_hvt ad=0.0609 pd=0.71 as=0.0714 ps=0.76 w=0.42 l=0.15
X3774 a_51775_36495# a_39752_36469# a_51412_36647# uio_oe[0] sky130_fd_pr__nfet_01v8 ad=0.0693 pd=0.75 as=0.09975 ps=0.895 w=0.42 l=0.15
X3775 a_42584_43023# ena uio_oe[0] uio_oe[0] sky130_fd_pr__nfet_01v8 ad=0.066 pd=0.745 as=0.2205 ps=1.89 w=0.42 l=0.15
X3776 a_57598_41757# a_57556_41365# a_57012_41365# uio_oe[0] sky130_fd_pr__nfet_01v8 ad=0.0441 pd=0.63 as=0.0693 ps=0.75 w=0.42 l=0.15
X3777 VDPWR a_21553_32641# a_21875_37021# VDPWR sky130_fd_pr__pfet_01v8_hvt ad=0.16655 pd=1.39 as=0.0567 ps=0.69 w=0.42 l=0.15
X3778 a_17292_33417# a_17507_33198# a_17434_33224# VDPWR sky130_fd_pr__pfet_01v8_hvt ad=0.1932 pd=1.34 as=0.07665 ps=0.785 w=0.42 l=0.15
X3779 a_45351_40607# a_39947_42997# VDPWR VDPWR sky130_fd_pr__pfet_01v8_hvt ad=0.0567 pd=0.69 as=0.0819 ps=0.81 w=0.42 l=0.15
X3780 ua[5] a_20620_18376# a_20490_18020# uio_oe[0] sky130_fd_pr__nfet_01v8 ad=0.1885 pd=1.88 as=0.1885 ps=1.88 w=0.65 l=0.15
X3781 VDPWR a_36661_41391# a_60153_40086# VDPWR sky130_fd_pr__pfet_01v8_hvt ad=0.15835 pd=1.395 as=0.07665 ps=0.785 w=0.42 l=0.15
X3782 a_36427_36475# a_41990_38671# VDPWR VDPWR sky130_fd_pr__pfet_01v8_hvt ad=0.26 pd=2.52 as=0.149 ps=1.325 w=1 l=0.15
X3783 uio_oe[0] a_51412_36647# a_50784_36744# uio_oe[0] sky130_fd_pr__nfet_01v8 ad=0.11285 pd=1.045 as=0.169 ps=1.82 w=0.65 l=0.15
X3784 a_57363_39901# a_38649_43023# VDPWR VDPWR sky130_fd_pr__pfet_01v8_hvt ad=0.1664 pd=1.8 as=0.0864 ps=0.91 w=0.64 l=0.15
X3785 uio_oe[0] a_40379_35551# a_42637_38493# uio_oe[0] sky130_fd_pr__nfet_01v8 ad=0.12495 pd=1.015 as=0.06405 ps=0.725 w=0.42 l=0.15
X3786 a_39686_37910# a_37029_37583# VDPWR VDPWR sky130_fd_pr__pfet_01v8_hvt ad=0.07665 pd=0.785 as=0.15835 ps=1.395 w=0.42 l=0.15
X3787 a_25295_34056# a_25044_33703# a_24836_33881# VDPWR sky130_fd_pr__pfet_01v8_hvt ad=0.0441 pd=0.63 as=0.1932 ps=1.34 w=0.42 l=0.15
X3788 VDPWR rst_n a_46027_39759# VDPWR sky130_fd_pr__pfet_01v8_hvt ad=0.135 pd=1.27 as=0.26 ps=2.52 w=1 l=0.15
X3789 VDPWR a_56843_39733# a_38740_39733# VDPWR sky130_fd_pr__pfet_01v8_hvt ad=0.3012 pd=2.66 as=0.26 ps=2.52 w=1 l=0.15
X3790 a_57757_38493# a_44905_38671# uio_oe[0] uio_oe[0] sky130_fd_pr__nfet_01v8 ad=0.0441 pd=0.63 as=0.1346 ps=1.15 w=0.42 l=0.15
X3791 a_52579_37910# a_51620_37557# a_52507_37910# VDPWR sky130_fd_pr__pfet_01v8_hvt ad=0.1932 pd=1.34 as=0.0441 ps=0.63 w=0.42 l=0.15
X3792 a_60302_42479# a_60215_42721# a_59898_42611# VDPWR sky130_fd_pr__pfet_01v8_hvt ad=0.12915 pd=1.185 as=0.0588 ps=0.7 w=0.42 l=0.15
X3793 a_59956_39189# a_48125_41935# VDPWR VDPWR sky130_fd_pr__pfet_01v8_hvt ad=0.1092 pd=1.36 as=0.12285 ps=1.17 w=0.42 l=0.15
X3794 uio_oe[0] a_38532_38359# a_25116_36681# uio_oe[0] sky130_fd_pr__nfet_01v8 ad=0.11285 pd=1.045 as=0.169 ps=1.82 w=0.65 l=0.15
X3795 a_24532_14020# a_16812_8642# uio_oe[0] uio_oe[0] sky130_fd_pr__nfet_01v8 ad=1.4703 pd=10.72 as=1.4703 ps=10.72 w=5.07 l=1
X3796 a_37859_42518# a_37042_34863# a_37787_42518# VDPWR sky130_fd_pr__pfet_01v8_hvt ad=0.1932 pd=1.34 as=0.0441 ps=0.63 w=0.42 l=0.15
X3797 a_54393_38671# a_53203_38671# a_54284_38671# uio_oe[0] sky130_fd_pr__special_nfet_01v8 ad=0.0669 pd=0.75 as=0.0711 ps=0.755 w=0.36 l=0.15
X3798 uio_oe[0] a_50159_37820# a_50090_37949# uio_oe[0] sky130_fd_pr__nfet_01v8 ad=0.1346 pd=1.15 as=0.0999 ps=0.985 w=0.64 l=0.15
X3799 uio_oe[0] a_37839_40847# a_38005_40847# uio_oe[0] sky130_fd_pr__nfet_01v8 ad=0.08775 pd=0.92 as=0.08775 ps=0.92 w=0.65 l=0.15
X3800 a_22218_35400# a_21252_35593# VDPWR VDPWR sky130_fd_pr__pfet_01v8_hvt ad=0.07665 pd=0.785 as=0.15835 ps=1.395 w=0.42 l=0.15
X3801 VDPWR a_17059_33729# a_18531_34095# VDPWR sky130_fd_pr__pfet_01v8_hvt ad=0.0714 pd=0.76 as=0.1092 ps=1.36 w=0.42 l=0.15
X3802 a_54459_35381# a_46193_39759# VDPWR VDPWR sky130_fd_pr__pfet_01v8_hvt ad=0.0567 pd=0.69 as=0.0819 ps=0.81 w=0.42 l=0.15
X3803 VDPWR a_56916_41623# a_39752_41659# VDPWR sky130_fd_pr__pfet_01v8_hvt ad=0.149 pd=1.325 as=0.26 ps=2.52 w=1 l=0.15
X3804 a_42445_36469# a_42613_36724# a_43157_36271# uio_oe[0] sky130_fd_pr__nfet_01v8 ad=0.25025 pd=1.42 as=0.08775 ps=0.92 w=0.65 l=0.15
X3805 a_22505_34571# a_21252_34505# VDPWR VDPWR sky130_fd_pr__pfet_01v8_hvt ad=0.1176 pd=1.4 as=0.0693 ps=0.75 w=0.42 l=0.15
X3806 a_61644_41935# a_60729_41935# a_61297_42177# uio_oe[0] sky130_fd_pr__special_nfet_01v8 ad=0.0711 pd=0.755 as=0.0999 ps=0.985 w=0.36 l=0.15
X3807 a_41040_38645# a_40864_38671# a_41184_38671# uio_oe[0] sky130_fd_pr__nfet_01v8 ad=0.1092 pd=1.36 as=0.0441 ps=0.63 w=0.42 l=0.15
X3808 uio_oe[0] a_36999_37557# a_37029_37583# uio_oe[0] sky130_fd_pr__nfet_01v8 ad=0.08775 pd=0.92 as=0.08775 ps=0.92 w=0.65 l=0.15
X3809 a_38991_37910# a_38740_37557# a_38532_37735# VDPWR sky130_fd_pr__pfet_01v8_hvt ad=0.0441 pd=0.63 as=0.1932 ps=1.34 w=0.42 l=0.15
X3810 a_38961_36469# a_37029_37583# VDPWR VDPWR sky130_fd_pr__pfet_01v8_hvt ad=0.1176 pd=1.4 as=0.0693 ps=0.75 w=0.42 l=0.15
X3811 a_53827_42301# a_48125_41935# VDPWR VDPWR sky130_fd_pr__pfet_01v8_hvt ad=0.1092 pd=1.36 as=0.07035 ps=0.755 w=0.42 l=0.15
X3812 VDPWR a_46761_41089# a_46651_41213# VDPWR sky130_fd_pr__pfet_01v8_hvt ad=0.07035 pd=0.755 as=0.1155 ps=0.97 w=0.42 l=0.15
X3813 a_40617_35161# a_37661_37052# uio_oe[0] uio_oe[0] sky130_fd_pr__nfet_01v8 ad=0.1092 pd=1.36 as=0.1449 ps=1.11 w=0.42 l=0.15
X3814 VDPWR a_38285_34863# a_41385_40342# VDPWR sky130_fd_pr__pfet_01v8_hvt ad=0.15835 pd=1.395 as=0.07665 ps=0.785 w=0.42 l=0.15
X3815 a_56843_40277# a_57046_40435# VDPWR VDPWR sky130_fd_pr__pfet_01v8_hvt ad=0.0567 pd=0.69 as=0.1134 ps=1.38 w=0.42 l=0.15
X3816 a_43682_39037# a_42605_38671# a_43520_38671# VDPWR sky130_fd_pr__pfet_01v8_hvt ad=0.0567 pd=0.69 as=0.0588 ps=0.7 w=0.42 l=0.15
X3817 uio_oe[0] a_42917_37557# a_42851_37583# uio_oe[0] sky130_fd_pr__nfet_01v8 ad=0.1449 pd=1.11 as=0.0693 ps=0.75 w=0.42 l=0.15
X3818 a_57829_39759# a_57450_40125# a_57757_39759# uio_oe[0] sky130_fd_pr__nfet_01v8 ad=0.1401 pd=1.1 as=0.0441 ps=0.63 w=0.42 l=0.15
X3819 a_60729_39759# a_60563_39759# VDPWR VDPWR sky130_fd_pr__pfet_01v8_hvt ad=0.1664 pd=1.8 as=0.0864 ps=0.91 w=0.64 l=0.15
X3820 a_45719_39447# a_36447_40849# VDPWR VDPWR sky130_fd_pr__pfet_01v8_hvt ad=0.0567 pd=0.69 as=0.16655 ps=1.39 w=0.42 l=0.15
X3821 uio_oe[0] a_62237_37337# a_62171_37405# uio_oe[0] sky130_fd_pr__nfet_01v8 ad=0.1449 pd=1.11 as=0.0693 ps=0.75 w=0.42 l=0.15
X3822 a_51554_37910# a_48677_38127# VDPWR VDPWR sky130_fd_pr__pfet_01v8_hvt ad=0.07665 pd=0.785 as=0.15835 ps=1.395 w=0.42 l=0.15
X3823 a_46013_38823# a_43559_35407# a_46176_38921# VDPWR sky130_fd_pr__pfet_01v8_hvt ad=0.1092 pd=1.36 as=0.0441 ps=0.63 w=0.42 l=0.15
X3824 a_52573_38493# a_52538_38259# a_52335_38101# uio_oe[0] sky130_fd_pr__nfet_01v8 ad=0.06405 pd=0.725 as=0.1092 ps=1.36 w=0.42 l=0.15
X3825 uio_oe[0] a_38005_41391# a_40415_36495# uio_oe[0] sky130_fd_pr__nfet_01v8 ad=0.0567 pd=0.69 as=0.1092 ps=1.36 w=0.42 l=0.15
X3826 a_42457_36249# a_37661_38140# VDPWR VDPWR sky130_fd_pr__pfet_01v8_hvt ad=0.1176 pd=1.4 as=0.0693 ps=0.75 w=0.42 l=0.15
X3827 uio_oe[0] a_16812_8642# a_18146_20730# uio_oe[0] sky130_fd_pr__nfet_01v8 ad=1.4703 pd=10.72 as=1.4703 ps=10.72 w=5.07 l=1
X3828 a_57664_35773# a_57450_35773# VDPWR VDPWR sky130_fd_pr__pfet_01v8_hvt ad=0.1155 pd=0.97 as=0.07035 ps=0.755 w=0.42 l=0.15
X3829 VDPWR a_24836_34969# a_24787_34817# VDPWR sky130_fd_pr__pfet_01v8_hvt ad=0.15835 pd=1.395 as=0.26 ps=2.52 w=1 l=0.15
X3830 a_39643_43023# a_39293_43023# a_39548_43023# VDPWR sky130_fd_pr__pfet_01v8_hvt ad=0.07245 pd=0.765 as=0.0651 ps=0.73 w=0.42 l=0.15
X3831 a_44261_40847# a_44095_40847# VDPWR VDPWR sky130_fd_pr__pfet_01v8_hvt ad=0.1664 pd=1.8 as=0.0864 ps=0.91 w=0.64 l=0.15
X3832 a_61998_40847# a_48125_41935# uio_oe[0] uio_oe[0] sky130_fd_pr__nfet_01v8 ad=0.06405 pd=0.725 as=0.12495 ps=1.015 w=0.42 l=0.15
X3833 a_46805_40669# a_46761_40277# a_46639_40681# uio_oe[0] sky130_fd_pr__nfet_01v8 ad=0.0441 pd=0.63 as=0.1401 ps=1.1 w=0.42 l=0.15
X3834 a_57081_39759# a_57046_40011# a_56843_39733# uio_oe[0] sky130_fd_pr__nfet_01v8 ad=0.06405 pd=0.725 as=0.1092 ps=1.36 w=0.42 l=0.15
X3835 uio_oe[0] a_36999_38101# a_37029_38127# uio_oe[0] sky130_fd_pr__nfet_01v8 ad=0.08775 pd=0.92 as=0.08775 ps=0.92 w=0.65 l=0.15
X3836 a_44516_43023# ui_in[0] VDPWR VDPWR sky130_fd_pr__pfet_01v8_hvt ad=0.0651 pd=0.73 as=0.1092 ps=1.36 w=0.42 l=0.15
X3837 a_51841_42777# a_48677_39759# uio_oe[0] uio_oe[0] sky130_fd_pr__nfet_01v8 ad=0.1092 pd=1.36 as=0.1449 ps=1.11 w=0.42 l=0.15
X3838 uio_oe[0] a_52335_39189# a_51620_39483# uio_oe[0] sky130_fd_pr__nfet_01v8 ad=0.2087 pd=2.02 as=0.169 ps=1.82 w=0.65 l=0.15
X3839 uio_oe[0] a_57012_37013# a_57148_37039# uio_oe[0] sky130_fd_pr__nfet_01v8 ad=0.1137 pd=1.01 as=0.1404 ps=1.6 w=0.54 l=0.15
X3840 VDPWR a_36425_34293# a_41793_34569# VDPWR sky130_fd_pr__pfet_01v8_hvt ad=0.135 pd=1.27 as=0.135 ps=1.27 w=1 l=0.15
X3841 a_60720_41757# a_60584_41705# VDPWR VDPWR sky130_fd_pr__pfet_01v8_hvt ad=0.0567 pd=0.69 as=0.0567 ps=0.69 w=0.42 l=0.15
X3842 a_53981_37583# a_53937_37825# a_53815_37583# uio_oe[0] sky130_fd_pr__nfet_01v8 ad=0.0441 pd=0.63 as=0.1401 ps=1.1 w=0.42 l=0.15
X3843 a_25020_33417# a_17500_33453# a_25162_33551# uio_oe[0] sky130_fd_pr__nfet_01v8 ad=0.09975 pd=0.895 as=0.0693 ps=0.75 w=0.42 l=0.15
X3844 VDPWR a_59956_34837# a_60092_34863# VDPWR sky130_fd_pr__pfet_01v8_hvt ad=0.12285 pd=1.17 as=0.2184 ps=2.2 w=0.84 l=0.15
X3845 a_46193_41935# a_46027_41935# VDPWR VDPWR sky130_fd_pr__pfet_01v8_hvt ad=0.1664 pd=1.8 as=0.0864 ps=0.91 w=0.64 l=0.15
X3846 a_53815_36495# a_53369_36495# a_53719_36495# uio_oe[0] sky130_fd_pr__special_nfet_01v8 ad=0.1401 pd=1.1 as=0.0594 ps=0.69 w=0.36 l=0.15
X3847 a_40619_36193# a_38005_41391# VDPWR VDPWR sky130_fd_pr__pfet_01v8_hvt ad=0.1664 pd=1.8 as=0.0864 ps=0.91 w=0.64 l=0.15
X3848 a_45530_41935# a_39947_42997# uio_oe[0] uio_oe[0] sky130_fd_pr__nfet_01v8 ad=0.06405 pd=0.725 as=0.12495 ps=1.015 w=0.42 l=0.15
X3849 uio_oe[0] a_37029_42479# a_42163_40309# uio_oe[0] sky130_fd_pr__nfet_01v8 ad=0.0567 pd=0.69 as=0.1092 ps=1.36 w=0.42 l=0.15
X3850 uio_oe[0] a_59201_38645# a_59135_38671# uio_oe[0] sky130_fd_pr__nfet_01v8 ad=0.1449 pd=1.11 as=0.0693 ps=0.75 w=0.42 l=0.15
X3851 a_20620_14376# a_21875_35933# VDPWR VDPWR sky130_fd_pr__pfet_01v8_hvt ad=0.475 pd=2.95 as=0.16655 ps=1.39 w=1 l=0.15
X3852 a_17721_36747# a_17388_36681# uio_oe[0] uio_oe[0] sky130_fd_pr__nfet_01v8 ad=0.1092 pd=1.36 as=0.1449 ps=1.11 w=0.42 l=0.15
X3853 a_40302_35659# a_40619_35549# a_40577_35407# uio_oe[0] sky130_fd_pr__special_nfet_01v8 ad=0.0711 pd=0.755 as=0.0669 ps=0.75 w=0.36 l=0.15
X3854 uio_oe[0] a_45351_42997# a_45285_43023# uio_oe[0] sky130_fd_pr__nfet_01v8 ad=0.12495 pd=1.015 as=0.0669 ps=0.75 w=0.42 l=0.15
X3855 a_53321_42845# a_52942_42479# a_53249_42845# uio_oe[0] sky130_fd_pr__nfet_01v8 ad=0.1401 pd=1.1 as=0.0441 ps=0.63 w=0.42 l=0.15
X3856 VDPWR a_48125_43023# a_50304_41391# VDPWR sky130_fd_pr__pfet_01v8_hvt ad=0.07035 pd=0.755 as=0.1092 ps=1.36 w=0.42 l=0.15
X3857 a_37859_38166# a_36425_35078# a_37859_38493# uio_oe[0] sky130_fd_pr__nfet_01v8 ad=0.09975 pd=0.895 as=0.0693 ps=0.75 w=0.42 l=0.15
X3858 VDPWR a_62237_37337# a_62267_37078# VDPWR sky130_fd_pr__pfet_01v8_hvt ad=0.0693 pd=0.75 as=0.0441 ps=0.63 w=0.42 l=0.15
X3859 a_38717_35201# a_37029_37583# uio_oe[0] uio_oe[0] sky130_fd_pr__nfet_01v8 ad=0.0567 pd=0.69 as=0.1118 ps=1.04 w=0.42 l=0.15
X3860 a_22395_35183# a_20923_34817# uio_oe[0] uio_oe[0] sky130_fd_pr__nfet_01v8 ad=0.1092 pd=1.36 as=0.1092 ps=1.36 w=0.42 l=0.15
X3861 a_40987_39457# a_38005_41391# VDPWR VDPWR sky130_fd_pr__pfet_01v8_hvt ad=0.1664 pd=1.8 as=0.0864 ps=0.91 w=0.64 l=0.15
X3862 a_52538_34995# a_52816_34979# a_52772_34863# VDPWR sky130_fd_pr__pfet_01v8_hvt ad=0.0588 pd=0.7 as=0.0567 ps=0.69 w=0.42 l=0.15
X3863 uio_oe[0] a_37029_42479# a_44095_41397# uio_oe[0] sky130_fd_pr__nfet_01v8 ad=0.0567 pd=0.69 as=0.1092 ps=1.36 w=0.42 l=0.15
X3864 a_39544_37735# a_39759_36777# a_39686_37910# VDPWR sky130_fd_pr__pfet_01v8_hvt ad=0.1932 pd=1.34 as=0.07665 ps=0.785 w=0.42 l=0.15
X3865 a_24836_37145# a_25044_36967# a_24978_36993# uio_oe[0] sky130_fd_pr__nfet_01v8 ad=0.09975 pd=0.895 as=0.0693 ps=0.75 w=0.42 l=0.15
X3866 a_38019_35773# a_37839_35773# VDPWR VDPWR sky130_fd_pr__pfet_01v8_hvt ad=0.0609 pd=0.71 as=0.0714 ps=0.76 w=0.42 l=0.15
X3867 a_42897_43265# a_42679_43023# uio_oe[0] uio_oe[0] sky130_fd_pr__nfet_01v8 ad=0.0999 pd=0.985 as=0.1346 ps=1.15 w=0.64 l=0.15
X3868 a_57450_42301# a_57363_42077# a_57046_42187# VDPWR sky130_fd_pr__pfet_01v8_hvt ad=0.12915 pd=1.185 as=0.0588 ps=0.7 w=0.42 l=0.15
X3869 a_37913_43023# a_37747_43023# uio_oe[0] uio_oe[0] sky130_fd_pr__nfet_01v8 ad=0.08775 pd=0.92 as=0.08775 ps=0.92 w=0.65 l=0.15
X3870 VDPWR a_38532_42711# a_17388_36681# VDPWR sky130_fd_pr__pfet_01v8_hvt ad=0.15835 pd=1.395 as=0.26 ps=2.52 w=1 l=0.15
X3871 VDPWR a_58144_40008# a_58082_40125# VDPWR sky130_fd_pr__pfet_01v8_hvt ad=0.1092 pd=1.36 as=0.0651 ps=0.73 w=0.42 l=0.15
X3872 a_16756_18782# a_18011_34845# uio_oe[0] uio_oe[0] sky130_fd_pr__nfet_01v8 ad=0.182 pd=1.86 as=0.1118 ps=1.04 w=0.65 l=0.15
X3873 a_27562_10464# a_24484_10782# ua[5] uio_oe[0] sky130_fd_pr__nfet_01v8 ad=0.1885 pd=1.88 as=0.1885 ps=1.88 w=0.65 l=0.15
X3874 uio_oe[0] a_37029_42479# a_46027_42485# uio_oe[0] sky130_fd_pr__nfet_01v8 ad=0.0567 pd=0.69 as=0.1092 ps=1.36 w=0.42 l=0.15
X3875 uio_oe[0] a_61819_40821# a_61753_40847# uio_oe[0] sky130_fd_pr__nfet_01v8 ad=0.12495 pd=1.015 as=0.0669 ps=0.75 w=0.42 l=0.15
X3876 a_39686_40669# a_38005_40847# uio_oe[0] uio_oe[0] sky130_fd_pr__nfet_01v8 ad=0.0693 pd=0.75 as=0.11285 ps=1.045 w=0.42 l=0.15
X3877 a_36275_37949# a_17500_33453# uio_oe[0] uio_oe[0] sky130_fd_pr__nfet_01v8 ad=0.1092 pd=1.36 as=0.1092 ps=1.36 w=0.42 l=0.15
X3878 a_29247_36815# a_17507_33198# a_28884_36681# uio_oe[0] sky130_fd_pr__nfet_01v8 ad=0.0693 pd=0.75 as=0.09975 ps=0.895 w=0.42 l=0.15
X3879 a_50090_35773# a_49964_35675# a_49686_35659# uio_oe[0] sky130_fd_pr__special_nfet_01v8 ad=0.0999 pd=0.985 as=0.0711 ps=0.755 w=0.36 l=0.15
X3880 uio_oe[0] a_29129_34791# a_29063_34817# uio_oe[0] sky130_fd_pr__nfet_01v8 ad=0.1449 pd=1.11 as=0.0693 ps=0.75 w=0.42 l=0.15
X3881 VDPWR a_61819_41909# a_61806_42301# VDPWR sky130_fd_pr__pfet_01v8_hvt ad=0.0819 pd=0.81 as=0.0567 ps=0.69 w=0.42 l=0.15
X3882 a_58248_41391# a_57472_41669# a_57640_41705# uio_oe[0] sky130_fd_pr__special_nfet_01v8 ad=0.0935 pd=0.965 as=0.072 ps=0.76 w=0.36 l=0.15
X3883 a_61297_41089# a_61079_40847# VDPWR VDPWR sky130_fd_pr__pfet_01v8_hvt ad=0.12915 pd=1.185 as=0.2184 ps=2.2 w=0.84 l=0.15
X3884 a_60371_40277# a_60176_40419# a_60681_40669# uio_oe[0] sky130_fd_pr__special_nfet_01v8 ad=0.0594 pd=0.69 as=0.1401 ps=1.1 w=0.36 l=0.15
X3885 VDPWR a_58772_34471# a_58144_34568# VDPWR sky130_fd_pr__pfet_01v8_hvt ad=0.15835 pd=1.395 as=0.26 ps=2.52 w=1 l=0.15
X3886 VDPWR a_44905_38671# a_57776_37405# VDPWR sky130_fd_pr__pfet_01v8_hvt ad=0.0798 pd=0.8 as=0.0567 ps=0.69 w=0.42 l=0.15
X3887 uio_oe[0] a_37361_41391# a_59685_36822# uio_oe[0] sky130_fd_pr__nfet_01v8 ad=0.1449 pd=1.11 as=0.1092 ps=1.36 w=0.42 l=0.15
X3888 VDPWR a_24787_34817# a_26259_35183# VDPWR sky130_fd_pr__pfet_01v8_hvt ad=0.0714 pd=0.76 as=0.1092 ps=1.36 w=0.42 l=0.15
X3889 a_53827_35773# a_46193_39759# VDPWR VDPWR sky130_fd_pr__pfet_01v8_hvt ad=0.1092 pd=1.36 as=0.07035 ps=0.755 w=0.42 l=0.15
X3890 a_59695_42453# a_59898_42611# VDPWR VDPWR sky130_fd_pr__pfet_01v8_hvt ad=0.0567 pd=0.69 as=0.1134 ps=1.38 w=0.42 l=0.15
X3891 a_30233_35659# a_28980_35593# VDPWR VDPWR sky130_fd_pr__pfet_01v8_hvt ad=0.1176 pd=1.4 as=0.0693 ps=0.75 w=0.42 l=0.15
X3892 a_38073_42518# a_36956_35095# a_37859_42518# VDPWR sky130_fd_pr__pfet_01v8_hvt ad=0.07665 pd=0.785 as=0.1932 ps=1.34 w=0.42 l=0.15
X3893 uio_oe[0] a_38961_40601# a_38895_40669# uio_oe[0] sky130_fd_pr__nfet_01v8 ad=0.1449 pd=1.11 as=0.0693 ps=0.75 w=0.42 l=0.15
X3894 a_21961_34845# a_20923_34817# a_21875_34845# uio_oe[0] sky130_fd_pr__nfet_01v8 ad=0.0567 pd=0.69 as=0.1176 ps=1.4 w=0.42 l=0.15
X3895 a_50159_39189# a_49964_39331# a_50469_39581# uio_oe[0] sky130_fd_pr__special_nfet_01v8 ad=0.0594 pd=0.69 as=0.1401 ps=1.1 w=0.36 l=0.15
X3896 a_51412_37735# a_39752_37557# a_51554_37910# VDPWR sky130_fd_pr__pfet_01v8_hvt ad=0.1932 pd=1.34 as=0.07665 ps=0.785 w=0.42 l=0.15
X3897 uio_oe[0] a_44905_38671# a_49721_35407# uio_oe[0] sky130_fd_pr__nfet_01v8 ad=0.12495 pd=1.015 as=0.06405 ps=0.725 w=0.42 l=0.15
X3898 VDPWR a_44905_38671# a_50304_37949# VDPWR sky130_fd_pr__pfet_01v8_hvt ad=0.07035 pd=0.755 as=0.1092 ps=1.36 w=0.42 l=0.15
X3899 VDPWR a_21553_32641# a_22575_37359# VDPWR sky130_fd_pr__pfet_01v8_hvt ad=0.2279 pd=1.74 as=0.0609 ps=0.71 w=0.42 l=0.15
X3900 a_50722_35951# a_49964_36067# a_50159_35925# VDPWR sky130_fd_pr__pfet_01v8_hvt ad=0.0651 pd=0.73 as=0.07245 ps=0.765 w=0.42 l=0.15
X3901 ua[4] a_24484_14376# a_24354_22020# uio_oe[0] sky130_fd_pr__nfet_01v8 ad=0.1885 pd=1.88 as=0.1885 ps=1.88 w=0.65 l=0.15
X3902 a_60365_35407# a_59939_35734# VDPWR VDPWR sky130_fd_pr__pfet_01v8_hvt ad=0.26 pd=2.52 as=0.15835 ps=1.395 w=1 l=0.15
X3903 a_53369_41935# a_53203_41935# uio_oe[0] uio_oe[0] sky130_fd_pr__nfet_01v8 ad=0.1092 pd=1.36 as=0.0567 ps=0.69 w=0.42 l=0.15
X3904 a_59323_41430# a_54479_41404# a_58864_41623# VDPWR sky130_fd_pr__pfet_01v8_hvt ad=0.0441 pd=0.63 as=0.1932 ps=1.34 w=0.42 l=0.15
X3905 a_36607_39455# a_37183_40277# uio_oe[0] uio_oe[0] sky130_fd_pr__nfet_01v8 ad=0.08775 pd=0.92 as=0.08775 ps=0.92 w=0.65 l=0.15
X3906 uio_oe[0] uio_oe[0] uio_oe[0] uio_oe[0] sky130_fd_pr__nfet_01v8 ad=0.1885 pd=1.88 as=0 ps=0 w=0.65 l=0.15
X3907 uio_oe[0] a_60215_38369# a_60176_38243# uio_oe[0] sky130_fd_pr__nfet_01v8 ad=0.0567 pd=0.69 as=0.1092 ps=1.36 w=0.42 l=0.15
X3908 VDPWR a_61297_37825# a_61187_37949# VDPWR sky130_fd_pr__pfet_01v8_hvt ad=0.07035 pd=0.755 as=0.1155 ps=0.97 w=0.42 l=0.15
X3909 a_51554_40669# a_48677_39759# uio_oe[0] uio_oe[0] sky130_fd_pr__nfet_01v8 ad=0.0693 pd=0.75 as=0.11285 ps=1.045 w=0.42 l=0.15
X3910 a_57829_38671# a_57450_39037# a_57757_38671# uio_oe[0] sky130_fd_pr__nfet_01v8 ad=0.1401 pd=1.1 as=0.0441 ps=0.63 w=0.42 l=0.15
X3911 a_24978_36993# a_24932_37145# uio_oe[0] uio_oe[0] sky130_fd_pr__nfet_01v8 ad=0.0693 pd=0.75 as=0.11285 ps=1.045 w=0.42 l=0.15
X3912 VDPWR a_36999_42453# a_37029_42479# VDPWR sky130_fd_pr__pfet_01v8_hvt ad=0.135 pd=1.27 as=0.135 ps=1.27 w=1 l=0.15
X3913 a_58980_36469# a_61819_36469# VDPWR VDPWR sky130_fd_pr__pfet_01v8_hvt ad=0.26 pd=2.52 as=0.3012 ps=2.66 w=1 l=0.15
X3914 a_25924_10020# a_4259_22596# a_25746_10020# uio_oe[0] sky130_fd_pr__nfet_01v8 ad=0.2436 pd=2.26 as=0.2436 ps=2.26 w=0.84 l=0.6
X3915 uio_oe[0] a_36385_38127# a_39127_43023# uio_oe[0] sky130_fd_pr__nfet_01v8 ad=0.0567 pd=0.69 as=0.1092 ps=1.36 w=0.42 l=0.15
X3916 a_60215_40545# a_37913_43023# uio_oe[0] uio_oe[0] sky130_fd_pr__nfet_01v8 ad=0.1092 pd=1.36 as=0.0567 ps=0.69 w=0.42 l=0.15
X3917 a_50003_38813# a_38649_43023# VDPWR VDPWR sky130_fd_pr__pfet_01v8_hvt ad=0.1664 pd=1.8 as=0.0864 ps=0.91 w=0.64 l=0.15
X3918 a_60584_37353# a_60500_37013# a_60988_37405# uio_oe[0] sky130_fd_pr__special_nfet_01v8 ad=0.072 pd=0.76 as=0.06705 ps=0.75 w=0.36 l=0.15
X3919 a_42329_41397# a_42163_41397# VDPWR VDPWR sky130_fd_pr__pfet_01v8_hvt ad=0.1664 pd=1.8 as=0.0864 ps=0.91 w=0.64 l=0.15
X3920 a_57450_41213# a_57324_41115# a_57046_41099# uio_oe[0] sky130_fd_pr__special_nfet_01v8 ad=0.0999 pd=0.985 as=0.0711 ps=0.755 w=0.36 l=0.15
X3921 a_28842_35905# a_28796_36057# uio_oe[0] uio_oe[0] sky130_fd_pr__nfet_01v8 ad=0.0693 pd=0.75 as=0.11285 ps=1.045 w=0.42 l=0.15
X3922 a_57081_38671# a_57046_38923# a_56843_38645# uio_oe[0] sky130_fd_pr__nfet_01v8 ad=0.06405 pd=0.725 as=0.1092 ps=1.36 w=0.42 l=0.15
X3923 a_60298_37405# a_46193_39759# uio_oe[0] uio_oe[0] sky130_fd_pr__nfet_01v8 ad=0.0483 pd=0.65 as=0.1137 ps=1.01 w=0.42 l=0.15
X3924 a_43419_42783# a_43244_42857# a_43598_42845# uio_oe[0] sky130_fd_pr__nfet_01v8 ad=0.1092 pd=1.36 as=0.06405 ps=0.725 w=0.42 l=0.15
X3925 VDPWR a_42897_42453# a_42787_42479# VDPWR sky130_fd_pr__pfet_01v8_hvt ad=0.07035 pd=0.755 as=0.1155 ps=0.97 w=0.42 l=0.15
X3926 VDPWR a_37661_38140# a_42857_37078# VDPWR sky130_fd_pr__pfet_01v8_hvt ad=0.15835 pd=1.395 as=0.07665 ps=0.785 w=0.42 l=0.15
X3927 VDPWR a_36447_40849# a_36499_36647# VDPWR sky130_fd_pr__pfet_01v8_hvt ad=0.1092 pd=1.36 as=0.1176 ps=1.4 w=0.42 l=0.15
X3928 a_46193_40309# a_46027_40309# VDPWR VDPWR sky130_fd_pr__pfet_01v8_hvt ad=0.1664 pd=1.8 as=0.0864 ps=0.91 w=0.64 l=0.15
X3929 uio_oe[0] a_48125_41935# a_53981_40847# uio_oe[0] sky130_fd_pr__nfet_01v8 ad=0.1346 pd=1.15 as=0.0441 ps=0.63 w=0.42 l=0.15
X3930 a_54284_39759# a_53369_39759# a_53937_40001# uio_oe[0] sky130_fd_pr__special_nfet_01v8 ad=0.0711 pd=0.755 as=0.0999 ps=0.985 w=0.36 l=0.15
X3931 VDPWR a_52855_40545# a_52816_40419# VDPWR sky130_fd_pr__pfet_01v8_hvt ad=0.0864 pd=0.91 as=0.1664 ps=1.8 w=0.64 l=0.15
X3932 uio_oe[0] a_45095_39733# a_43918_36041# uio_oe[0] sky130_fd_pr__nfet_01v8 ad=0.08775 pd=0.92 as=0.08775 ps=0.92 w=0.65 l=0.15
X3933 a_42907_35951# a_42613_36724# uio_oe[0] uio_oe[0] sky130_fd_pr__nfet_01v8 ad=0.08775 pd=0.92 as=0.169 ps=1.82 w=0.65 l=0.15
X3934 a_60365_34319# a_59939_34646# uio_oe[0] uio_oe[0] sky130_fd_pr__nfet_01v8 ad=0.169 pd=1.82 as=0.11285 ps=1.045 w=0.65 l=0.15
X3935 uio_oe[0] a_57519_34556# a_57450_34685# uio_oe[0] sky130_fd_pr__nfet_01v8 ad=0.1346 pd=1.15 as=0.0999 ps=0.985 w=0.64 l=0.15
X3936 VDPWR a_38961_39733# a_38991_40086# VDPWR sky130_fd_pr__pfet_01v8_hvt ad=0.0693 pd=0.75 as=0.0441 ps=0.63 w=0.42 l=0.15
X3937 a_43075_38101# a_42880_38243# a_43385_38493# uio_oe[0] sky130_fd_pr__special_nfet_01v8 ad=0.0594 pd=0.69 as=0.1401 ps=1.1 w=0.36 l=0.15
X3938 VDPWR ua[5] uio_oe[0] sky130_fd_pr__res_high_po_1p41 l=11.61
X3939 a_30167_36815# a_18427_33198# a_29804_36681# uio_oe[0] sky130_fd_pr__nfet_01v8 ad=0.0693 pd=0.75 as=0.09975 ps=0.895 w=0.42 l=0.15
X3940 a_57450_35773# a_57363_35549# a_57046_35659# VDPWR sky130_fd_pr__pfet_01v8_hvt ad=0.12915 pd=1.185 as=0.0588 ps=0.7 w=0.42 l=0.15
X3941 a_45095_39733# a_45431_39733# VDPWR VDPWR sky130_fd_pr__pfet_01v8_hvt ad=0.26 pd=2.52 as=0.135 ps=1.27 w=1 l=0.15
X3942 a_61079_39759# a_60729_39759# a_60984_39759# VDPWR sky130_fd_pr__pfet_01v8_hvt ad=0.07245 pd=0.765 as=0.0651 ps=0.73 w=0.42 l=0.15
X3943 a_16756_10782# a_18711_37359# uio_oe[0] uio_oe[0] sky130_fd_pr__nfet_01v8 ad=0.169 pd=1.82 as=0.1013 ps=0.99 w=0.65 l=0.15
X3944 a_30034_26464# a_28348_10782# ua[4] uio_oe[0] sky130_fd_pr__nfet_01v8 ad=0.1885 pd=1.88 as=0.1885 ps=1.88 w=0.65 l=0.15
X3945 a_49721_41757# a_49686_41523# a_49483_41365# uio_oe[0] sky130_fd_pr__nfet_01v8 ad=0.06405 pd=0.725 as=0.1092 ps=1.36 w=0.42 l=0.15
X3946 VDPWR a_46193_39759# a_53156_38127# VDPWR sky130_fd_pr__pfet_01v8_hvt ad=0.07035 pd=0.755 as=0.1092 ps=1.36 w=0.42 l=0.15
X3947 a_54627_37405# a_54479_37052# a_54264_37271# uio_oe[0] sky130_fd_pr__nfet_01v8 ad=0.0693 pd=0.75 as=0.09975 ps=0.895 w=0.42 l=0.15
X3948 a_59939_34646# a_51620_34293# a_59939_34319# uio_oe[0] sky130_fd_pr__nfet_01v8 ad=0.09975 pd=0.895 as=0.0693 ps=0.75 w=0.42 l=0.15
X3949 a_51620_34293# a_54459_34293# VDPWR VDPWR sky130_fd_pr__pfet_01v8_hvt ad=0.26 pd=2.52 as=0.3012 ps=2.66 w=1 l=0.15
X3950 a_60458_34863# a_60092_34863# VDPWR VDPWR sky130_fd_pr__pfet_01v8_hvt ad=0.0441 pd=0.63 as=0.1092 ps=1.36 w=0.42 l=0.15
X3951 a_50397_37405# a_44905_38671# uio_oe[0] uio_oe[0] sky130_fd_pr__nfet_01v8 ad=0.0441 pd=0.63 as=0.1346 ps=1.15 w=0.42 l=0.15
X3952 a_39549_34837# a_39647_34877# uio_oe[0] uio_oe[0] sky130_fd_pr__nfet_01v8 ad=0.0567 pd=0.69 as=0.10187 ps=0.99 w=0.42 l=0.15
X3953 a_58980_35381# a_61819_35381# uio_oe[0] uio_oe[0] sky130_fd_pr__nfet_01v8 ad=0.169 pd=1.82 as=0.2087 ps=2.02 w=0.65 l=0.15
X3954 uio_oe[0] a_54693_42777# a_54627_42845# uio_oe[0] sky130_fd_pr__nfet_01v8 ad=0.1449 pd=1.11 as=0.0693 ps=0.75 w=0.42 l=0.15
X3955 a_52800_37583# a_51620_37557# a_52579_37910# uio_oe[0] sky130_fd_pr__nfet_01v8 ad=0.0693 pd=0.75 as=0.09975 ps=0.895 w=0.42 l=0.15
X3956 a_58082_42301# a_57324_42203# a_57519_42172# VDPWR sky130_fd_pr__pfet_01v8_hvt ad=0.0651 pd=0.73 as=0.07245 ps=0.765 w=0.42 l=0.15
X3957 VDPWR a_53937_41089# a_53827_41213# VDPWR sky130_fd_pr__pfet_01v8_hvt ad=0.07035 pd=0.755 as=0.1155 ps=0.97 w=0.42 l=0.15
X3958 VDPWR a_61819_35381# a_61806_35773# VDPWR sky130_fd_pr__pfet_01v8_hvt ad=0.0819 pd=0.81 as=0.0567 ps=0.69 w=0.42 l=0.15
X3959 a_52772_42479# a_52335_42453# VDPWR VDPWR sky130_fd_pr__pfet_01v8_hvt ad=0.0567 pd=0.69 as=0.0819 ps=0.81 w=0.42 l=0.15
X3960 VDPWR a_38532_41623# a_17388_34505# VDPWR sky130_fd_pr__pfet_01v8_hvt ad=0.15835 pd=1.395 as=0.26 ps=2.52 w=1 l=0.15
X3961 a_37029_38127# a_36999_38101# uio_oe[0] uio_oe[0] sky130_fd_pr__nfet_01v8 ad=0.08775 pd=0.92 as=0.169 ps=1.82 w=0.65 l=0.15
X3962 a_57694_37039# a_57472_37317# a_57012_37013# VDPWR sky130_fd_pr__pfet_01v8_hvt ad=0.0483 pd=0.65 as=0.0819 ps=0.81 w=0.42 l=0.15
X3963 VDPWR a_40379_35551# a_40920_35951# VDPWR sky130_fd_pr__pfet_01v8_hvt ad=0.07035 pd=0.755 as=0.1092 ps=1.36 w=0.42 l=0.15
X3964 a_30034_26464# a_4259_22596# a_29738_24730# uio_oe[0] sky130_fd_pr__nfet_01v8 ad=0.2436 pd=2.26 as=0.2436 ps=2.26 w=0.84 l=0.6
X3965 uio_oe[0] a_25449_34571# a_25383_34639# uio_oe[0] sky130_fd_pr__nfet_01v8 ad=0.1449 pd=1.11 as=0.0693 ps=0.75 w=0.42 l=0.15
X3966 VDPWR a_37085_35951# a_38073_42518# VDPWR sky130_fd_pr__pfet_01v8_hvt ad=0.15835 pd=1.395 as=0.07665 ps=0.785 w=0.42 l=0.15
X3967 uio_oe[0] a_16812_8642# a_28346_20730# uio_oe[0] sky130_fd_pr__nfet_01v8 ad=1.4703 pd=10.72 as=1.4703 ps=10.72 w=5.07 l=1
X3968 uio_oe[0] a_59860_35095# a_54479_34876# uio_oe[0] sky130_fd_pr__nfet_01v8 ad=0.097 pd=0.975 as=0.169 ps=1.82 w=0.65 l=0.15
X3969 uio_oe[0] a_17255_32793# a_36503_35381# uio_oe[0] sky130_fd_pr__nfet_01v8 ad=0.1092 pd=1.36 as=0.1092 ps=1.36 w=0.42 l=0.15
X3970 a_29281_32641# a_29015_33007# VDPWR VDPWR sky130_fd_pr__pfet_01v8_hvt ad=0.26 pd=2.52 as=0.2279 ps=1.74 w=1 l=0.15
X3971 a_41225_34569# a_37851_36647# VDPWR VDPWR sky130_fd_pr__pfet_01v8_hvt ad=0.135 pd=1.27 as=0.135 ps=1.27 w=1 l=0.15
X3972 a_60416_41669# a_37913_43023# VDPWR VDPWR sky130_fd_pr__pfet_01v8_hvt ad=0.1664 pd=1.8 as=0.0864 ps=0.91 w=0.64 l=0.15
X3973 a_49920_35951# a_49483_35925# VDPWR VDPWR sky130_fd_pr__pfet_01v8_hvt ad=0.0567 pd=0.69 as=0.0819 ps=0.81 w=0.42 l=0.15
X3974 VDPWR a_50003_35549# a_49964_35675# VDPWR sky130_fd_pr__pfet_01v8_hvt ad=0.0864 pd=0.91 as=0.1664 ps=1.8 w=0.64 l=0.15
X3975 a_40379_35551# a_40495_42453# VDPWR VDPWR sky130_fd_pr__pfet_01v8_hvt ad=0.135 pd=1.27 as=0.26 ps=2.52 w=1 l=0.15
X3976 a_61297_40001# a_61079_39759# VDPWR VDPWR sky130_fd_pr__pfet_01v8_hvt ad=0.12915 pd=1.185 as=0.2184 ps=2.2 w=0.84 l=0.15
X3977 VDPWR a_60215_36193# a_60176_36067# VDPWR sky130_fd_pr__pfet_01v8_hvt ad=0.0864 pd=0.91 as=0.1664 ps=1.8 w=0.64 l=0.15
X3978 a_61819_41909# a_61644_41935# a_61998_41935# uio_oe[0] sky130_fd_pr__nfet_01v8 ad=0.1092 pd=1.36 as=0.06405 ps=0.725 w=0.42 l=0.15
X3979 a_40337_35407# a_40302_35659# a_40099_35381# uio_oe[0] sky130_fd_pr__nfet_01v8 ad=0.06405 pd=0.725 as=0.1092 ps=1.36 w=0.42 l=0.15
X3980 VDPWR a_21585_33483# a_21615_33224# VDPWR sky130_fd_pr__pfet_01v8_hvt ad=0.0693 pd=0.75 as=0.0441 ps=0.63 w=0.42 l=0.15
X3981 a_37579_34863# a_37328_34979# uio_oe[0] uio_oe[0] sky130_fd_pr__nfet_01v8 ad=0.169 pd=1.82 as=0.10025 ps=0.985 w=0.65 l=0.15
X3982 a_57012_37013# a_57472_37317# a_57430_37405# uio_oe[0] sky130_fd_pr__nfet_01v8 ad=0.0693 pd=0.75 as=0.0441 ps=0.63 w=0.42 l=0.15
X3983 uio_oe[0] a_50003_36193# a_49964_36067# uio_oe[0] sky130_fd_pr__nfet_01v8 ad=0.0567 pd=0.69 as=0.1092 ps=1.36 w=0.42 l=0.15
X3984 a_58082_35951# a_57363_36193# a_57519_35925# uio_oe[0] sky130_fd_pr__special_nfet_01v8 ad=0.066 pd=0.745 as=0.0594 ps=0.69 w=0.36 l=0.15
X3985 a_16804_10020# a_4259_22596# a_16626_10020# uio_oe[0] sky130_fd_pr__nfet_01v8 ad=0.2436 pd=2.26 as=0.2436 ps=2.26 w=0.84 l=0.6
X3986 a_53369_41935# a_53203_41935# VDPWR VDPWR sky130_fd_pr__pfet_01v8_hvt ad=0.1664 pd=1.8 as=0.0864 ps=0.91 w=0.64 l=0.15
X3987 VDPWR a_54284_39759# a_54459_39733# VDPWR sky130_fd_pr__pfet_01v8_hvt ad=0.1134 pd=1.38 as=0.0567 ps=0.69 w=0.42 l=0.15
X3988 VDPWR a_44905_38671# a_50304_36861# VDPWR sky130_fd_pr__pfet_01v8_hvt ad=0.07035 pd=0.755 as=0.1092 ps=1.36 w=0.42 l=0.15
X3989 VDPWR a_21553_32641# a_22575_36271# VDPWR sky130_fd_pr__pfet_01v8_hvt ad=0.2279 pd=1.74 as=0.0609 ps=0.71 w=0.42 l=0.15
X3990 a_50722_35951# a_50003_36193# a_50159_35925# uio_oe[0] sky130_fd_pr__special_nfet_01v8 ad=0.066 pd=0.745 as=0.0594 ps=0.69 w=0.36 l=0.15
X3991 VDPWR a_18641_34571# a_18671_34312# VDPWR sky130_fd_pr__pfet_01v8_hvt ad=0.0693 pd=0.75 as=0.0441 ps=0.63 w=0.42 l=0.15
X3992 a_57450_38127# a_57324_38243# a_57046_38259# uio_oe[0] sky130_fd_pr__special_nfet_01v8 ad=0.0999 pd=0.985 as=0.0711 ps=0.755 w=0.36 l=0.15
X3993 a_49961_35229# a_49483_34837# uio_oe[0] uio_oe[0] sky130_fd_pr__nfet_01v8 ad=0.0669 pd=0.75 as=0.12495 ps=1.015 w=0.42 l=0.15
X3994 VDPWR a_39544_38823# a_21068_33881# VDPWR sky130_fd_pr__pfet_01v8_hvt ad=0.15835 pd=1.395 as=0.26 ps=2.52 w=1 l=0.15
X3995 a_44909_37735# a_45114_37735# a_45072_37833# VDPWR sky130_fd_pr__pfet_01v8_hvt ad=0.1092 pd=1.36 as=0.0441 ps=0.63 w=0.42 l=0.15
X3996 VDPWR a_61297_36737# a_61187_36861# VDPWR sky130_fd_pr__pfet_01v8_hvt ad=0.07035 pd=0.755 as=0.1155 ps=0.97 w=0.42 l=0.15
X3997 uio_oe[0] uio_in[0] a_37747_43023# uio_oe[0] sky130_fd_pr__nfet_01v8 ad=0.08775 pd=0.92 as=0.169 ps=1.82 w=0.65 l=0.15
X3998 a_44621_38447# a_44327_38359# a_44537_38447# uio_oe[0] sky130_fd_pr__nfet_01v8 ad=0.25025 pd=1.42 as=0.08775 ps=0.92 w=0.65 l=0.15
X3999 VDPWR a_40775_35644# a_40706_35773# VDPWR sky130_fd_pr__pfet_01v8_hvt ad=0.2184 pd=2.2 as=0.12915 ps=1.185 w=0.84 l=0.15
X4000 a_61808_35095# a_58980_35381# a_61950_34902# VDPWR sky130_fd_pr__pfet_01v8_hvt ad=0.1932 pd=1.34 as=0.07665 ps=0.785 w=0.42 l=0.15
X4001 a_53827_42301# a_53203_41935# a_53719_41935# VDPWR sky130_fd_pr__pfet_01v8_hvt ad=0.1155 pd=0.97 as=0.07245 ps=0.765 w=0.42 l=0.15
X4002 a_47217_40847# a_46027_40847# a_47108_40847# uio_oe[0] sky130_fd_pr__special_nfet_01v8 ad=0.0669 pd=0.75 as=0.0711 ps=0.755 w=0.36 l=0.15
X4003 VDPWR a_36427_36475# a_37469_36745# VDPWR sky130_fd_pr__pfet_01v8_hvt ad=0.14825 pd=1.34 as=0.0441 ps=0.63 w=0.42 l=0.15
X4004 a_18196_14020# a_4259_22596# a_18018_14020# uio_oe[0] sky130_fd_pr__nfet_01v8 ad=0.2436 pd=2.26 as=0.2436 ps=2.26 w=0.84 l=0.6
X4005 a_25876_18376# a_26439_34095# VDPWR VDPWR sky130_fd_pr__pfet_01v8_hvt ad=0.26 pd=2.52 as=0.2279 ps=1.74 w=1 l=0.15
X4006 a_59860_35095# a_59956_34837# VDPWR VDPWR sky130_fd_pr__pfet_01v8_hvt ad=0.1664 pd=1.8 as=0.149 ps=1.325 w=0.64 l=0.15
X4007 a_57757_37583# a_44905_38671# uio_oe[0] uio_oe[0] sky130_fd_pr__nfet_01v8 ad=0.0441 pd=0.63 as=0.1346 ps=1.15 w=0.42 l=0.15
X4008 uio_oe[0] a_60416_35141# a_60500_34837# uio_oe[0] sky130_fd_pr__nfet_01v8 ad=0.0567 pd=0.69 as=0.1092 ps=1.36 w=0.42 l=0.15
X4009 a_40928_37583# a_40811_37796# VDPWR VDPWR sky130_fd_pr__pfet_01v8_hvt ad=0.0651 pd=0.73 as=0.1092 ps=1.36 w=0.42 l=0.15
X4010 ua[4] a_28348_14376# a_31002_22020# uio_oe[0] sky130_fd_pr__nfet_01v8 ad=0.1885 pd=1.88 as=0.1885 ps=1.88 w=0.65 l=0.15
X4011 VDPWR a_42897_41365# a_42787_41391# VDPWR sky130_fd_pr__pfet_01v8_hvt ad=0.07035 pd=0.755 as=0.1155 ps=0.97 w=0.42 l=0.15
X4012 a_50003_38369# a_41685_42479# uio_oe[0] uio_oe[0] sky130_fd_pr__nfet_01v8 ad=0.1092 pd=1.36 as=0.0567 ps=0.69 w=0.42 l=0.15
X4013 ua[5] a_20620_10376# a_21882_14020# uio_oe[0] sky130_fd_pr__nfet_01v8 ad=0.1885 pd=1.88 as=0.1885 ps=1.88 w=0.65 l=0.15
X4014 VDPWR a_51412_38823# a_50784_38920# VDPWR sky130_fd_pr__pfet_01v8_hvt ad=0.15835 pd=1.395 as=0.26 ps=2.52 w=1 l=0.15
X4015 a_54284_38671# a_53369_38671# a_53937_38913# uio_oe[0] sky130_fd_pr__special_nfet_01v8 ad=0.0711 pd=0.755 as=0.0999 ps=0.985 w=0.36 l=0.15
X4016 a_45338_42301# a_44261_41935# a_45176_41935# VDPWR sky130_fd_pr__pfet_01v8_hvt ad=0.0567 pd=0.69 as=0.0588 ps=0.7 w=0.42 l=0.15
X4017 VDPWR a_60416_39493# a_60500_39189# VDPWR sky130_fd_pr__pfet_01v8_hvt ad=0.0864 pd=0.91 as=0.1664 ps=1.8 w=0.64 l=0.15
X4018 a_40670_38259# a_40948_38243# a_40904_38127# VDPWR sky130_fd_pr__pfet_01v8_hvt ad=0.0588 pd=0.7 as=0.0567 ps=0.69 w=0.42 l=0.15
X4019 VDPWR a_37361_41391# a_52325_35734# VDPWR sky130_fd_pr__pfet_01v8_hvt ad=0.0693 pd=0.75 as=0.1176 ps=1.4 w=0.42 l=0.15
X4020 uio_oe[0] a_58144_34568# a_58082_34685# uio_oe[0] sky130_fd_pr__nfet_01v8 ad=0.2205 pd=1.89 as=0.066 ps=0.745 w=0.42 l=0.15
X4021 a_39686_40342# a_38005_40847# VDPWR VDPWR sky130_fd_pr__pfet_01v8_hvt ad=0.07665 pd=0.785 as=0.15835 ps=1.395 w=0.42 l=0.15
X4022 VDPWR a_46761_40277# a_46651_40303# VDPWR sky130_fd_pr__pfet_01v8_hvt ad=0.07035 pd=0.755 as=0.1155 ps=0.97 w=0.42 l=0.15
X4023 VDPWR a_56843_40277# a_39752_40571# VDPWR sky130_fd_pr__pfet_01v8_hvt ad=0.3012 pd=2.66 as=0.26 ps=2.52 w=1 l=0.15
X4024 a_57519_35925# a_57324_36067# a_57829_36317# uio_oe[0] sky130_fd_pr__special_nfet_01v8 ad=0.0594 pd=0.69 as=0.1401 ps=1.1 w=0.36 l=0.15
X4025 a_60584_39529# a_60416_39493# a_60988_39215# VDPWR sky130_fd_pr__pfet_01v8_hvt ad=0.0567 pd=0.69 as=0.0945 ps=0.87 w=0.42 l=0.15
X4026 ua[4] a_16756_14782# a_16626_14020# uio_oe[0] sky130_fd_pr__nfet_01v8 ad=0.1885 pd=1.88 as=0.1885 ps=1.88 w=0.65 l=0.15
X4027 VDPWR a_53937_34561# a_53827_34685# VDPWR sky130_fd_pr__pfet_01v8_hvt ad=0.07035 pd=0.755 as=0.1155 ps=0.97 w=0.42 l=0.15
X4028 a_58082_35773# a_57324_35675# a_57519_35644# VDPWR sky130_fd_pr__pfet_01v8_hvt ad=0.0651 pd=0.73 as=0.07245 ps=0.765 w=0.42 l=0.15
X4029 a_41288_40125# a_41074_40125# VDPWR VDPWR sky130_fd_pr__pfet_01v8_hvt ad=0.1155 pd=0.97 as=0.07035 ps=0.755 w=0.42 l=0.15
X4030 uio_oe[0] a_58298_39445# a_58248_39215# uio_oe[0] sky130_fd_pr__nfet_01v8 ad=0.1664 pd=1.8 as=0.0935 ps=0.965 w=0.64 l=0.15
X4031 a_26369_35659# a_25116_35593# uio_oe[0] uio_oe[0] sky130_fd_pr__nfet_01v8 ad=0.1092 pd=1.36 as=0.1449 ps=1.11 w=0.42 l=0.15
X4032 a_21114_33729# a_21068_33881# uio_oe[0] uio_oe[0] sky130_fd_pr__nfet_01v8 ad=0.0693 pd=0.75 as=0.11285 ps=1.045 w=0.42 l=0.15
X4033 a_17537_34791# a_17204_34969# VDPWR VDPWR sky130_fd_pr__pfet_01v8_hvt ad=0.1176 pd=1.4 as=0.0693 ps=0.75 w=0.42 l=0.15
X4034 a_37029_42479# a_36999_42453# VDPWR VDPWR sky130_fd_pr__pfet_01v8_hvt ad=0.135 pd=1.27 as=0.26 ps=2.52 w=1 l=0.15
X4035 a_46193_39759# a_46027_39759# uio_oe[0] uio_oe[0] sky130_fd_pr__nfet_01v8 ad=0.08775 pd=0.92 as=0.08775 ps=0.92 w=0.65 l=0.15
X4036 a_58044_39581# a_57776_39581# uio_oe[0] uio_oe[0] sky130_fd_pr__nfet_01v8 ad=0.06705 pd=0.75 as=0.0882 ps=0.84 w=0.42 l=0.15
X4037 uio_oe[0] uio_oe[0] uio_oe[0] uio_oe[0] sky130_fd_pr__nfet_01v8 ad=0.1885 pd=1.88 as=0 ps=0 w=0.65 l=0.15
X4038 uio_oe[0] a_50784_39189# a_50722_39215# uio_oe[0] sky130_fd_pr__nfet_01v8 ad=0.2205 pd=1.89 as=0.066 ps=0.745 w=0.42 l=0.15
X4039 uio_oe[0] a_57363_36637# a_57324_36763# uio_oe[0] sky130_fd_pr__nfet_01v8 ad=0.0567 pd=0.69 as=0.1092 ps=1.36 w=0.42 l=0.15
X4040 VDPWR a_25265_33703# a_25295_34056# VDPWR sky130_fd_pr__pfet_01v8_hvt ad=0.0693 pd=0.75 as=0.0441 ps=0.63 w=0.42 l=0.15
X4041 a_61079_40847# a_60563_40847# a_60984_40847# uio_oe[0] sky130_fd_pr__special_nfet_01v8 ad=0.0594 pd=0.69 as=0.066 ps=0.745 w=0.36 l=0.15
X4042 a_38991_40342# a_38740_40571# a_38532_40535# VDPWR sky130_fd_pr__pfet_01v8_hvt ad=0.0441 pd=0.63 as=0.1932 ps=1.34 w=0.42 l=0.15
X4043 uio_oe[0] a_37361_41391# a_52325_35734# uio_oe[0] sky130_fd_pr__nfet_01v8 ad=0.1449 pd=1.11 as=0.1092 ps=1.36 w=0.42 l=0.15
X4044 VDPWR a_41751_34471# a_41961_34569# VDPWR sky130_fd_pr__pfet_01v8_hvt ad=0.26 pd=2.52 as=0.135 ps=1.27 w=1 l=0.15
X4045 a_52772_41391# a_52335_41365# VDPWR VDPWR sky130_fd_pr__pfet_01v8_hvt ad=0.0567 pd=0.69 as=0.0819 ps=0.81 w=0.42 l=0.15
X4046 a_59898_38259# a_60176_38243# a_60132_38127# VDPWR sky130_fd_pr__pfet_01v8_hvt ad=0.0588 pd=0.7 as=0.0567 ps=0.69 w=0.42 l=0.15
X4047 ua[4] a_18148_18782# a_18018_18020# uio_oe[0] sky130_fd_pr__nfet_01v8 ad=0.1885 pd=1.88 as=0.1885 ps=1.88 w=0.65 l=0.15
X4048 uio_oe[0] a_25449_33483# a_25383_33551# uio_oe[0] sky130_fd_pr__nfet_01v8 ad=0.1449 pd=1.11 as=0.0693 ps=0.75 w=0.42 l=0.15
X4049 a_44516_42845# a_44399_42650# VDPWR VDPWR sky130_fd_pr__pfet_01v8_hvt ad=0.0651 pd=0.73 as=0.1092 ps=1.36 w=0.42 l=0.15
X4050 uio_oe[0] a_49483_41365# a_38740_41659# uio_oe[0] sky130_fd_pr__nfet_01v8 ad=0.2087 pd=2.02 as=0.169 ps=1.82 w=0.65 l=0.15
X4051 a_28348_18782# a_29603_34845# uio_oe[0] uio_oe[0] sky130_fd_pr__nfet_01v8 ad=0.182 pd=1.86 as=0.1118 ps=1.04 w=0.65 l=0.15
X4052 a_51841_41909# a_48677_39759# uio_oe[0] uio_oe[0] sky130_fd_pr__nfet_01v8 ad=0.1092 pd=1.36 as=0.1449 ps=1.11 w=0.42 l=0.15
X4053 a_59956_41365# a_60500_41365# a_60458_41391# VDPWR sky130_fd_pr__pfet_01v8_hvt ad=0.0819 pd=0.81 as=0.0441 ps=0.63 w=0.42 l=0.15
X4054 a_20914_14464# a_20620_14376# ua[4] uio_oe[0] sky130_fd_pr__nfet_01v8 ad=0.1885 pd=1.88 as=0.1885 ps=1.88 w=0.65 l=0.15
X4055 a_51554_40342# a_48677_39759# VDPWR VDPWR sky130_fd_pr__pfet_01v8_hvt ad=0.07665 pd=0.785 as=0.15835 ps=1.395 w=0.42 l=0.15
X4056 VDPWR a_61242_39445# a_61192_39215# VDPWR sky130_fd_pr__pfet_01v8_hvt ad=0.2184 pd=2.2 as=0.12495 ps=1.175 w=0.84 l=0.15
X4057 a_26439_37359# a_26259_37359# VDPWR VDPWR sky130_fd_pr__pfet_01v8_hvt ad=0.0609 pd=0.71 as=0.0714 ps=0.76 w=0.42 l=0.15
X4058 VDPWR a_17292_36681# a_17243_36449# VDPWR sky130_fd_pr__pfet_01v8_hvt ad=0.15835 pd=1.395 as=0.26 ps=2.52 w=1 l=0.15
X4059 a_60153_34646# a_51620_34293# a_59939_34646# VDPWR sky130_fd_pr__pfet_01v8_hvt ad=0.07665 pd=0.785 as=0.1932 ps=1.34 w=0.42 l=0.15
X4060 a_53624_39759# a_53005_39759# VDPWR VDPWR sky130_fd_pr__pfet_01v8_hvt ad=0.0651 pd=0.73 as=0.1092 ps=1.36 w=0.42 l=0.15
X4061 uio_oe[0] a_37913_41935# a_60563_36495# uio_oe[0] sky130_fd_pr__nfet_01v8 ad=0.0567 pd=0.69 as=0.1092 ps=1.36 w=0.42 l=0.15
X4062 VDPWR a_37851_36647# a_39209_35951# VDPWR sky130_fd_pr__pfet_01v8_hvt ad=0.26 pd=2.52 as=0.105 ps=1.21 w=1 l=0.15
X4063 a_61341_39759# a_61297_40001# a_61175_39759# uio_oe[0] sky130_fd_pr__nfet_01v8 ad=0.0441 pd=0.63 as=0.1401 ps=1.1 w=0.42 l=0.15
X4064 a_37859_37910# a_37579_34863# a_37859_37583# uio_oe[0] sky130_fd_pr__nfet_01v8 ad=0.09975 pd=0.895 as=0.0693 ps=0.75 w=0.42 l=0.15
X4065 a_52813_36317# a_52335_35925# uio_oe[0] uio_oe[0] sky130_fd_pr__nfet_01v8 ad=0.0669 pd=0.75 as=0.12495 ps=1.015 w=0.42 l=0.15
X4066 a_51841_36249# a_48677_38127# VDPWR VDPWR sky130_fd_pr__pfet_01v8_hvt ad=0.1176 pd=1.4 as=0.0693 ps=0.75 w=0.42 l=0.15
X4067 a_41987_34863# a_37029_37583# uio_oe[0] uio_oe[0] sky130_fd_pr__nfet_01v8 ad=0.08775 pd=0.92 as=0.169 ps=1.82 w=0.65 l=0.15
X4068 uio_oe[0] a_25265_36967# a_25199_36993# uio_oe[0] sky130_fd_pr__nfet_01v8 ad=0.1449 pd=1.11 as=0.0693 ps=0.75 w=0.42 l=0.15
X4069 ua[5] a_16756_10782# a_16626_26020# uio_oe[0] sky130_fd_pr__nfet_01v8 ad=0.1885 pd=1.88 as=0.1885 ps=1.88 w=0.65 l=0.15
X4070 a_38649_43023# a_38483_43023# uio_oe[0] uio_oe[0] sky130_fd_pr__nfet_01v8 ad=0.08775 pd=0.92 as=0.08775 ps=0.92 w=0.65 l=0.15
X4071 uio_oe[0] a_42445_36469# a_42389_36822# uio_oe[0] sky130_fd_pr__nfet_01v8 ad=0.1449 pd=1.11 as=0.1092 ps=1.36 w=0.42 l=0.15
X4072 a_20914_14464# ua[2] a_20668_14020# uio_oe[0] sky130_fd_pr__nfet_01v8 ad=0.2436 pd=2.26 as=0.2436 ps=2.26 w=0.84 l=0.6
X4073 VDPWR a_44829_43265# a_44719_43389# VDPWR sky130_fd_pr__pfet_01v8_hvt ad=0.07035 pd=0.755 as=0.1155 ps=0.97 w=0.42 l=0.15
X4074 uio_oe[0] a_37029_42479# a_44095_40847# uio_oe[0] sky130_fd_pr__nfet_01v8 ad=0.0567 pd=0.69 as=0.1092 ps=1.36 w=0.42 l=0.15
X4075 a_36530_39347# a_36808_39331# a_36764_39215# VDPWR sky130_fd_pr__pfet_01v8_hvt ad=0.0588 pd=0.7 as=0.0567 ps=0.69 w=0.42 l=0.15
X4076 VDPWR a_57012_37013# a_57148_37039# VDPWR sky130_fd_pr__pfet_01v8_hvt ad=0.12285 pd=1.17 as=0.2184 ps=2.2 w=0.84 l=0.15
X4077 a_22306_18464# a_22012_18376# ua[4] uio_oe[0] sky130_fd_pr__nfet_01v8 ad=0.1885 pd=1.88 as=0.1885 ps=1.88 w=0.65 l=0.15
X4078 a_60374_35229# a_60092_34863# a_60298_35229# uio_oe[0] sky130_fd_pr__nfet_01v8 ad=0.0441 pd=0.63 as=0.0483 ps=0.65 w=0.42 l=0.15
X4079 a_50722_34863# a_50003_35105# a_50159_34837# uio_oe[0] sky130_fd_pr__special_nfet_01v8 ad=0.066 pd=0.745 as=0.0594 ps=0.69 w=0.36 l=0.15
X4080 a_38019_34863# a_37839_34863# VDPWR VDPWR sky130_fd_pr__pfet_01v8_hvt ad=0.0609 pd=0.71 as=0.0714 ps=0.76 w=0.42 l=0.15
X4081 a_53827_35773# a_53203_35407# a_53719_35407# VDPWR sky130_fd_pr__pfet_01v8_hvt ad=0.1155 pd=0.97 as=0.07245 ps=0.765 w=0.42 l=0.15
X4082 a_41224_41659# a_45351_42783# uio_oe[0] uio_oe[0] sky130_fd_pr__nfet_01v8 ad=0.169 pd=1.82 as=0.2087 ps=2.02 w=0.65 l=0.15
X4083 a_39907_40669# a_38089_40623# a_39544_40535# uio_oe[0] sky130_fd_pr__nfet_01v8 ad=0.0693 pd=0.75 as=0.09975 ps=0.895 w=0.42 l=0.15
X4084 uio_oe[0] a_39947_42997# a_46805_40669# uio_oe[0] sky130_fd_pr__nfet_01v8 ad=0.1346 pd=1.15 as=0.0441 ps=0.63 w=0.42 l=0.15
X4085 VDPWR a_46193_39759# a_60720_37405# VDPWR sky130_fd_pr__pfet_01v8_hvt ad=0.0798 pd=0.8 as=0.0567 ps=0.69 w=0.42 l=0.15
X4086 a_57472_37317# a_41685_42479# VDPWR VDPWR sky130_fd_pr__pfet_01v8_hvt ad=0.1664 pd=1.8 as=0.0864 ps=0.91 w=0.64 l=0.15
X4087 VDPWR a_38005_41391# a_46027_43023# VDPWR sky130_fd_pr__pfet_01v8_hvt ad=0.0864 pd=0.91 as=0.1664 ps=1.8 w=0.64 l=0.15
X4088 a_48125_43023# a_47959_43023# uio_oe[0] uio_oe[0] sky130_fd_pr__nfet_01v8 ad=0.08775 pd=0.92 as=0.08775 ps=0.92 w=0.65 l=0.15
X4089 uio_oe[0] a_54459_37557# a_54393_37583# uio_oe[0] sky130_fd_pr__nfet_01v8 ad=0.12495 pd=1.015 as=0.0669 ps=0.75 w=0.42 l=0.15
X4090 a_50003_36193# a_41685_42479# VDPWR VDPWR sky130_fd_pr__pfet_01v8_hvt ad=0.1664 pd=1.8 as=0.0864 ps=0.91 w=0.64 l=0.15
X4091 uio_oe[0] a_37029_42479# a_46027_41935# uio_oe[0] sky130_fd_pr__nfet_01v8 ad=0.0567 pd=0.69 as=0.1092 ps=1.36 w=0.42 l=0.15
X4092 uio_oe[0] a_56843_41909# a_38740_41909# uio_oe[0] sky130_fd_pr__nfet_01v8 ad=0.2087 pd=2.02 as=0.169 ps=1.82 w=0.65 l=0.15
X4093 a_43081_40001# a_42863_39759# VDPWR VDPWR sky130_fd_pr__pfet_01v8_hvt ad=0.12915 pd=1.185 as=0.2184 ps=2.2 w=0.84 l=0.15
X4094 a_22306_18464# a_4259_22596# a_22010_16730# uio_oe[0] sky130_fd_pr__nfet_01v8 ad=0.2436 pd=2.26 as=0.2436 ps=2.26 w=0.84 l=0.6
X4095 a_49686_35659# a_50003_35549# a_49961_35407# uio_oe[0] sky130_fd_pr__special_nfet_01v8 ad=0.0711 pd=0.755 as=0.0669 ps=0.75 w=0.36 l=0.15
X4096 a_20914_26464# a_20620_10376# ua[5] uio_oe[0] sky130_fd_pr__nfet_01v8 ad=0.1885 pd=1.88 as=0.1885 ps=1.88 w=0.65 l=0.15
X4097 a_39544_40535# a_38089_40623# a_39686_40342# VDPWR sky130_fd_pr__pfet_01v8_hvt ad=0.1932 pd=1.34 as=0.07665 ps=0.785 w=0.42 l=0.15
X4098 VDPWR a_48125_43023# a_49483_38645# VDPWR sky130_fd_pr__pfet_01v8_hvt ad=0.0819 pd=0.81 as=0.0567 ps=0.69 w=0.42 l=0.15
X4099 a_38080_37405# a_37452_34953# a_37859_37078# uio_oe[0] sky130_fd_pr__nfet_01v8 ad=0.0693 pd=0.75 as=0.09975 ps=0.895 w=0.42 l=0.15
X4100 a_40931_36495# a_40581_36495# a_40836_36495# VDPWR sky130_fd_pr__pfet_01v8_hvt ad=0.07245 pd=0.765 as=0.0651 ps=0.73 w=0.42 l=0.15
X4101 a_41016_41623# a_37795_40535# a_41158_41430# VDPWR sky130_fd_pr__pfet_01v8_hvt ad=0.1932 pd=1.34 as=0.07665 ps=0.785 w=0.42 l=0.15
X4102 a_52942_37039# a_52816_37155# a_52538_37171# uio_oe[0] sky130_fd_pr__special_nfet_01v8 ad=0.0999 pd=0.985 as=0.0711 ps=0.755 w=0.36 l=0.15
X4103 uio_oe[0] a_29804_33417# a_28908_33703# uio_oe[0] sky130_fd_pr__nfet_01v8 ad=0.11285 pd=1.045 as=0.169 ps=1.82 w=0.65 l=0.15
X4104 a_42787_43389# a_42163_43023# a_42679_43023# VDPWR sky130_fd_pr__pfet_01v8_hvt ad=0.1155 pd=0.97 as=0.07245 ps=0.765 w=0.42 l=0.15
X4105 uio_oe[0] a_46193_39759# a_52573_36317# uio_oe[0] sky130_fd_pr__nfet_01v8 ad=0.12495 pd=1.015 as=0.06405 ps=0.725 w=0.42 l=0.15
X4106 a_25479_34312# a_17500_33453# a_25020_34505# VDPWR sky130_fd_pr__pfet_01v8_hvt ad=0.0441 pd=0.63 as=0.1932 ps=1.34 w=0.42 l=0.15
X4107 a_51775_40669# a_38740_40571# a_51412_40535# uio_oe[0] sky130_fd_pr__nfet_01v8 ad=0.0693 pd=0.75 as=0.09975 ps=0.895 w=0.42 l=0.15
X4108 uio_oe[0] a_39555_35559# a_28796_36057# uio_oe[0] sky130_fd_pr__nfet_01v8 ad=0.1118 pd=1.04 as=0.182 ps=1.86 w=0.65 l=0.15
X4109 uio_oe[0] a_61242_37269# a_61192_37039# uio_oe[0] sky130_fd_pr__nfet_01v8 ad=0.1664 pd=1.8 as=0.0935 ps=0.965 w=0.64 l=0.15
X4110 a_53011_39189# a_52855_39457# a_53156_39215# VDPWR sky130_fd_pr__pfet_01v8_hvt ad=0.07245 pd=0.765 as=0.1155 ps=0.97 w=0.42 l=0.15
X4111 uio_oe[0] a_61624_36183# a_60996_35925# uio_oe[0] sky130_fd_pr__nfet_01v8 ad=0.11285 pd=1.045 as=0.169 ps=1.82 w=0.65 l=0.15
X4112 a_60516_35951# a_60302_35951# VDPWR VDPWR sky130_fd_pr__pfet_01v8_hvt ad=0.1155 pd=0.97 as=0.07035 ps=0.755 w=0.42 l=0.15
X4113 a_59201_39733# a_48677_39759# uio_oe[0] uio_oe[0] sky130_fd_pr__nfet_01v8 ad=0.1092 pd=1.36 as=0.1449 ps=1.11 w=0.42 l=0.15
X4114 a_58914_38166# a_48677_38127# VDPWR VDPWR sky130_fd_pr__pfet_01v8_hvt ad=0.07665 pd=0.785 as=0.15835 ps=1.395 w=0.42 l=0.15
X4115 uio_oe[0] a_24836_37145# a_24787_36993# uio_oe[0] sky130_fd_pr__nfet_01v8 ad=0.11285 pd=1.045 as=0.169 ps=1.82 w=0.65 l=0.15
X4116 a_50722_37039# a_49964_37155# a_50159_37013# VDPWR sky130_fd_pr__pfet_01v8_hvt ad=0.0651 pd=0.73 as=0.07245 ps=0.765 w=0.42 l=0.15
X4117 uio_oe[0] a_21156_33417# a_21107_33185# uio_oe[0] sky130_fd_pr__nfet_01v8 ad=0.11285 pd=1.045 as=0.169 ps=1.82 w=0.65 l=0.15
X4118 VDPWR a_28884_34505# a_28835_34273# VDPWR sky130_fd_pr__pfet_01v8_hvt ad=0.15835 pd=1.395 as=0.26 ps=2.52 w=1 l=0.15
X4119 VDPWR a_38771_34879# a_38543_35095# VDPWR sky130_fd_pr__pfet_01v8_hvt ad=0.1176 pd=1.4 as=0.0567 ps=0.69 w=0.42 l=0.15
X4120 a_51412_40535# a_38740_40571# a_51554_40342# VDPWR sky130_fd_pr__pfet_01v8_hvt ad=0.1932 pd=1.34 as=0.07665 ps=0.785 w=0.42 l=0.15
X4121 a_53937_36737# a_53719_36495# VDPWR VDPWR sky130_fd_pr__pfet_01v8_hvt ad=0.12915 pd=1.185 as=0.2184 ps=2.2 w=0.84 l=0.15
X4122 uio_oe[0] a_29281_32641# a_30393_34817# uio_oe[0] sky130_fd_pr__nfet_01v8 ad=0.1013 pd=0.99 as=0.0504 ps=0.66 w=0.42 l=0.15
X4123 uio_oe[0] a_54264_42711# a_53636_42453# uio_oe[0] sky130_fd_pr__nfet_01v8 ad=0.11285 pd=1.045 as=0.169 ps=1.82 w=0.65 l=0.15
X4124 a_42673_34347# a_36447_40849# uio_oe[0] uio_oe[0] sky130_fd_pr__nfet_01v8 ad=0.0567 pd=0.69 as=0.1118 ps=1.04 w=0.42 l=0.15
X4125 a_52335_40277# a_52538_40435# VDPWR VDPWR sky130_fd_pr__pfet_01v8_hvt ad=0.0567 pd=0.69 as=0.1134 ps=1.38 w=0.42 l=0.15
X4126 a_52507_40086# a_52325_40086# VDPWR VDPWR sky130_fd_pr__pfet_01v8_hvt ad=0.0441 pd=0.63 as=0.0693 ps=0.75 w=0.42 l=0.15
X4127 uio_oe[0] a_37661_38140# a_42864_37405# uio_oe[0] sky130_fd_pr__nfet_01v8 ad=0.11285 pd=1.045 as=0.0693 ps=0.75 w=0.42 l=0.15
X4128 a_43876_36067# a_42445_36469# VDPWR VDPWR sky130_fd_pr__pfet_01v8_hvt ad=0.0441 pd=0.63 as=0.14575 ps=1.335 w=0.42 l=0.15
X4129 VDPWR a_37361_41391# a_60153_34646# VDPWR sky130_fd_pr__pfet_01v8_hvt ad=0.15835 pd=1.395 as=0.07665 ps=0.785 w=0.42 l=0.15
X4130 a_43419_41909# a_43244_41935# a_43598_41935# uio_oe[0] sky130_fd_pr__nfet_01v8 ad=0.1092 pd=1.36 as=0.06405 ps=0.725 w=0.42 l=0.15
X4131 VDPWR a_37361_41391# a_59685_37910# VDPWR sky130_fd_pr__pfet_01v8_hvt ad=0.0693 pd=0.75 as=0.1176 ps=1.4 w=0.42 l=0.15
X4132 uio_oe[0] a_28700_36057# a_28651_35905# uio_oe[0] sky130_fd_pr__nfet_01v8 ad=0.11285 pd=1.045 as=0.169 ps=1.82 w=0.65 l=0.15
X4133 a_43157_36271# a_42685_36611# uio_oe[0] uio_oe[0] sky130_fd_pr__nfet_01v8 ad=0.08775 pd=0.92 as=0.08775 ps=0.92 w=0.65 l=0.15
X4134 a_57363_34461# a_41685_42479# VDPWR VDPWR sky130_fd_pr__pfet_01v8_hvt ad=0.1664 pd=1.8 as=0.0864 ps=0.91 w=0.64 l=0.15
X4135 uio_oe[0] a_42045_34319# a_43437_35095# uio_oe[0] sky130_fd_pr__nfet_01v8 ad=0.1092 pd=1.36 as=0.0567 ps=0.69 w=0.42 l=0.15
X4136 a_44516_41757# a_44399_41562# VDPWR VDPWR sky130_fd_pr__pfet_01v8_hvt ad=0.0651 pd=0.73 as=0.1092 ps=1.36 w=0.42 l=0.15
X4137 a_57046_41099# a_57363_40989# a_57321_40847# uio_oe[0] sky130_fd_pr__special_nfet_01v8 ad=0.0711 pd=0.755 as=0.0669 ps=0.75 w=0.36 l=0.15
X4138 a_28396_14020# a_4259_22596# a_28218_14020# uio_oe[0] sky130_fd_pr__nfet_01v8 ad=0.2436 pd=2.26 as=0.2436 ps=2.26 w=0.84 l=0.6
X4139 a_16756_14376# a_18011_35933# VDPWR VDPWR sky130_fd_pr__pfet_01v8_hvt ad=0.475 pd=2.95 as=0.16655 ps=1.39 w=1 l=0.15
X4140 VDPWR a_18427_33198# a_17507_33198# VDPWR sky130_fd_pr__pfet_01v8_hvt ad=0.26 pd=2.52 as=0.26 ps=2.52 w=1 l=0.15
X4141 a_41074_40125# a_40987_39901# a_40670_40011# VDPWR sky130_fd_pr__pfet_01v8_hvt ad=0.12915 pd=1.185 as=0.0588 ps=0.7 w=0.42 l=0.15
X4142 a_45719_39447# a_44327_38359# a_45893_39553# uio_oe[0] sky130_fd_pr__nfet_01v8 ad=0.1176 pd=1.4 as=0.0567 ps=0.69 w=0.42 l=0.15
X4143 VDPWR a_49483_38101# a_38740_38395# VDPWR sky130_fd_pr__pfet_01v8_hvt ad=0.3012 pd=2.66 as=0.26 ps=2.52 w=1 l=0.15
X4144 a_26439_36271# a_26259_36271# VDPWR VDPWR sky130_fd_pr__pfet_01v8_hvt ad=0.0609 pd=0.71 as=0.0714 ps=0.76 w=0.42 l=0.15
X4145 VDPWR a_17292_35593# a_17243_35361# VDPWR sky130_fd_pr__pfet_01v8_hvt ad=0.15835 pd=1.395 as=0.26 ps=2.52 w=1 l=0.15
X4146 uio_oe[0] a_47959_41935# a_48125_41935# uio_oe[0] sky130_fd_pr__nfet_01v8 ad=0.169 pd=1.82 as=0.08775 ps=0.92 w=0.65 l=0.15
X4147 VDPWR a_59293_41689# a_59323_41430# VDPWR sky130_fd_pr__pfet_01v8_hvt ad=0.0693 pd=0.75 as=0.0441 ps=0.63 w=0.42 l=0.15
X4148 a_61341_38671# a_61297_38913# a_61175_38671# uio_oe[0] sky130_fd_pr__nfet_01v8 ad=0.0441 pd=0.63 as=0.1401 ps=1.1 w=0.42 l=0.15
X4149 VDPWR a_53011_38101# a_52942_38127# VDPWR sky130_fd_pr__pfet_01v8_hvt ad=0.2184 pd=2.2 as=0.12915 ps=1.185 w=0.84 l=0.15
X4150 uio_oe[0] a_37361_41391# a_60160_34319# uio_oe[0] sky130_fd_pr__nfet_01v8 ad=0.11285 pd=1.045 as=0.0693 ps=0.75 w=0.42 l=0.15
X4151 a_49721_40847# a_49686_41099# a_49483_40821# uio_oe[0] sky130_fd_pr__nfet_01v8 ad=0.06405 pd=0.725 as=0.1092 ps=1.36 w=0.42 l=0.15
X4152 a_61175_37583# a_60729_37583# a_61079_37583# uio_oe[0] sky130_fd_pr__special_nfet_01v8 ad=0.1401 pd=1.1 as=0.0594 ps=0.69 w=0.36 l=0.15
X4153 a_42321_35183# a_41987_34863# a_42237_34863# VDPWR sky130_fd_pr__pfet_01v8_hvt ad=0.3 pd=2.6 as=0.26 ps=2.52 w=1 l=0.15
X4154 VDPWR a_50159_42172# a_50090_42301# VDPWR sky130_fd_pr__pfet_01v8_hvt ad=0.2184 pd=2.2 as=0.12915 ps=1.185 w=0.84 l=0.15
X4155 VDPWR a_37029_42479# a_44095_40847# VDPWR sky130_fd_pr__pfet_01v8_hvt ad=0.0864 pd=0.91 as=0.1664 ps=1.8 w=0.64 l=0.15
X4156 uio_oe[0] a_50784_40008# a_50722_40125# uio_oe[0] sky130_fd_pr__nfet_01v8 ad=0.2205 pd=1.89 as=0.066 ps=0.745 w=0.42 l=0.15
X4157 a_37029_38127# a_36999_38101# uio_oe[0] uio_oe[0] sky130_fd_pr__nfet_01v8 ad=0.08775 pd=0.92 as=0.08775 ps=0.92 w=0.65 l=0.15
X4158 a_30034_10464# a_28348_10376# ua[4] uio_oe[0] sky130_fd_pr__nfet_01v8 ad=0.1885 pd=1.88 as=0.1885 ps=1.88 w=0.65 l=0.15
X4159 a_60729_34319# a_60563_34319# VDPWR VDPWR sky130_fd_pr__pfet_01v8_hvt ad=0.1664 pd=1.8 as=0.0864 ps=0.91 w=0.64 l=0.15
X4160 a_39213_35407# a_37795_40535# uio_oe[0] uio_oe[0] sky130_fd_pr__nfet_01v8 ad=0.08775 pd=0.92 as=0.169 ps=1.82 w=0.65 l=0.15
X4161 a_60988_35229# a_60720_35229# uio_oe[0] uio_oe[0] sky130_fd_pr__nfet_01v8 ad=0.06705 pd=0.75 as=0.0882 ps=0.84 w=0.42 l=0.15
X4162 a_43600_34979# a_37169_38671# VDPWR VDPWR sky130_fd_pr__pfet_01v8_hvt ad=0.0441 pd=0.63 as=0.14575 ps=1.335 w=0.42 l=0.15
X4163 a_30393_34817# a_30123_35183# a_30303_35183# uio_oe[0] sky130_fd_pr__nfet_01v8 ad=0.0504 pd=0.66 as=0.1092 ps=1.36 w=0.42 l=0.15
X4164 a_29159_35144# a_28908_34791# a_28700_34969# VDPWR sky130_fd_pr__pfet_01v8_hvt ad=0.0441 pd=0.63 as=0.1932 ps=1.34 w=0.42 l=0.15
X4165 a_46651_41213# a_39947_42997# VDPWR VDPWR sky130_fd_pr__pfet_01v8_hvt ad=0.1092 pd=1.36 as=0.07035 ps=0.755 w=0.42 l=0.15
X4166 a_47462_43023# a_40379_35551# uio_oe[0] uio_oe[0] sky130_fd_pr__nfet_01v8 ad=0.06405 pd=0.725 as=0.12495 ps=1.015 w=0.42 l=0.15
X4167 uio_oe[0] a_40469_41909# a_40304_34293# uio_oe[0] sky130_fd_pr__nfet_01v8 ad=0.10187 pd=0.99 as=0.1755 ps=1.84 w=0.65 l=0.15
X4168 VDPWR a_37029_42479# a_46027_41935# VDPWR sky130_fd_pr__pfet_01v8_hvt ad=0.0864 pd=0.91 as=0.1664 ps=1.8 w=0.64 l=0.15
X4169 a_60160_39759# a_58980_39733# a_59939_40086# uio_oe[0] sky130_fd_pr__nfet_01v8 ad=0.0693 pd=0.75 as=0.09975 ps=0.895 w=0.42 l=0.15
X4170 a_59293_39513# a_48677_39759# VDPWR VDPWR sky130_fd_pr__pfet_01v8_hvt ad=0.1176 pd=1.4 as=0.0693 ps=0.75 w=0.42 l=0.15
X4171 VDPWR a_40619_36193# a_40580_36067# VDPWR sky130_fd_pr__pfet_01v8_hvt ad=0.0864 pd=0.91 as=0.1664 ps=1.8 w=0.64 l=0.15
X4172 a_54723_35990# a_51620_36219# a_54264_36183# VDPWR sky130_fd_pr__pfet_01v8_hvt ad=0.0441 pd=0.63 as=0.1932 ps=1.34 w=0.42 l=0.15
X4173 a_30034_10464# ua[0] a_29788_10020# uio_oe[0] sky130_fd_pr__nfet_01v8 ad=0.2436 pd=2.26 as=0.2436 ps=2.26 w=0.84 l=0.6
X4174 uio_oe[0] a_59201_42777# a_59135_42845# uio_oe[0] sky130_fd_pr__nfet_01v8 ad=0.1449 pd=1.11 as=0.0693 ps=0.75 w=0.42 l=0.15
X4175 a_42584_41935# ui_in[2] VDPWR VDPWR sky130_fd_pr__pfet_01v8_hvt ad=0.0651 pd=0.73 as=0.1092 ps=1.36 w=0.42 l=0.15
X4176 a_18711_37359# a_18531_37359# VDPWR VDPWR sky130_fd_pr__pfet_01v8_hvt ad=0.0609 pd=0.71 as=0.0714 ps=0.76 w=0.42 l=0.15
X4177 a_26369_35659# a_25116_35593# VDPWR VDPWR sky130_fd_pr__pfet_01v8_hvt ad=0.1176 pd=1.4 as=0.0693 ps=0.75 w=0.42 l=0.15
X4178 ua[4] a_28348_18782# a_28218_18020# uio_oe[0] sky130_fd_pr__nfet_01v8 ad=0.1885 pd=1.88 as=0.1885 ps=1.88 w=0.65 l=0.15
X4179 a_57012_37013# a_44905_38671# VDPWR VDPWR sky130_fd_pr__pfet_01v8_hvt ad=0.1092 pd=1.36 as=0.12285 ps=1.17 w=0.42 l=0.15
X4180 a_42584_40669# a_42467_40474# uio_oe[0] uio_oe[0] sky130_fd_pr__nfet_01v8 ad=0.066 pd=0.745 as=0.2205 ps=1.89 w=0.42 l=0.15
X4181 a_41496_36495# a_40415_36495# a_41149_36737# VDPWR sky130_fd_pr__pfet_01v8_hvt ad=0.0588 pd=0.7 as=0.12915 ps=1.185 w=0.42 l=0.15
X4182 VDPWR a_17689_32641# a_18711_37359# VDPWR sky130_fd_pr__pfet_01v8_hvt ad=0.2279 pd=1.74 as=0.0609 ps=0.71 w=0.42 l=0.15
X4183 a_17050_14464# a_16756_14376# ua[4] uio_oe[0] sky130_fd_pr__nfet_01v8 ad=0.1885 pd=1.88 as=0.1885 ps=1.88 w=0.65 l=0.15
X4184 a_46761_42453# a_46543_42857# uio_oe[0] uio_oe[0] sky130_fd_pr__nfet_01v8 ad=0.0999 pd=0.985 as=0.1346 ps=1.15 w=0.64 l=0.15
X4185 a_52942_40303# a_52855_40545# a_52538_40435# VDPWR sky130_fd_pr__pfet_01v8_hvt ad=0.12915 pd=1.185 as=0.0588 ps=0.7 w=0.42 l=0.15
X4186 a_58772_38359# a_39752_38395# a_58914_38166# VDPWR sky130_fd_pr__pfet_01v8_hvt ad=0.1932 pd=1.34 as=0.07665 ps=0.785 w=0.42 l=0.15
X4187 a_49920_37039# a_49483_37013# VDPWR VDPWR sky130_fd_pr__pfet_01v8_hvt ad=0.0567 pd=0.69 as=0.0819 ps=0.81 w=0.42 l=0.15
X4188 a_53005_36495# a_52579_36822# uio_oe[0] uio_oe[0] sky130_fd_pr__nfet_01v8 ad=0.169 pd=1.82 as=0.11285 ps=1.045 w=0.65 l=0.15
X4189 uio_oe[0] a_50003_35549# a_49964_35675# uio_oe[0] sky130_fd_pr__nfet_01v8 ad=0.0567 pd=0.69 as=0.1092 ps=1.36 w=0.42 l=0.15
X4190 a_42679_40847# a_42163_40847# a_42584_40847# uio_oe[0] sky130_fd_pr__special_nfet_01v8 ad=0.0594 pd=0.69 as=0.066 ps=0.745 w=0.36 l=0.15
X4191 a_21553_32641# a_21287_33007# VDPWR VDPWR sky130_fd_pr__pfet_01v8_hvt ad=0.26 pd=2.52 as=0.2279 ps=1.74 w=1 l=0.15
X4192 a_50469_37405# a_50090_37039# a_50397_37405# uio_oe[0] sky130_fd_pr__nfet_01v8 ad=0.1401 pd=1.1 as=0.0441 ps=0.63 w=0.42 l=0.15
X4193 VDPWR a_44905_38671# a_50304_35951# VDPWR sky130_fd_pr__pfet_01v8_hvt ad=0.07035 pd=0.755 as=0.1092 ps=1.36 w=0.42 l=0.15
X4194 a_49961_34319# a_49483_34293# uio_oe[0] uio_oe[0] sky130_fd_pr__nfet_01v8 ad=0.0669 pd=0.75 as=0.12495 ps=1.015 w=0.42 l=0.15
X4195 a_44516_41757# a_44399_41562# uio_oe[0] uio_oe[0] sky130_fd_pr__nfet_01v8 ad=0.066 pd=0.745 as=0.2205 ps=1.89 w=0.42 l=0.15
X4196 a_39544_36647# a_39752_36469# a_39686_36495# uio_oe[0] sky130_fd_pr__nfet_01v8 ad=0.09975 pd=0.895 as=0.0693 ps=0.75 w=0.42 l=0.15
X4197 a_30034_22464# a_28348_10376# ua[5] uio_oe[0] sky130_fd_pr__nfet_01v8 ad=0.1885 pd=1.88 as=0.1885 ps=1.88 w=0.65 l=0.15
X4198 VDPWR a_50159_34837# a_50090_34863# VDPWR sky130_fd_pr__pfet_01v8_hvt ad=0.2184 pd=2.2 as=0.12915 ps=1.185 w=0.84 l=0.15
X4199 a_59939_41935# a_59685_42262# uio_oe[0] uio_oe[0] sky130_fd_pr__nfet_01v8 ad=0.0693 pd=0.75 as=0.1449 ps=1.11 w=0.42 l=0.15
X4200 a_46651_41213# a_46027_40847# a_46543_40847# VDPWR sky130_fd_pr__pfet_01v8_hvt ad=0.1155 pd=0.97 as=0.07245 ps=0.765 w=0.42 l=0.15
X4201 a_57046_38259# a_57363_38369# a_57321_38493# uio_oe[0] sky130_fd_pr__special_nfet_01v8 ad=0.0711 pd=0.755 as=0.0669 ps=0.75 w=0.36 l=0.15
X4202 a_43525_37039# a_41141_40316# VDPWR VDPWR sky130_fd_pr__pfet_01v8_hvt ad=0.135 pd=1.27 as=0.135 ps=1.27 w=1 l=0.15
X4203 a_52579_36822# a_51620_37307# a_52579_36495# uio_oe[0] sky130_fd_pr__nfet_01v8 ad=0.09975 pd=0.895 as=0.0693 ps=0.75 w=0.42 l=0.15
X4204 uio_oe[0] a_36919_35951# a_37085_35951# uio_oe[0] sky130_fd_pr__nfet_01v8 ad=0.169 pd=1.82 as=0.08775 ps=0.92 w=0.65 l=0.15
X4205 a_22439_34639# a_18427_33198# a_22076_34505# uio_oe[0] sky130_fd_pr__nfet_01v8 ad=0.0693 pd=0.75 as=0.09975 ps=0.895 w=0.42 l=0.15
X4206 a_56916_35095# a_57012_34837# VDPWR VDPWR sky130_fd_pr__pfet_01v8_hvt ad=0.1664 pd=1.8 as=0.149 ps=1.325 w=0.64 l=0.15
X4207 a_59201_38645# a_48677_39759# uio_oe[0] uio_oe[0] sky130_fd_pr__nfet_01v8 ad=0.1092 pd=1.36 as=0.1449 ps=1.11 w=0.42 l=0.15
X4208 uio_oe[0] a_25940_36681# a_25044_36967# uio_oe[0] sky130_fd_pr__nfet_01v8 ad=0.11285 pd=1.045 as=0.169 ps=1.82 w=0.65 l=0.15
X4209 a_28842_36232# a_28796_36057# VDPWR VDPWR sky130_fd_pr__pfet_01v8_hvt ad=0.07665 pd=0.785 as=0.15835 ps=1.395 w=0.42 l=0.15
X4210 a_17050_14464# ua[3] a_16804_14020# uio_oe[0] sky130_fd_pr__nfet_01v8 ad=0.2436 pd=2.26 as=0.2436 ps=2.26 w=0.84 l=0.6
X4211 a_58248_34863# a_57556_34837# a_57640_35177# VDPWR sky130_fd_pr__pfet_01v8_hvt ad=0.12495 pd=1.175 as=0.0567 ps=0.69 w=0.42 l=0.15
X4212 a_61806_42301# a_60729_41935# a_61644_41935# VDPWR sky130_fd_pr__pfet_01v8_hvt ad=0.0567 pd=0.69 as=0.0588 ps=0.7 w=0.42 l=0.15
X4213 uio_oe[0] a_49483_39733# a_39752_39733# uio_oe[0] sky130_fd_pr__nfet_01v8 ad=0.2087 pd=2.02 as=0.169 ps=1.82 w=0.65 l=0.15
X4214 uio_oe[0] a_52855_37281# a_52816_37155# uio_oe[0] sky130_fd_pr__nfet_01v8 ad=0.0567 pd=0.69 as=0.1092 ps=1.36 w=0.42 l=0.15
X4215 a_25739_35933# a_24787_35905# VDPWR VDPWR sky130_fd_pr__pfet_01v8_hvt ad=0.0567 pd=0.69 as=0.1176 ps=1.4 w=0.42 l=0.15
X4216 a_24778_22464# a_24484_14782# ua[4] uio_oe[0] sky130_fd_pr__nfet_01v8 ad=0.1885 pd=1.88 as=0.1885 ps=1.88 w=0.65 l=0.15
X4217 a_47108_40847# a_46193_40847# a_46761_41089# uio_oe[0] sky130_fd_pr__special_nfet_01v8 ad=0.0711 pd=0.755 as=0.0999 ps=0.985 w=0.36 l=0.15
X4218 a_60988_41391# a_60720_41757# VDPWR VDPWR sky130_fd_pr__pfet_01v8_hvt ad=0.0945 pd=0.87 as=0.0798 ps=0.8 w=0.42 l=0.15
X4219 uio_oe[0] a_60584_41705# a_60542_41757# uio_oe[0] sky130_fd_pr__nfet_01v8 ad=0.1092 pd=1.36 as=0.0441 ps=0.63 w=0.42 l=0.15
X4220 uio_oe[0] a_37183_40277# a_36607_39455# uio_oe[0] sky130_fd_pr__nfet_01v8 ad=0.08775 pd=0.92 as=0.08775 ps=0.92 w=0.65 l=0.15
X4221 uio_oe[0] a_44621_39535# a_46289_39447# uio_oe[0] sky130_fd_pr__nfet_01v8 ad=0.1092 pd=1.36 as=0.0567 ps=0.69 w=0.42 l=0.15
X4222 uio_oe[0] a_43075_38101# a_43006_38127# uio_oe[0] sky130_fd_pr__nfet_01v8 ad=0.1346 pd=1.15 as=0.0999 ps=0.985 w=0.64 l=0.15
X4223 VDPWR a_60996_38101# a_60934_38127# VDPWR sky130_fd_pr__pfet_01v8_hvt ad=0.1092 pd=1.36 as=0.0651 ps=0.73 w=0.42 l=0.15
X4224 a_44513_37611# a_36447_40849# uio_oe[0] uio_oe[0] sky130_fd_pr__nfet_01v8 ad=0.0567 pd=0.69 as=0.1118 ps=1.04 w=0.42 l=0.15
X4225 a_50003_37725# a_41685_42479# uio_oe[0] uio_oe[0] sky130_fd_pr__nfet_01v8 ad=0.1092 pd=1.36 as=0.0567 ps=0.69 w=0.42 l=0.15
X4226 a_60302_35951# a_60215_36193# a_59898_36083# VDPWR sky130_fd_pr__pfet_01v8_hvt ad=0.12915 pd=1.185 as=0.0588 ps=0.7 w=0.42 l=0.15
X4227 a_17050_26464# a_16756_10376# ua[5] uio_oe[0] sky130_fd_pr__nfet_01v8 ad=0.1885 pd=1.88 as=0.1885 ps=1.88 w=0.65 l=0.15
X4228 a_37313_39581# a_36934_39215# a_37241_39581# uio_oe[0] sky130_fd_pr__nfet_01v8 ad=0.1401 pd=1.1 as=0.0441 ps=0.63 w=0.42 l=0.15
X4229 a_17250_37320# a_17204_37145# VDPWR VDPWR sky130_fd_pr__pfet_01v8_hvt ad=0.07665 pd=0.785 as=0.15835 ps=1.395 w=0.42 l=0.15
X4230 a_25825_37021# a_24787_36993# a_25739_37021# uio_oe[0] sky130_fd_pr__nfet_01v8 ad=0.0567 pd=0.69 as=0.1176 ps=1.4 w=0.42 l=0.15
X4231 a_51412_36647# a_51620_36469# a_51554_36495# uio_oe[0] sky130_fd_pr__nfet_01v8 ad=0.09975 pd=0.895 as=0.0693 ps=0.75 w=0.42 l=0.15
X4232 a_24778_22464# a_4259_22596# a_24482_20730# uio_oe[0] sky130_fd_pr__nfet_01v8 ad=0.2436 pd=2.26 as=0.2436 ps=2.26 w=0.84 l=0.6
X4233 VDPWR a_50159_35644# a_50090_35773# VDPWR sky130_fd_pr__pfet_01v8_hvt ad=0.2184 pd=2.2 as=0.12915 ps=1.185 w=0.84 l=0.15
X4234 a_37029_42479# a_36999_42453# VDPWR VDPWR sky130_fd_pr__pfet_01v8_hvt ad=0.135 pd=1.27 as=0.135 ps=1.27 w=1 l=0.15
X4235 VDPWR a_42028_36183# a_41400_35656# VDPWR sky130_fd_pr__pfet_01v8_hvt ad=0.15835 pd=1.395 as=0.26 ps=2.52 w=1 l=0.15
X4236 a_57829_42845# a_57450_42479# a_57757_42845# uio_oe[0] sky130_fd_pr__nfet_01v8 ad=0.1401 pd=1.1 as=0.0441 ps=0.63 w=0.42 l=0.15
X4237 VDPWR a_37029_37583# a_38543_34471# VDPWR sky130_fd_pr__pfet_01v8_hvt ad=0.1176 pd=1.4 as=0.0567 ps=0.69 w=0.42 l=0.15
X4238 a_38005_41391# a_37839_41391# uio_oe[0] uio_oe[0] sky130_fd_pr__nfet_01v8 ad=0.08775 pd=0.92 as=0.08775 ps=0.92 w=0.65 l=0.15
X4239 a_59867_42262# a_59685_42262# VDPWR VDPWR sky130_fd_pr__pfet_01v8_hvt ad=0.0441 pd=0.63 as=0.0693 ps=0.75 w=0.42 l=0.15
X4240 uio_oe[0] a_50784_38920# a_50722_39037# uio_oe[0] sky130_fd_pr__nfet_01v8 ad=0.2205 pd=1.89 as=0.066 ps=0.745 w=0.42 l=0.15
X4241 VDPWR a_41496_36495# a_41671_36469# VDPWR sky130_fd_pr__pfet_01v8_hvt ad=0.1134 pd=1.38 as=0.0567 ps=0.69 w=0.42 l=0.15
X4242 a_37085_35951# a_36919_35951# VDPWR VDPWR sky130_fd_pr__pfet_01v8_hvt ad=0.135 pd=1.27 as=0.135 ps=1.27 w=1 l=0.15
X4243 uio_oe[0] a_48125_43023# a_49721_39581# uio_oe[0] sky130_fd_pr__nfet_01v8 ad=0.12495 pd=1.015 as=0.06405 ps=0.725 w=0.42 l=0.15
X4244 a_38674_38493# a_37029_37583# uio_oe[0] uio_oe[0] sky130_fd_pr__nfet_01v8 ad=0.0693 pd=0.75 as=0.11285 ps=1.045 w=0.42 l=0.15
X4245 uio_oe[0] a_45431_39733# a_48511_38127# uio_oe[0] sky130_fd_pr__nfet_01v8 ad=0.08775 pd=0.92 as=0.169 ps=1.82 w=0.65 l=0.15
X4246 a_41149_36737# a_40931_36495# uio_oe[0] uio_oe[0] sky130_fd_pr__nfet_01v8 ad=0.0999 pd=0.985 as=0.1346 ps=1.15 w=0.64 l=0.15
X4247 a_41425_41097# a_37795_40535# a_41343_41097# VDPWR sky130_fd_pr__pfet_01v8_hvt ad=0.135 pd=1.27 as=0.26 ps=2.52 w=1 l=0.15
X4248 a_57081_42845# a_57046_42611# a_56843_42453# uio_oe[0] sky130_fd_pr__nfet_01v8 ad=0.06405 pd=0.725 as=0.1092 ps=1.36 w=0.42 l=0.15
X4249 VDPWR a_37029_42479# a_46027_40309# VDPWR sky130_fd_pr__pfet_01v8_hvt ad=0.0864 pd=0.91 as=0.1664 ps=1.8 w=0.64 l=0.15
X4250 a_40003_38166# a_39752_38395# a_39544_38359# VDPWR sky130_fd_pr__pfet_01v8_hvt ad=0.0441 pd=0.63 as=0.1932 ps=1.34 w=0.42 l=0.15
X4251 VDPWR a_29281_32641# a_29603_37021# VDPWR sky130_fd_pr__pfet_01v8_hvt ad=0.16655 pd=1.39 as=0.0567 ps=0.69 w=0.42 l=0.15
X4252 uio_oe[0] a_45351_40607# a_45285_40681# uio_oe[0] sky130_fd_pr__nfet_01v8 ad=0.12495 pd=1.015 as=0.0669 ps=0.75 w=0.42 l=0.15
X4253 a_60160_38671# a_58980_38645# a_59939_38998# uio_oe[0] sky130_fd_pr__nfet_01v8 ad=0.0693 pd=0.75 as=0.09975 ps=0.895 w=0.42 l=0.15
X4254 a_18711_36271# a_18531_36271# VDPWR VDPWR sky130_fd_pr__pfet_01v8_hvt ad=0.0609 pd=0.71 as=0.0714 ps=0.76 w=0.42 l=0.15
X4255 VDPWR a_50003_42721# a_49964_42595# VDPWR sky130_fd_pr__pfet_01v8_hvt ad=0.0864 pd=0.91 as=0.1664 ps=1.8 w=0.64 l=0.15
X4256 VDPWR a_45095_39733# a_43918_36041# VDPWR sky130_fd_pr__pfet_01v8_hvt ad=0.135 pd=1.27 as=0.135 ps=1.27 w=1 l=0.15
X4257 a_58914_36495# a_48677_38127# uio_oe[0] uio_oe[0] sky130_fd_pr__nfet_01v8 ad=0.0693 pd=0.75 as=0.11285 ps=1.045 w=0.42 l=0.15
X4258 a_41677_40847# a_41343_41097# a_41593_41097# VDPWR sky130_fd_pr__pfet_01v8_hvt ad=0.3 pd=2.6 as=0.26 ps=2.52 w=1 l=0.15
X4259 uio_oe[0] a_47283_41695# a_47217_41769# uio_oe[0] sky130_fd_pr__nfet_01v8 ad=0.12495 pd=1.015 as=0.0669 ps=0.75 w=0.42 l=0.15
X4260 VDPWR a_17689_32641# a_18711_36271# VDPWR sky130_fd_pr__pfet_01v8_hvt ad=0.2279 pd=1.74 as=0.0609 ps=0.71 w=0.42 l=0.15
X4261 a_28700_36057# a_28835_35361# a_28842_36232# VDPWR sky130_fd_pr__pfet_01v8_hvt ad=0.1932 pd=1.34 as=0.07665 ps=0.785 w=0.42 l=0.15
X4262 a_53574_40303# a_52816_40419# a_53011_40277# VDPWR sky130_fd_pr__pfet_01v8_hvt ad=0.0651 pd=0.73 as=0.07245 ps=0.765 w=0.42 l=0.15
X4263 a_52855_38369# a_37913_41935# VDPWR VDPWR sky130_fd_pr__pfet_01v8_hvt ad=0.1664 pd=1.8 as=0.0864 ps=0.91 w=0.64 l=0.15
X4264 a_27562_26464# a_24484_10782# ua[4] uio_oe[0] sky130_fd_pr__nfet_01v8 ad=0.1885 pd=1.88 as=0.1885 ps=1.88 w=0.65 l=0.15
X4265 VDPWR a_44829_42453# a_44719_42479# VDPWR sky130_fd_pr__pfet_01v8_hvt ad=0.07035 pd=0.755 as=0.1155 ps=0.97 w=0.42 l=0.15
X4266 uio_oe[0] a_41671_37343# a_41605_37417# uio_oe[0] sky130_fd_pr__nfet_01v8 ad=0.12495 pd=1.015 as=0.0669 ps=0.75 w=0.42 l=0.15
X4267 a_18442_18464# a_18148_18782# ua[5] uio_oe[0] sky130_fd_pr__nfet_01v8 ad=0.1885 pd=1.88 as=0.1885 ps=1.88 w=0.65 l=0.15
X4268 a_61806_35773# a_60729_35407# a_61644_35407# VDPWR sky130_fd_pr__pfet_01v8_hvt ad=0.0567 pd=0.69 as=0.0588 ps=0.7 w=0.42 l=0.15
X4269 a_51871_38166# a_51620_38395# a_51412_38359# VDPWR sky130_fd_pr__pfet_01v8_hvt ad=0.0441 pd=0.63 as=0.1932 ps=1.34 w=0.42 l=0.15
X4270 a_51841_37337# a_48677_38127# VDPWR VDPWR sky130_fd_pr__pfet_01v8_hvt ad=0.1176 pd=1.4 as=0.0693 ps=0.75 w=0.42 l=0.15
X4271 ua[5] a_16756_10376# a_16626_10020# uio_oe[0] sky130_fd_pr__nfet_01v8 ad=0.1885 pd=1.88 as=0.1885 ps=1.88 w=0.65 l=0.15
X4272 a_57280_39037# a_56843_38645# VDPWR VDPWR sky130_fd_pr__pfet_01v8_hvt ad=0.0567 pd=0.69 as=0.0819 ps=0.81 w=0.42 l=0.15
X4273 a_22439_33551# a_18427_33198# a_22076_33417# uio_oe[0] sky130_fd_pr__nfet_01v8 ad=0.0693 pd=0.75 as=0.09975 ps=0.895 w=0.42 l=0.15
X4274 a_62171_35229# a_58980_35381# a_61808_35095# uio_oe[0] sky130_fd_pr__nfet_01v8 ad=0.0693 pd=0.75 as=0.09975 ps=0.895 w=0.42 l=0.15
X4275 VDPWR a_61644_40847# a_61819_40821# VDPWR sky130_fd_pr__pfet_01v8_hvt ad=0.1134 pd=1.38 as=0.0567 ps=0.69 w=0.42 l=0.15
X4276 a_43313_38493# a_40379_35551# uio_oe[0] uio_oe[0] sky130_fd_pr__nfet_01v8 ad=0.0441 pd=0.63 as=0.1346 ps=1.15 w=0.42 l=0.15
X4277 VDPWR a_60416_41669# a_60500_41365# VDPWR sky130_fd_pr__pfet_01v8_hvt ad=0.0864 pd=0.91 as=0.1664 ps=1.8 w=0.64 l=0.15
X4278 a_61187_37949# a_60563_37583# a_61079_37583# VDPWR sky130_fd_pr__pfet_01v8_hvt ad=0.1155 pd=0.97 as=0.07245 ps=0.765 w=0.42 l=0.15
X4279 uio_oe[0] a_25940_35593# a_25044_35879# uio_oe[0] sky130_fd_pr__nfet_01v8 ad=0.11285 pd=1.045 as=0.169 ps=1.82 w=0.65 l=0.15
X4280 a_27562_26464# a_4259_22596# a_27266_24730# uio_oe[0] sky130_fd_pr__nfet_01v8 ad=0.2436 pd=2.26 as=0.2436 ps=2.26 w=0.84 l=0.6
X4281 uio_oe[0] a_49483_38645# a_39752_38645# uio_oe[0] sky130_fd_pr__nfet_01v8 ad=0.2087 pd=2.02 as=0.169 ps=1.82 w=0.65 l=0.15
X4282 a_25739_34845# a_24787_34817# VDPWR VDPWR sky130_fd_pr__pfet_01v8_hvt ad=0.0567 pd=0.69 as=0.1176 ps=1.4 w=0.42 l=0.15
X4283 a_17108_37145# a_17243_36449# a_17250_37320# VDPWR sky130_fd_pr__pfet_01v8_hvt ad=0.1932 pd=1.34 as=0.07665 ps=0.785 w=0.42 l=0.15
X4284 ua[4] a_24484_14376# a_27138_22020# uio_oe[0] sky130_fd_pr__nfet_01v8 ad=0.1885 pd=1.88 as=0.1885 ps=1.88 w=0.65 l=0.15
X4285 a_61644_38671# a_60563_38671# a_61297_38913# VDPWR sky130_fd_pr__pfet_01v8_hvt ad=0.0588 pd=0.7 as=0.12915 ps=1.185 w=0.42 l=0.15
X4286 ua[5] a_16756_10376# a_18018_14020# uio_oe[0] sky130_fd_pr__nfet_01v8 ad=0.1885 pd=1.88 as=0.1885 ps=1.88 w=0.65 l=0.15
X4287 a_44469_38921# a_43283_34319# VDPWR VDPWR sky130_fd_pr__pfet_01v8_hvt ad=0.105 pd=1.21 as=0.26 ps=2.52 w=1 l=0.15
X4288 VDPWR a_36607_39455# a_36327_39733# VDPWR sky130_fd_pr__pfet_01v8_hvt ad=0.0819 pd=0.81 as=0.0567 ps=0.69 w=0.42 l=0.15
X4289 a_38674_39254# a_38005_40847# VDPWR VDPWR sky130_fd_pr__pfet_01v8_hvt ad=0.07665 pd=0.785 as=0.15835 ps=1.395 w=0.42 l=0.15
X4290 VDPWR a_37639_36495# a_45015_39215# VDPWR sky130_fd_pr__pfet_01v8_hvt ad=0.0714 pd=0.76 as=0.1092 ps=1.36 w=0.42 l=0.15
X4291 a_54693_39513# a_36661_41391# uio_oe[0] uio_oe[0] sky130_fd_pr__nfet_01v8 ad=0.1092 pd=1.36 as=0.1449 ps=1.11 w=0.42 l=0.15
X4292 VDPWR a_44905_38671# a_49483_38101# VDPWR sky130_fd_pr__pfet_01v8_hvt ad=0.0819 pd=0.81 as=0.0567 ps=0.69 w=0.42 l=0.15
X4293 uio_oe[0] a_21401_35879# a_21335_35905# uio_oe[0] sky130_fd_pr__nfet_01v8 ad=0.1449 pd=1.11 as=0.0693 ps=0.75 w=0.42 l=0.15
X4294 a_20914_10464# a_20620_10782# ua[5] uio_oe[0] sky130_fd_pr__nfet_01v8 ad=0.1885 pd=1.88 as=0.1885 ps=1.88 w=0.65 l=0.15
X4295 a_44611_41935# a_44261_41935# a_44516_41935# VDPWR sky130_fd_pr__pfet_01v8_hvt ad=0.07245 pd=0.765 as=0.0651 ps=0.73 w=0.42 l=0.15
X4296 a_59227_39581# a_39752_39483# a_58864_39447# uio_oe[0] sky130_fd_pr__nfet_01v8 ad=0.0693 pd=0.75 as=0.09975 ps=0.895 w=0.42 l=0.15
X4297 a_22076_35593# a_18420_33453# a_22218_35727# uio_oe[0] sky130_fd_pr__nfet_01v8 ad=0.09975 pd=0.895 as=0.0693 ps=0.75 w=0.42 l=0.15
X4298 a_20668_10020# a_16812_8642# uio_oe[0] uio_oe[0] sky130_fd_pr__nfet_01v8 ad=1.4703 pd=10.72 as=1.4703 ps=10.72 w=5.07 l=1
X4299 a_61297_34561# a_61079_34319# VDPWR VDPWR sky130_fd_pr__pfet_01v8_hvt ad=0.12915 pd=1.185 as=0.2184 ps=2.2 w=0.84 l=0.15
X4300 a_42787_42479# a_42163_42485# a_42679_42857# VDPWR sky130_fd_pr__pfet_01v8_hvt ad=0.1155 pd=0.97 as=0.07245 ps=0.765 w=0.42 l=0.15
X4301 a_52538_37171# a_52855_37281# a_52813_37405# uio_oe[0] sky130_fd_pr__special_nfet_01v8 ad=0.0711 pd=0.755 as=0.0669 ps=0.75 w=0.36 l=0.15
X4302 a_28348_14376# a_29603_35933# VDPWR VDPWR sky130_fd_pr__pfet_01v8_hvt ad=0.475 pd=2.95 as=0.16655 ps=1.39 w=1 l=0.15
X4303 a_59695_35925# a_59898_36083# VDPWR VDPWR sky130_fd_pr__pfet_01v8_hvt ad=0.0567 pd=0.69 as=0.1134 ps=1.38 w=0.42 l=0.15
X4304 a_21114_34056# a_21068_33881# VDPWR VDPWR sky130_fd_pr__pfet_01v8_hvt ad=0.07665 pd=0.785 as=0.15835 ps=1.395 w=0.42 l=0.15
X4305 a_59956_34837# a_60416_35141# a_60374_35229# uio_oe[0] sky130_fd_pr__nfet_01v8 ad=0.0693 pd=0.75 as=0.0441 ps=0.63 w=0.42 l=0.15
X4306 VDPWR a_36875_38823# a_37085_38921# VDPWR sky130_fd_pr__pfet_01v8_hvt ad=0.26 pd=2.52 as=0.135 ps=1.27 w=1 l=0.15
X4307 uio_oe[0] a_36355_38101# a_36385_38127# uio_oe[0] sky130_fd_pr__nfet_01v8 ad=0.08775 pd=0.92 as=0.08775 ps=0.92 w=0.65 l=0.15
X4308 VDPWR a_42445_36469# a_42857_36822# VDPWR sky130_fd_pr__pfet_01v8_hvt ad=0.15835 pd=1.395 as=0.07665 ps=0.785 w=0.42 l=0.15
X4309 a_29343_36488# a_17500_33453# a_28884_36681# VDPWR sky130_fd_pr__pfet_01v8_hvt ad=0.0441 pd=0.63 as=0.1932 ps=1.34 w=0.42 l=0.15
X4310 a_31426_22464# a_28348_14782# ua[4] uio_oe[0] sky130_fd_pr__nfet_01v8 ad=0.1885 pd=1.88 as=0.1885 ps=1.88 w=0.65 l=0.15
X4311 a_54459_35381# a_54284_35407# a_54638_35407# uio_oe[0] sky130_fd_pr__nfet_01v8 ad=0.1092 pd=1.36 as=0.06405 ps=0.725 w=0.42 l=0.15
X4312 a_57858_37405# a_57640_37353# a_57776_37405# uio_oe[0] sky130_fd_pr__nfet_01v8 ad=0.0441 pd=0.63 as=0.1092 ps=1.36 w=0.42 l=0.15
X4313 a_53369_36495# a_53203_36495# VDPWR VDPWR sky130_fd_pr__pfet_01v8_hvt ad=0.1664 pd=1.8 as=0.0864 ps=0.91 w=0.64 l=0.15
X4314 a_22306_14464# a_20620_10782# ua[5] uio_oe[0] sky130_fd_pr__nfet_01v8 ad=0.1885 pd=1.88 as=0.1885 ps=1.88 w=0.65 l=0.15
X4315 a_42860_38671# a_42743_38884# VDPWR VDPWR sky130_fd_pr__pfet_01v8_hvt ad=0.0651 pd=0.73 as=0.1092 ps=1.36 w=0.42 l=0.15
X4316 uio_oe[0] a_37795_40535# a_42793_35559# uio_oe[0] sky130_fd_pr__nfet_01v8 ad=0.1092 pd=1.36 as=0.0567 ps=0.69 w=0.42 l=0.15
X4317 a_46331_42650# a_47283_42997# uio_oe[0] uio_oe[0] sky130_fd_pr__nfet_01v8 ad=0.169 pd=1.82 as=0.2087 ps=2.02 w=0.65 l=0.15
X4318 a_51841_41909# a_48677_39759# VDPWR VDPWR sky130_fd_pr__pfet_01v8_hvt ad=0.1176 pd=1.4 as=0.0693 ps=0.75 w=0.42 l=0.15
X4319 a_54393_41935# a_53203_41935# a_54284_41935# uio_oe[0] sky130_fd_pr__special_nfet_01v8 ad=0.0669 pd=0.75 as=0.0711 ps=0.755 w=0.36 l=0.15
X4320 uio_oe[0] a_50159_41084# a_50090_41213# uio_oe[0] sky130_fd_pr__nfet_01v8 ad=0.1346 pd=1.15 as=0.0999 ps=0.985 w=0.64 l=0.15
X4321 VDPWR a_45443_38823# a_37829_38140# VDPWR sky130_fd_pr__pfet_01v8_hvt ad=0.16655 pd=1.39 as=0.475 ps=2.95 w=1 l=0.15
X4322 a_31426_22464# a_4259_22596# a_31130_20730# uio_oe[0] sky130_fd_pr__nfet_01v8 ad=0.2436 pd=2.26 as=0.2436 ps=2.26 w=0.84 l=0.6
X4323 VDPWR a_54459_38645# a_54446_39037# VDPWR sky130_fd_pr__pfet_01v8_hvt ad=0.0819 pd=0.81 as=0.0567 ps=0.69 w=0.42 l=0.15
X4324 VDPWR a_57519_37820# a_57450_37949# VDPWR sky130_fd_pr__pfet_01v8_hvt ad=0.2184 pd=2.2 as=0.12915 ps=1.185 w=0.84 l=0.15
X4325 a_18531_36271# a_17059_35905# uio_oe[0] uio_oe[0] sky130_fd_pr__nfet_01v8 ad=0.1092 pd=1.36 as=0.1092 ps=1.36 w=0.42 l=0.15
X4326 a_38674_38998# a_38005_40847# VDPWR VDPWR sky130_fd_pr__pfet_01v8_hvt ad=0.07665 pd=0.785 as=0.15835 ps=1.395 w=0.42 l=0.15
X4327 a_37313_39759# a_36934_40125# a_37241_39759# uio_oe[0] sky130_fd_pr__nfet_01v8 ad=0.1401 pd=1.1 as=0.0441 ps=0.63 w=0.42 l=0.15
X4328 a_50090_40125# a_49964_40027# a_49686_40011# uio_oe[0] sky130_fd_pr__special_nfet_01v8 ad=0.0999 pd=0.985 as=0.0711 ps=0.755 w=0.36 l=0.15
X4329 uio_oe[0] uio_oe[0] uio_oe[0] uio_oe[0] sky130_fd_pr__nfet_01v8 ad=0.1885 pd=1.88 as=0 ps=0 w=0.65 l=0.15
X4330 uio_oe[0] a_58864_39447# a_58298_39445# uio_oe[0] sky130_fd_pr__nfet_01v8 ad=0.11285 pd=1.045 as=0.169 ps=1.82 w=0.65 l=0.15
X4331 a_4259_22596# uio_oe[0] sky130_fd_pr__cap_mim_m3_1 l=22 w=22
X4332 a_57363_34461# a_41685_42479# uio_oe[0] uio_oe[0] sky130_fd_pr__nfet_01v8 ad=0.1092 pd=1.36 as=0.0567 ps=0.69 w=0.42 l=0.15
X4333 uio_oe[0] a_46027_39759# a_46193_39759# uio_oe[0] sky130_fd_pr__nfet_01v8 ad=0.08775 pd=0.92 as=0.08775 ps=0.92 w=0.65 l=0.15
X4334 a_52573_41757# a_52538_41523# a_52335_41365# uio_oe[0] sky130_fd_pr__nfet_01v8 ad=0.06405 pd=0.725 as=0.1092 ps=1.36 w=0.42 l=0.15
X4335 a_39973_39513# a_38005_40847# uio_oe[0] uio_oe[0] sky130_fd_pr__nfet_01v8 ad=0.1092 pd=1.36 as=0.1449 ps=1.11 w=0.42 l=0.15
X4336 a_20668_14020# a_4259_22596# a_20490_14020# uio_oe[0] sky130_fd_pr__nfet_01v8 ad=0.2436 pd=2.26 as=0.2436 ps=2.26 w=0.84 l=0.6
X4337 VDPWR a_61644_34319# a_61819_34293# VDPWR sky130_fd_pr__pfet_01v8_hvt ad=0.1134 pd=1.38 as=0.0567 ps=0.69 w=0.42 l=0.15
X4338 VDPWR a_44829_41365# a_44719_41391# VDPWR sky130_fd_pr__pfet_01v8_hvt ad=0.07035 pd=0.755 as=0.1155 ps=0.97 w=0.42 l=0.15
X4339 uio_oe[0] a_57363_40545# a_57324_40419# uio_oe[0] sky130_fd_pr__nfet_01v8 ad=0.0567 pd=0.69 as=0.1092 ps=1.36 w=0.42 l=0.15
X4340 a_46193_39759# a_46027_39759# VDPWR VDPWR sky130_fd_pr__pfet_01v8_hvt ad=0.135 pd=1.27 as=0.135 ps=1.27 w=1 l=0.15
X4341 uio_oe[0] a_48125_43023# a_49721_39759# uio_oe[0] sky130_fd_pr__nfet_01v8 ad=0.12495 pd=1.015 as=0.06405 ps=0.725 w=0.42 l=0.15
X4342 VDPWR a_56916_37271# a_39752_37307# VDPWR sky130_fd_pr__pfet_01v8_hvt ad=0.149 pd=1.325 as=0.26 ps=2.52 w=1 l=0.15
X4343 a_28700_34969# a_28908_34791# a_28842_34817# uio_oe[0] sky130_fd_pr__nfet_01v8 ad=0.09975 pd=0.895 as=0.0693 ps=0.75 w=0.42 l=0.15
X4344 a_39686_40086# a_38005_40847# VDPWR VDPWR sky130_fd_pr__pfet_01v8_hvt ad=0.07665 pd=0.785 as=0.15835 ps=1.395 w=0.42 l=0.15
X4345 a_52579_40086# a_51620_39733# a_52507_40086# VDPWR sky130_fd_pr__pfet_01v8_hvt ad=0.1932 pd=1.34 as=0.0441 ps=0.63 w=0.42 l=0.15
X4346 a_36355_38101# uio_in[0] VDPWR VDPWR sky130_fd_pr__pfet_01v8_hvt ad=0.26 pd=2.52 as=0.135 ps=1.27 w=1 l=0.15
X4347 uio_oe[0] a_58144_38101# a_58082_38127# uio_oe[0] sky130_fd_pr__nfet_01v8 ad=0.2205 pd=1.89 as=0.066 ps=0.745 w=0.42 l=0.15
X4348 a_43713_36183# a_43918_36041# a_43876_36067# VDPWR sky130_fd_pr__pfet_01v8_hvt ad=0.1092 pd=1.36 as=0.0441 ps=0.63 w=0.42 l=0.15
X4349 a_50159_38908# a_50003_38813# a_50304_39037# VDPWR sky130_fd_pr__pfet_01v8_hvt ad=0.07245 pd=0.765 as=0.1155 ps=0.97 w=0.42 l=0.15
X4350 a_46651_40303# a_39947_42997# VDPWR VDPWR sky130_fd_pr__pfet_01v8_hvt ad=0.1092 pd=1.36 as=0.07035 ps=0.755 w=0.42 l=0.15
X4351 a_38532_39447# a_37795_40535# a_38674_39254# VDPWR sky130_fd_pr__pfet_01v8_hvt ad=0.1932 pd=1.34 as=0.07665 ps=0.785 w=0.42 l=0.15
X4352 a_61187_36861# a_60563_36495# a_61079_36495# VDPWR sky130_fd_pr__pfet_01v8_hvt ad=0.1155 pd=0.97 as=0.07245 ps=0.765 w=0.42 l=0.15
X4353 a_43244_40847# a_42163_40847# a_42897_41089# VDPWR sky130_fd_pr__pfet_01v8_hvt ad=0.0588 pd=0.7 as=0.12915 ps=1.185 w=0.42 l=0.15
X4354 a_53981_40847# a_53937_41089# a_53815_40847# uio_oe[0] sky130_fd_pr__nfet_01v8 ad=0.0441 pd=0.63 as=0.1401 ps=1.1 w=0.42 l=0.15
X4355 a_54638_36495# a_46193_39759# uio_oe[0] uio_oe[0] sky130_fd_pr__nfet_01v8 ad=0.06405 pd=0.725 as=0.12495 ps=1.015 w=0.42 l=0.15
X4356 a_28348_14782# a_30303_36271# uio_oe[0] uio_oe[0] sky130_fd_pr__nfet_01v8 ad=0.169 pd=1.82 as=0.1013 ps=0.99 w=0.65 l=0.15
X4357 a_60729_34319# a_60563_34319# uio_oe[0] uio_oe[0] sky130_fd_pr__nfet_01v8 ad=0.1092 pd=1.36 as=0.0567 ps=0.69 w=0.42 l=0.15
X4358 a_53719_34319# a_53203_34319# a_53624_34319# uio_oe[0] sky130_fd_pr__special_nfet_01v8 ad=0.0594 pd=0.69 as=0.066 ps=0.745 w=0.36 l=0.15
X4359 a_57046_40011# a_57324_40027# a_57280_40125# VDPWR sky130_fd_pr__pfet_01v8_hvt ad=0.0588 pd=0.7 as=0.0567 ps=0.69 w=0.42 l=0.15
X4360 a_30263_36488# a_18420_33453# a_29804_36681# VDPWR sky130_fd_pr__pfet_01v8_hvt ad=0.0441 pd=0.63 as=0.1932 ps=1.34 w=0.42 l=0.15
X4361 a_52772_35951# a_52335_35925# VDPWR VDPWR sky130_fd_pr__pfet_01v8_hvt ad=0.0567 pd=0.69 as=0.0819 ps=0.81 w=0.42 l=0.15
X4362 a_20972_33881# a_21107_33185# a_21114_34056# VDPWR sky130_fd_pr__pfet_01v8_hvt ad=0.1932 pd=1.34 as=0.07665 ps=0.785 w=0.42 l=0.15
X4363 uio_oe[0] a_59201_41909# a_59135_41935# uio_oe[0] sky130_fd_pr__nfet_01v8 ad=0.1449 pd=1.11 as=0.0693 ps=0.75 w=0.42 l=0.15
X4364 a_38991_40086# a_38740_39733# a_38532_39911# VDPWR sky130_fd_pr__pfet_01v8_hvt ad=0.0441 pd=0.63 as=0.1932 ps=1.34 w=0.42 l=0.15
X4365 a_57640_41705# a_57472_41669# a_58044_41391# VDPWR sky130_fd_pr__pfet_01v8_hvt ad=0.0567 pd=0.69 as=0.0945 ps=0.87 w=0.42 l=0.15
X4366 a_54723_37078# a_51620_37307# a_54264_37271# VDPWR sky130_fd_pr__pfet_01v8_hvt ad=0.0441 pd=0.63 as=0.1932 ps=1.34 w=0.42 l=0.15
X4367 a_29804_36681# a_18420_33453# a_29946_36815# uio_oe[0] sky130_fd_pr__nfet_01v8 ad=0.09975 pd=0.895 as=0.0693 ps=0.75 w=0.42 l=0.15
X4368 a_17108_36057# a_17316_35879# a_17250_35905# uio_oe[0] sky130_fd_pr__nfet_01v8 ad=0.09975 pd=0.895 as=0.0693 ps=0.75 w=0.42 l=0.15
X4369 a_51554_34902# a_48677_38127# VDPWR VDPWR sky130_fd_pr__pfet_01v8_hvt ad=0.07665 pd=0.785 as=0.15835 ps=1.395 w=0.42 l=0.15
X4370 a_54264_37271# a_51620_37307# a_54406_37405# uio_oe[0] sky130_fd_pr__nfet_01v8 ad=0.09975 pd=0.895 as=0.0693 ps=0.75 w=0.42 l=0.15
X4371 a_60984_36495# a_60365_36495# uio_oe[0] uio_oe[0] sky130_fd_pr__nfet_01v8 ad=0.066 pd=0.745 as=0.2205 ps=1.89 w=0.42 l=0.15
X4372 a_42787_41391# a_42163_41397# a_42679_41769# VDPWR sky130_fd_pr__pfet_01v8_hvt ad=0.1155 pd=0.97 as=0.07245 ps=0.765 w=0.42 l=0.15
X4373 a_51554_40086# a_48677_39759# VDPWR VDPWR sky130_fd_pr__pfet_01v8_hvt ad=0.07665 pd=0.785 as=0.15835 ps=1.395 w=0.42 l=0.15
X4374 VDPWR a_28700_37145# a_28651_36993# VDPWR sky130_fd_pr__pfet_01v8_hvt ad=0.15835 pd=1.395 as=0.26 ps=2.52 w=1 l=0.15
X4375 a_59231_35990# a_54479_35964# a_58772_36183# VDPWR sky130_fd_pr__pfet_01v8_hvt ad=0.0441 pd=0.63 as=0.1932 ps=1.34 w=0.42 l=0.15
X4376 uio_oe[0] a_41711_34569# a_42045_34319# uio_oe[0] sky130_fd_pr__nfet_01v8 ad=0.208 pd=1.94 as=0.25025 ps=1.42 w=0.65 l=0.15
X4377 a_61192_34863# a_60500_34837# a_60584_35177# VDPWR sky130_fd_pr__pfet_01v8_hvt ad=0.12495 pd=1.175 as=0.0567 ps=0.69 w=0.42 l=0.15
X4378 a_53249_35229# a_46193_39759# uio_oe[0] uio_oe[0] sky130_fd_pr__nfet_01v8 ad=0.0441 pd=0.63 as=0.1346 ps=1.15 w=0.42 l=0.15
X4379 uio_oe[0] a_39973_36469# a_39907_36495# uio_oe[0] sky130_fd_pr__nfet_01v8 ad=0.1449 pd=1.11 as=0.0693 ps=0.75 w=0.42 l=0.15
X4380 uio_oe[0] a_37361_41391# a_52800_36495# uio_oe[0] sky130_fd_pr__nfet_01v8 ad=0.11285 pd=1.045 as=0.0693 ps=0.75 w=0.42 l=0.15
X4381 a_29313_33483# a_28980_33417# VDPWR VDPWR sky130_fd_pr__pfet_01v8_hvt ad=0.1176 pd=1.4 as=0.0693 ps=0.75 w=0.42 l=0.15
X4382 a_25265_33703# a_24932_33881# uio_oe[0] uio_oe[0] sky130_fd_pr__nfet_01v8 ad=0.1092 pd=1.36 as=0.1449 ps=1.11 w=0.42 l=0.15
X4383 a_41711_34569# a_41751_34471# uio_oe[0] uio_oe[0] sky130_fd_pr__nfet_01v8 ad=0.08775 pd=0.92 as=0.169 ps=1.82 w=0.65 l=0.15
X4384 a_44516_40847# ui_in[6] uio_oe[0] uio_oe[0] sky130_fd_pr__nfet_01v8 ad=0.066 pd=0.745 as=0.2205 ps=1.89 w=0.42 l=0.15
X4385 a_40987_38369# a_38005_41391# uio_oe[0] uio_oe[0] sky130_fd_pr__nfet_01v8 ad=0.1092 pd=1.36 as=0.0567 ps=0.69 w=0.42 l=0.15
X4386 a_60302_38127# a_60176_38243# a_59898_38259# uio_oe[0] sky130_fd_pr__special_nfet_01v8 ad=0.0999 pd=0.985 as=0.0711 ps=0.755 w=0.36 l=0.15
X4387 a_60720_37405# a_60584_37353# VDPWR VDPWR sky130_fd_pr__pfet_01v8_hvt ad=0.0567 pd=0.69 as=0.0567 ps=0.69 w=0.42 l=0.15
X4388 ua[4] a_20620_18782# a_20490_18020# uio_oe[0] sky130_fd_pr__nfet_01v8 ad=0.1885 pd=1.88 as=0.1885 ps=1.88 w=0.65 l=0.15
X4389 VDPWR a_42499_34471# a_41316_35131# VDPWR sky130_fd_pr__pfet_01v8_hvt ad=0.16655 pd=1.39 as=0.475 ps=2.95 w=1 l=0.15
X4390 a_43437_35095# a_42045_34319# a_43600_34979# VDPWR sky130_fd_pr__pfet_01v8_hvt ad=0.1092 pd=1.36 as=0.0441 ps=0.63 w=0.42 l=0.15
X4391 a_46651_40303# a_46027_40309# a_46543_40681# VDPWR sky130_fd_pr__pfet_01v8_hvt ad=0.1155 pd=0.97 as=0.07245 ps=0.765 w=0.42 l=0.15
X4392 a_22060_14020# a_4259_22596# a_21882_14020# uio_oe[0] sky130_fd_pr__nfet_01v8 ad=0.2436 pd=2.26 as=0.2436 ps=2.26 w=0.84 l=0.6
X4393 a_60609_42845# a_48125_41935# uio_oe[0] uio_oe[0] sky130_fd_pr__nfet_01v8 ad=0.0441 pd=0.63 as=0.1346 ps=1.15 w=0.42 l=0.15
X4394 uio_oe[0] a_40379_35551# a_41684_38671# uio_oe[0] sky130_fd_pr__nfet_01v8 ad=0.1137 pd=1.01 as=0.0483 ps=0.65 w=0.42 l=0.15
X4395 uio_oe[0] a_25417_32641# a_26529_34817# uio_oe[0] sky130_fd_pr__nfet_01v8 ad=0.1013 pd=0.99 as=0.0504 ps=0.66 w=0.42 l=0.15
X4396 VDPWR a_47959_43023# a_48125_43023# VDPWR sky130_fd_pr__pfet_01v8_hvt ad=0.26 pd=2.52 as=0.135 ps=1.27 w=1 l=0.15
X4397 a_41141_40316# a_43419_41695# uio_oe[0] uio_oe[0] sky130_fd_pr__nfet_01v8 ad=0.169 pd=1.82 as=0.2087 ps=2.02 w=0.65 l=0.15
X4398 VDPWR a_44905_38671# a_50304_37039# VDPWR sky130_fd_pr__pfet_01v8_hvt ad=0.07035 pd=0.755 as=0.1092 ps=1.36 w=0.42 l=0.15
X4399 VDPWR a_54693_36249# a_54723_35990# VDPWR sky130_fd_pr__pfet_01v8_hvt ad=0.0693 pd=0.75 as=0.0441 ps=0.63 w=0.42 l=0.15
X4400 a_28642_18464# a_28348_18782# ua[5] uio_oe[0] sky130_fd_pr__nfet_01v8 ad=0.1885 pd=1.88 as=0.1885 ps=1.88 w=0.65 l=0.15
X4401 a_38532_38823# a_37795_40535# a_38674_38998# VDPWR sky130_fd_pr__pfet_01v8_hvt ad=0.1932 pd=1.34 as=0.07665 ps=0.785 w=0.42 l=0.15
X4402 a_53005_38671# a_52579_38998# VDPWR VDPWR sky130_fd_pr__pfet_01v8_hvt ad=0.26 pd=2.52 as=0.15835 ps=1.395 w=1 l=0.15
X4403 uio_oe[0] a_21553_32641# a_21961_34845# uio_oe[0] sky130_fd_pr__nfet_01v8 ad=0.1118 pd=1.04 as=0.0567 ps=0.69 w=0.42 l=0.15
X4404 VDPWR a_58298_41621# a_58248_41391# VDPWR sky130_fd_pr__pfet_01v8_hvt ad=0.2184 pd=2.2 as=0.12495 ps=1.175 w=0.84 l=0.15
X4405 uio_oe[0] a_25020_34505# a_24971_34273# uio_oe[0] sky130_fd_pr__nfet_01v8 ad=0.11285 pd=1.045 as=0.169 ps=1.82 w=0.65 l=0.15
X4406 uio_oe[0] a_38532_40535# a_21252_36681# uio_oe[0] sky130_fd_pr__nfet_01v8 ad=0.11285 pd=1.045 as=0.169 ps=1.82 w=0.65 l=0.15
X4407 a_58980_39733# a_61819_39733# uio_oe[0] uio_oe[0] sky130_fd_pr__nfet_01v8 ad=0.169 pd=1.82 as=0.2087 ps=2.02 w=0.65 l=0.15
X4408 a_49483_38645# a_49686_38923# VDPWR VDPWR sky130_fd_pr__pfet_01v8_hvt ad=0.0567 pd=0.69 as=0.1134 ps=1.38 w=0.42 l=0.15
X4409 a_43897_36647# a_37452_34293# uio_oe[0] uio_oe[0] sky130_fd_pr__nfet_01v8 ad=0.0567 pd=0.69 as=0.10025 ps=0.985 w=0.42 l=0.15
X4410 a_42863_39759# a_42347_39759# a_42768_39759# uio_oe[0] sky130_fd_pr__special_nfet_01v8 ad=0.0594 pd=0.69 as=0.066 ps=0.745 w=0.36 l=0.15
X4411 a_40706_35951# a_40619_36193# a_40302_36083# VDPWR sky130_fd_pr__pfet_01v8_hvt ad=0.12915 pd=1.185 as=0.0588 ps=0.7 w=0.42 l=0.15
X4412 a_23452_18020# a_4259_22596# a_23274_18020# uio_oe[0] sky130_fd_pr__nfet_01v8 ad=0.2436 pd=2.26 as=0.2436 ps=2.26 w=0.84 l=0.6
X4413 uio_oe[0] a_49483_34837# a_38771_34879# uio_oe[0] sky130_fd_pr__nfet_01v8 ad=0.2087 pd=2.02 as=0.169 ps=1.82 w=0.65 l=0.15
X4414 uio_oe[0] a_51841_36469# a_51775_36495# uio_oe[0] sky130_fd_pr__nfet_01v8 ad=0.1449 pd=1.11 as=0.0693 ps=0.75 w=0.42 l=0.15
X4415 a_29129_35879# a_28796_36057# uio_oe[0] uio_oe[0] sky130_fd_pr__nfet_01v8 ad=0.1092 pd=1.36 as=0.1449 ps=1.11 w=0.42 l=0.15
X4416 a_50159_42453# a_49964_42595# a_50469_42845# uio_oe[0] sky130_fd_pr__special_nfet_01v8 ad=0.0594 pd=0.69 as=0.1401 ps=1.1 w=0.36 l=0.15
X4417 a_50090_39037# a_49964_38939# a_49686_38923# uio_oe[0] sky130_fd_pr__special_nfet_01v8 ad=0.0999 pd=0.985 as=0.0711 ps=0.755 w=0.36 l=0.15
X4418 a_43006_38127# a_42919_38369# a_42602_38259# VDPWR sky130_fd_pr__pfet_01v8_hvt ad=0.12915 pd=1.185 as=0.0588 ps=0.7 w=0.42 l=0.15
X4419 ua[5] a_28348_14376# a_28218_14020# uio_oe[0] sky130_fd_pr__nfet_01v8 ad=0.1885 pd=1.88 as=0.1885 ps=1.88 w=0.65 l=0.15
X4420 a_18641_33483# a_17388_33417# VDPWR VDPWR sky130_fd_pr__pfet_01v8_hvt ad=0.1176 pd=1.4 as=0.0693 ps=0.75 w=0.42 l=0.15
X4421 a_30303_34095# a_30123_34095# VDPWR VDPWR sky130_fd_pr__pfet_01v8_hvt ad=0.0609 pd=0.71 as=0.0714 ps=0.76 w=0.42 l=0.15
X4422 a_38005_41391# a_37839_41391# uio_oe[0] uio_oe[0] sky130_fd_pr__nfet_01v8 ad=0.08775 pd=0.92 as=0.08775 ps=0.92 w=0.65 l=0.15
X4423 VDPWR a_43244_40847# a_43419_40821# VDPWR sky130_fd_pr__pfet_01v8_hvt ad=0.1134 pd=1.38 as=0.0567 ps=0.69 w=0.42 l=0.15
X4424 a_39544_39911# a_38089_40623# a_39686_40086# VDPWR sky130_fd_pr__pfet_01v8_hvt ad=0.1932 pd=1.34 as=0.07665 ps=0.785 w=0.42 l=0.15
X4425 a_60371_35925# a_60176_36067# a_60681_36317# uio_oe[0] sky130_fd_pr__special_nfet_01v8 ad=0.0594 pd=0.69 as=0.1401 ps=1.1 w=0.36 l=0.15
X4426 a_17050_10464# a_16756_10782# ua[5] uio_oe[0] sky130_fd_pr__nfet_01v8 ad=0.1885 pd=1.88 as=0.1885 ps=1.88 w=0.65 l=0.15
X4427 a_57829_41935# a_57450_42301# a_57757_41935# uio_oe[0] sky130_fd_pr__nfet_01v8 ad=0.1401 pd=1.1 as=0.0441 ps=0.63 w=0.42 l=0.15
X4428 a_38543_35095# a_37029_37583# VDPWR VDPWR sky130_fd_pr__pfet_01v8_hvt ad=0.0567 pd=0.69 as=0.16655 ps=1.39 w=0.42 l=0.15
X4429 a_38895_38493# a_38089_40623# a_38532_38359# uio_oe[0] sky130_fd_pr__nfet_01v8 ad=0.0693 pd=0.75 as=0.09975 ps=0.895 w=0.42 l=0.15
X4430 a_8459_24172# uio_oe[0] uio_oe[0] sky130_fd_pr__res_xhigh_po_1p41 l=5.88
X4431 a_53719_37583# a_53369_37583# a_53624_37583# VDPWR sky130_fd_pr__pfet_01v8_hvt ad=0.07245 pd=0.765 as=0.0651 ps=0.73 w=0.42 l=0.15
X4432 a_42425_35657# a_37661_37052# VDPWR VDPWR sky130_fd_pr__pfet_01v8_hvt ad=0.135 pd=1.27 as=0.135 ps=1.27 w=1 l=0.15
X4433 a_26529_34817# a_26259_35183# a_26439_35183# uio_oe[0] sky130_fd_pr__nfet_01v8 ad=0.0504 pd=0.66 as=0.1092 ps=1.36 w=0.42 l=0.15
X4434 a_38674_37583# a_37029_37583# uio_oe[0] uio_oe[0] sky130_fd_pr__nfet_01v8 ad=0.0693 pd=0.75 as=0.11285 ps=1.045 w=0.42 l=0.15
X4435 VDPWR a_45176_41935# a_45351_41909# VDPWR sky130_fd_pr__pfet_01v8_hvt ad=0.1134 pd=1.38 as=0.0567 ps=0.69 w=0.42 l=0.15
X4436 uio_oe[0] a_48125_43023# a_49721_38671# uio_oe[0] sky130_fd_pr__nfet_01v8 ad=0.12495 pd=1.015 as=0.06405 ps=0.725 w=0.42 l=0.15
X4437 a_57081_41935# a_57046_42187# a_56843_41909# uio_oe[0] sky130_fd_pr__nfet_01v8 ad=0.06405 pd=0.725 as=0.1092 ps=1.36 w=0.42 l=0.15
X4438 uio_oe[0] a_16812_8642# a_24482_24730# uio_oe[0] sky130_fd_pr__nfet_01v8 ad=1.4703 pd=10.72 as=1.4703 ps=10.72 w=5.07 l=1
X4439 a_44537_39215# a_36425_35381# VDPWR VDPWR sky130_fd_pr__pfet_01v8_hvt ad=0.135 pd=1.27 as=0.135 ps=1.27 w=1 l=0.15
X4440 a_42149_37039# a_41671_37343# VDPWR VDPWR sky130_fd_pr__pfet_01v8_hvt ad=0.26 pd=2.52 as=0.3012 ps=2.66 w=1 l=0.15
X4441 a_36457_36745# a_36427_36475# VDPWR VDPWR sky130_fd_pr__pfet_01v8_hvt ad=0.0441 pd=0.63 as=0.14825 ps=1.34 w=0.42 l=0.15
X4442 a_29946_34639# a_28980_34505# uio_oe[0] uio_oe[0] sky130_fd_pr__nfet_01v8 ad=0.0693 pd=0.75 as=0.11285 ps=1.045 w=0.42 l=0.15
X4443 a_51412_35095# a_38771_34879# a_51554_34902# VDPWR sky130_fd_pr__pfet_01v8_hvt ad=0.1932 pd=1.34 as=0.07665 ps=0.785 w=0.42 l=0.15
X4444 uio_oe[0] a_52335_41365# a_51620_41659# uio_oe[0] sky130_fd_pr__nfet_01v8 ad=0.2087 pd=2.02 as=0.169 ps=1.82 w=0.65 l=0.15
X4445 a_52507_34646# a_52325_34646# VDPWR VDPWR sky130_fd_pr__pfet_01v8_hvt ad=0.0441 pd=0.63 as=0.0693 ps=0.75 w=0.42 l=0.15
X4446 VDPWR a_17721_34571# a_17751_34312# VDPWR sky130_fd_pr__pfet_01v8_hvt ad=0.0693 pd=0.75 as=0.0441 ps=0.63 w=0.42 l=0.15
X4447 a_51412_39911# a_39752_39733# a_51554_40086# VDPWR sky130_fd_pr__pfet_01v8_hvt ad=0.1932 pd=1.34 as=0.07665 ps=0.785 w=0.42 l=0.15
X4448 a_28884_34505# a_17507_33198# a_29026_34312# VDPWR sky130_fd_pr__pfet_01v8_hvt ad=0.1932 pd=1.34 as=0.07665 ps=0.785 w=0.42 l=0.15
X4449 a_44261_42485# a_44095_42485# VDPWR VDPWR sky130_fd_pr__pfet_01v8_hvt ad=0.1664 pd=1.8 as=0.0864 ps=0.91 w=0.64 l=0.15
X4450 a_50159_36732# a_49964_36763# a_50469_36495# uio_oe[0] sky130_fd_pr__special_nfet_01v8 ad=0.0594 pd=0.69 as=0.1401 ps=1.1 w=0.36 l=0.15
X4451 VDPWR a_16812_8642# uio_oe[0] sky130_fd_pr__res_high_po_1p41 l=44.98
X4452 uio_oe[0] a_47283_40821# a_47217_40847# uio_oe[0] sky130_fd_pr__nfet_01v8 ad=0.12495 pd=1.015 as=0.0669 ps=0.75 w=0.42 l=0.15
X4453 uio_oe[0] a_58772_36647# a_58144_36744# uio_oe[0] sky130_fd_pr__nfet_01v8 ad=0.11285 pd=1.045 as=0.169 ps=1.82 w=0.65 l=0.15
X4454 a_17689_32641# a_17423_33007# VDPWR VDPWR sky130_fd_pr__pfet_01v8_hvt ad=0.26 pd=2.52 as=0.2279 ps=1.74 w=1 l=0.15
X4455 a_21298_34639# a_21252_34505# uio_oe[0] uio_oe[0] sky130_fd_pr__nfet_01v8 ad=0.0693 pd=0.75 as=0.11285 ps=1.045 w=0.42 l=0.15
X4456 a_61998_35407# a_46193_39759# uio_oe[0] uio_oe[0] sky130_fd_pr__nfet_01v8 ad=0.06405 pd=0.725 as=0.12495 ps=1.015 w=0.42 l=0.15
X4457 a_39973_39733# a_38005_40847# uio_oe[0] uio_oe[0] sky130_fd_pr__nfet_01v8 ad=0.1092 pd=1.36 as=0.1449 ps=1.11 w=0.42 l=0.15
X4458 a_41697_37583# a_40507_37583# a_41588_37583# uio_oe[0] sky130_fd_pr__special_nfet_01v8 ad=0.0669 pd=0.75 as=0.0711 ps=0.755 w=0.36 l=0.15
X4459 a_61297_36737# a_61079_36495# uio_oe[0] uio_oe[0] sky130_fd_pr__nfet_01v8 ad=0.0999 pd=0.985 as=0.1346 ps=1.15 w=0.64 l=0.15
X4460 a_59939_42262# a_58980_41909# a_59867_42262# VDPWR sky130_fd_pr__pfet_01v8_hvt ad=0.1932 pd=1.34 as=0.0441 ps=0.63 w=0.42 l=0.15
X4461 a_18354_35727# a_17388_35593# uio_oe[0] uio_oe[0] sky130_fd_pr__nfet_01v8 ad=0.0693 pd=0.75 as=0.11285 ps=1.045 w=0.42 l=0.15
X4462 a_52800_40847# a_51620_40821# a_52579_41174# uio_oe[0] sky130_fd_pr__nfet_01v8 ad=0.0693 pd=0.75 as=0.09975 ps=0.895 w=0.42 l=0.15
X4463 a_37003_39996# a_36808_40027# a_37313_39759# uio_oe[0] sky130_fd_pr__special_nfet_01v8 ad=0.0594 pd=0.69 as=0.1401 ps=1.1 w=0.36 l=0.15
X4464 a_51841_37337# a_48677_38127# uio_oe[0] uio_oe[0] sky130_fd_pr__nfet_01v8 ad=0.1092 pd=1.36 as=0.1449 ps=1.11 w=0.42 l=0.15
X4465 a_44829_41089# a_44611_40847# uio_oe[0] uio_oe[0] sky130_fd_pr__nfet_01v8 ad=0.0999 pd=0.985 as=0.1346 ps=1.15 w=0.64 l=0.15
X4466 a_42971_40125# a_42347_39759# a_42863_39759# VDPWR sky130_fd_pr__pfet_01v8_hvt ad=0.1155 pd=0.97 as=0.07245 ps=0.765 w=0.42 l=0.15
X4467 a_57280_38127# a_56843_38101# VDPWR VDPWR sky130_fd_pr__pfet_01v8_hvt ad=0.0567 pd=0.69 as=0.0819 ps=0.81 w=0.42 l=0.15
X4468 uio_oe[0] a_57519_37820# a_57450_37949# uio_oe[0] sky130_fd_pr__nfet_01v8 ad=0.1346 pd=1.15 as=0.0999 ps=0.985 w=0.64 l=0.15
X4469 a_27562_10464# a_24484_10376# ua[4] uio_oe[0] sky130_fd_pr__nfet_01v8 ad=0.1885 pd=1.88 as=0.1885 ps=1.88 w=0.65 l=0.15
X4470 a_60365_37583# a_59939_37910# uio_oe[0] uio_oe[0] sky130_fd_pr__nfet_01v8 ad=0.169 pd=1.82 as=0.11285 ps=1.045 w=0.65 l=0.15
X4471 VDPWR a_21401_36967# a_21431_37320# VDPWR sky130_fd_pr__pfet_01v8_hvt ad=0.0693 pd=0.75 as=0.0441 ps=0.63 w=0.42 l=0.15
X4472 a_59956_34837# a_46193_39759# VDPWR VDPWR sky130_fd_pr__pfet_01v8_hvt ad=0.1092 pd=1.36 as=0.12285 ps=1.17 w=0.42 l=0.15
X4473 a_43629_38671# a_42439_38671# a_43520_38671# uio_oe[0] sky130_fd_pr__special_nfet_01v8 ad=0.0669 pd=0.75 as=0.0711 ps=0.755 w=0.36 l=0.15
X4474 VDPWR a_37913_41935# a_53203_37583# VDPWR sky130_fd_pr__pfet_01v8_hvt ad=0.0864 pd=0.91 as=0.1664 ps=1.8 w=0.64 l=0.15
X4475 a_40099_35381# a_40302_35659# VDPWR VDPWR sky130_fd_pr__pfet_01v8_hvt ad=0.0567 pd=0.69 as=0.1134 ps=1.38 w=0.42 l=0.15
X4476 a_53156_39215# a_52942_39215# VDPWR VDPWR sky130_fd_pr__pfet_01v8_hvt ad=0.1155 pd=0.97 as=0.07035 ps=0.755 w=0.42 l=0.15
X4477 VDPWR a_44339_37735# a_42613_37052# VDPWR sky130_fd_pr__pfet_01v8_hvt ad=0.16655 pd=1.39 as=0.475 ps=2.95 w=1 l=0.15
X4478 a_36545_37405# a_36275_37039# a_36455_37039# uio_oe[0] sky130_fd_pr__nfet_01v8 ad=0.0504 pd=0.66 as=0.1092 ps=1.36 w=0.42 l=0.15
X4479 a_53321_37405# a_52942_37039# a_53249_37405# uio_oe[0] sky130_fd_pr__nfet_01v8 ad=0.1401 pd=1.1 as=0.0441 ps=0.63 w=0.42 l=0.15
X4480 a_38285_36495# a_38019_36861# VDPWR VDPWR sky130_fd_pr__pfet_01v8_hvt ad=0.26 pd=2.52 as=0.2279 ps=1.74 w=1 l=0.15
X4481 a_59939_37910# a_51620_37557# a_59939_37583# uio_oe[0] sky130_fd_pr__nfet_01v8 ad=0.09975 pd=0.895 as=0.0693 ps=0.75 w=0.42 l=0.15
X4482 a_62237_37337# a_37361_41391# VDPWR VDPWR sky130_fd_pr__pfet_01v8_hvt ad=0.1176 pd=1.4 as=0.0693 ps=0.75 w=0.42 l=0.15
X4483 a_27562_10464# ua[1] a_27316_10020# uio_oe[0] sky130_fd_pr__nfet_01v8 ad=0.2436 pd=2.26 as=0.2436 ps=2.26 w=0.84 l=0.6
X4484 a_58980_38645# a_61819_38645# uio_oe[0] uio_oe[0] sky130_fd_pr__nfet_01v8 ad=0.169 pd=1.82 as=0.2087 ps=2.02 w=0.65 l=0.15
X4485 uio_oe[0] a_36661_41391# a_52325_40086# uio_oe[0] sky130_fd_pr__nfet_01v8 ad=0.1449 pd=1.11 as=0.1092 ps=1.36 w=0.42 l=0.15
X4486 a_58914_37910# a_48677_38127# VDPWR VDPWR sky130_fd_pr__pfet_01v8_hvt ad=0.07665 pd=0.785 as=0.15835 ps=1.395 w=0.42 l=0.15
X4487 uio_oe[0] a_16812_8642# a_25874_16730# uio_oe[0] sky130_fd_pr__nfet_01v8 ad=1.4703 pd=10.72 as=1.4703 ps=10.72 w=5.07 l=1
X4488 a_30123_34095# a_28651_33729# uio_oe[0] uio_oe[0] sky130_fd_pr__nfet_01v8 ad=0.1092 pd=1.36 as=0.1092 ps=1.36 w=0.42 l=0.15
X4489 VDPWR a_38532_37271# a_25116_34505# VDPWR sky130_fd_pr__pfet_01v8_hvt ad=0.15835 pd=1.395 as=0.26 ps=2.52 w=1 l=0.15
X4490 a_60802_37405# a_60584_37353# a_60720_37405# uio_oe[0] sky130_fd_pr__nfet_01v8 ad=0.0441 pd=0.63 as=0.1092 ps=1.36 w=0.42 l=0.15
X4491 VDPWR a_59201_38425# a_59231_38166# VDPWR sky130_fd_pr__pfet_01v8_hvt ad=0.0693 pd=0.75 as=0.0441 ps=0.63 w=0.42 l=0.15
X4492 uio_oe[0] a_61819_35381# a_61753_35407# uio_oe[0] sky130_fd_pr__nfet_01v8 ad=0.12495 pd=1.015 as=0.0669 ps=0.75 w=0.42 l=0.15
X4493 VDPWR a_51841_38425# a_51871_38166# VDPWR sky130_fd_pr__pfet_01v8_hvt ad=0.0693 pd=0.75 as=0.0441 ps=0.63 w=0.42 l=0.15
X4494 a_40931_37417# a_40581_37045# a_40836_37405# VDPWR sky130_fd_pr__pfet_01v8_hvt ad=0.07245 pd=0.765 as=0.0651 ps=0.73 w=0.42 l=0.15
X4495 a_39544_40535# a_39752_40571# a_39686_40669# uio_oe[0] sky130_fd_pr__nfet_01v8 ad=0.09975 pd=0.895 as=0.0693 ps=0.75 w=0.42 l=0.15
X4496 uio_oe[0] a_29313_36747# a_29247_36815# uio_oe[0] sky130_fd_pr__nfet_01v8 ad=0.1449 pd=1.11 as=0.0693 ps=0.75 w=0.42 l=0.15
X4497 a_59201_42777# a_48677_39759# uio_oe[0] uio_oe[0] sky130_fd_pr__nfet_01v8 ad=0.1092 pd=1.36 as=0.1449 ps=1.11 w=0.42 l=0.15
X4498 a_60153_38998# a_51620_38645# a_59939_38998# VDPWR sky130_fd_pr__pfet_01v8_hvt ad=0.07665 pd=0.785 as=0.1932 ps=1.34 w=0.42 l=0.15
X4499 a_43385_38493# a_43006_38127# a_43313_38493# uio_oe[0] sky130_fd_pr__nfet_01v8 ad=0.1401 pd=1.1 as=0.0441 ps=0.63 w=0.42 l=0.15
X4500 VDPWR a_57519_38101# a_57450_38127# VDPWR sky130_fd_pr__pfet_01v8_hvt ad=0.2184 pd=2.2 as=0.12915 ps=1.185 w=0.84 l=0.15
X4501 a_27562_22464# a_24484_14376# ua[5] uio_oe[0] sky130_fd_pr__nfet_01v8 ad=0.1885 pd=1.88 as=0.1885 ps=1.88 w=0.65 l=0.15
X4502 a_25924_10020# a_16812_8642# uio_oe[0] uio_oe[0] sky130_fd_pr__nfet_01v8 ad=1.4703 pd=10.72 as=1.4703 ps=10.72 w=5.07 l=1
X4503 a_60934_40303# a_60215_40545# a_60371_40277# uio_oe[0] sky130_fd_pr__special_nfet_01v8 ad=0.066 pd=0.745 as=0.0594 ps=0.69 w=0.36 l=0.15
X4504 a_50722_40125# a_49964_40027# a_50159_39996# VDPWR sky130_fd_pr__pfet_01v8_hvt ad=0.0651 pd=0.73 as=0.07245 ps=0.765 w=0.42 l=0.15
X4505 a_61766_38166# a_37361_41391# VDPWR VDPWR sky130_fd_pr__pfet_01v8_hvt ad=0.07665 pd=0.785 as=0.15835 ps=1.395 w=0.42 l=0.15
X4506 a_53719_36495# a_53369_36495# a_53624_36495# VDPWR sky130_fd_pr__pfet_01v8_hvt ad=0.07245 pd=0.765 as=0.0651 ps=0.73 w=0.42 l=0.15
X4507 a_53011_41365# a_52816_41507# a_53321_41757# uio_oe[0] sky130_fd_pr__special_nfet_01v8 ad=0.0594 pd=0.69 as=0.1401 ps=1.1 w=0.36 l=0.15
X4508 VDPWR a_49483_39733# a_39752_39733# VDPWR sky130_fd_pr__pfet_01v8_hvt ad=0.3012 pd=2.66 as=0.26 ps=2.52 w=1 l=0.15
X4509 uio_oe[0] a_50003_39457# a_49964_39331# uio_oe[0] sky130_fd_pr__nfet_01v8 ad=0.0567 pd=0.69 as=0.1092 ps=1.36 w=0.42 l=0.15
X4510 a_57757_40847# a_48125_43023# uio_oe[0] uio_oe[0] sky130_fd_pr__nfet_01v8 ad=0.0441 pd=0.63 as=0.1346 ps=1.15 w=0.42 l=0.15
X4511 a_50722_39215# a_50003_39457# a_50159_39189# uio_oe[0] sky130_fd_pr__special_nfet_01v8 ad=0.066 pd=0.745 as=0.0594 ps=0.69 w=0.36 l=0.15
X4512 a_51620_36469# a_54459_36469# uio_oe[0] uio_oe[0] sky130_fd_pr__nfet_01v8 ad=0.169 pd=1.82 as=0.2087 ps=2.02 w=0.65 l=0.15
X4513 a_37452_34293# a_38019_35773# uio_oe[0] uio_oe[0] sky130_fd_pr__nfet_01v8 ad=0.169 pd=1.82 as=0.1013 ps=0.99 w=0.65 l=0.15
X4514 a_40904_39215# a_40467_39189# VDPWR VDPWR sky130_fd_pr__pfet_01v8_hvt ad=0.0567 pd=0.69 as=0.0819 ps=0.81 w=0.42 l=0.15
X4515 a_49961_38493# a_49483_38101# uio_oe[0] uio_oe[0] sky130_fd_pr__nfet_01v8 ad=0.0669 pd=0.75 as=0.12495 ps=1.015 w=0.42 l=0.15
X4516 VDPWR a_25449_35659# a_25479_35400# VDPWR sky130_fd_pr__pfet_01v8_hvt ad=0.0693 pd=0.75 as=0.0441 ps=0.63 w=0.42 l=0.15
X4517 a_29946_33551# a_28980_33417# uio_oe[0] uio_oe[0] sky130_fd_pr__nfet_01v8 ad=0.0693 pd=0.75 as=0.11285 ps=1.045 w=0.42 l=0.15
X4518 a_46448_41757# a_46331_41562# uio_oe[0] uio_oe[0] sky130_fd_pr__nfet_01v8 ad=0.066 pd=0.745 as=0.2205 ps=1.89 w=0.42 l=0.15
X4519 a_50003_41633# a_38649_43023# uio_oe[0] uio_oe[0] sky130_fd_pr__nfet_01v8 ad=0.1092 pd=1.36 as=0.0567 ps=0.69 w=0.42 l=0.15
X4520 a_51554_35229# a_48677_38127# uio_oe[0] uio_oe[0] sky130_fd_pr__nfet_01v8 ad=0.0693 pd=0.75 as=0.11285 ps=1.045 w=0.42 l=0.15
X4521 a_54284_41935# a_53369_41935# a_53937_42177# uio_oe[0] sky130_fd_pr__special_nfet_01v8 ad=0.0711 pd=0.755 as=0.0999 ps=0.985 w=0.36 l=0.15
X4522 a_51412_40535# a_51620_40571# a_51554_40669# uio_oe[0] sky130_fd_pr__nfet_01v8 ad=0.09975 pd=0.895 as=0.0693 ps=0.75 w=0.42 l=0.15
X4523 uio_oe[0] a_53011_39189# a_52942_39215# uio_oe[0] sky130_fd_pr__nfet_01v8 ad=0.1346 pd=1.15 as=0.0999 ps=0.985 w=0.64 l=0.15
X4524 VDPWR a_36999_37013# a_37029_37039# VDPWR sky130_fd_pr__pfet_01v8_hvt ad=0.135 pd=1.27 as=0.135 ps=1.27 w=1 l=0.15
X4525 a_40836_37405# a_36956_35095# uio_oe[0] uio_oe[0] sky130_fd_pr__nfet_01v8 ad=0.066 pd=0.745 as=0.2205 ps=1.89 w=0.42 l=0.15
X4526 VDPWR a_52335_38101# a_51620_38395# VDPWR sky130_fd_pr__pfet_01v8_hvt ad=0.3012 pd=2.66 as=0.26 ps=2.52 w=1 l=0.15
X4527 a_38543_34471# a_38651_34471# VDPWR VDPWR sky130_fd_pr__pfet_01v8_hvt ad=0.0567 pd=0.69 as=0.16655 ps=1.39 w=0.42 l=0.15
X4528 a_49686_40011# a_50003_39901# a_49961_39759# uio_oe[0] sky130_fd_pr__special_nfet_01v8 ad=0.0711 pd=0.755 as=0.0669 ps=0.75 w=0.36 l=0.15
X4529 a_17751_33224# a_17500_33453# a_17292_33417# VDPWR sky130_fd_pr__pfet_01v8_hvt ad=0.0441 pd=0.63 as=0.1932 ps=1.34 w=0.42 l=0.15
X4530 VDPWR a_39544_40999# a_17204_33881# VDPWR sky130_fd_pr__pfet_01v8_hvt ad=0.15835 pd=1.395 as=0.26 ps=2.52 w=1 l=0.15
X4531 a_40950_39037# a_40415_38671# a_40864_38671# VDPWR sky130_fd_pr__pfet_01v8_hvt ad=0.0945 pd=0.87 as=0.0567 ps=0.69 w=0.42 l=0.15
X4532 a_25874_20730# ua[1] a_25746_22020# uio_oe[0] sky130_fd_pr__nfet_01v8 ad=0.2436 pd=2.26 as=0.2436 ps=2.26 w=0.84 l=0.6
X4533 a_21298_33551# a_21252_33417# uio_oe[0] uio_oe[0] sky130_fd_pr__nfet_01v8 ad=0.0693 pd=0.75 as=0.11285 ps=1.045 w=0.42 l=0.15
X4534 a_57450_35773# a_57324_35675# a_57046_35659# uio_oe[0] sky130_fd_pr__special_nfet_01v8 ad=0.0999 pd=0.985 as=0.0711 ps=0.755 w=0.36 l=0.15
X4535 VDPWR a_48125_41935# a_53156_40303# VDPWR sky130_fd_pr__pfet_01v8_hvt ad=0.07035 pd=0.755 as=0.1092 ps=1.36 w=0.42 l=0.15
X4536 uio_oe[0] a_57472_39493# a_57556_39189# uio_oe[0] sky130_fd_pr__nfet_01v8 ad=0.0567 pd=0.69 as=0.1092 ps=1.36 w=0.42 l=0.15
X4537 a_39973_38645# a_38005_40847# uio_oe[0] uio_oe[0] sky130_fd_pr__nfet_01v8 ad=0.1092 pd=1.36 as=0.1449 ps=1.11 w=0.42 l=0.15
X4538 uio_oe[0] a_50784_42453# a_50722_42479# uio_oe[0] sky130_fd_pr__nfet_01v8 ad=0.2205 pd=1.89 as=0.066 ps=0.745 w=0.42 l=0.15
X4539 a_47462_40669# a_39947_42997# uio_oe[0] uio_oe[0] sky130_fd_pr__nfet_01v8 ad=0.06405 pd=0.725 as=0.12495 ps=1.015 w=0.42 l=0.15
X4540 a_40562_43023# a_39947_42997# uio_oe[0] uio_oe[0] sky130_fd_pr__nfet_01v8 ad=0.06405 pd=0.725 as=0.12495 ps=1.015 w=0.42 l=0.15
X4541 VDPWR a_54264_39447# a_53636_39189# VDPWR sky130_fd_pr__pfet_01v8_hvt ad=0.15835 pd=1.395 as=0.26 ps=2.52 w=1 l=0.15
X4542 a_29603_37021# a_28651_36993# VDPWR VDPWR sky130_fd_pr__pfet_01v8_hvt ad=0.0567 pd=0.69 as=0.1176 ps=1.4 w=0.42 l=0.15
X4543 a_52793_37910# a_51620_38395# a_52579_37910# VDPWR sky130_fd_pr__pfet_01v8_hvt ad=0.07665 pd=0.785 as=0.1932 ps=1.34 w=0.42 l=0.15
X4544 uio_oe[0] a_58144_37832# a_58082_37949# uio_oe[0] sky130_fd_pr__nfet_01v8 ad=0.2205 pd=1.89 as=0.066 ps=0.745 w=0.42 l=0.15
X4545 a_31180_18020# a_16812_8642# uio_oe[0] uio_oe[0] sky130_fd_pr__nfet_01v8 ad=1.4703 pd=10.72 as=1.4703 ps=10.72 w=5.07 l=1
X4546 uio_oe[0] a_46193_39759# a_53981_35407# uio_oe[0] sky130_fd_pr__nfet_01v8 ad=0.1346 pd=1.15 as=0.0441 ps=0.63 w=0.42 l=0.15
X4547 a_50159_38101# a_50003_38369# a_50304_38127# VDPWR sky130_fd_pr__pfet_01v8_hvt ad=0.07245 pd=0.765 as=0.1155 ps=0.97 w=0.42 l=0.15
X4548 a_58772_37735# a_38740_37557# a_58914_37910# VDPWR sky130_fd_pr__pfet_01v8_hvt ad=0.1932 pd=1.34 as=0.07665 ps=0.785 w=0.42 l=0.15
X4549 VDPWR a_37851_36647# a_43327_36647# VDPWR sky130_fd_pr__pfet_01v8_hvt ad=0.1176 pd=1.4 as=0.0567 ps=0.69 w=0.42 l=0.15
X4550 a_59867_36822# a_59685_36822# VDPWR VDPWR sky130_fd_pr__pfet_01v8_hvt ad=0.0441 pd=0.63 as=0.0693 ps=0.75 w=0.42 l=0.15
X4551 uio_oe[0] a_28884_33417# a_28835_33185# uio_oe[0] sky130_fd_pr__nfet_01v8 ad=0.11285 pd=1.045 as=0.169 ps=1.82 w=0.65 l=0.15
X4552 a_21114_36993# a_21068_37145# uio_oe[0] uio_oe[0] sky130_fd_pr__nfet_01v8 ad=0.0693 pd=0.75 as=0.11285 ps=1.045 w=0.42 l=0.15
X4553 a_43244_40681# a_42163_40309# a_42897_40277# VDPWR sky130_fd_pr__pfet_01v8_hvt ad=0.0588 pd=0.7 as=0.12915 ps=1.185 w=0.42 l=0.15
X4554 uio_oe[0] a_30233_36747# a_30167_36815# uio_oe[0] sky130_fd_pr__nfet_01v8 ad=0.1449 pd=1.11 as=0.0693 ps=0.75 w=0.42 l=0.15
X4555 uio_oe[0] a_17537_35879# a_17471_35905# uio_oe[0] sky130_fd_pr__nfet_01v8 ad=0.1449 pd=1.11 as=0.0693 ps=0.75 w=0.42 l=0.15
X4556 a_21431_36232# a_21180_35879# a_20972_36057# VDPWR sky130_fd_pr__pfet_01v8_hvt ad=0.0441 pd=0.63 as=0.1932 ps=1.34 w=0.42 l=0.15
X4557 a_49721_36317# a_49686_36083# a_49483_35925# uio_oe[0] sky130_fd_pr__nfet_01v8 ad=0.06405 pd=0.725 as=0.1092 ps=1.36 w=0.42 l=0.15
X4558 VDPWR a_51412_40999# a_50784_41096# VDPWR sky130_fd_pr__pfet_01v8_hvt ad=0.15835 pd=1.395 as=0.26 ps=2.52 w=1 l=0.15
X4559 a_58914_40669# a_48677_39759# uio_oe[0] uio_oe[0] sky130_fd_pr__nfet_01v8 ad=0.0693 pd=0.75 as=0.11285 ps=1.045 w=0.42 l=0.15
X4560 uio_oe[0] a_54693_37337# a_54627_37405# uio_oe[0] sky130_fd_pr__nfet_01v8 ad=0.1449 pd=1.11 as=0.0693 ps=0.75 w=0.42 l=0.15
X4561 a_41338_35951# a_40619_36193# a_40775_35925# uio_oe[0] sky130_fd_pr__special_nfet_01v8 ad=0.066 pd=0.745 as=0.0594 ps=0.69 w=0.36 l=0.15
X4562 VDPWR a_41016_41623# a_40967_41391# VDPWR sky130_fd_pr__pfet_01v8_hvt ad=0.15835 pd=1.395 as=0.26 ps=2.52 w=1 l=0.15
X4563 uio_oe[0] a_36661_41391# a_52325_38998# uio_oe[0] sky130_fd_pr__nfet_01v8 ad=0.1449 pd=1.11 as=0.1092 ps=1.36 w=0.42 l=0.15
X4564 VDPWR a_36661_41391# a_60153_38998# VDPWR sky130_fd_pr__pfet_01v8_hvt ad=0.15835 pd=1.395 as=0.07665 ps=0.785 w=0.42 l=0.15
X4565 a_23452_10020# a_16812_8642# uio_oe[0] uio_oe[0] sky130_fd_pr__nfet_01v8 ad=1.4703 pd=10.72 as=1.4703 ps=10.72 w=5.07 l=1
X4566 a_25199_34817# a_24971_34273# a_24836_34969# uio_oe[0] sky130_fd_pr__nfet_01v8 ad=0.0693 pd=0.75 as=0.09975 ps=0.895 w=0.42 l=0.15
X4567 a_49920_40125# a_49483_39733# VDPWR VDPWR sky130_fd_pr__pfet_01v8_hvt ad=0.0567 pd=0.69 as=0.0819 ps=0.81 w=0.42 l=0.15
X4568 uio_oe[0] a_36329_36469# a_17255_32793# uio_oe[0] sky130_fd_pr__nfet_01v8 ad=0.10187 pd=0.99 as=0.1755 ps=1.84 w=0.65 l=0.15
X4569 a_57363_38813# a_38649_43023# VDPWR VDPWR sky130_fd_pr__pfet_01v8_hvt ad=0.1664 pd=1.8 as=0.0864 ps=0.91 w=0.64 l=0.15
X4570 a_61624_38359# a_58980_38645# a_61766_38166# VDPWR sky130_fd_pr__pfet_01v8_hvt ad=0.1932 pd=1.34 as=0.07665 ps=0.785 w=0.42 l=0.15
X4571 a_52772_37039# a_52335_37013# VDPWR VDPWR sky130_fd_pr__pfet_01v8_hvt ad=0.0567 pd=0.69 as=0.0819 ps=0.81 w=0.42 l=0.15
X4572 VDPWR a_29129_35879# a_29159_36232# VDPWR sky130_fd_pr__pfet_01v8_hvt ad=0.0693 pd=0.75 as=0.0441 ps=0.63 w=0.42 l=0.15
X4573 a_59956_37013# a_60500_37013# a_60458_37039# VDPWR sky130_fd_pr__pfet_01v8_hvt ad=0.0819 pd=0.81 as=0.0441 ps=0.63 w=0.42 l=0.15
X4574 a_29946_34312# a_28980_34505# VDPWR VDPWR sky130_fd_pr__pfet_01v8_hvt ad=0.07665 pd=0.785 as=0.15835 ps=1.395 w=0.42 l=0.15
X4575 a_41496_37417# a_40415_37045# a_41149_37013# VDPWR sky130_fd_pr__pfet_01v8_hvt ad=0.0588 pd=0.7 as=0.12915 ps=1.185 w=0.42 l=0.15
X4576 VDPWR a_41309_34319# a_39759_39228# VDPWR sky130_fd_pr__pfet_01v8_hvt ad=0.26 pd=2.52 as=0.26 ps=2.52 w=1 l=0.15
X4577 a_59898_38259# a_60215_38369# a_60173_38493# uio_oe[0] sky130_fd_pr__special_nfet_01v8 ad=0.0711 pd=0.755 as=0.0669 ps=0.75 w=0.36 l=0.15
X4578 a_61950_34902# a_37361_41391# VDPWR VDPWR sky130_fd_pr__pfet_01v8_hvt ad=0.07665 pd=0.785 as=0.15835 ps=1.395 w=0.42 l=0.15
X4579 a_58248_34863# a_57472_35141# a_57640_35177# uio_oe[0] sky130_fd_pr__special_nfet_01v8 ad=0.0935 pd=0.965 as=0.072 ps=0.76 w=0.36 l=0.15
X4580 uio_oe[0] a_54459_40821# a_54393_40847# uio_oe[0] sky130_fd_pr__nfet_01v8 ad=0.12495 pd=1.015 as=0.0669 ps=0.75 w=0.42 l=0.15
X4581 a_42895_34863# a_42715_34863# VDPWR VDPWR sky130_fd_pr__pfet_01v8_hvt ad=0.0609 pd=0.71 as=0.0714 ps=0.76 w=0.42 l=0.15
X4582 a_40811_37796# a_41171_40342# uio_oe[0] uio_oe[0] sky130_fd_pr__nfet_01v8 ad=0.169 pd=1.82 as=0.11285 ps=1.045 w=0.65 l=0.15
X4583 a_52813_39581# a_52335_39189# uio_oe[0] uio_oe[0] sky130_fd_pr__nfet_01v8 ad=0.0669 pd=0.75 as=0.12495 ps=1.015 w=0.42 l=0.15
X4584 a_53011_40277# a_52816_40419# a_53321_40669# uio_oe[0] sky130_fd_pr__special_nfet_01v8 ad=0.0594 pd=0.69 as=0.1401 ps=1.1 w=0.36 l=0.15
X4585 VDPWR a_30233_36747# a_30263_36488# VDPWR sky130_fd_pr__pfet_01v8_hvt ad=0.0693 pd=0.75 as=0.0441 ps=0.63 w=0.42 l=0.15
X4586 a_21298_34312# a_21252_34505# VDPWR VDPWR sky130_fd_pr__pfet_01v8_hvt ad=0.07665 pd=0.785 as=0.15835 ps=1.395 w=0.42 l=0.15
X4587 a_42941_42845# a_42897_42453# a_42775_42857# uio_oe[0] sky130_fd_pr__nfet_01v8 ad=0.0441 pd=0.63 as=0.1401 ps=1.1 w=0.42 l=0.15
X4588 VDPWR a_40464_40999# a_39759_42492# VDPWR sky130_fd_pr__pfet_01v8_hvt ad=0.15835 pd=1.395 as=0.26 ps=2.52 w=1 l=0.15
X4589 a_60729_38671# a_60563_38671# VDPWR VDPWR sky130_fd_pr__pfet_01v8_hvt ad=0.1664 pd=1.8 as=0.0864 ps=0.91 w=0.64 l=0.15
X4590 a_49483_38101# a_49686_38259# VDPWR VDPWR sky130_fd_pr__pfet_01v8_hvt ad=0.0567 pd=0.69 as=0.1134 ps=1.38 w=0.42 l=0.15
X4591 uio_oe[0] a_41059_34863# a_41338_35951# uio_oe[0] sky130_fd_pr__nfet_01v8 ad=0.2205 pd=1.89 as=0.066 ps=0.745 w=0.42 l=0.15
X4592 VDPWR a_17255_32793# a_21107_33007# VDPWR sky130_fd_pr__pfet_01v8_hvt ad=0.0714 pd=0.76 as=0.1092 ps=1.36 w=0.42 l=0.15
X4593 a_21585_33483# a_21252_33417# VDPWR VDPWR sky130_fd_pr__pfet_01v8_hvt ad=0.1176 pd=1.4 as=0.0693 ps=0.75 w=0.42 l=0.15
X4594 VDPWR a_54693_37337# a_54723_37078# VDPWR sky130_fd_pr__pfet_01v8_hvt ad=0.0693 pd=0.75 as=0.0441 ps=0.63 w=0.42 l=0.15
X4595 a_18354_35400# a_17388_35593# VDPWR VDPWR sky130_fd_pr__pfet_01v8_hvt ad=0.07665 pd=0.785 as=0.15835 ps=1.395 w=0.42 l=0.15
X4596 ua[4] a_20620_10782# a_21882_14020# uio_oe[0] sky130_fd_pr__nfet_01v8 ad=0.1885 pd=1.88 as=0.1885 ps=1.88 w=0.65 l=0.15
X4597 a_57430_39581# a_57148_39215# a_57354_39581# uio_oe[0] sky130_fd_pr__nfet_01v8 ad=0.0441 pd=0.63 as=0.0483 ps=0.65 w=0.42 l=0.15
X4598 uio_oe[0] a_39544_38359# a_24932_37145# uio_oe[0] sky130_fd_pr__nfet_01v8 ad=0.11285 pd=1.045 as=0.169 ps=1.82 w=0.65 l=0.15
X4599 uio_oe[0] uio_oe[0] uio_oe[0] uio_oe[0] sky130_fd_pr__nfet_01v8 ad=0.1885 pd=1.88 as=0 ps=0 w=0.65 l=0.15
X4600 uio_oe[0] a_37795_40535# a_38109_36495# uio_oe[0] sky130_fd_pr__nfet_01v8 ad=0.1013 pd=0.99 as=0.0504 ps=0.66 w=0.42 l=0.15
X4601 a_16754_20730# ua[3] a_16626_22020# uio_oe[0] sky130_fd_pr__nfet_01v8 ad=0.2436 pd=2.26 as=0.2436 ps=2.26 w=0.84 l=0.6
X4602 VDPWR a_29281_32641# a_30303_35183# VDPWR sky130_fd_pr__pfet_01v8_hvt ad=0.2279 pd=1.74 as=0.0609 ps=0.71 w=0.42 l=0.15
X4603 a_41338_35773# a_40580_35675# a_40775_35644# VDPWR sky130_fd_pr__pfet_01v8_hvt ad=0.0651 pd=0.73 as=0.07245 ps=0.765 w=0.42 l=0.15
X4604 VDPWR a_26369_33483# a_26399_33224# VDPWR sky130_fd_pr__pfet_01v8_hvt ad=0.0693 pd=0.75 as=0.0441 ps=0.63 w=0.42 l=0.15
X4605 a_59293_41689# a_48677_39759# uio_oe[0] uio_oe[0] sky130_fd_pr__nfet_01v8 ad=0.1092 pd=1.36 as=0.1449 ps=1.11 w=0.42 l=0.15
X4606 VDPWR a_43244_40681# a_43419_40607# VDPWR sky130_fd_pr__pfet_01v8_hvt ad=0.1134 pd=1.38 as=0.0567 ps=0.69 w=0.42 l=0.15
X4607 a_40003_37910# a_39752_37557# a_39544_37735# VDPWR sky130_fd_pr__pfet_01v8_hvt ad=0.0441 pd=0.63 as=0.1932 ps=1.34 w=0.42 l=0.15
X4608 VDPWR a_37361_41391# a_52793_37910# VDPWR sky130_fd_pr__pfet_01v8_hvt ad=0.15835 pd=1.395 as=0.07665 ps=0.785 w=0.42 l=0.15
X4609 a_28348_10782# a_30303_37359# VDPWR VDPWR sky130_fd_pr__pfet_01v8_hvt ad=0.26 pd=2.52 as=0.2279 ps=1.74 w=1 l=0.15
X4610 a_49686_38923# a_50003_38813# a_49961_38671# uio_oe[0] sky130_fd_pr__special_nfet_01v8 ad=0.0711 pd=0.755 as=0.0669 ps=0.75 w=0.36 l=0.15
X4611 a_41039_36861# a_40379_35551# VDPWR VDPWR sky130_fd_pr__pfet_01v8_hvt ad=0.1092 pd=1.36 as=0.07035 ps=0.755 w=0.42 l=0.15
X4612 VDPWR a_41519_42479# a_41685_42479# VDPWR sky130_fd_pr__pfet_01v8_hvt ad=0.26 pd=2.52 as=0.135 ps=1.27 w=1 l=0.15
X4613 uio_oe[0] a_58298_41621# a_58248_41391# uio_oe[0] sky130_fd_pr__nfet_01v8 ad=0.1664 pd=1.8 as=0.0935 ps=0.965 w=0.64 l=0.15
X4614 uio_oe[0] a_44287_38127# a_44621_38447# uio_oe[0] sky130_fd_pr__nfet_01v8 ad=0.208 pd=1.94 as=0.25025 ps=1.42 w=0.65 l=0.15
X4615 VDPWR a_57363_39901# a_57324_40027# VDPWR sky130_fd_pr__pfet_01v8_hvt ad=0.0864 pd=0.91 as=0.1664 ps=1.8 w=0.64 l=0.15
X4616 a_38895_37583# a_37851_36647# a_38532_37735# uio_oe[0] sky130_fd_pr__nfet_01v8 ad=0.0693 pd=0.75 as=0.09975 ps=0.895 w=0.42 l=0.15
X4617 a_21401_35879# a_21068_36057# uio_oe[0] uio_oe[0] sky130_fd_pr__nfet_01v8 ad=0.1092 pd=1.36 as=0.1449 ps=1.11 w=0.42 l=0.15
X4618 uio_oe[0] uio_oe[0] uio_oe[0] uio_oe[0] sky130_fd_pr__nfet_01v8 ad=0.1885 pd=1.88 as=0 ps=0 w=0.65 l=0.15
X4619 a_18146_24730# ua[3] a_18018_26020# uio_oe[0] sky130_fd_pr__nfet_01v8 ad=0.2436 pd=2.26 as=0.2436 ps=2.26 w=0.84 l=0.6
X4620 VDPWR a_53636_42453# a_53574_42479# VDPWR sky130_fd_pr__pfet_01v8_hvt ad=0.1092 pd=1.36 as=0.0651 ps=0.73 w=0.42 l=0.15
X4621 a_46543_41935# a_46193_41935# a_46448_41935# VDPWR sky130_fd_pr__pfet_01v8_hvt ad=0.07245 pd=0.765 as=0.0651 ps=0.73 w=0.42 l=0.15
X4622 uio_oe[0] a_50003_39901# a_49964_40027# uio_oe[0] sky130_fd_pr__nfet_01v8 ad=0.0567 pd=0.69 as=0.1092 ps=1.36 w=0.42 l=0.15
X4623 uio_oe[0] a_48125_41935# a_52573_39581# uio_oe[0] sky130_fd_pr__nfet_01v8 ad=0.12495 pd=1.015 as=0.06405 ps=0.725 w=0.42 l=0.15
X4624 uio_oe[0] a_51412_38359# a_50784_38101# uio_oe[0] sky130_fd_pr__nfet_01v8 ad=0.11285 pd=1.045 as=0.169 ps=1.82 w=0.65 l=0.15
X4625 ua[5] a_20620_14376# a_20490_14020# uio_oe[0] sky130_fd_pr__nfet_01v8 ad=0.1885 pd=1.88 as=0.1885 ps=1.88 w=0.65 l=0.15
X4626 a_54446_39037# a_53369_38671# a_54284_38671# VDPWR sky130_fd_pr__pfet_01v8_hvt ad=0.0567 pd=0.69 as=0.0588 ps=0.7 w=0.42 l=0.15
X4627 a_59898_40435# a_60176_40419# a_60132_40303# VDPWR sky130_fd_pr__pfet_01v8_hvt ad=0.0588 pd=0.7 as=0.0567 ps=0.69 w=0.42 l=0.15
X4628 VDPWR a_44739_38671# a_44905_38671# VDPWR sky130_fd_pr__pfet_01v8_hvt ad=0.135 pd=1.27 as=0.135 ps=1.27 w=1 l=0.15
X4629 a_36385_38127# a_36355_38101# VDPWR VDPWR sky130_fd_pr__pfet_01v8_hvt ad=0.135 pd=1.27 as=0.26 ps=2.52 w=1 l=0.15
X4630 uio_oe[0] a_38532_37735# a_25116_35593# uio_oe[0] sky130_fd_pr__nfet_01v8 ad=0.11285 pd=1.045 as=0.169 ps=1.82 w=0.65 l=0.15
X4631 VDPWR a_41496_37417# a_41671_37343# VDPWR sky130_fd_pr__pfet_01v8_hvt ad=0.1134 pd=1.38 as=0.0567 ps=0.69 w=0.42 l=0.15
X4632 a_59231_42262# a_58980_41909# a_58772_42087# VDPWR sky130_fd_pr__pfet_01v8_hvt ad=0.0441 pd=0.63 as=0.1932 ps=1.34 w=0.42 l=0.15
X4633 a_26399_36488# a_18420_33453# a_25940_36681# VDPWR sky130_fd_pr__pfet_01v8_hvt ad=0.0441 pd=0.63 as=0.1932 ps=1.34 w=0.42 l=0.15
X4634 ua[5] a_20620_10782# a_21882_26020# uio_oe[0] sky130_fd_pr__nfet_01v8 ad=0.1885 pd=1.88 as=0.1885 ps=1.88 w=0.65 l=0.15
X4635 a_51871_37910# a_51620_37557# a_51412_37735# VDPWR sky130_fd_pr__pfet_01v8_hvt ad=0.0441 pd=0.63 as=0.1932 ps=1.34 w=0.42 l=0.15
X4636 a_51841_36469# a_48677_38127# VDPWR VDPWR sky130_fd_pr__pfet_01v8_hvt ad=0.1176 pd=1.4 as=0.0693 ps=0.75 w=0.42 l=0.15
X4637 a_42685_36611# a_43603_39519# VDPWR VDPWR sky130_fd_pr__pfet_01v8_hvt ad=0.26 pd=2.52 as=0.3012 ps=2.66 w=1 l=0.15
X4638 a_37029_37039# a_36999_37013# VDPWR VDPWR sky130_fd_pr__pfet_01v8_hvt ad=0.135 pd=1.27 as=0.26 ps=2.52 w=1 l=0.15
X4639 a_25940_36681# a_18420_33453# a_26082_36815# uio_oe[0] sky130_fd_pr__nfet_01v8 ad=0.09975 pd=0.895 as=0.0693 ps=0.75 w=0.42 l=0.15
X4640 a_20972_33881# a_21180_33703# a_21114_33729# uio_oe[0] sky130_fd_pr__nfet_01v8 ad=0.09975 pd=0.895 as=0.0693 ps=0.75 w=0.42 l=0.15
X4641 a_61819_38645# a_48125_41935# VDPWR VDPWR sky130_fd_pr__pfet_01v8_hvt ad=0.0567 pd=0.69 as=0.0819 ps=0.81 w=0.42 l=0.15
X4642 a_38109_36495# a_37839_36861# a_38019_36861# uio_oe[0] sky130_fd_pr__nfet_01v8 ad=0.0504 pd=0.66 as=0.1092 ps=1.36 w=0.42 l=0.15
X4643 a_21519_34639# a_17507_33198# a_21156_34505# uio_oe[0] sky130_fd_pr__nfet_01v8 ad=0.0693 pd=0.75 as=0.09975 ps=0.895 w=0.42 l=0.15
X4644 VDPWR a_37913_43023# a_60563_39759# VDPWR sky130_fd_pr__pfet_01v8_hvt ad=0.0864 pd=0.91 as=0.1664 ps=1.8 w=0.64 l=0.15
X4645 ua[4] a_16756_10376# a_16626_26020# uio_oe[0] sky130_fd_pr__nfet_01v8 ad=0.1885 pd=1.88 as=0.1885 ps=1.88 w=0.65 l=0.15
X4646 a_61079_35407# a_60563_35407# a_60984_35407# uio_oe[0] sky130_fd_pr__special_nfet_01v8 ad=0.0594 pd=0.69 as=0.066 ps=0.745 w=0.36 l=0.15
X4647 a_61341_41935# a_61297_42177# a_61175_41935# uio_oe[0] sky130_fd_pr__nfet_01v8 ad=0.0441 pd=0.63 as=0.1401 ps=1.1 w=0.42 l=0.15
X4648 a_18575_35727# a_18427_33198# a_18212_35593# uio_oe[0] sky130_fd_pr__nfet_01v8 ad=0.0693 pd=0.75 as=0.09975 ps=0.895 w=0.42 l=0.15
X4649 a_25265_33703# a_24932_33881# VDPWR VDPWR sky130_fd_pr__pfet_01v8_hvt ad=0.1176 pd=1.4 as=0.0693 ps=0.75 w=0.42 l=0.15
X4650 a_61175_40847# a_60729_40847# a_61079_40847# uio_oe[0] sky130_fd_pr__special_nfet_01v8 ad=0.1401 pd=1.1 as=0.0594 ps=0.69 w=0.36 l=0.15
X4651 VDPWR a_46027_39759# a_46193_39759# VDPWR sky130_fd_pr__pfet_01v8_hvt ad=0.135 pd=1.27 as=0.135 ps=1.27 w=1 l=0.15
X4652 VDPWR a_39973_37337# a_40003_37078# VDPWR sky130_fd_pr__pfet_01v8_hvt ad=0.0693 pd=0.75 as=0.0441 ps=0.63 w=0.42 l=0.15
X4653 uio_oe[0] a_56843_42453# a_39752_42747# uio_oe[0] sky130_fd_pr__nfet_01v8 ad=0.2087 pd=2.02 as=0.169 ps=1.82 w=0.65 l=0.15
X4654 VDPWR a_56843_37557# a_38740_37557# VDPWR sky130_fd_pr__pfet_01v8_hvt ad=0.3012 pd=2.66 as=0.26 ps=2.52 w=1 l=0.15
X4655 a_62083_38166# a_54479_38140# a_61624_38359# VDPWR sky130_fd_pr__pfet_01v8_hvt ad=0.0441 pd=0.63 as=0.1932 ps=1.34 w=0.42 l=0.15
X4656 a_41588_37583# a_40673_37583# a_41241_37825# uio_oe[0] sky130_fd_pr__special_nfet_01v8 ad=0.0711 pd=0.755 as=0.0999 ps=0.985 w=0.36 l=0.15
X4657 uio_oe[0] a_37839_40847# a_38005_40847# uio_oe[0] sky130_fd_pr__nfet_01v8 ad=0.169 pd=1.82 as=0.08775 ps=0.92 w=0.65 l=0.15
X4658 uio_oe[0] a_40467_38101# a_37795_40535# uio_oe[0] sky130_fd_pr__nfet_01v8 ad=0.2087 pd=2.02 as=0.169 ps=1.82 w=0.65 l=0.15
X4659 a_22060_10020# a_16812_8642# uio_oe[0] uio_oe[0] sky130_fd_pr__nfet_01v8 ad=1.4703 pd=10.72 as=1.4703 ps=10.72 w=5.07 l=1
X4660 a_18212_35593# a_18427_33198# a_18354_35400# VDPWR sky130_fd_pr__pfet_01v8_hvt ad=0.1932 pd=1.34 as=0.07665 ps=0.785 w=0.42 l=0.15
X4661 a_57363_38369# a_41685_42479# uio_oe[0] uio_oe[0] sky130_fd_pr__nfet_01v8 ad=0.1092 pd=1.36 as=0.0567 ps=0.69 w=0.42 l=0.15
X4662 uio_oe[0] a_36999_37557# a_37029_37583# uio_oe[0] sky130_fd_pr__nfet_01v8 ad=0.08775 pd=0.92 as=0.08775 ps=0.92 w=0.65 l=0.15
X4663 a_4259_27772# a_8459_24172# uio_oe[0] sky130_fd_pr__res_xhigh_po_1p41 l=5.88
X4664 VDPWR a_37029_37583# a_42237_34863# VDPWR sky130_fd_pr__pfet_01v8_hvt ad=0.26 pd=2.52 as=0.135 ps=1.27 w=1 l=0.15
X4665 VDPWR a_39544_42711# a_17204_37145# VDPWR sky130_fd_pr__pfet_01v8_hvt ad=0.15835 pd=1.395 as=0.26 ps=2.52 w=1 l=0.15
X4666 VDPWR a_38961_39513# a_38991_39254# VDPWR sky130_fd_pr__pfet_01v8_hvt ad=0.0693 pd=0.75 as=0.0441 ps=0.63 w=0.42 l=0.15
X4667 VDPWR a_58772_38823# a_58144_38920# VDPWR sky130_fd_pr__pfet_01v8_hvt ad=0.15835 pd=1.395 as=0.26 ps=2.52 w=1 l=0.15
X4668 uio_oe[0] a_37361_41391# a_60160_37583# uio_oe[0] sky130_fd_pr__nfet_01v8 ad=0.11285 pd=1.045 as=0.0693 ps=0.75 w=0.42 l=0.15
X4669 VDPWR a_36661_41391# a_59685_40086# VDPWR sky130_fd_pr__pfet_01v8_hvt ad=0.0693 pd=0.75 as=0.1176 ps=1.4 w=0.42 l=0.15
X4670 a_20914_26464# a_20620_10782# ua[4] uio_oe[0] sky130_fd_pr__nfet_01v8 ad=0.1885 pd=1.88 as=0.1885 ps=1.88 w=0.65 l=0.15
X4671 a_44611_43023# a_44095_43023# a_44516_43023# uio_oe[0] sky130_fd_pr__special_nfet_01v8 ad=0.0594 pd=0.69 as=0.066 ps=0.745 w=0.36 l=0.15
X4672 VDPWR a_41763_37557# a_41750_37949# VDPWR sky130_fd_pr__pfet_01v8_hvt ad=0.0819 pd=0.81 as=0.0567 ps=0.69 w=0.42 l=0.15
X4673 VDPWR a_28651_36993# a_30123_37359# VDPWR sky130_fd_pr__pfet_01v8_hvt ad=0.0714 pd=0.76 as=0.1092 ps=1.36 w=0.42 l=0.15
X4674 a_62237_37337# a_37361_41391# uio_oe[0] uio_oe[0] sky130_fd_pr__nfet_01v8 ad=0.1092 pd=1.36 as=0.1449 ps=1.11 w=0.42 l=0.15
X4675 a_19588_18020# a_4259_22596# a_19410_18020# uio_oe[0] sky130_fd_pr__nfet_01v8 ad=0.2436 pd=2.26 as=0.2436 ps=2.26 w=0.84 l=0.6
X4676 a_52579_34646# a_51620_34293# a_52507_34646# VDPWR sky130_fd_pr__pfet_01v8_hvt ad=0.1932 pd=1.34 as=0.0441 ps=0.63 w=0.42 l=0.15
X4677 a_29129_35879# a_28796_36057# VDPWR VDPWR sky130_fd_pr__pfet_01v8_hvt ad=0.1176 pd=1.4 as=0.0693 ps=0.75 w=0.42 l=0.15
X4678 a_60984_41935# a_60365_41935# VDPWR VDPWR sky130_fd_pr__pfet_01v8_hvt ad=0.0651 pd=0.73 as=0.1092 ps=1.36 w=0.42 l=0.15
X4679 VDPWR a_48125_43023# a_49483_40821# VDPWR sky130_fd_pr__pfet_01v8_hvt ad=0.0819 pd=0.81 as=0.0567 ps=0.69 w=0.42 l=0.15
X4680 VDPWR a_39861_43265# a_39751_43389# VDPWR sky130_fd_pr__pfet_01v8_hvt ad=0.07035 pd=0.755 as=0.1155 ps=0.97 w=0.42 l=0.15
X4681 VDPWR a_46193_39759# a_52335_38101# VDPWR sky130_fd_pr__pfet_01v8_hvt ad=0.0819 pd=0.81 as=0.0567 ps=0.69 w=0.42 l=0.15
X4682 a_60584_35177# a_60416_35141# a_60988_34863# VDPWR sky130_fd_pr__pfet_01v8_hvt ad=0.0567 pd=0.69 as=0.0945 ps=0.87 w=0.42 l=0.15
X4683 a_42329_41397# a_42163_41397# uio_oe[0] uio_oe[0] sky130_fd_pr__nfet_01v8 ad=0.1092 pd=1.36 as=0.0567 ps=0.69 w=0.42 l=0.15
X4684 a_20914_26464# a_4259_22596# a_20618_24730# uio_oe[0] sky130_fd_pr__nfet_01v8 ad=0.2436 pd=2.26 as=0.2436 ps=2.26 w=0.84 l=0.6
X4685 ua[5] a_20620_18782# a_23274_18020# uio_oe[0] sky130_fd_pr__nfet_01v8 ad=0.1885 pd=1.88 as=0.1885 ps=1.88 w=0.65 l=0.15
X4686 VDPWR a_43419_42997# a_43406_43389# VDPWR sky130_fd_pr__pfet_01v8_hvt ad=0.0819 pd=0.81 as=0.0567 ps=0.69 w=0.42 l=0.15
X4687 uio_oe[0] a_39973_40601# a_39907_40669# uio_oe[0] sky130_fd_pr__nfet_01v8 ad=0.1449 pd=1.11 as=0.0693 ps=0.75 w=0.42 l=0.15
X4688 a_45176_40847# a_44095_40847# a_44829_41089# VDPWR sky130_fd_pr__pfet_01v8_hvt ad=0.0588 pd=0.7 as=0.12915 ps=1.185 w=0.42 l=0.15
X4689 a_52579_34319# a_52325_34646# uio_oe[0] uio_oe[0] sky130_fd_pr__nfet_01v8 ad=0.0693 pd=0.75 as=0.1449 ps=1.11 w=0.42 l=0.15
X4690 a_36956_35095# a_40383_42997# uio_oe[0] uio_oe[0] sky130_fd_pr__nfet_01v8 ad=0.169 pd=1.82 as=0.2087 ps=2.02 w=0.65 l=0.15
X4691 VDPWR a_51412_42711# a_50784_42453# VDPWR sky130_fd_pr__pfet_01v8_hvt ad=0.15835 pd=1.395 as=0.26 ps=2.52 w=1 l=0.15
X4692 a_44611_42857# a_44095_42485# a_44516_42845# uio_oe[0] sky130_fd_pr__special_nfet_01v8 ad=0.0594 pd=0.69 as=0.066 ps=0.745 w=0.36 l=0.15
X4693 a_59201_41909# a_48677_39759# uio_oe[0] uio_oe[0] sky130_fd_pr__nfet_01v8 ad=0.1092 pd=1.36 as=0.1449 ps=1.11 w=0.42 l=0.15
X4694 a_51554_34646# a_48677_38127# VDPWR VDPWR sky130_fd_pr__pfet_01v8_hvt ad=0.07665 pd=0.785 as=0.15835 ps=1.395 w=0.42 l=0.15
X4695 VDPWR a_39973_41909# a_40003_42262# VDPWR sky130_fd_pr__pfet_01v8_hvt ad=0.0693 pd=0.75 as=0.0441 ps=0.63 w=0.42 l=0.15
X4696 a_58914_40342# a_48677_39759# VDPWR VDPWR sky130_fd_pr__pfet_01v8_hvt ad=0.07665 pd=0.785 as=0.15835 ps=1.395 w=0.42 l=0.15
X4697 a_40639_42087# a_37795_40535# uio_oe[0] uio_oe[0] sky130_fd_pr__nfet_01v8 ad=0.1092 pd=1.36 as=0.1575 ps=1.17 w=0.42 l=0.15
X4698 a_47108_41935# a_46027_41935# a_46761_42177# VDPWR sky130_fd_pr__pfet_01v8_hvt ad=0.0588 pd=0.7 as=0.12915 ps=1.185 w=0.42 l=0.15
X4699 VDPWR a_53636_41365# a_53574_41391# VDPWR sky130_fd_pr__pfet_01v8_hvt ad=0.1092 pd=1.36 as=0.0651 ps=0.73 w=0.42 l=0.15
X4700 uio_oe[0] a_36327_39189# a_18427_33198# uio_oe[0] sky130_fd_pr__nfet_01v8 ad=0.2087 pd=2.02 as=0.169 ps=1.82 w=0.65 l=0.15
X4701 VDPWR a_38961_38645# a_38991_38998# VDPWR sky130_fd_pr__pfet_01v8_hvt ad=0.0693 pd=0.75 as=0.0441 ps=0.63 w=0.42 l=0.15
X4702 uio_oe[0] a_50003_38813# a_49964_38939# uio_oe[0] sky130_fd_pr__nfet_01v8 ad=0.0567 pd=0.69 as=0.1092 ps=1.36 w=0.42 l=0.15
X4703 a_59201_36249# a_48677_38127# VDPWR VDPWR sky130_fd_pr__pfet_01v8_hvt ad=0.1176 pd=1.4 as=0.0693 ps=0.75 w=0.42 l=0.15
X4704 uio_oe[0] a_40775_35644# a_40706_35773# uio_oe[0] sky130_fd_pr__nfet_01v8 ad=0.1346 pd=1.15 as=0.0999 ps=0.985 w=0.64 l=0.15
X4705 a_44339_39944# a_42696_37557# uio_oe[0] uio_oe[0] sky130_fd_pr__nfet_01v8 ad=0.08775 pd=0.92 as=0.08775 ps=0.92 w=0.65 l=0.15
X4706 a_49961_37583# a_49483_37557# uio_oe[0] uio_oe[0] sky130_fd_pr__nfet_01v8 ad=0.0669 pd=0.75 as=0.12495 ps=1.015 w=0.42 l=0.15
X4707 VDPWR a_42793_35559# a_40403_34876# VDPWR sky130_fd_pr__pfet_01v8_hvt ad=0.14575 pd=1.335 as=0.34 ps=2.68 w=1 l=0.15
X4708 VDPWR a_61242_35093# a_61192_34863# VDPWR sky130_fd_pr__pfet_01v8_hvt ad=0.2184 pd=2.2 as=0.12495 ps=1.175 w=0.84 l=0.15
X4709 a_58980_39733# a_61819_39733# VDPWR VDPWR sky130_fd_pr__pfet_01v8_hvt ad=0.26 pd=2.52 as=0.3012 ps=2.66 w=1 l=0.15
X4710 a_51775_35229# a_38771_34879# a_51412_35095# uio_oe[0] sky130_fd_pr__nfet_01v8 ad=0.0693 pd=0.75 as=0.09975 ps=0.895 w=0.42 l=0.15
X4711 a_49686_42611# a_49964_42595# a_49920_42479# VDPWR sky130_fd_pr__pfet_01v8_hvt ad=0.0588 pd=0.7 as=0.0567 ps=0.69 w=0.42 l=0.15
X4712 a_46448_40847# ui_in[7] uio_oe[0] uio_oe[0] sky130_fd_pr__nfet_01v8 ad=0.066 pd=0.745 as=0.2205 ps=1.89 w=0.42 l=0.15
X4713 uio_oe[0] a_51841_40601# a_51775_40669# uio_oe[0] sky130_fd_pr__nfet_01v8 ad=0.1449 pd=1.11 as=0.0693 ps=0.75 w=0.42 l=0.15
X4714 a_58864_39447# a_54479_39228# a_59006_39581# uio_oe[0] sky130_fd_pr__nfet_01v8 ad=0.09975 pd=0.895 as=0.0693 ps=0.75 w=0.42 l=0.15
X4715 a_50003_40989# a_38649_43023# uio_oe[0] uio_oe[0] sky130_fd_pr__nfet_01v8 ad=0.1092 pd=1.36 as=0.0567 ps=0.69 w=0.42 l=0.15
X4716 a_50304_39037# a_50090_39037# VDPWR VDPWR sky130_fd_pr__pfet_01v8_hvt ad=0.1155 pd=0.97 as=0.07035 ps=0.755 w=0.42 l=0.15
X4717 uio_oe[0] a_46193_39759# a_60802_37405# uio_oe[0] sky130_fd_pr__nfet_01v8 ad=0.0882 pd=0.84 as=0.0441 ps=0.63 w=0.42 l=0.15
X4718 a_51554_34319# a_48677_38127# uio_oe[0] uio_oe[0] sky130_fd_pr__nfet_01v8 ad=0.0693 pd=0.75 as=0.11285 ps=1.045 w=0.42 l=0.15
X4719 uio_oe[0] a_37839_41391# a_38005_41391# uio_oe[0] sky130_fd_pr__nfet_01v8 ad=0.08775 pd=0.92 as=0.08775 ps=0.92 w=0.65 l=0.15
X4720 a_43419_40821# a_39947_42997# VDPWR VDPWR sky130_fd_pr__pfet_01v8_hvt ad=0.0567 pd=0.69 as=0.0819 ps=0.81 w=0.42 l=0.15
X4721 a_61187_39037# a_48125_41935# VDPWR VDPWR sky130_fd_pr__pfet_01v8_hvt ad=0.1092 pd=1.36 as=0.07035 ps=0.755 w=0.42 l=0.15
X4722 VDPWR a_49483_40277# a_38740_40571# VDPWR sky130_fd_pr__pfet_01v8_hvt ad=0.3012 pd=2.66 as=0.26 ps=2.52 w=1 l=0.15
X4723 uio_oe[0] uio_oe[0] uio_oe[0] uio_oe[0] sky130_fd_pr__nfet_01v8 ad=0.1885 pd=1.88 as=0 ps=0 w=0.65 l=0.15
X4724 a_21519_33551# a_17507_33198# a_21156_33417# uio_oe[0] sky130_fd_pr__nfet_01v8 ad=0.0693 pd=0.75 as=0.09975 ps=0.895 w=0.42 l=0.15
X4725 VDPWR a_46013_38823# a_45114_37735# VDPWR sky130_fd_pr__pfet_01v8_hvt ad=0.14575 pd=1.335 as=0.34 ps=2.68 w=1 l=0.15
X4726 a_51620_38645# a_54459_38645# VDPWR VDPWR sky130_fd_pr__pfet_01v8_hvt ad=0.26 pd=2.52 as=0.3012 ps=2.66 w=1 l=0.15
X4727 uio_oe[0] a_22076_34505# a_21180_34791# uio_oe[0] sky130_fd_pr__nfet_01v8 ad=0.11285 pd=1.045 as=0.169 ps=1.82 w=0.65 l=0.15
X4728 VDPWR a_53011_40277# a_52942_40303# VDPWR sky130_fd_pr__pfet_01v8_hvt ad=0.2184 pd=2.2 as=0.12915 ps=1.185 w=0.84 l=0.15
X4729 a_61808_39447# a_58980_39733# a_61950_39254# VDPWR sky130_fd_pr__pfet_01v8_hvt ad=0.1932 pd=1.34 as=0.07665 ps=0.785 w=0.42 l=0.15
X4730 uio_oe[0] a_54264_37271# a_53636_37013# uio_oe[0] sky130_fd_pr__nfet_01v8 ad=0.11285 pd=1.045 as=0.169 ps=1.82 w=0.65 l=0.15
X4731 a_57363_36193# a_41685_42479# VDPWR VDPWR sky130_fd_pr__pfet_01v8_hvt ad=0.1664 pd=1.8 as=0.0864 ps=0.91 w=0.64 l=0.15
X4732 a_60416_41669# a_37913_43023# uio_oe[0] uio_oe[0] sky130_fd_pr__nfet_01v8 ad=0.1092 pd=1.36 as=0.0567 ps=0.69 w=0.42 l=0.15
X4733 a_40467_39733# a_40670_40011# VDPWR VDPWR sky130_fd_pr__pfet_01v8_hvt ad=0.0567 pd=0.69 as=0.1134 ps=1.38 w=0.42 l=0.15
X4734 a_61950_35229# a_37361_41391# uio_oe[0] uio_oe[0] sky130_fd_pr__nfet_01v8 ad=0.0693 pd=0.75 as=0.11285 ps=1.045 w=0.42 l=0.15
X4735 uio_oe[0] a_50784_42184# a_50722_42301# uio_oe[0] sky130_fd_pr__nfet_01v8 ad=0.2205 pd=1.89 as=0.066 ps=0.745 w=0.42 l=0.15
X4736 a_61297_38913# a_61079_38671# VDPWR VDPWR sky130_fd_pr__pfet_01v8_hvt ad=0.12915 pd=1.185 as=0.2184 ps=2.2 w=0.84 l=0.15
X4737 a_60988_37039# a_60720_37405# VDPWR VDPWR sky130_fd_pr__pfet_01v8_hvt ad=0.0945 pd=0.87 as=0.0798 ps=0.8 w=0.42 l=0.15
X4738 a_57046_35659# a_57363_35549# a_57321_35407# uio_oe[0] sky130_fd_pr__special_nfet_01v8 ad=0.0711 pd=0.755 as=0.0669 ps=0.75 w=0.36 l=0.15
X4739 uio_oe[0] a_48125_43023# a_49721_42845# uio_oe[0] sky130_fd_pr__nfet_01v8 ad=0.12495 pd=1.015 as=0.06405 ps=0.725 w=0.42 l=0.15
X4740 a_38674_41757# a_38005_40847# uio_oe[0] uio_oe[0] sky130_fd_pr__nfet_01v8 ad=0.0693 pd=0.75 as=0.11285 ps=1.045 w=0.42 l=0.15
X4741 VDPWR a_37029_42479# a_42163_41397# VDPWR sky130_fd_pr__pfet_01v8_hvt ad=0.0864 pd=0.91 as=0.1664 ps=1.8 w=0.64 l=0.15
X4742 uio_oe[0] a_60996_38101# a_60934_38127# uio_oe[0] sky130_fd_pr__nfet_01v8 ad=0.2205 pd=1.89 as=0.066 ps=0.745 w=0.42 l=0.15
X4743 a_54459_39733# a_54284_39759# a_54638_39759# uio_oe[0] sky130_fd_pr__nfet_01v8 ad=0.1092 pd=1.36 as=0.06405 ps=0.725 w=0.42 l=0.15
X4744 VDPWR a_40379_35551# a_41420_39037# VDPWR sky130_fd_pr__pfet_01v8_hvt ad=0.12285 pd=1.17 as=0.1092 ps=1.36 w=0.42 l=0.15
X4745 a_60984_35407# a_60365_35407# VDPWR VDPWR sky130_fd_pr__pfet_01v8_hvt ad=0.0651 pd=0.73 as=0.1092 ps=1.36 w=0.42 l=0.15
X4746 a_60160_41935# a_58980_41909# a_59939_42262# uio_oe[0] sky130_fd_pr__nfet_01v8 ad=0.0693 pd=0.75 as=0.09975 ps=0.895 w=0.42 l=0.15
X4747 VDPWR a_39544_41623# a_17204_34969# VDPWR sky130_fd_pr__pfet_01v8_hvt ad=0.15835 pd=1.395 as=0.26 ps=2.52 w=1 l=0.15
X4748 a_59293_41689# a_48677_39759# VDPWR VDPWR sky130_fd_pr__pfet_01v8_hvt ad=0.1176 pd=1.4 as=0.0693 ps=0.75 w=0.42 l=0.15
X4749 uio_oe[0] a_46193_39759# a_59933_36317# uio_oe[0] sky130_fd_pr__nfet_01v8 ad=0.12495 pd=1.015 as=0.06405 ps=0.725 w=0.42 l=0.15
X4750 a_28346_24730# ua[0] a_28218_26020# uio_oe[0] sky130_fd_pr__nfet_01v8 ad=0.2436 pd=2.26 as=0.2436 ps=2.26 w=0.84 l=0.6
X4751 VDPWR a_44905_38671# a_49483_34293# VDPWR sky130_fd_pr__pfet_01v8_hvt ad=0.0819 pd=0.81 as=0.0567 ps=0.69 w=0.42 l=0.15
X4752 VDPWR a_37029_42479# a_44095_42485# VDPWR sky130_fd_pr__pfet_01v8_hvt ad=0.0864 pd=0.91 as=0.1664 ps=1.8 w=0.64 l=0.15
X4753 VDPWR a_18427_33198# a_36455_37949# VDPWR sky130_fd_pr__pfet_01v8_hvt ad=0.2279 pd=1.74 as=0.0609 ps=0.71 w=0.42 l=0.15
X4754 a_59006_39581# a_48677_39759# uio_oe[0] uio_oe[0] sky130_fd_pr__nfet_01v8 ad=0.0693 pd=0.75 as=0.11285 ps=1.045 w=0.42 l=0.15
X4755 VDPWR a_28651_35905# a_30123_36271# VDPWR sky130_fd_pr__pfet_01v8_hvt ad=0.0714 pd=0.76 as=0.1092 ps=1.36 w=0.42 l=0.15
X4756 a_49721_35407# a_49686_35659# a_49483_35381# uio_oe[0] sky130_fd_pr__nfet_01v8 ad=0.06405 pd=0.725 as=0.1092 ps=1.36 w=0.42 l=0.15
X4757 uio_oe[0] a_37913_41935# a_53203_36495# uio_oe[0] sky130_fd_pr__nfet_01v8 ad=0.0567 pd=0.69 as=0.1092 ps=1.36 w=0.42 l=0.15
X4758 VDPWR a_47108_41935# a_47283_41909# VDPWR sky130_fd_pr__pfet_01v8_hvt ad=0.1134 pd=1.38 as=0.0567 ps=0.69 w=0.42 l=0.15
X4759 a_51412_34471# a_39783_34321# a_51554_34646# VDPWR sky130_fd_pr__pfet_01v8_hvt ad=0.1932 pd=1.34 as=0.07665 ps=0.785 w=0.42 l=0.15
X4760 a_53011_34837# a_52855_35105# a_53156_34863# VDPWR sky130_fd_pr__pfet_01v8_hvt ad=0.07245 pd=0.765 as=0.1155 ps=0.97 w=0.42 l=0.15
X4761 a_58772_40535# a_39752_40571# a_58914_40342# VDPWR sky130_fd_pr__pfet_01v8_hvt ad=0.1932 pd=1.34 as=0.07665 ps=0.785 w=0.42 l=0.15
X4762 uio_oe[0] a_38543_35559# a_28980_35593# uio_oe[0] sky130_fd_pr__nfet_01v8 ad=0.1118 pd=1.04 as=0.182 ps=1.86 w=0.65 l=0.15
X4763 a_30034_22464# a_28348_10782# ua[4] uio_oe[0] sky130_fd_pr__nfet_01v8 ad=0.1885 pd=1.88 as=0.1885 ps=1.88 w=0.65 l=0.15
X4764 VDPWR a_51412_41623# a_50784_41365# VDPWR sky130_fd_pr__pfet_01v8_hvt ad=0.15835 pd=1.395 as=0.26 ps=2.52 w=1 l=0.15
X4765 a_59939_36822# a_58980_36469# a_59867_36822# VDPWR sky130_fd_pr__pfet_01v8_hvt ad=0.1932 pd=1.34 as=0.0441 ps=0.63 w=0.42 l=0.15
X4766 a_43598_42845# a_39947_42997# uio_oe[0] uio_oe[0] sky130_fd_pr__nfet_01v8 ad=0.06405 pd=0.725 as=0.12495 ps=1.015 w=0.42 l=0.15
X4767 a_37029_37583# a_36999_37557# uio_oe[0] uio_oe[0] sky130_fd_pr__nfet_01v8 ad=0.08775 pd=0.92 as=0.169 ps=1.82 w=0.65 l=0.15
X4768 VDPWR a_37851_36647# a_41057_34569# VDPWR sky130_fd_pr__pfet_01v8_hvt ad=0.135 pd=1.27 as=0.135 ps=1.27 w=1 l=0.15
X4769 uio_oe[0] a_49483_41909# a_39752_41909# uio_oe[0] sky130_fd_pr__nfet_01v8 ad=0.2087 pd=2.02 as=0.169 ps=1.82 w=0.65 l=0.15
X4770 VDPWR a_48125_43023# a_50304_40125# VDPWR sky130_fd_pr__pfet_01v8_hvt ad=0.07035 pd=0.755 as=0.1092 ps=1.36 w=0.42 l=0.15
X4771 VDPWR a_61297_40001# a_61187_40125# VDPWR sky130_fd_pr__pfet_01v8_hvt ad=0.07035 pd=0.755 as=0.1155 ps=0.97 w=0.42 l=0.15
X4772 a_30034_22464# a_4259_22596# a_29738_20730# uio_oe[0] sky130_fd_pr__nfet_01v8 ad=0.2436 pd=2.26 as=0.2436 ps=2.26 w=0.84 l=0.6
X4773 a_25151_33007# a_24971_33007# VDPWR VDPWR sky130_fd_pr__pfet_01v8_hvt ad=0.0609 pd=0.71 as=0.0714 ps=0.76 w=0.42 l=0.15
X4774 uio_oe[0] a_41400_35656# a_41338_35773# uio_oe[0] sky130_fd_pr__nfet_01v8 ad=0.2205 pd=1.89 as=0.066 ps=0.745 w=0.42 l=0.15
X4775 a_25825_33757# a_24787_33729# a_25739_33757# uio_oe[0] sky130_fd_pr__nfet_01v8 ad=0.0567 pd=0.69 as=0.1176 ps=1.4 w=0.42 l=0.15
X4776 a_42941_41935# a_42897_42177# a_42775_41935# uio_oe[0] sky130_fd_pr__nfet_01v8 ad=0.0441 pd=0.63 as=0.1401 ps=1.1 w=0.42 l=0.15
X4777 a_42775_40847# a_42329_40847# a_42679_40847# uio_oe[0] sky130_fd_pr__special_nfet_01v8 ad=0.1401 pd=1.1 as=0.0594 ps=0.69 w=0.36 l=0.15
X4778 VDPWR a_25209_32899# a_25151_33007# VDPWR sky130_fd_pr__pfet_01v8_hvt ad=0.2279 pd=1.74 as=0.0609 ps=0.71 w=0.42 l=0.15
X4779 a_20620_18376# a_22575_35183# uio_oe[0] uio_oe[0] sky130_fd_pr__nfet_01v8 ad=0.169 pd=1.82 as=0.1013 ps=0.99 w=0.65 l=0.15
X4780 a_38674_42518# a_38005_40847# VDPWR VDPWR sky130_fd_pr__pfet_01v8_hvt ad=0.07665 pd=0.785 as=0.15835 ps=1.395 w=0.42 l=0.15
X4781 a_54693_42777# a_36661_41391# uio_oe[0] uio_oe[0] sky130_fd_pr__nfet_01v8 ad=0.1092 pd=1.36 as=0.1449 ps=1.11 w=0.42 l=0.15
X4782 a_25162_36488# a_25116_36681# VDPWR VDPWR sky130_fd_pr__pfet_01v8_hvt ad=0.07665 pd=0.785 as=0.15835 ps=1.395 w=0.42 l=0.15
X4783 a_57354_35229# a_44905_38671# uio_oe[0] uio_oe[0] sky130_fd_pr__nfet_01v8 ad=0.0483 pd=0.65 as=0.1137 ps=1.01 w=0.42 l=0.15
X4784 a_40647_34902# a_37310_34471# a_40188_35095# VDPWR sky130_fd_pr__pfet_01v8_hvt ad=0.0441 pd=0.63 as=0.1932 ps=1.34 w=0.42 l=0.15
X4785 a_49686_41523# a_49964_41507# a_49920_41391# VDPWR sky130_fd_pr__pfet_01v8_hvt ad=0.0588 pd=0.7 as=0.0567 ps=0.69 w=0.42 l=0.15
X4786 a_50003_40989# a_38649_43023# VDPWR VDPWR sky130_fd_pr__pfet_01v8_hvt ad=0.1664 pd=1.8 as=0.0864 ps=0.91 w=0.64 l=0.15
X4787 a_17050_26464# a_16756_10782# ua[4] uio_oe[0] sky130_fd_pr__nfet_01v8 ad=0.1885 pd=1.88 as=0.1885 ps=1.88 w=0.65 l=0.15
X4788 uio_oe[0] a_36447_40849# a_39209_34319# uio_oe[0] sky130_fd_pr__nfet_01v8 ad=0.169 pd=1.82 as=0.08775 ps=0.92 w=0.65 l=0.15
X4789 uio_oe[0] a_52335_34837# a_51620_35131# uio_oe[0] sky130_fd_pr__nfet_01v8 ad=0.2087 pd=2.02 as=0.169 ps=1.82 w=0.65 l=0.15
X4790 VDPWR a_60996_40277# a_60934_40303# VDPWR sky130_fd_pr__pfet_01v8_hvt ad=0.1092 pd=1.36 as=0.0651 ps=0.73 w=0.42 l=0.15
X4791 a_29738_16730# ua[0] a_29610_18020# uio_oe[0] sky130_fd_pr__nfet_01v8 ad=0.2436 pd=2.26 as=0.2436 ps=2.26 w=0.84 l=0.6
X4792 uio_oe[0] a_22505_34571# a_22439_34639# uio_oe[0] sky130_fd_pr__nfet_01v8 ad=0.1449 pd=1.11 as=0.0693 ps=0.75 w=0.42 l=0.15
X4793 a_25449_34571# a_25116_34505# uio_oe[0] uio_oe[0] sky130_fd_pr__nfet_01v8 ad=0.1092 pd=1.36 as=0.1449 ps=1.11 w=0.42 l=0.15
X4794 a_44707_41935# a_44261_41935# a_44611_41935# uio_oe[0] sky130_fd_pr__special_nfet_01v8 ad=0.1401 pd=1.1 as=0.0594 ps=0.69 w=0.36 l=0.15
X4795 a_39213_35183# a_36427_36475# uio_oe[0] uio_oe[0] sky130_fd_pr__nfet_01v8 ad=0.08775 pd=0.92 as=0.169 ps=1.82 w=0.65 l=0.15
X4796 uio_oe[0] a_54264_36183# a_53636_35925# uio_oe[0] sky130_fd_pr__nfet_01v8 ad=0.11285 pd=1.045 as=0.169 ps=1.82 w=0.65 l=0.15
X4797 a_17250_33729# a_17204_33881# uio_oe[0] uio_oe[0] sky130_fd_pr__nfet_01v8 ad=0.0693 pd=0.75 as=0.11285 ps=1.045 w=0.42 l=0.15
X4798 VDPWR a_50784_39189# a_50722_39215# VDPWR sky130_fd_pr__pfet_01v8_hvt ad=0.1092 pd=1.36 as=0.0651 ps=0.73 w=0.42 l=0.15
X4799 a_17050_26464# a_4259_22596# a_16754_24730# uio_oe[0] sky130_fd_pr__nfet_01v8 ad=0.2436 pd=2.26 as=0.2436 ps=2.26 w=0.84 l=0.6
X4800 a_36503_34293# a_17255_32793# VDPWR VDPWR sky130_fd_pr__pfet_01v8_hvt ad=0.1092 pd=1.36 as=0.0714 ps=0.76 w=0.42 l=0.15
X4801 a_40379_35551# a_40495_42453# VDPWR VDPWR sky130_fd_pr__pfet_01v8_hvt ad=0.135 pd=1.27 as=0.135 ps=1.27 w=1 l=0.15
X4802 uio_oe[0] a_43419_42783# a_43353_42857# uio_oe[0] sky130_fd_pr__nfet_01v8 ad=0.12495 pd=1.015 as=0.0669 ps=0.75 w=0.42 l=0.15
X4803 VDPWR a_44739_38671# a_44905_38671# VDPWR sky130_fd_pr__pfet_01v8_hvt ad=0.26 pd=2.52 as=0.135 ps=1.27 w=1 l=0.15
X4804 a_50090_39037# a_50003_38813# a_49686_38923# VDPWR sky130_fd_pr__pfet_01v8_hvt ad=0.12915 pd=1.185 as=0.0588 ps=0.7 w=0.42 l=0.15
X4805 a_29804_33417# a_18427_33198# a_29946_33224# VDPWR sky130_fd_pr__pfet_01v8_hvt ad=0.1932 pd=1.34 as=0.07665 ps=0.785 w=0.42 l=0.15
X4806 VDPWR a_48125_41935# a_60516_42479# VDPWR sky130_fd_pr__pfet_01v8_hvt ad=0.07035 pd=0.755 as=0.1092 ps=1.36 w=0.42 l=0.15
X4807 a_40003_40342# a_39752_40571# a_39544_40535# VDPWR sky130_fd_pr__pfet_01v8_hvt ad=0.0441 pd=0.63 as=0.1932 ps=1.34 w=0.42 l=0.15
X4808 uio_oe[0] a_57640_37353# a_57598_37405# uio_oe[0] sky130_fd_pr__nfet_01v8 ad=0.1092 pd=1.36 as=0.0441 ps=0.63 w=0.42 l=0.15
X4809 a_18196_10020# a_4259_22596# a_18018_10020# uio_oe[0] sky130_fd_pr__nfet_01v8 ad=0.2436 pd=2.26 as=0.2436 ps=2.26 w=0.84 l=0.6
X4810 a_54459_38645# a_54284_38671# a_54638_38671# uio_oe[0] sky130_fd_pr__nfet_01v8 ad=0.1092 pd=1.36 as=0.06405 ps=0.725 w=0.42 l=0.15
X4811 a_37029_37039# a_36999_37013# VDPWR VDPWR sky130_fd_pr__pfet_01v8_hvt ad=0.135 pd=1.27 as=0.135 ps=1.27 w=1 l=0.15
X4812 uio_oe[0] a_26369_36747# a_26303_36815# uio_oe[0] sky130_fd_pr__nfet_01v8 ad=0.1449 pd=1.11 as=0.0693 ps=0.75 w=0.42 l=0.15
X4813 a_17567_36232# a_17316_35879# a_17108_36057# VDPWR sky130_fd_pr__pfet_01v8_hvt ad=0.0441 pd=0.63 as=0.1932 ps=1.34 w=0.42 l=0.15
X4814 uio_oe[0] a_29281_32641# a_29689_34845# uio_oe[0] sky130_fd_pr__nfet_01v8 ad=0.1118 pd=1.04 as=0.0567 ps=0.69 w=0.42 l=0.15
X4815 a_36661_41391# a_36631_41365# VDPWR VDPWR sky130_fd_pr__pfet_01v8_hvt ad=0.135 pd=1.27 as=0.26 ps=2.52 w=1 l=0.15
X4816 a_52855_35105# a_37913_41935# VDPWR VDPWR sky130_fd_pr__pfet_01v8_hvt ad=0.1664 pd=1.8 as=0.0864 ps=0.91 w=0.64 l=0.15
X4817 uio_oe[0] a_37747_43023# a_37913_43023# uio_oe[0] sky130_fd_pr__nfet_01v8 ad=0.08775 pd=0.92 as=0.08775 ps=0.92 w=0.65 l=0.15
X4818 a_41193_37405# a_41149_37013# a_41027_37417# uio_oe[0] sky130_fd_pr__nfet_01v8 ad=0.0441 pd=0.63 as=0.1401 ps=1.1 w=0.42 l=0.15
X4819 a_57472_37317# a_41685_42479# uio_oe[0] uio_oe[0] sky130_fd_pr__nfet_01v8 ad=0.1092 pd=1.36 as=0.0567 ps=0.69 w=0.42 l=0.15
X4820 ua[5] a_20620_10376# a_21882_10020# uio_oe[0] sky130_fd_pr__nfet_01v8 ad=0.1885 pd=1.88 as=0.1885 ps=1.88 w=0.65 l=0.15
X4821 a_40864_38671# a_40581_38671# a_40769_38671# VDPWR sky130_fd_pr__pfet_01v8_hvt ad=0.0567 pd=0.69 as=0.12495 ps=1.175 w=0.42 l=0.15
X4822 a_49686_37835# a_49964_37851# a_49920_37949# VDPWR sky130_fd_pr__pfet_01v8_hvt ad=0.0588 pd=0.7 as=0.0567 ps=0.69 w=0.42 l=0.15
X4823 a_38532_38359# a_38740_38395# a_38674_38493# uio_oe[0] sky130_fd_pr__nfet_01v8 ad=0.09975 pd=0.895 as=0.0693 ps=0.75 w=0.42 l=0.15
X4824 a_21156_35593# a_17507_33198# a_21298_35400# VDPWR sky130_fd_pr__pfet_01v8_hvt ad=0.1932 pd=1.34 as=0.07665 ps=0.785 w=0.42 l=0.15
X4825 a_39973_42777# a_37029_38127# uio_oe[0] uio_oe[0] sky130_fd_pr__nfet_01v8 ad=0.1092 pd=1.36 as=0.1449 ps=1.11 w=0.42 l=0.15
X4826 VDPWR a_22505_35659# a_22535_35400# VDPWR sky130_fd_pr__pfet_01v8_hvt ad=0.0693 pd=0.75 as=0.0441 ps=0.63 w=0.42 l=0.15
X4827 ua[4] a_16756_10782# a_16626_10020# uio_oe[0] sky130_fd_pr__nfet_01v8 ad=0.1885 pd=1.88 as=0.1885 ps=1.88 w=0.65 l=0.15
X4828 a_18442_18464# a_18148_18376# ua[4] uio_oe[0] sky130_fd_pr__nfet_01v8 ad=0.1885 pd=1.88 as=0.1885 ps=1.88 w=0.65 l=0.15
X4829 a_28884_34505# a_17500_33453# a_29026_34639# uio_oe[0] sky130_fd_pr__nfet_01v8 ad=0.09975 pd=0.895 as=0.0693 ps=0.75 w=0.42 l=0.15
X4830 a_51871_40342# a_51620_40571# a_51412_40535# VDPWR sky130_fd_pr__pfet_01v8_hvt ad=0.0441 pd=0.63 as=0.1932 ps=1.34 w=0.42 l=0.15
X4831 uio_oe[0] a_17689_32641# a_18097_35933# uio_oe[0] sky130_fd_pr__nfet_01v8 ad=0.1118 pd=1.04 as=0.0567 ps=0.69 w=0.42 l=0.15
X4832 a_57280_41213# a_56843_40821# VDPWR VDPWR sky130_fd_pr__pfet_01v8_hvt ad=0.0567 pd=0.69 as=0.0819 ps=0.81 w=0.42 l=0.15
X4833 a_18801_33729# a_18531_34095# a_18711_34095# uio_oe[0] sky130_fd_pr__nfet_01v8 ad=0.0504 pd=0.66 as=0.1092 ps=1.36 w=0.42 l=0.15
X4834 VDPWR a_36631_41365# a_36661_41391# VDPWR sky130_fd_pr__pfet_01v8_hvt ad=0.135 pd=1.27 as=0.135 ps=1.27 w=1 l=0.15
X4835 a_60132_38127# a_59695_38101# VDPWR VDPWR sky130_fd_pr__pfet_01v8_hvt ad=0.0567 pd=0.69 as=0.0819 ps=0.81 w=0.42 l=0.15
X4836 a_57363_37725# a_41685_42479# uio_oe[0] uio_oe[0] sky130_fd_pr__nfet_01v8 ad=0.1092 pd=1.36 as=0.0567 ps=0.69 w=0.42 l=0.15
X4837 a_25020_36681# a_17507_33198# a_25162_36488# VDPWR sky130_fd_pr__pfet_01v8_hvt ad=0.1932 pd=1.34 as=0.07665 ps=0.785 w=0.42 l=0.15
X4838 a_38532_42711# a_37851_36647# a_38674_42518# VDPWR sky130_fd_pr__pfet_01v8_hvt ad=0.1932 pd=1.34 as=0.07665 ps=0.785 w=0.42 l=0.15
X4839 VDPWR a_59201_37557# a_59231_37910# VDPWR sky130_fd_pr__pfet_01v8_hvt ad=0.0693 pd=0.75 as=0.0441 ps=0.63 w=0.42 l=0.15
X4840 VDPWR a_50003_37281# a_49964_37155# VDPWR sky130_fd_pr__pfet_01v8_hvt ad=0.0864 pd=0.91 as=0.1664 ps=1.8 w=0.64 l=0.15
X4841 a_18442_18464# a_4259_22596# a_18146_16730# uio_oe[0] sky130_fd_pr__nfet_01v8 ad=0.2436 pd=2.26 as=0.2436 ps=2.26 w=0.84 l=0.6
X4842 VDPWR a_51841_37557# a_51871_37910# VDPWR sky130_fd_pr__pfet_01v8_hvt ad=0.0693 pd=0.75 as=0.0441 ps=0.63 w=0.42 l=0.15
X4843 a_58772_36647# a_58980_36469# a_58914_36495# uio_oe[0] sky130_fd_pr__nfet_01v8 ad=0.09975 pd=0.895 as=0.0693 ps=0.75 w=0.42 l=0.15
X4844 a_17721_33483# a_17388_33417# VDPWR VDPWR sky130_fd_pr__pfet_01v8_hvt ad=0.1176 pd=1.4 as=0.0693 ps=0.75 w=0.42 l=0.15
X4845 a_61644_40847# a_60563_40847# a_61297_41089# VDPWR sky130_fd_pr__pfet_01v8_hvt ad=0.0588 pd=0.7 as=0.12915 ps=1.185 w=0.42 l=0.15
X4846 a_38543_36183# a_38771_35967# a_38717_36289# uio_oe[0] sky130_fd_pr__nfet_01v8 ad=0.1176 pd=1.4 as=0.0567 ps=0.69 w=0.42 l=0.15
X4847 a_27316_10020# a_16812_8642# uio_oe[0] uio_oe[0] sky130_fd_pr__nfet_01v8 ad=1.4703 pd=10.72 as=1.4703 ps=10.72 w=5.07 l=1
X4848 uio_oe[0] uio_oe[0] uio_oe[0] uio_oe[0] sky130_fd_pr__nfet_01v8 ad=1.4703 pd=10.72 as=0 ps=0 w=5.07 l=1
X4849 ua[4] a_16756_10782# a_18018_14020# uio_oe[0] sky130_fd_pr__nfet_01v8 ad=0.1885 pd=1.88 as=0.1885 ps=1.88 w=0.65 l=0.15
X4850 a_41706_40125# a_40948_40027# a_41143_39996# VDPWR sky130_fd_pr__pfet_01v8_hvt ad=0.0651 pd=0.73 as=0.07245 ps=0.765 w=0.42 l=0.15
X4851 a_20914_10464# a_20620_10376# ua[4] uio_oe[0] sky130_fd_pr__nfet_01v8 ad=0.1885 pd=1.88 as=0.1885 ps=1.88 w=0.65 l=0.15
X4852 a_38674_41430# a_38005_40847# VDPWR VDPWR sky130_fd_pr__pfet_01v8_hvt ad=0.07665 pd=0.785 as=0.15835 ps=1.395 w=0.42 l=0.15
X4853 VDPWR a_48125_43023# a_49483_40277# VDPWR sky130_fd_pr__pfet_01v8_hvt ad=0.0819 pd=0.81 as=0.0567 ps=0.69 w=0.42 l=0.15
X4854 uio_oe[0] a_40987_39457# a_40948_39331# uio_oe[0] sky130_fd_pr__nfet_01v8 ad=0.0567 pd=0.69 as=0.1092 ps=1.36 w=0.42 l=0.15
X4855 VDPWR a_25417_32641# a_26439_35183# VDPWR sky130_fd_pr__pfet_01v8_hvt ad=0.2279 pd=1.74 as=0.0609 ps=0.71 w=0.42 l=0.15
X4856 VDPWR a_57640_39529# a_57694_39215# VDPWR sky130_fd_pr__pfet_01v8_hvt ad=0.0567 pd=0.69 as=0.0483 ps=0.65 w=0.42 l=0.15
X4857 a_40302_35659# a_40580_35675# a_40536_35773# VDPWR sky130_fd_pr__pfet_01v8_hvt ad=0.0588 pd=0.7 as=0.0567 ps=0.69 w=0.42 l=0.15
X4858 a_42329_40847# a_42163_40847# uio_oe[0] uio_oe[0] sky130_fd_pr__nfet_01v8 ad=0.1092 pd=1.36 as=0.0567 ps=0.69 w=0.42 l=0.15
X4859 a_40581_38671# a_40415_38671# VDPWR VDPWR sky130_fd_pr__pfet_01v8_hvt ad=0.1664 pd=1.8 as=0.0864 ps=0.91 w=0.64 l=0.15
X4860 VDPWR a_51412_35559# a_50784_35656# VDPWR sky130_fd_pr__pfet_01v8_hvt ad=0.15835 pd=1.395 as=0.26 ps=2.52 w=1 l=0.15
X4861 uio_oe[0] a_22505_33483# a_22439_33551# uio_oe[0] sky130_fd_pr__nfet_01v8 ad=0.1449 pd=1.11 as=0.0693 ps=0.75 w=0.42 l=0.15
X4862 uio_oe[0] a_20972_33881# a_20923_33729# uio_oe[0] sky130_fd_pr__nfet_01v8 ad=0.11285 pd=1.045 as=0.169 ps=1.82 w=0.65 l=0.15
X4863 VDPWR a_43419_42783# a_43406_42479# VDPWR sky130_fd_pr__pfet_01v8_hvt ad=0.0819 pd=0.81 as=0.0567 ps=0.69 w=0.42 l=0.15
X4864 VDPWR a_62053_38425# a_62083_38166# VDPWR sky130_fd_pr__pfet_01v8_hvt ad=0.0693 pd=0.75 as=0.0441 ps=0.63 w=0.42 l=0.15
X4865 a_53719_37583# a_53203_37583# a_53624_37583# uio_oe[0] sky130_fd_pr__special_nfet_01v8 ad=0.0594 pd=0.69 as=0.066 ps=0.745 w=0.36 l=0.15
X4866 a_60729_37583# a_60563_37583# uio_oe[0] uio_oe[0] sky130_fd_pr__nfet_01v8 ad=0.1092 pd=1.36 as=0.0567 ps=0.69 w=0.42 l=0.15
X4867 a_25449_33483# a_25116_33417# uio_oe[0] uio_oe[0] sky130_fd_pr__nfet_01v8 ad=0.1092 pd=1.36 as=0.1449 ps=1.11 w=0.42 l=0.15
X4868 VDPWR a_48125_43023# a_57664_42301# VDPWR sky130_fd_pr__pfet_01v8_hvt ad=0.07035 pd=0.755 as=0.1092 ps=1.36 w=0.42 l=0.15
X4869 a_52507_38998# a_52325_38998# VDPWR VDPWR sky130_fd_pr__pfet_01v8_hvt ad=0.0441 pd=0.63 as=0.0693 ps=0.75 w=0.42 l=0.15
X4870 a_20914_10464# ua[2] a_20668_10020# uio_oe[0] sky130_fd_pr__nfet_01v8 ad=0.2436 pd=2.26 as=0.2436 ps=2.26 w=0.84 l=0.6
X4871 ua[5] a_16756_14782# a_16626_22020# uio_oe[0] sky130_fd_pr__nfet_01v8 ad=0.1885 pd=1.88 as=0.1885 ps=1.88 w=0.65 l=0.15
X4872 a_45176_40681# a_44095_40309# a_44829_40277# VDPWR sky130_fd_pr__pfet_01v8_hvt ad=0.0588 pd=0.7 as=0.12915 ps=1.185 w=0.42 l=0.15
X4873 VDPWR a_57472_37317# a_57556_37013# VDPWR sky130_fd_pr__pfet_01v8_hvt ad=0.0864 pd=0.91 as=0.1664 ps=1.8 w=0.64 l=0.15
X4874 a_21401_35879# a_21068_36057# VDPWR VDPWR sky130_fd_pr__pfet_01v8_hvt ad=0.1176 pd=1.4 as=0.0693 ps=0.75 w=0.42 l=0.15
X4875 a_22306_14464# a_20620_10376# ua[4] uio_oe[0] sky130_fd_pr__nfet_01v8 ad=0.1885 pd=1.88 as=0.1885 ps=1.88 w=0.65 l=0.15
X4876 a_29026_34639# a_28980_34505# uio_oe[0] uio_oe[0] sky130_fd_pr__nfet_01v8 ad=0.0693 pd=0.75 as=0.11285 ps=1.045 w=0.42 l=0.15
X4877 uio_oe[0] rst_n a_47959_43023# uio_oe[0] sky130_fd_pr__nfet_01v8 ad=0.08775 pd=0.92 as=0.169 ps=1.82 w=0.65 l=0.15
X4878 a_57640_37353# a_57472_37317# a_58044_37039# VDPWR sky130_fd_pr__pfet_01v8_hvt ad=0.0567 pd=0.69 as=0.0945 ps=0.87 w=0.42 l=0.15
X4879 a_40619_35549# a_38005_41391# VDPWR VDPWR sky130_fd_pr__pfet_01v8_hvt ad=0.1664 pd=1.8 as=0.0864 ps=0.91 w=0.64 l=0.15
X4880 uio_oe[0] a_16812_8642# a_16812_8642# uio_oe[0] sky130_fd_pr__nfet_01v8 ad=1.16 pd=8.29 as=1.16 ps=8.29 w=8 l=1
X4881 a_38285_38127# a_37859_38166# VDPWR VDPWR sky130_fd_pr__pfet_01v8_hvt ad=0.26 pd=2.52 as=0.15835 ps=1.395 w=1 l=0.15
X4882 a_61998_39759# a_48125_41935# uio_oe[0] uio_oe[0] sky130_fd_pr__nfet_01v8 ad=0.06405 pd=0.725 as=0.12495 ps=1.015 w=0.42 l=0.15
X4883 a_24836_36057# a_24971_35361# a_24978_36232# VDPWR sky130_fd_pr__pfet_01v8_hvt ad=0.1932 pd=1.34 as=0.07665 ps=0.785 w=0.42 l=0.15
X4884 a_53249_38493# a_46193_39759# uio_oe[0] uio_oe[0] sky130_fd_pr__nfet_01v8 ad=0.0441 pd=0.63 as=0.1346 ps=1.15 w=0.42 l=0.15
X4885 a_42237_35183# a_41316_41909# uio_oe[0] uio_oe[0] sky130_fd_pr__nfet_01v8 ad=0.08775 pd=0.92 as=0.08775 ps=0.92 w=0.65 l=0.15
X4886 a_38005_40303# a_37851_36647# VDPWR VDPWR sky130_fd_pr__pfet_01v8_hvt ad=0.135 pd=1.27 as=0.135 ps=1.27 w=1 l=0.15
X4887 uio_oe[0] a_59293_39513# a_59227_39581# uio_oe[0] sky130_fd_pr__nfet_01v8 ad=0.1449 pd=1.11 as=0.0693 ps=0.75 w=0.42 l=0.15
X4888 a_25265_36967# a_24932_37145# uio_oe[0] uio_oe[0] sky130_fd_pr__nfet_01v8 ad=0.1092 pd=1.36 as=0.1449 ps=1.11 w=0.42 l=0.15
X4889 ua[5] a_16756_10782# a_18018_26020# uio_oe[0] sky130_fd_pr__nfet_01v8 ad=0.1885 pd=1.88 as=0.1885 ps=1.88 w=0.65 l=0.15
X4890 VDPWR a_17481_32899# a_17423_33007# VDPWR sky130_fd_pr__pfet_01v8_hvt ad=0.2279 pd=1.74 as=0.0609 ps=0.71 w=0.42 l=0.15
X4891 uio_oe[0] a_41763_37557# a_41697_37583# uio_oe[0] sky130_fd_pr__nfet_01v8 ad=0.12495 pd=1.015 as=0.0669 ps=0.75 w=0.42 l=0.15
X4892 a_42643_36495# a_42389_36822# uio_oe[0] uio_oe[0] sky130_fd_pr__nfet_01v8 ad=0.0693 pd=0.75 as=0.1449 ps=1.11 w=0.42 l=0.15
X4893 a_40619_36193# a_38005_41391# uio_oe[0] uio_oe[0] sky130_fd_pr__nfet_01v8 ad=0.1092 pd=1.36 as=0.0567 ps=0.69 w=0.42 l=0.15
X4894 a_22306_14464# ua[2] a_22060_14020# uio_oe[0] sky130_fd_pr__nfet_01v8 ad=0.2436 pd=2.26 as=0.2436 ps=2.26 w=0.84 l=0.6
X4895 a_51775_34319# a_39783_34321# a_51412_34471# uio_oe[0] sky130_fd_pr__nfet_01v8 ad=0.0693 pd=0.75 as=0.09975 ps=0.895 w=0.42 l=0.15
X4896 a_57519_42453# a_57363_42721# a_57664_42479# VDPWR sky130_fd_pr__pfet_01v8_hvt ad=0.07245 pd=0.765 as=0.1155 ps=0.97 w=0.42 l=0.15
X4897 VDPWR a_54459_40821# a_54446_41213# VDPWR sky130_fd_pr__pfet_01v8_hvt ad=0.0819 pd=0.81 as=0.0567 ps=0.69 w=0.42 l=0.15
X4898 a_20914_22464# a_20620_14376# ua[5] uio_oe[0] sky130_fd_pr__nfet_01v8 ad=0.1885 pd=1.88 as=0.1885 ps=1.88 w=0.65 l=0.15
X4899 a_60542_35229# a_60500_34837# a_59956_34837# uio_oe[0] sky130_fd_pr__nfet_01v8 ad=0.0441 pd=0.63 as=0.0693 ps=0.75 w=0.42 l=0.15
X4900 a_50304_38127# a_50090_38127# VDPWR VDPWR sky130_fd_pr__pfet_01v8_hvt ad=0.1155 pd=0.97 as=0.07035 ps=0.755 w=0.42 l=0.15
X4901 uio_oe[0] a_46193_39759# a_61341_36495# uio_oe[0] sky130_fd_pr__nfet_01v8 ad=0.1346 pd=1.15 as=0.0441 ps=0.63 w=0.42 l=0.15
X4902 a_50090_42301# a_49964_42203# a_49686_42187# uio_oe[0] sky130_fd_pr__special_nfet_01v8 ad=0.0999 pd=0.985 as=0.0711 ps=0.755 w=0.36 l=0.15
X4903 a_41143_38101# a_40987_38369# a_41288_38127# VDPWR sky130_fd_pr__pfet_01v8_hvt ad=0.07245 pd=0.765 as=0.1155 ps=0.97 w=0.42 l=0.15
X4904 a_43419_40607# a_39947_42997# VDPWR VDPWR sky130_fd_pr__pfet_01v8_hvt ad=0.0567 pd=0.69 as=0.0819 ps=0.81 w=0.42 l=0.15
X4905 uio_oe[0] a_51412_34471# a_50784_34568# uio_oe[0] sky130_fd_pr__nfet_01v8 ad=0.11285 pd=1.045 as=0.169 ps=1.82 w=0.65 l=0.15
X4906 a_48125_43023# a_47959_43023# uio_oe[0] uio_oe[0] sky130_fd_pr__nfet_01v8 ad=0.08775 pd=0.92 as=0.08775 ps=0.92 w=0.65 l=0.15
X4907 uio_oe[0] a_58864_41623# a_58298_41621# uio_oe[0] sky130_fd_pr__nfet_01v8 ad=0.11285 pd=1.045 as=0.169 ps=1.82 w=0.65 l=0.15
X4908 uio_oe[0] a_43695_38645# a_43629_38671# uio_oe[0] sky130_fd_pr__nfet_01v8 ad=0.12495 pd=1.015 as=0.0669 ps=0.75 w=0.42 l=0.15
X4909 VDPWR a_58298_37269# a_58248_37039# VDPWR sky130_fd_pr__pfet_01v8_hvt ad=0.2184 pd=2.2 as=0.12495 ps=1.175 w=0.84 l=0.15
X4910 a_49686_36747# a_49964_36763# a_49920_36861# VDPWR sky130_fd_pr__pfet_01v8_hvt ad=0.0588 pd=0.7 as=0.0567 ps=0.69 w=0.42 l=0.15
X4911 a_47283_42997# a_40379_35551# VDPWR VDPWR sky130_fd_pr__pfet_01v8_hvt ad=0.0567 pd=0.69 as=0.0819 ps=0.81 w=0.42 l=0.15
X4912 a_57757_36317# a_44905_38671# uio_oe[0] uio_oe[0] sky130_fd_pr__nfet_01v8 ad=0.0441 pd=0.63 as=0.1346 ps=1.15 w=0.42 l=0.15
X4913 a_57280_34685# a_56843_34293# VDPWR VDPWR sky130_fd_pr__pfet_01v8_hvt ad=0.0567 pd=0.69 as=0.0819 ps=0.81 w=0.42 l=0.15
X4914 a_38895_41757# a_38089_40623# a_38532_41623# uio_oe[0] sky130_fd_pr__nfet_01v8 ad=0.0693 pd=0.75 as=0.09975 ps=0.895 w=0.42 l=0.15
X4915 a_22306_26464# a_20620_10376# ua[5] uio_oe[0] sky130_fd_pr__nfet_01v8 ad=0.1885 pd=1.88 as=0.1885 ps=1.88 w=0.65 l=0.15
X4916 uio_oe[0] a_50159_35644# a_50090_35773# uio_oe[0] sky130_fd_pr__nfet_01v8 ad=0.1346 pd=1.15 as=0.0999 ps=0.985 w=0.64 l=0.15
X4917 a_21107_33007# a_17255_32793# uio_oe[0] uio_oe[0] sky130_fd_pr__nfet_01v8 ad=0.1092 pd=1.36 as=0.1092 ps=1.36 w=0.42 l=0.15
X4918 a_38674_40847# a_38005_40847# uio_oe[0] uio_oe[0] sky130_fd_pr__nfet_01v8 ad=0.0693 pd=0.75 as=0.11285 ps=1.045 w=0.42 l=0.15
X4919 a_57598_39581# a_57556_39189# a_57012_39189# uio_oe[0] sky130_fd_pr__nfet_01v8 ad=0.0441 pd=0.63 as=0.0693 ps=0.75 w=0.42 l=0.15
X4920 VDPWR a_58144_38920# a_58082_39037# VDPWR sky130_fd_pr__pfet_01v8_hvt ad=0.1092 pd=1.36 as=0.0651 ps=0.73 w=0.42 l=0.15
X4921 a_28884_33417# a_17500_33453# a_29026_33551# uio_oe[0] sky130_fd_pr__nfet_01v8 ad=0.09975 pd=0.895 as=0.0693 ps=0.75 w=0.42 l=0.15
X4922 uio_oe[0] a_48125_43023# a_49721_41935# uio_oe[0] sky130_fd_pr__nfet_01v8 ad=0.12495 pd=1.015 as=0.06405 ps=0.725 w=0.42 l=0.15
X4923 a_53005_40847# a_52579_41174# VDPWR VDPWR sky130_fd_pr__pfet_01v8_hvt ad=0.26 pd=2.52 as=0.15835 ps=1.395 w=1 l=0.15
X4924 a_42919_38369# a_38005_41391# VDPWR VDPWR sky130_fd_pr__pfet_01v8_hvt ad=0.1664 pd=1.8 as=0.0864 ps=0.91 w=0.64 l=0.15
X4925 a_22076_33417# a_18427_33198# a_22218_33224# VDPWR sky130_fd_pr__pfet_01v8_hvt ad=0.1932 pd=1.34 as=0.07665 ps=0.785 w=0.42 l=0.15
X4926 uio_oe[0] a_61819_39733# a_61753_39759# uio_oe[0] sky130_fd_pr__nfet_01v8 ad=0.12495 pd=1.015 as=0.0669 ps=0.75 w=0.42 l=0.15
X4927 a_61644_34319# a_60563_34319# a_61297_34561# VDPWR sky130_fd_pr__pfet_01v8_hvt ad=0.0588 pd=0.7 as=0.12915 ps=1.185 w=0.42 l=0.15
X4928 VDPWR a_57363_34461# a_57324_34587# VDPWR sky130_fd_pr__pfet_01v8_hvt ad=0.0864 pd=0.91 as=0.1664 ps=1.8 w=0.64 l=0.15
X4929 a_22535_34312# a_18420_33453# a_22076_34505# VDPWR sky130_fd_pr__pfet_01v8_hvt ad=0.0441 pd=0.63 as=0.1932 ps=1.34 w=0.42 l=0.15
X4930 a_38532_41623# a_38089_40623# a_38674_41430# VDPWR sky130_fd_pr__pfet_01v8_hvt ad=0.1932 pd=1.34 as=0.07665 ps=0.785 w=0.42 l=0.15
X4931 a_50159_41084# a_50003_40989# a_50304_41213# VDPWR sky130_fd_pr__pfet_01v8_hvt ad=0.07245 pd=0.765 as=0.1155 ps=0.97 w=0.42 l=0.15
X4932 a_25449_34571# a_25116_34505# VDPWR VDPWR sky130_fd_pr__pfet_01v8_hvt ad=0.1176 pd=1.4 as=0.0693 ps=0.75 w=0.42 l=0.15
X4933 VDPWR a_40379_35551# a_41288_38127# VDPWR sky130_fd_pr__pfet_01v8_hvt ad=0.07035 pd=0.755 as=0.1092 ps=1.36 w=0.42 l=0.15
X4934 a_43550_37583# a_43504_37735# uio_oe[0] uio_oe[0] sky130_fd_pr__nfet_01v8 ad=0.0693 pd=0.75 as=0.11285 ps=1.045 w=0.42 l=0.15
X4935 uio_oe[0] a_40617_35161# a_40551_35229# uio_oe[0] sky130_fd_pr__nfet_01v8 ad=0.1449 pd=1.11 as=0.0693 ps=0.75 w=0.42 l=0.15
X4936 uio_oe[0] clk a_41519_42479# uio_oe[0] sky130_fd_pr__nfet_01v8 ad=0.08775 pd=0.92 as=0.169 ps=1.82 w=0.65 l=0.15
X4937 VDPWR a_28700_33881# a_28651_33729# VDPWR sky130_fd_pr__pfet_01v8_hvt ad=0.15835 pd=1.395 as=0.26 ps=2.52 w=1 l=0.15
X4938 a_59231_36822# a_58980_36469# a_58772_36647# VDPWR sky130_fd_pr__pfet_01v8_hvt ad=0.0441 pd=0.63 as=0.1932 ps=1.34 w=0.42 l=0.15
X4939 a_52573_36317# a_52538_36083# a_52335_35925# uio_oe[0] sky130_fd_pr__nfet_01v8 ad=0.06405 pd=0.725 as=0.1092 ps=1.36 w=0.42 l=0.15
X4940 a_28396_10020# a_4259_22596# a_28218_10020# uio_oe[0] sky130_fd_pr__nfet_01v8 ad=0.2436 pd=2.26 as=0.2436 ps=2.26 w=0.84 l=0.6
X4941 VDPWR a_25940_34505# a_25044_34791# VDPWR sky130_fd_pr__pfet_01v8_hvt ad=0.15835 pd=1.395 as=0.26 ps=2.52 w=1 l=0.15
X4942 a_61766_40669# a_36661_41391# uio_oe[0] uio_oe[0] sky130_fd_pr__nfet_01v8 ad=0.0693 pd=0.75 as=0.11285 ps=1.045 w=0.42 l=0.15
X4943 ua[5] a_16756_18782# a_19410_18020# uio_oe[0] sky130_fd_pr__nfet_01v8 ad=0.1885 pd=1.88 as=0.1885 ps=1.88 w=0.65 l=0.15
X4944 VDPWR a_44905_38671# a_57664_35773# VDPWR sky130_fd_pr__pfet_01v8_hvt ad=0.07035 pd=0.755 as=0.1092 ps=1.36 w=0.42 l=0.15
X4945 a_42329_40847# a_42163_40847# VDPWR VDPWR sky130_fd_pr__pfet_01v8_hvt ad=0.1664 pd=1.8 as=0.0864 ps=0.91 w=0.64 l=0.15
X4946 uio_oe[0] a_53636_40277# a_53574_40303# uio_oe[0] sky130_fd_pr__nfet_01v8 ad=0.2205 pd=1.89 as=0.066 ps=0.745 w=0.42 l=0.15
X4947 a_37003_39189# a_36847_39457# a_37148_39215# VDPWR sky130_fd_pr__pfet_01v8_hvt ad=0.07245 pd=0.765 as=0.1155 ps=0.97 w=0.42 l=0.15
X4948 VDPWR a_43075_38101# a_43006_38127# VDPWR sky130_fd_pr__pfet_01v8_hvt ad=0.2184 pd=2.2 as=0.12915 ps=1.185 w=0.84 l=0.15
X4949 a_20618_24730# ua[2] a_20490_26020# uio_oe[0] sky130_fd_pr__nfet_01v8 ad=0.2436 pd=2.26 as=0.2436 ps=2.26 w=0.84 l=0.6
X4950 VDPWR a_37913_41935# a_60563_34319# VDPWR sky130_fd_pr__pfet_01v8_hvt ad=0.0864 pd=0.91 as=0.1664 ps=1.8 w=0.64 l=0.15
X4951 uio_oe[0] a_57012_34837# a_57148_34863# uio_oe[0] sky130_fd_pr__nfet_01v8 ad=0.1137 pd=1.01 as=0.1404 ps=1.6 w=0.54 l=0.15
X4952 VDPWR a_48125_43023# a_56843_41909# VDPWR sky130_fd_pr__pfet_01v8_hvt ad=0.0819 pd=0.81 as=0.0567 ps=0.69 w=0.42 l=0.15
X4953 a_59201_41909# a_48677_39759# VDPWR VDPWR sky130_fd_pr__pfet_01v8_hvt ad=0.1176 pd=1.4 as=0.0693 ps=0.75 w=0.42 l=0.15
X4954 VDPWR a_43419_41695# a_43406_41391# VDPWR sky130_fd_pr__pfet_01v8_hvt ad=0.0819 pd=0.81 as=0.0567 ps=0.69 w=0.42 l=0.15
X4955 uio_oe[0] a_57519_41084# a_57450_41213# uio_oe[0] sky130_fd_pr__nfet_01v8 ad=0.1346 pd=1.15 as=0.0999 ps=0.985 w=0.64 l=0.15
X4956 a_37029_37583# a_36999_37557# uio_oe[0] uio_oe[0] sky130_fd_pr__nfet_01v8 ad=0.08775 pd=0.92 as=0.08775 ps=0.92 w=0.65 l=0.15
X4957 a_53815_34319# a_53369_34319# a_53719_34319# uio_oe[0] sky130_fd_pr__special_nfet_01v8 ad=0.1401 pd=1.1 as=0.0594 ps=0.69 w=0.36 l=0.15
X4958 a_53981_35407# a_53937_35649# a_53815_35407# uio_oe[0] sky130_fd_pr__nfet_01v8 ad=0.0441 pd=0.63 as=0.1401 ps=1.1 w=0.42 l=0.15
X4959 a_60365_40847# a_59939_41174# uio_oe[0] uio_oe[0] sky130_fd_pr__nfet_01v8 ad=0.169 pd=1.82 as=0.11285 ps=1.045 w=0.65 l=0.15
X4960 a_28642_18464# a_28348_18376# ua[4] uio_oe[0] sky130_fd_pr__nfet_01v8 ad=0.1885 pd=1.88 as=0.1885 ps=1.88 w=0.65 l=0.15
X4961 a_29026_33551# a_28980_33417# uio_oe[0] uio_oe[0] sky130_fd_pr__nfet_01v8 ad=0.0693 pd=0.75 as=0.11285 ps=1.045 w=0.42 l=0.15
X4962 uio_oe[0] a_58298_35093# a_58248_34863# uio_oe[0] sky130_fd_pr__nfet_01v8 ad=0.1664 pd=1.8 as=0.0935 ps=0.965 w=0.64 l=0.15
X4963 a_43598_41935# a_39947_42997# uio_oe[0] uio_oe[0] sky130_fd_pr__nfet_01v8 ad=0.06405 pd=0.725 as=0.12495 ps=1.015 w=0.42 l=0.15
X4964 VDPWR a_43695_38645# a_43682_39037# VDPWR sky130_fd_pr__pfet_01v8_hvt ad=0.0819 pd=0.81 as=0.0567 ps=0.69 w=0.42 l=0.15
X4965 a_39739_43023# a_39293_43023# a_39643_43023# uio_oe[0] sky130_fd_pr__special_nfet_01v8 ad=0.1401 pd=1.1 as=0.0594 ps=0.69 w=0.36 l=0.15
X4966 a_57450_40125# a_57324_40027# a_57046_40011# uio_oe[0] sky130_fd_pr__special_nfet_01v8 ad=0.0999 pd=0.985 as=0.0711 ps=0.755 w=0.36 l=0.15
X4967 VDPWR a_44327_38359# a_45719_39447# VDPWR sky130_fd_pr__pfet_01v8_hvt ad=0.1176 pd=1.4 as=0.0567 ps=0.69 w=0.42 l=0.15
X4968 a_23698_18464# a_20620_18376# ua[5] uio_oe[0] sky130_fd_pr__nfet_01v8 ad=0.1885 pd=1.88 as=0.1885 ps=1.88 w=0.65 l=0.15
X4969 VDPWR a_54459_34293# a_54446_34685# VDPWR sky130_fd_pr__pfet_01v8_hvt ad=0.0819 pd=0.81 as=0.0567 ps=0.69 w=0.42 l=0.15
X4970 a_61998_38671# a_48125_41935# uio_oe[0] uio_oe[0] sky130_fd_pr__nfet_01v8 ad=0.06405 pd=0.725 as=0.12495 ps=1.015 w=0.42 l=0.15
X4971 a_49483_40821# a_49686_41099# VDPWR VDPWR sky130_fd_pr__pfet_01v8_hvt ad=0.0567 pd=0.69 as=0.1134 ps=1.38 w=0.42 l=0.15
X4972 a_59939_41174# a_51620_40821# a_59939_40847# uio_oe[0] sky130_fd_pr__nfet_01v8 ad=0.09975 pd=0.895 as=0.0693 ps=0.75 w=0.42 l=0.15
X4973 a_58980_41909# a_61819_41909# uio_oe[0] uio_oe[0] sky130_fd_pr__nfet_01v8 ad=0.169 pd=1.82 as=0.2087 ps=2.02 w=0.65 l=0.15
X4974 VDPWR a_61808_41623# a_61242_41621# VDPWR sky130_fd_pr__pfet_01v8_hvt ad=0.15835 pd=1.395 as=0.26 ps=2.52 w=1 l=0.15
X4975 a_28642_18464# a_4259_22596# a_28346_16730# uio_oe[0] sky130_fd_pr__nfet_01v8 ad=0.2436 pd=2.26 as=0.2436 ps=2.26 w=0.84 l=0.6
X4976 a_24836_34969# a_25044_34791# a_24978_34817# uio_oe[0] sky130_fd_pr__nfet_01v8 ad=0.09975 pd=0.895 as=0.0693 ps=0.75 w=0.42 l=0.15
X4977 uio_oe[0] a_40379_35551# a_42941_43023# uio_oe[0] sky130_fd_pr__nfet_01v8 ad=0.1346 pd=1.15 as=0.0441 ps=0.63 w=0.42 l=0.15
X4978 uio_oe[0] a_40987_39901# a_40948_40027# uio_oe[0] sky130_fd_pr__nfet_01v8 ad=0.0567 pd=0.69 as=0.1092 ps=1.36 w=0.42 l=0.15
X4979 uio_oe[0] a_48125_41935# a_53981_39759# uio_oe[0] sky130_fd_pr__nfet_01v8 ad=0.1346 pd=1.15 as=0.0441 ps=0.63 w=0.42 l=0.15
X4980 a_42513_39221# a_42347_39221# uio_oe[0] uio_oe[0] sky130_fd_pr__nfet_01v8 ad=0.1092 pd=1.36 as=0.0567 ps=0.69 w=0.42 l=0.15
X4981 a_25162_36815# a_25116_36681# uio_oe[0] uio_oe[0] sky130_fd_pr__nfet_01v8 ad=0.0693 pd=0.75 as=0.11285 ps=1.045 w=0.42 l=0.15
X4982 VDPWR a_37361_41391# a_59685_34646# VDPWR sky130_fd_pr__pfet_01v8_hvt ad=0.0693 pd=0.75 as=0.1176 ps=1.4 w=0.42 l=0.15
X4983 a_43406_43389# a_42329_43023# a_43244_43023# VDPWR sky130_fd_pr__pfet_01v8_hvt ad=0.0567 pd=0.69 as=0.0588 ps=0.7 w=0.42 l=0.15
X4984 a_36999_38101# a_37335_37557# uio_oe[0] uio_oe[0] sky130_fd_pr__nfet_01v8 ad=0.169 pd=1.82 as=0.08775 ps=0.92 w=0.65 l=0.15
X4985 uio_oe[0] uio_oe[0] uio_oe[0] uio_oe[0] sky130_fd_pr__nfet_01v8 ad=1.4703 pd=10.72 as=0 ps=0 w=5.07 l=1
X4986 ua[4] a_28348_14782# a_28218_14020# uio_oe[0] sky130_fd_pr__nfet_01v8 ad=0.1885 pd=1.88 as=0.1885 ps=1.88 w=0.65 l=0.15
X4987 a_45351_41695# a_45176_41769# a_45530_41757# uio_oe[0] sky130_fd_pr__nfet_01v8 ad=0.1092 pd=1.36 as=0.06405 ps=0.725 w=0.42 l=0.15
X4988 VDPWR a_36607_39455# a_37148_39215# VDPWR sky130_fd_pr__pfet_01v8_hvt ad=0.07035 pd=0.755 as=0.1092 ps=1.36 w=0.42 l=0.15
X4989 VDPWR a_41108_35095# a_41059_34863# VDPWR sky130_fd_pr__pfet_01v8_hvt ad=0.15835 pd=1.395 as=0.26 ps=2.52 w=1 l=0.15
X4990 VDPWR a_20923_33729# a_22395_34095# VDPWR sky130_fd_pr__pfet_01v8_hvt ad=0.0714 pd=0.76 as=0.1092 ps=1.36 w=0.42 l=0.15
X4991 a_17471_33729# a_17243_33185# a_17108_33881# uio_oe[0] sky130_fd_pr__nfet_01v8 ad=0.0693 pd=0.75 as=0.09975 ps=0.895 w=0.42 l=0.15
X4992 a_61079_38671# a_60729_38671# a_60984_38671# VDPWR sky130_fd_pr__pfet_01v8_hvt ad=0.07245 pd=0.765 as=0.0651 ps=0.73 w=0.42 l=0.15
X4993 uio_oe[0] a_36327_35381# a_21345_32899# uio_oe[0] sky130_fd_pr__nfet_01v8 ad=0.1013 pd=0.99 as=0.169 ps=1.82 w=0.65 l=0.15
X4994 a_17050_10464# a_16756_10376# ua[4] uio_oe[0] sky130_fd_pr__nfet_01v8 ad=0.1885 pd=1.88 as=0.1885 ps=1.88 w=0.65 l=0.15
X4995 a_54693_36249# a_37361_41391# VDPWR VDPWR sky130_fd_pr__pfet_01v8_hvt ad=0.1176 pd=1.4 as=0.0693 ps=0.75 w=0.42 l=0.15
X4996 a_46543_43023# a_46027_43023# a_46448_43023# uio_oe[0] sky130_fd_pr__special_nfet_01v8 ad=0.0594 pd=0.69 as=0.066 ps=0.745 w=0.36 l=0.15
X4997 a_46761_42453# a_46543_42857# VDPWR VDPWR sky130_fd_pr__pfet_01v8_hvt ad=0.12915 pd=1.185 as=0.2184 ps=2.2 w=0.84 l=0.15
X4998 VDPWR a_41141_40316# a_43357_37039# VDPWR sky130_fd_pr__pfet_01v8_hvt ad=0.135 pd=1.27 as=0.135 ps=1.27 w=1 l=0.15
X4999 a_22010_24730# ua[2] a_21882_26020# uio_oe[0] sky130_fd_pr__nfet_01v8 ad=0.2436 pd=2.26 as=0.2436 ps=2.26 w=0.84 l=0.6
X5000 uio_oe[0] a_50159_42453# a_50090_42479# uio_oe[0] sky130_fd_pr__nfet_01v8 ad=0.1346 pd=1.15 as=0.0999 ps=0.985 w=0.64 l=0.15
X5001 a_30123_37359# a_28651_36993# uio_oe[0] uio_oe[0] sky130_fd_pr__nfet_01v8 ad=0.1092 pd=1.36 as=0.1092 ps=1.36 w=0.42 l=0.15
X5002 VDPWR a_42685_36611# a_42989_35951# VDPWR sky130_fd_pr__pfet_01v8_hvt ad=0.135 pd=1.27 as=0.135 ps=1.27 w=1 l=0.15
X5003 uio_oe[0] a_17108_33881# a_17059_33729# uio_oe[0] sky130_fd_pr__nfet_01v8 ad=0.11285 pd=1.045 as=0.169 ps=1.82 w=0.65 l=0.15
X5004 uio_oe[0] a_37361_41391# a_59685_34646# uio_oe[0] sky130_fd_pr__nfet_01v8 ad=0.1449 pd=1.11 as=0.1092 ps=1.36 w=0.42 l=0.15
X5005 a_50159_34556# a_50003_34461# a_50304_34685# VDPWR sky130_fd_pr__pfet_01v8_hvt ad=0.07245 pd=0.765 as=0.1155 ps=0.97 w=0.42 l=0.15
X5006 VDPWR a_39783_34321# a_39555_34471# VDPWR sky130_fd_pr__pfet_01v8_hvt ad=0.1176 pd=1.4 as=0.0567 ps=0.69 w=0.42 l=0.15
X5007 a_39751_43389# a_39947_42997# VDPWR VDPWR sky130_fd_pr__pfet_01v8_hvt ad=0.1092 pd=1.36 as=0.07035 ps=0.755 w=0.42 l=0.15
X5008 uio_oe[0] a_50003_42721# a_49964_42595# uio_oe[0] sky130_fd_pr__nfet_01v8 ad=0.0567 pd=0.69 as=0.1092 ps=1.36 w=0.42 l=0.15
X5009 a_58082_42479# a_57363_42721# a_57519_42453# uio_oe[0] sky130_fd_pr__special_nfet_01v8 ad=0.066 pd=0.745 as=0.0594 ps=0.69 w=0.36 l=0.15
X5010 uio_oe[0] a_43419_41909# a_43353_41935# uio_oe[0] sky130_fd_pr__nfet_01v8 ad=0.12495 pd=1.015 as=0.0669 ps=0.75 w=0.42 l=0.15
X5011 a_54284_37583# a_53203_37583# a_53937_37825# VDPWR sky130_fd_pr__pfet_01v8_hvt ad=0.0588 pd=0.7 as=0.12915 ps=1.185 w=0.42 l=0.15
X5012 a_41039_37039# a_40379_35551# VDPWR VDPWR sky130_fd_pr__pfet_01v8_hvt ad=0.1092 pd=1.36 as=0.07035 ps=0.755 w=0.42 l=0.15
X5013 a_50159_37013# a_49964_37155# a_50469_37405# uio_oe[0] sky130_fd_pr__special_nfet_01v8 ad=0.0594 pd=0.69 as=0.1401 ps=1.1 w=0.36 l=0.15
X5014 a_17050_10464# ua[3] a_16804_10020# uio_oe[0] sky130_fd_pr__nfet_01v8 ad=0.2436 pd=2.26 as=0.2436 ps=2.26 w=0.84 l=0.6
X5015 a_50722_42479# a_50003_42721# a_50159_42453# uio_oe[0] sky130_fd_pr__special_nfet_01v8 ad=0.066 pd=0.745 as=0.0594 ps=0.69 w=0.36 l=0.15
X5016 VDPWR a_60371_42453# a_60302_42479# VDPWR sky130_fd_pr__pfet_01v8_hvt ad=0.2184 pd=2.2 as=0.12915 ps=1.185 w=0.84 l=0.15
X5017 uio_oe[0] a_61819_38645# a_61753_38671# uio_oe[0] sky130_fd_pr__nfet_01v8 ad=0.12495 pd=1.015 as=0.0669 ps=0.75 w=0.42 l=0.15
X5018 a_42897_42177# a_42679_41935# VDPWR VDPWR sky130_fd_pr__pfet_01v8_hvt ad=0.12915 pd=1.185 as=0.2184 ps=2.2 w=0.84 l=0.15
X5019 a_49961_41757# a_49483_41365# uio_oe[0] uio_oe[0] sky130_fd_pr__nfet_01v8 ad=0.0669 pd=0.75 as=0.12495 ps=1.015 w=0.42 l=0.15
X5020 a_39686_38493# a_38005_40847# uio_oe[0] uio_oe[0] sky130_fd_pr__nfet_01v8 ad=0.0693 pd=0.75 as=0.11285 ps=1.045 w=0.42 l=0.15
X5021 a_50090_38127# a_50003_38369# a_49686_38259# VDPWR sky130_fd_pr__pfet_01v8_hvt ad=0.12915 pd=1.185 as=0.0588 ps=0.7 w=0.42 l=0.15
X5022 VDPWR a_39973_36469# a_40003_36822# VDPWR sky130_fd_pr__pfet_01v8_hvt ad=0.0693 pd=0.75 as=0.0441 ps=0.63 w=0.42 l=0.15
X5023 a_44725_40009# a_42696_37557# VDPWR VDPWR sky130_fd_pr__pfet_01v8_hvt ad=0.135 pd=1.27 as=0.135 ps=1.27 w=1 l=0.15
X5024 uio_oe[0] a_37747_43023# a_37913_43023# uio_oe[0] sky130_fd_pr__nfet_01v8 ad=0.169 pd=1.82 as=0.08775 ps=0.92 w=0.65 l=0.15
X5025 a_58914_40086# a_48677_39759# VDPWR VDPWR sky130_fd_pr__pfet_01v8_hvt ad=0.07665 pd=0.785 as=0.15835 ps=1.395 w=0.42 l=0.15
X5026 a_43081_39189# a_42863_39593# VDPWR VDPWR sky130_fd_pr__pfet_01v8_hvt ad=0.12915 pd=1.185 as=0.2184 ps=2.2 w=0.84 l=0.15
X5027 a_58248_39215# a_57472_39493# a_57640_39529# uio_oe[0] sky130_fd_pr__special_nfet_01v8 ad=0.0935 pd=0.965 as=0.072 ps=0.76 w=0.36 l=0.15
X5028 VDPWR a_53636_35925# a_53574_35951# VDPWR sky130_fd_pr__pfet_01v8_hvt ad=0.1092 pd=1.36 as=0.0651 ps=0.73 w=0.42 l=0.15
X5029 uio_oe[0] a_60215_36193# a_60176_36067# uio_oe[0] sky130_fd_pr__nfet_01v8 ad=0.0567 pd=0.69 as=0.1092 ps=1.36 w=0.42 l=0.15
X5030 a_60934_35951# a_60215_36193# a_60371_35925# uio_oe[0] sky130_fd_pr__special_nfet_01v8 ad=0.066 pd=0.745 as=0.0594 ps=0.69 w=0.36 l=0.15
X5031 ua[5] a_28348_10782# a_28218_26020# uio_oe[0] sky130_fd_pr__nfet_01v8 ad=0.1885 pd=1.88 as=0.1885 ps=1.88 w=0.65 l=0.15
X5032 a_29026_34312# a_28980_34505# VDPWR VDPWR sky130_fd_pr__pfet_01v8_hvt ad=0.07665 pd=0.785 as=0.15835 ps=1.395 w=0.42 l=0.15
X5033 a_24978_34817# a_24932_34969# uio_oe[0] uio_oe[0] sky130_fd_pr__nfet_01v8 ad=0.0693 pd=0.75 as=0.11285 ps=1.045 w=0.42 l=0.15
X5034 a_57519_37820# a_57363_37725# a_57664_37949# VDPWR sky130_fd_pr__pfet_01v8_hvt ad=0.07245 pd=0.765 as=0.1155 ps=0.97 w=0.42 l=0.15
X5035 VDPWR a_17255_32793# a_28835_33007# VDPWR sky130_fd_pr__pfet_01v8_hvt ad=0.0714 pd=0.76 as=0.1092 ps=1.36 w=0.42 l=0.15
X5036 a_46543_42857# a_46027_42485# a_46448_42845# uio_oe[0] sky130_fd_pr__special_nfet_01v8 ad=0.0594 pd=0.69 as=0.066 ps=0.745 w=0.36 l=0.15
X5037 uio_oe[0] a_38961_38425# a_38895_38493# uio_oe[0] sky130_fd_pr__nfet_01v8 ad=0.1449 pd=1.11 as=0.0693 ps=0.75 w=0.42 l=0.15
X5038 VDPWR a_44905_38671# a_56843_35381# VDPWR sky130_fd_pr__pfet_01v8_hvt ad=0.0819 pd=0.81 as=0.0567 ps=0.69 w=0.42 l=0.15
X5039 uio_oe[0] a_60416_41669# a_60500_41365# uio_oe[0] sky130_fd_pr__nfet_01v8 ad=0.0567 pd=0.69 as=0.1092 ps=1.36 w=0.42 l=0.15
X5040 a_38285_38671# a_37859_38998# uio_oe[0] uio_oe[0] sky130_fd_pr__nfet_01v8 ad=0.169 pd=1.82 as=0.11285 ps=1.045 w=0.65 l=0.15
X5041 VDPWR a_54284_38671# a_54459_38645# VDPWR sky130_fd_pr__pfet_01v8_hvt ad=0.1134 pd=1.38 as=0.0567 ps=0.69 w=0.42 l=0.15
X5042 a_17050_22464# a_16756_14376# ua[5] uio_oe[0] sky130_fd_pr__nfet_01v8 ad=0.1885 pd=1.88 as=0.1885 ps=1.88 w=0.65 l=0.15
X5043 a_43353_43023# a_42163_43023# a_43244_43023# uio_oe[0] sky130_fd_pr__special_nfet_01v8 ad=0.0669 pd=0.75 as=0.0711 ps=0.755 w=0.36 l=0.15
X5044 a_38532_37735# a_38740_37557# a_38674_37583# uio_oe[0] sky130_fd_pr__nfet_01v8 ad=0.09975 pd=0.895 as=0.0693 ps=0.75 w=0.42 l=0.15
X5045 a_39973_41909# a_38005_40847# uio_oe[0] uio_oe[0] sky130_fd_pr__nfet_01v8 ad=0.1092 pd=1.36 as=0.1449 ps=1.11 w=0.42 l=0.15
X5046 a_39751_43389# a_39127_43023# a_39643_43023# VDPWR sky130_fd_pr__pfet_01v8_hvt ad=0.1155 pd=0.97 as=0.07245 ps=0.765 w=0.42 l=0.15
X5047 a_20620_14782# a_22575_36271# VDPWR VDPWR sky130_fd_pr__pfet_01v8_hvt ad=0.26 pd=2.52 as=0.2279 ps=1.74 w=1 l=0.15
X5048 a_51554_38493# a_48677_38127# uio_oe[0] uio_oe[0] sky130_fd_pr__nfet_01v8 ad=0.0693 pd=0.75 as=0.11285 ps=1.045 w=0.42 l=0.15
X5049 uio_oe[0] a_58144_41096# a_58082_41213# uio_oe[0] sky130_fd_pr__nfet_01v8 ad=0.2205 pd=1.89 as=0.066 ps=0.745 w=0.42 l=0.15
X5050 a_57280_40303# a_56843_40277# VDPWR VDPWR sky130_fd_pr__pfet_01v8_hvt ad=0.0567 pd=0.69 as=0.0819 ps=0.81 w=0.42 l=0.15
X5051 a_60638_39215# a_60416_39493# a_59956_39189# VDPWR sky130_fd_pr__pfet_01v8_hvt ad=0.0483 pd=0.65 as=0.0819 ps=0.81 w=0.42 l=0.15
X5052 a_57519_42453# a_57324_42595# a_57829_42845# uio_oe[0] sky130_fd_pr__special_nfet_01v8 ad=0.0594 pd=0.69 as=0.1401 ps=1.1 w=0.36 l=0.15
X5053 uio_oe[0] a_37183_40277# a_36607_39455# uio_oe[0] sky130_fd_pr__nfet_01v8 ad=0.08775 pd=0.92 as=0.08775 ps=0.92 w=0.65 l=0.15
X5054 a_49483_34293# a_49686_34571# VDPWR VDPWR sky130_fd_pr__pfet_01v8_hvt ad=0.0567 pd=0.69 as=0.1134 ps=1.38 w=0.42 l=0.15
X5055 a_60215_38369# a_37913_41935# uio_oe[0] uio_oe[0] sky130_fd_pr__nfet_01v8 ad=0.1092 pd=1.36 as=0.0567 ps=0.69 w=0.42 l=0.15
X5056 a_58082_36861# a_57363_36637# a_57519_36732# uio_oe[0] sky130_fd_pr__special_nfet_01v8 ad=0.066 pd=0.745 as=0.0594 ps=0.69 w=0.36 l=0.15
X5057 VDPWR a_17537_35879# a_17567_36232# VDPWR sky130_fd_pr__pfet_01v8_hvt ad=0.0693 pd=0.75 as=0.0441 ps=0.63 w=0.42 l=0.15
X5058 a_57450_39037# a_57324_38939# a_57046_38923# uio_oe[0] sky130_fd_pr__special_nfet_01v8 ad=0.0999 pd=0.985 as=0.0711 ps=0.755 w=0.36 l=0.15
X5059 a_41143_38101# a_40948_38243# a_41453_38493# uio_oe[0] sky130_fd_pr__special_nfet_01v8 ad=0.0594 pd=0.69 as=0.1401 ps=1.1 w=0.36 l=0.15
X5060 a_50722_36861# a_50003_36637# a_50159_36732# uio_oe[0] sky130_fd_pr__special_nfet_01v8 ad=0.066 pd=0.745 as=0.0594 ps=0.69 w=0.36 l=0.15
X5061 a_36999_42453# clk VDPWR VDPWR sky130_fd_pr__pfet_01v8_hvt ad=0.26 pd=2.52 as=0.135 ps=1.27 w=1 l=0.15
X5062 a_16756_18376# a_18711_35183# uio_oe[0] uio_oe[0] sky130_fd_pr__nfet_01v8 ad=0.169 pd=1.82 as=0.1013 ps=0.99 w=0.65 l=0.15
X5063 a_21156_34505# a_17500_33453# a_21298_34639# uio_oe[0] sky130_fd_pr__nfet_01v8 ad=0.09975 pd=0.895 as=0.0693 ps=0.75 w=0.42 l=0.15
X5064 a_43353_42857# a_42163_42485# a_43244_42857# uio_oe[0] sky130_fd_pr__special_nfet_01v8 ad=0.0669 pd=0.75 as=0.0711 ps=0.755 w=0.36 l=0.15
X5065 a_36875_38823# a_43419_40607# VDPWR VDPWR sky130_fd_pr__pfet_01v8_hvt ad=0.26 pd=2.52 as=0.3012 ps=2.66 w=1 l=0.15
X5066 uio_oe[0] a_40379_35551# a_41193_37405# uio_oe[0] sky130_fd_pr__nfet_01v8 ad=0.1346 pd=1.15 as=0.0441 ps=0.63 w=0.42 l=0.15
X5067 uio_oe[0] a_36661_41391# a_52325_42262# uio_oe[0] sky130_fd_pr__nfet_01v8 ad=0.1449 pd=1.11 as=0.1092 ps=1.36 w=0.42 l=0.15
X5068 a_37566_40125# a_36847_39901# a_37003_39996# uio_oe[0] sky130_fd_pr__special_nfet_01v8 ad=0.066 pd=0.745 as=0.0594 ps=0.69 w=0.36 l=0.15
X5069 uio_oe[0] a_48125_41935# a_53981_38671# uio_oe[0] sky130_fd_pr__nfet_01v8 ad=0.1346 pd=1.15 as=0.0441 ps=0.63 w=0.42 l=0.15
X5070 a_37085_35951# a_36919_35951# VDPWR VDPWR sky130_fd_pr__pfet_01v8_hvt ad=0.135 pd=1.27 as=0.135 ps=1.27 w=1 l=0.15
X5071 a_18212_35593# a_18420_33453# a_18354_35727# uio_oe[0] sky130_fd_pr__nfet_01v8 ad=0.09975 pd=0.895 as=0.0693 ps=0.75 w=0.42 l=0.15
X5072 VDPWR a_17255_32793# a_37195_35773# VDPWR sky130_fd_pr__pfet_01v8_hvt ad=0.0714 pd=0.76 as=0.1092 ps=1.36 w=0.42 l=0.15
X5073 a_52800_35407# a_51620_35381# a_52579_35734# uio_oe[0] sky130_fd_pr__nfet_01v8 ad=0.0693 pd=0.75 as=0.09975 ps=0.895 w=0.42 l=0.15
X5074 uio_oe[0] a_48511_38127# a_48677_38127# uio_oe[0] sky130_fd_pr__nfet_01v8 ad=0.08775 pd=0.92 as=0.08775 ps=0.92 w=0.65 l=0.15
X5075 VDPWR a_52855_38369# a_52816_38243# VDPWR sky130_fd_pr__pfet_01v8_hvt ad=0.0864 pd=0.91 as=0.1664 ps=1.8 w=0.64 l=0.15
X5076 a_53624_36495# a_53005_36495# uio_oe[0] uio_oe[0] sky130_fd_pr__nfet_01v8 ad=0.066 pd=0.745 as=0.2205 ps=1.89 w=0.42 l=0.15
X5077 VDPWR a_25020_33417# a_24971_33185# VDPWR sky130_fd_pr__pfet_01v8_hvt ad=0.15835 pd=1.395 as=0.26 ps=2.52 w=1 l=0.15
X5078 a_41593_41097# a_41224_41659# VDPWR VDPWR sky130_fd_pr__pfet_01v8_hvt ad=0.135 pd=1.27 as=0.135 ps=1.27 w=1 l=0.15
X5079 a_39686_39254# a_38005_40847# VDPWR VDPWR sky130_fd_pr__pfet_01v8_hvt ad=0.07665 pd=0.785 as=0.15835 ps=1.395 w=0.42 l=0.15
X5080 a_17250_34056# a_17204_33881# VDPWR VDPWR sky130_fd_pr__pfet_01v8_hvt ad=0.07665 pd=0.785 as=0.15835 ps=1.395 w=0.42 l=0.15
X5081 a_26082_34639# a_25116_34505# uio_oe[0] uio_oe[0] sky130_fd_pr__nfet_01v8 ad=0.0693 pd=0.75 as=0.11285 ps=1.045 w=0.42 l=0.15
X5082 VDPWR a_59201_40601# a_59231_40342# VDPWR sky130_fd_pr__pfet_01v8_hvt ad=0.0693 pd=0.75 as=0.0441 ps=0.63 w=0.42 l=0.15
X5083 ua[5] a_29740_18376# a_29610_18020# uio_oe[0] sky130_fd_pr__nfet_01v8 ad=0.1885 pd=1.88 as=0.1885 ps=1.88 w=0.65 l=0.15
X5084 VDPWR a_51841_40601# a_51871_40342# VDPWR sky130_fd_pr__pfet_01v8_hvt ad=0.0693 pd=0.75 as=0.0441 ps=0.63 w=0.42 l=0.15
X5085 a_47270_41213# a_46193_40847# a_47108_40847# VDPWR sky130_fd_pr__pfet_01v8_hvt ad=0.0567 pd=0.69 as=0.0588 ps=0.7 w=0.42 l=0.15
X5086 a_49721_39581# a_49686_39347# a_49483_39189# uio_oe[0] sky130_fd_pr__nfet_01v8 ad=0.06405 pd=0.725 as=0.1092 ps=1.36 w=0.42 l=0.15
X5087 a_27562_22464# a_24484_14782# ua[4] uio_oe[0] sky130_fd_pr__nfet_01v8 ad=0.1885 pd=1.88 as=0.1885 ps=1.88 w=0.65 l=0.15
X5088 a_41057_34569# a_37795_40535# a_40975_34569# VDPWR sky130_fd_pr__pfet_01v8_hvt ad=0.135 pd=1.27 as=0.26 ps=2.52 w=1 l=0.15
X5089 a_46761_41365# a_46543_41769# VDPWR VDPWR sky130_fd_pr__pfet_01v8_hvt ad=0.12915 pd=1.185 as=0.2184 ps=2.2 w=0.84 l=0.15
X5090 VDPWR a_57519_40277# a_57450_40303# VDPWR sky130_fd_pr__pfet_01v8_hvt ad=0.2184 pd=2.2 as=0.12915 ps=1.185 w=0.84 l=0.15
X5091 a_52793_40086# a_51620_40571# a_52579_40086# VDPWR sky130_fd_pr__pfet_01v8_hvt ad=0.07665 pd=0.785 as=0.1932 ps=1.34 w=0.42 l=0.15
X5092 a_37859_38671# a_37605_38998# uio_oe[0] uio_oe[0] sky130_fd_pr__nfet_01v8 ad=0.0693 pd=0.75 as=0.1449 ps=1.11 w=0.42 l=0.15
X5093 a_58864_37271# a_39752_37307# a_59006_37078# VDPWR sky130_fd_pr__pfet_01v8_hvt ad=0.1932 pd=1.34 as=0.07665 ps=0.785 w=0.42 l=0.15
X5094 a_18442_14464# a_16756_10782# ua[5] uio_oe[0] sky130_fd_pr__nfet_01v8 ad=0.1885 pd=1.88 as=0.1885 ps=1.88 w=0.65 l=0.15
X5095 a_61079_39759# a_60563_39759# a_60984_39759# uio_oe[0] sky130_fd_pr__special_nfet_01v8 ad=0.0594 pd=0.69 as=0.066 ps=0.745 w=0.36 l=0.15
X5096 a_38991_39254# a_38740_39483# a_38532_39447# VDPWR sky130_fd_pr__pfet_01v8_hvt ad=0.0441 pd=0.63 as=0.1932 ps=1.34 w=0.42 l=0.15
X5097 a_38961_38425# a_37029_37583# VDPWR VDPWR sky130_fd_pr__pfet_01v8_hvt ad=0.1176 pd=1.4 as=0.0693 ps=0.75 w=0.42 l=0.15
X5098 a_44873_43023# a_44829_43265# a_44707_43023# uio_oe[0] sky130_fd_pr__nfet_01v8 ad=0.0441 pd=0.63 as=0.1401 ps=1.1 w=0.42 l=0.15
X5099 a_52813_42845# a_52335_42453# uio_oe[0] uio_oe[0] sky130_fd_pr__nfet_01v8 ad=0.0669 pd=0.75 as=0.12495 ps=1.015 w=0.42 l=0.15
X5100 a_61766_40342# a_36661_41391# VDPWR VDPWR sky130_fd_pr__pfet_01v8_hvt ad=0.07665 pd=0.785 as=0.15835 ps=1.395 w=0.42 l=0.15
X5101 a_58772_39911# a_38740_39733# a_58914_40086# VDPWR sky130_fd_pr__pfet_01v8_hvt ad=0.1932 pd=1.34 as=0.07665 ps=0.785 w=0.42 l=0.15
X5102 a_54284_36495# a_53203_36495# a_53937_36737# VDPWR sky130_fd_pr__pfet_01v8_hvt ad=0.0588 pd=0.7 as=0.12915 ps=1.185 w=0.42 l=0.15
X5103 a_42864_36495# a_42613_36724# a_42643_36822# uio_oe[0] sky130_fd_pr__nfet_01v8 ad=0.0693 pd=0.75 as=0.09975 ps=0.895 w=0.42 l=0.15
X5104 a_57519_36732# a_57324_36763# a_57829_36495# uio_oe[0] sky130_fd_pr__special_nfet_01v8 ad=0.0594 pd=0.69 as=0.1401 ps=1.1 w=0.36 l=0.15
X5105 VDPWR a_51412_36183# a_50784_35925# VDPWR sky130_fd_pr__pfet_01v8_hvt ad=0.15835 pd=1.395 as=0.26 ps=2.52 w=1 l=0.15
X5106 a_60374_41757# a_60092_41391# a_60298_41757# uio_oe[0] sky130_fd_pr__nfet_01v8 ad=0.0441 pd=0.63 as=0.0483 ps=0.65 w=0.42 l=0.15
X5107 a_27562_22464# a_4259_22596# a_27266_20730# uio_oe[0] sky130_fd_pr__nfet_01v8 ad=0.2436 pd=2.26 as=0.2436 ps=2.26 w=0.84 l=0.6
X5108 a_42513_39759# a_42347_39759# uio_oe[0] uio_oe[0] sky130_fd_pr__nfet_01v8 ad=0.1092 pd=1.36 as=0.0567 ps=0.69 w=0.42 l=0.15
X5109 a_40619_35549# a_38005_41391# uio_oe[0] uio_oe[0] sky130_fd_pr__nfet_01v8 ad=0.1092 pd=1.36 as=0.0567 ps=0.69 w=0.42 l=0.15
X5110 a_4259_22596# ua[2] uio_oe[0] sky130_fd_pr__res_xhigh_po_0p35 l=17.36
X5111 a_39209_34319# a_38285_38671# a_39127_34319# uio_oe[0] sky130_fd_pr__nfet_01v8 ad=0.08775 pd=0.92 as=0.169 ps=1.82 w=0.65 l=0.15
X5112 uio_oe[0] a_62053_40601# a_61987_40669# uio_oe[0] sky130_fd_pr__nfet_01v8 ad=0.1449 pd=1.11 as=0.0693 ps=0.75 w=0.42 l=0.15
X5113 a_51554_39254# a_48677_39759# VDPWR VDPWR sky130_fd_pr__pfet_01v8_hvt ad=0.07665 pd=0.785 as=0.15835 ps=1.395 w=0.42 l=0.15
X5114 a_52538_42611# a_52816_42595# a_52772_42479# VDPWR sky130_fd_pr__pfet_01v8_hvt ad=0.0588 pd=0.7 as=0.0567 ps=0.69 w=0.42 l=0.15
X5115 ua[5] a_16756_10376# a_18018_10020# uio_oe[0] sky130_fd_pr__nfet_01v8 ad=0.1885 pd=1.88 as=0.1885 ps=1.88 w=0.65 l=0.15
X5116 uio_oe[0] a_53011_41365# a_52942_41391# uio_oe[0] sky130_fd_pr__nfet_01v8 ad=0.1346 pd=1.15 as=0.0999 ps=0.985 w=0.64 l=0.15
X5117 a_53624_38671# a_53005_38671# VDPWR VDPWR sky130_fd_pr__pfet_01v8_hvt ad=0.0651 pd=0.73 as=0.1092 ps=1.36 w=0.42 l=0.15
X5118 uio_oe[0] a_43327_36647# a_37452_34953# uio_oe[0] sky130_fd_pr__nfet_01v8 ad=0.1118 pd=1.04 as=0.182 ps=1.86 w=0.65 l=0.15
X5119 a_39686_38998# a_38005_40847# VDPWR VDPWR sky130_fd_pr__pfet_01v8_hvt ad=0.07665 pd=0.785 as=0.15835 ps=1.395 w=0.42 l=0.15
X5120 a_57519_36732# a_57363_36637# a_57664_36861# VDPWR sky130_fd_pr__pfet_01v8_hvt ad=0.07245 pd=0.765 as=0.1155 ps=0.97 w=0.42 l=0.15
X5121 VDPWR a_37795_40535# a_41225_34569# VDPWR sky130_fd_pr__pfet_01v8_hvt ad=0.26 pd=2.52 as=0.135 ps=1.27 w=1 l=0.15
X5122 VDPWR a_52335_40277# a_51620_40571# VDPWR sky130_fd_pr__pfet_01v8_hvt ad=0.3012 pd=2.66 as=0.26 ps=2.52 w=1 l=0.15
X5123 a_52579_38998# a_51620_38645# a_52507_38998# VDPWR sky130_fd_pr__pfet_01v8_hvt ad=0.1932 pd=1.34 as=0.0441 ps=0.63 w=0.42 l=0.15
X5124 uio_oe[0] a_36425_36166# a_44287_38127# uio_oe[0] sky130_fd_pr__nfet_01v8 ad=0.08775 pd=0.92 as=0.08775 ps=0.92 w=0.65 l=0.15
X5125 a_49686_36083# a_49964_36067# a_49920_35951# VDPWR sky130_fd_pr__pfet_01v8_hvt ad=0.0588 pd=0.7 as=0.0567 ps=0.69 w=0.42 l=0.15
X5126 a_53011_35925# a_52816_36067# a_53321_36317# uio_oe[0] sky130_fd_pr__special_nfet_01v8 ad=0.0594 pd=0.69 as=0.1401 ps=1.1 w=0.36 l=0.15
X5127 a_50003_35549# a_41685_42479# VDPWR VDPWR sky130_fd_pr__pfet_01v8_hvt ad=0.1664 pd=1.8 as=0.0864 ps=0.91 w=0.64 l=0.15
X5128 VDPWR a_40495_42453# a_40379_35551# VDPWR sky130_fd_pr__pfet_01v8_hvt ad=0.135 pd=1.27 as=0.135 ps=1.27 w=1 l=0.15
X5129 a_47283_42783# a_39947_42997# VDPWR VDPWR sky130_fd_pr__pfet_01v8_hvt ad=0.0567 pd=0.69 as=0.0819 ps=0.81 w=0.42 l=0.15
X5130 a_49686_42187# a_50003_42077# a_49961_41935# uio_oe[0] sky130_fd_pr__special_nfet_01v8 ad=0.0711 pd=0.755 as=0.0669 ps=0.75 w=0.36 l=0.15
X5131 VDPWR a_57519_41084# a_57450_41213# VDPWR sky130_fd_pr__pfet_01v8_hvt ad=0.2184 pd=2.2 as=0.12915 ps=1.185 w=0.84 l=0.15
X5132 a_57757_35407# a_44905_38671# uio_oe[0] uio_oe[0] sky130_fd_pr__nfet_01v8 ad=0.0441 pd=0.63 as=0.1346 ps=1.15 w=0.42 l=0.15
X5133 a_44707_41769# a_44261_41397# a_44611_41769# uio_oe[0] sky130_fd_pr__special_nfet_01v8 ad=0.1401 pd=1.1 as=0.0594 ps=0.69 w=0.36 l=0.15
X5134 a_53574_41391# a_52855_41633# a_53011_41365# uio_oe[0] sky130_fd_pr__special_nfet_01v8 ad=0.066 pd=0.745 as=0.0594 ps=0.69 w=0.36 l=0.15
X5135 a_60215_36193# a_37913_41935# VDPWR VDPWR sky130_fd_pr__pfet_01v8_hvt ad=0.1664 pd=1.8 as=0.0864 ps=0.91 w=0.64 l=0.15
X5136 a_38895_40847# a_38089_40623# a_38532_40999# uio_oe[0] sky130_fd_pr__nfet_01v8 ad=0.0693 pd=0.75 as=0.09975 ps=0.895 w=0.42 l=0.15
X5137 a_22218_36488# a_21252_36681# VDPWR VDPWR sky130_fd_pr__pfet_01v8_hvt ad=0.07665 pd=0.785 as=0.15835 ps=1.395 w=0.42 l=0.15
X5138 VDPWR a_40099_35381# a_36425_36166# VDPWR sky130_fd_pr__pfet_01v8_hvt ad=0.3012 pd=2.66 as=0.26 ps=2.52 w=1 l=0.15
X5139 a_42467_41562# a_43419_41909# uio_oe[0] uio_oe[0] sky130_fd_pr__nfet_01v8 ad=0.169 pd=1.82 as=0.2087 ps=2.02 w=0.65 l=0.15
X5140 VDPWR a_58144_38101# a_58082_38127# VDPWR sky130_fd_pr__pfet_01v8_hvt ad=0.1092 pd=1.36 as=0.0651 ps=0.73 w=0.42 l=0.15
X5141 a_53156_34863# a_52942_34863# VDPWR VDPWR sky130_fd_pr__pfet_01v8_hvt ad=0.1155 pd=0.97 as=0.07035 ps=0.755 w=0.42 l=0.15
X5142 uio_oe[0] a_48125_41935# a_52573_42845# uio_oe[0] sky130_fd_pr__nfet_01v8 ad=0.12495 pd=1.015 as=0.06405 ps=0.725 w=0.42 l=0.15
X5143 a_46761_42177# a_46543_41935# uio_oe[0] uio_oe[0] sky130_fd_pr__nfet_01v8 ad=0.0999 pd=0.985 as=0.1346 ps=1.15 w=0.64 l=0.15
X5144 a_38991_38998# a_38740_38645# a_38532_38823# VDPWR sky130_fd_pr__pfet_01v8_hvt ad=0.0441 pd=0.63 as=0.1932 ps=1.34 w=0.42 l=0.15
X5145 a_50003_36193# a_41685_42479# uio_oe[0] uio_oe[0] sky130_fd_pr__nfet_01v8 ad=0.1092 pd=1.36 as=0.0567 ps=0.69 w=0.42 l=0.15
X5146 a_22306_10464# a_20620_10782# ua[5] uio_oe[0] sky130_fd_pr__nfet_01v8 ad=0.1885 pd=1.88 as=0.1885 ps=1.88 w=0.65 l=0.15
X5147 a_51412_35095# a_51620_35131# a_51554_35229# uio_oe[0] sky130_fd_pr__nfet_01v8 ad=0.09975 pd=0.895 as=0.0693 ps=0.75 w=0.42 l=0.15
X5148 VDPWR a_20972_34969# a_20923_34817# VDPWR sky130_fd_pr__pfet_01v8_hvt ad=0.15835 pd=1.395 as=0.26 ps=2.52 w=1 l=0.15
X5149 uio_oe[0] a_38532_40999# a_17388_33417# uio_oe[0] sky130_fd_pr__nfet_01v8 ad=0.11285 pd=1.045 as=0.169 ps=1.82 w=0.65 l=0.15
X5150 a_50159_40277# a_50003_40545# a_50304_40303# VDPWR sky130_fd_pr__pfet_01v8_hvt ad=0.07245 pd=0.765 as=0.1155 ps=0.97 w=0.42 l=0.15
X5151 a_43771_37583# a_42347_38127# a_43408_37735# uio_oe[0] sky130_fd_pr__nfet_01v8 ad=0.0693 pd=0.75 as=0.09975 ps=0.895 w=0.42 l=0.15
X5152 a_29689_34845# a_28651_34817# a_29603_34845# uio_oe[0] sky130_fd_pr__nfet_01v8 ad=0.0567 pd=0.69 as=0.1176 ps=1.4 w=0.42 l=0.15
X5153 a_46639_41935# a_46193_41935# a_46543_41935# uio_oe[0] sky130_fd_pr__special_nfet_01v8 ad=0.1401 pd=1.1 as=0.0594 ps=0.69 w=0.36 l=0.15
X5154 a_42897_41365# a_42679_41769# uio_oe[0] uio_oe[0] sky130_fd_pr__nfet_01v8 ad=0.0999 pd=0.985 as=0.1346 ps=1.15 w=0.64 l=0.15
X5155 a_46331_40474# a_47283_40821# VDPWR VDPWR sky130_fd_pr__pfet_01v8_hvt ad=0.26 pd=2.52 as=0.3012 ps=2.66 w=1 l=0.15
X5156 a_43603_39519# a_40379_35551# VDPWR VDPWR sky130_fd_pr__pfet_01v8_hvt ad=0.0567 pd=0.69 as=0.0819 ps=0.81 w=0.42 l=0.15
X5157 a_39544_39447# a_39759_39228# a_39686_39254# VDPWR sky130_fd_pr__pfet_01v8_hvt ad=0.1932 pd=1.34 as=0.07665 ps=0.785 w=0.42 l=0.15
X5158 a_51554_38998# a_48677_39759# VDPWR VDPWR sky130_fd_pr__pfet_01v8_hvt ad=0.07665 pd=0.785 as=0.15835 ps=1.395 w=0.42 l=0.15
X5159 a_61987_40669# a_58980_40821# a_61624_40535# uio_oe[0] sky130_fd_pr__nfet_01v8 ad=0.0693 pd=0.75 as=0.09975 ps=0.895 w=0.42 l=0.15
X5160 uio_oe[0] a_40775_35925# a_40706_35951# uio_oe[0] sky130_fd_pr__nfet_01v8 ad=0.1346 pd=1.15 as=0.0999 ps=0.985 w=0.64 l=0.15
X5161 a_17108_33881# a_17243_33185# a_17250_34056# VDPWR sky130_fd_pr__pfet_01v8_hvt ad=0.1932 pd=1.34 as=0.07665 ps=0.785 w=0.42 l=0.15
X5162 uio_oe[0] a_43408_37735# a_43359_37583# uio_oe[0] sky130_fd_pr__nfet_01v8 ad=0.11285 pd=1.045 as=0.169 ps=1.82 w=0.65 l=0.15
X5163 uio_oe[0] a_50784_37013# a_50722_37039# uio_oe[0] sky130_fd_pr__nfet_01v8 ad=0.2205 pd=1.89 as=0.066 ps=0.745 w=0.42 l=0.15
X5164 a_58044_37405# a_57776_37405# uio_oe[0] uio_oe[0] sky130_fd_pr__nfet_01v8 ad=0.06705 pd=0.75 as=0.0882 ps=0.84 w=0.42 l=0.15
X5165 a_21156_33417# a_17500_33453# a_21298_33551# uio_oe[0] sky130_fd_pr__nfet_01v8 ad=0.09975 pd=0.895 as=0.0693 ps=0.75 w=0.42 l=0.15
X5166 uio_oe[0] a_57363_34461# a_57324_34587# uio_oe[0] sky130_fd_pr__nfet_01v8 ad=0.0567 pd=0.69 as=0.1092 ps=1.36 w=0.42 l=0.15
X5167 a_61187_40125# a_60563_39759# a_61079_39759# VDPWR sky130_fd_pr__pfet_01v8_hvt ad=0.1155 pd=0.97 as=0.07245 ps=0.765 w=0.42 l=0.15
X5168 a_25876_18782# a_25739_33757# uio_oe[0] uio_oe[0] sky130_fd_pr__nfet_01v8 ad=0.182 pd=1.86 as=0.1118 ps=1.04 w=0.65 l=0.15
X5169 a_44829_42453# a_44611_42857# uio_oe[0] uio_oe[0] sky130_fd_pr__nfet_01v8 ad=0.0999 pd=0.985 as=0.1346 ps=1.15 w=0.64 l=0.15
X5170 a_40003_40086# a_39752_39733# a_39544_39911# VDPWR sky130_fd_pr__pfet_01v8_hvt ad=0.0441 pd=0.63 as=0.1932 ps=1.34 w=0.42 l=0.15
X5171 uio_oe[0] uio_oe[0] uio_oe[0] uio_oe[0] sky130_fd_pr__nfet_01v8 ad=1.4703 pd=10.72 as=0 ps=0 w=5.07 l=1
X5172 VDPWR a_36661_41391# a_52793_40086# VDPWR sky130_fd_pr__pfet_01v8_hvt ad=0.15835 pd=1.395 as=0.07665 ps=0.785 w=0.42 l=0.15
X5173 a_53937_36737# a_53719_36495# uio_oe[0] uio_oe[0] sky130_fd_pr__nfet_01v8 ad=0.0999 pd=0.985 as=0.1346 ps=1.15 w=0.64 l=0.15
X5174 a_61624_40535# a_58980_40821# a_61766_40342# VDPWR sky130_fd_pr__pfet_01v8_hvt ad=0.1932 pd=1.34 as=0.07665 ps=0.785 w=0.42 l=0.15
X5175 VDPWR a_37661_38140# a_37605_38166# VDPWR sky130_fd_pr__pfet_01v8_hvt ad=0.0693 pd=0.75 as=0.1176 ps=1.4 w=0.42 l=0.15
X5176 a_18097_35933# a_17059_35905# a_18011_35933# uio_oe[0] sky130_fd_pr__nfet_01v8 ad=0.0567 pd=0.69 as=0.1176 ps=1.4 w=0.42 l=0.15
X5177 a_26082_33551# a_25116_33417# uio_oe[0] uio_oe[0] sky130_fd_pr__nfet_01v8 ad=0.0693 pd=0.75 as=0.11285 ps=1.045 w=0.42 l=0.15
X5178 uio_oe[0] a_40096_34471# a_39759_41129# uio_oe[0] sky130_fd_pr__nfet_01v8 ad=0.11285 pd=1.045 as=0.169 ps=1.82 w=0.65 l=0.15
X5179 a_36661_41391# a_36631_41365# VDPWR VDPWR sky130_fd_pr__pfet_01v8_hvt ad=0.135 pd=1.27 as=0.135 ps=1.27 w=1 l=0.15
X5180 a_38285_34863# a_38019_34863# uio_oe[0] uio_oe[0] sky130_fd_pr__nfet_01v8 ad=0.169 pd=1.82 as=0.1013 ps=0.99 w=0.65 l=0.15
X5181 a_20972_37145# a_21180_36967# a_21114_36993# uio_oe[0] sky130_fd_pr__nfet_01v8 ad=0.09975 pd=0.895 as=0.0693 ps=0.75 w=0.42 l=0.15
X5182 a_20668_10020# a_4259_22596# a_20490_10020# uio_oe[0] sky130_fd_pr__nfet_01v8 ad=0.2436 pd=2.26 as=0.2436 ps=2.26 w=0.84 l=0.6
X5183 a_51412_39447# a_38740_39483# a_51554_39254# VDPWR sky130_fd_pr__pfet_01v8_hvt ad=0.1932 pd=1.34 as=0.07665 ps=0.785 w=0.42 l=0.15
X5184 VDPWR a_38961_42777# a_38991_42518# VDPWR sky130_fd_pr__pfet_01v8_hvt ad=0.0693 pd=0.75 as=0.0441 ps=0.63 w=0.42 l=0.15
X5185 uio_oe[0] a_36661_41391# a_60160_40847# uio_oe[0] sky130_fd_pr__nfet_01v8 ad=0.11285 pd=1.045 as=0.0693 ps=0.75 w=0.42 l=0.15
X5186 a_58772_40535# a_54479_40316# a_58914_40669# uio_oe[0] sky130_fd_pr__nfet_01v8 ad=0.09975 pd=0.895 as=0.0693 ps=0.75 w=0.42 l=0.15
X5187 a_61079_38671# a_60563_38671# a_60984_38671# uio_oe[0] sky130_fd_pr__special_nfet_01v8 ad=0.0594 pd=0.69 as=0.066 ps=0.745 w=0.36 l=0.15
X5188 a_38717_36289# a_37029_37583# uio_oe[0] uio_oe[0] sky130_fd_pr__nfet_01v8 ad=0.0567 pd=0.69 as=0.1118 ps=1.04 w=0.42 l=0.15
X5189 uio_oe[0] a_37913_41935# a_60563_34319# uio_oe[0] sky130_fd_pr__nfet_01v8 ad=0.0567 pd=0.69 as=0.1092 ps=1.36 w=0.42 l=0.15
X5190 a_51871_34902# a_51620_35131# a_51412_35095# VDPWR sky130_fd_pr__pfet_01v8_hvt ad=0.0441 pd=0.63 as=0.1932 ps=1.34 w=0.42 l=0.15
X5191 VDPWR a_59956_41365# a_60092_41391# VDPWR sky130_fd_pr__pfet_01v8_hvt ad=0.12285 pd=1.17 as=0.2184 ps=2.2 w=0.84 l=0.15
X5192 a_52335_39189# a_52538_39347# VDPWR VDPWR sky130_fd_pr__pfet_01v8_hvt ad=0.0567 pd=0.69 as=0.1134 ps=1.38 w=0.42 l=0.15
X5193 uio_oe[0] a_46027_39759# a_46193_39759# uio_oe[0] sky130_fd_pr__nfet_01v8 ad=0.169 pd=1.82 as=0.08775 ps=0.92 w=0.65 l=0.15
X5194 a_57046_40011# a_57363_39901# a_57321_39759# uio_oe[0] sky130_fd_pr__special_nfet_01v8 ad=0.0711 pd=0.755 as=0.0669 ps=0.75 w=0.36 l=0.15
X5195 VDPWR a_41059_41935# a_41706_39215# VDPWR sky130_fd_pr__pfet_01v8_hvt ad=0.1092 pd=1.36 as=0.0651 ps=0.73 w=0.42 l=0.15
X5196 VDPWR a_59695_38101# a_54479_38140# VDPWR sky130_fd_pr__pfet_01v8_hvt ad=0.3012 pd=2.66 as=0.26 ps=2.52 w=1 l=0.15
X5197 a_25383_36815# a_17507_33198# a_25020_36681# uio_oe[0] sky130_fd_pr__nfet_01v8 ad=0.0693 pd=0.75 as=0.09975 ps=0.895 w=0.42 l=0.15
X5198 uio_oe[0] a_16812_8642# a_16812_8642# uio_oe[0] sky130_fd_pr__nfet_01v8 ad=1.16 pd=8.29 as=1.16 ps=8.29 w=8 l=1
X5199 uio_oe[0] a_25265_34791# a_25199_34817# uio_oe[0] sky130_fd_pr__nfet_01v8 ad=0.1449 pd=1.11 as=0.0693 ps=0.75 w=0.42 l=0.15
X5200 a_49483_40277# a_49686_40435# VDPWR VDPWR sky130_fd_pr__pfet_01v8_hvt ad=0.0567 pd=0.69 as=0.1134 ps=1.38 w=0.42 l=0.15
X5201 a_51871_40086# a_51620_39733# a_51412_39911# VDPWR sky130_fd_pr__pfet_01v8_hvt ad=0.0441 pd=0.63 as=0.1932 ps=1.34 w=0.42 l=0.15
X5202 a_39544_38823# a_38089_40623# a_39686_38998# VDPWR sky130_fd_pr__pfet_01v8_hvt ad=0.1932 pd=1.34 as=0.07665 ps=0.785 w=0.42 l=0.15
X5203 a_60988_41757# a_60720_41757# uio_oe[0] uio_oe[0] sky130_fd_pr__nfet_01v8 ad=0.06705 pd=0.75 as=0.0882 ps=0.84 w=0.42 l=0.15
X5204 a_43537_39593# a_42347_39221# a_43428_39593# uio_oe[0] sky130_fd_pr__special_nfet_01v8 ad=0.0669 pd=0.75 as=0.0711 ps=0.755 w=0.36 l=0.15
X5205 uio_oe[0] a_39544_40535# a_21068_37145# uio_oe[0] sky130_fd_pr__nfet_01v8 ad=0.11285 pd=1.045 as=0.169 ps=1.82 w=0.65 l=0.15
X5206 VDPWR a_38005_41391# a_40415_38671# VDPWR sky130_fd_pr__pfet_01v8_hvt ad=0.0864 pd=0.91 as=0.1664 ps=1.8 w=0.64 l=0.15
X5207 a_29740_18376# a_30303_34095# VDPWR VDPWR sky130_fd_pr__pfet_01v8_hvt ad=0.26 pd=2.52 as=0.2279 ps=1.74 w=1 l=0.15
X5208 a_43406_42479# a_42329_42485# a_43244_42857# VDPWR sky130_fd_pr__pfet_01v8_hvt ad=0.0567 pd=0.69 as=0.0588 ps=0.7 w=0.42 l=0.15
X5209 a_52538_41523# a_52816_41507# a_52772_41391# VDPWR sky130_fd_pr__pfet_01v8_hvt ad=0.0588 pd=0.7 as=0.0567 ps=0.69 w=0.42 l=0.15
X5210 a_45351_40821# a_45176_40847# a_45530_40847# uio_oe[0] sky130_fd_pr__nfet_01v8 ad=0.1092 pd=1.36 as=0.06405 ps=0.725 w=0.42 l=0.15
X5211 uio_oe[0] a_54459_35381# a_54393_35407# uio_oe[0] sky130_fd_pr__nfet_01v8 ad=0.12495 pd=1.015 as=0.0669 ps=0.75 w=0.42 l=0.15
X5212 a_49721_39759# a_49686_40011# a_49483_39733# uio_oe[0] sky130_fd_pr__nfet_01v8 ad=0.06405 pd=0.725 as=0.1092 ps=1.36 w=0.42 l=0.15
X5213 VDPWR a_54264_35095# a_53636_34837# VDPWR sky130_fd_pr__pfet_01v8_hvt ad=0.15835 pd=1.395 as=0.26 ps=2.52 w=1 l=0.15
X5214 a_53011_34837# a_52816_34979# a_53321_35229# uio_oe[0] sky130_fd_pr__special_nfet_01v8 ad=0.0594 pd=0.69 as=0.1401 ps=1.1 w=0.36 l=0.15
X5215 a_47283_41695# a_39947_42997# VDPWR VDPWR sky130_fd_pr__pfet_01v8_hvt ad=0.0567 pd=0.69 as=0.0819 ps=0.81 w=0.42 l=0.15
X5216 VDPWR a_57519_39996# a_57450_40125# VDPWR sky130_fd_pr__pfet_01v8_hvt ad=0.2184 pd=2.2 as=0.12915 ps=1.185 w=0.84 l=0.15
X5217 VDPWR a_40619_35549# a_40580_35675# VDPWR sky130_fd_pr__pfet_01v8_hvt ad=0.0864 pd=0.91 as=0.1664 ps=1.8 w=0.64 l=0.15
X5218 VDPWR a_50784_42184# a_50722_42301# VDPWR sky130_fd_pr__pfet_01v8_hvt ad=0.1092 pd=1.36 as=0.0651 ps=0.73 w=0.42 l=0.15
X5219 a_38674_41174# a_38005_40847# VDPWR VDPWR sky130_fd_pr__pfet_01v8_hvt ad=0.07665 pd=0.785 as=0.15835 ps=1.395 w=0.42 l=0.15
X5220 a_44707_40681# a_44261_40309# a_44611_40681# uio_oe[0] sky130_fd_pr__special_nfet_01v8 ad=0.1401 pd=1.1 as=0.0594 ps=0.69 w=0.36 l=0.15
X5221 a_53574_40303# a_52855_40545# a_53011_40277# uio_oe[0] sky130_fd_pr__special_nfet_01v8 ad=0.066 pd=0.745 as=0.0594 ps=0.69 w=0.36 l=0.15
X5222 a_30233_36747# a_28980_36681# VDPWR VDPWR sky130_fd_pr__pfet_01v8_hvt ad=0.1176 pd=1.4 as=0.0693 ps=0.75 w=0.42 l=0.15
X5223 VDPWR a_17689_32641# a_18011_33757# VDPWR sky130_fd_pr__pfet_01v8_hvt ad=0.16655 pd=1.39 as=0.0567 ps=0.69 w=0.42 l=0.15
X5224 a_44261_42485# a_44095_42485# uio_oe[0] uio_oe[0] sky130_fd_pr__nfet_01v8 ad=0.1092 pd=1.36 as=0.0567 ps=0.69 w=0.42 l=0.15
X5225 a_43432_35381# a_44339_39944# uio_oe[0] uio_oe[0] sky130_fd_pr__nfet_01v8 ad=0.25025 pd=1.42 as=0.208 ps=1.94 w=0.65 l=0.15
X5226 a_51412_38823# a_39752_38645# a_51554_38998# VDPWR sky130_fd_pr__pfet_01v8_hvt ad=0.1932 pd=1.34 as=0.07665 ps=0.785 w=0.42 l=0.15
X5227 a_54406_38166# a_37361_41391# VDPWR VDPWR sky130_fd_pr__pfet_01v8_hvt ad=0.07665 pd=0.785 as=0.15835 ps=1.395 w=0.42 l=0.15
X5228 ua[4] a_20620_14782# a_20490_14020# uio_oe[0] sky130_fd_pr__nfet_01v8 ad=0.1885 pd=1.88 as=0.1885 ps=1.88 w=0.65 l=0.15
X5229 a_6359_24172# a_4259_22596# uio_oe[0] sky130_fd_pr__res_xhigh_po_1p41 l=5.88
X5230 a_41108_42087# a_41316_41909# a_41250_41935# uio_oe[0] sky130_fd_pr__nfet_01v8 ad=0.09975 pd=0.895 as=0.0693 ps=0.75 w=0.42 l=0.15
X5231 a_39907_38493# a_39759_38140# a_39544_38359# uio_oe[0] sky130_fd_pr__nfet_01v8 ad=0.0693 pd=0.75 as=0.09975 ps=0.895 w=0.42 l=0.15
X5232 a_54693_37337# a_37361_41391# VDPWR VDPWR sky130_fd_pr__pfet_01v8_hvt ad=0.1176 pd=1.4 as=0.0693 ps=0.75 w=0.42 l=0.15
X5233 a_22060_10020# a_4259_22596# a_21882_10020# uio_oe[0] sky130_fd_pr__nfet_01v8 ad=0.2436 pd=2.26 as=0.2436 ps=2.26 w=0.84 l=0.6
X5234 uio_oe[0] a_50003_42077# a_49964_42203# uio_oe[0] sky130_fd_pr__nfet_01v8 ad=0.0567 pd=0.69 as=0.1092 ps=1.36 w=0.42 l=0.15
X5235 VDPWR a_58772_40999# a_58144_41096# VDPWR sky130_fd_pr__pfet_01v8_hvt ad=0.15835 pd=1.395 as=0.26 ps=2.52 w=1 l=0.15
X5236 uio_oe[0] a_51412_40535# a_50784_40277# uio_oe[0] sky130_fd_pr__nfet_01v8 ad=0.11285 pd=1.045 as=0.169 ps=1.82 w=0.65 l=0.15
X5237 uio_oe[0] a_40619_36193# a_40580_36067# uio_oe[0] sky130_fd_pr__nfet_01v8 ad=0.0567 pd=0.69 as=0.1092 ps=1.36 w=0.42 l=0.15
X5238 a_28642_14464# a_28348_14782# ua[5] uio_oe[0] sky130_fd_pr__nfet_01v8 ad=0.1885 pd=1.88 as=0.1885 ps=1.88 w=0.65 l=0.15
X5239 a_49961_40847# a_49483_40821# uio_oe[0] uio_oe[0] sky130_fd_pr__nfet_01v8 ad=0.0669 pd=0.75 as=0.12495 ps=1.015 w=0.42 l=0.15
X5240 a_54446_41213# a_53369_40847# a_54284_40847# VDPWR sky130_fd_pr__pfet_01v8_hvt ad=0.0567 pd=0.69 as=0.0588 ps=0.7 w=0.42 l=0.15
X5241 a_45431_39733# a_45195_39215# VDPWR VDPWR sky130_fd_pr__pfet_01v8_hvt ad=0.26 pd=2.52 as=0.2279 ps=1.74 w=1 l=0.15
X5242 a_39686_37583# a_37029_37583# uio_oe[0] uio_oe[0] sky130_fd_pr__nfet_01v8 ad=0.0693 pd=0.75 as=0.11285 ps=1.045 w=0.42 l=0.15
X5243 a_26082_34312# a_25116_34505# VDPWR VDPWR sky130_fd_pr__pfet_01v8_hvt ad=0.07665 pd=0.785 as=0.15835 ps=1.395 w=0.42 l=0.15
X5244 a_52579_37583# a_52325_37910# uio_oe[0] uio_oe[0] sky130_fd_pr__nfet_01v8 ad=0.0693 pd=0.75 as=0.1449 ps=1.11 w=0.42 l=0.15
X5245 VDPWR a_29804_36681# a_28908_36967# VDPWR sky130_fd_pr__pfet_01v8_hvt ad=0.15835 pd=1.395 as=0.26 ps=2.52 w=1 l=0.15
X5246 ua[4] a_20620_10376# a_21882_26020# uio_oe[0] sky130_fd_pr__nfet_01v8 ad=0.1885 pd=1.88 as=0.1885 ps=1.88 w=0.65 l=0.15
X5247 a_41961_34319# a_36425_34293# uio_oe[0] uio_oe[0] sky130_fd_pr__nfet_01v8 ad=0.08775 pd=0.92 as=0.08775 ps=0.92 w=0.65 l=0.15
X5248 a_60365_41935# a_59939_42262# VDPWR VDPWR sky130_fd_pr__pfet_01v8_hvt ad=0.26 pd=2.52 as=0.15835 ps=1.395 w=1 l=0.15
X5249 a_37469_36745# a_37195_36501# a_37387_36745# VDPWR sky130_fd_pr__pfet_01v8_hvt ad=0.0441 pd=0.63 as=0.1092 ps=1.36 w=0.42 l=0.15
X5250 uio_oe[0] a_47959_43023# a_48125_43023# uio_oe[0] sky130_fd_pr__nfet_01v8 ad=0.08775 pd=0.92 as=0.08775 ps=0.92 w=0.65 l=0.15
X5251 VDPWR a_46193_39759# a_60516_35951# VDPWR sky130_fd_pr__pfet_01v8_hvt ad=0.07035 pd=0.755 as=0.1092 ps=1.36 w=0.42 l=0.15
X5252 a_23452_14020# a_4259_22596# a_23274_14020# uio_oe[0] sky130_fd_pr__nfet_01v8 ad=0.2436 pd=2.26 as=0.2436 ps=2.26 w=0.84 l=0.6
X5253 a_61819_40821# a_48125_41935# VDPWR VDPWR sky130_fd_pr__pfet_01v8_hvt ad=0.0567 pd=0.69 as=0.0819 ps=0.81 w=0.42 l=0.15
X5254 uio_oe[0] a_38961_37557# a_38895_37583# uio_oe[0] sky130_fd_pr__nfet_01v8 ad=0.1449 pd=1.11 as=0.0693 ps=0.75 w=0.42 l=0.15
X5255 uio_oe[0] a_24836_34969# a_24787_34817# uio_oe[0] sky130_fd_pr__nfet_01v8 ad=0.11285 pd=1.045 as=0.169 ps=1.82 w=0.65 l=0.15
X5256 a_52942_39215# a_52855_39457# a_52538_39347# VDPWR sky130_fd_pr__pfet_01v8_hvt ad=0.12915 pd=1.185 as=0.0588 ps=0.7 w=0.42 l=0.15
X5257 a_38961_36469# a_37029_37583# uio_oe[0] uio_oe[0] sky130_fd_pr__nfet_01v8 ad=0.1092 pd=1.36 as=0.1449 ps=1.11 w=0.42 l=0.15
X5258 ua[5] a_28348_10376# a_28218_10020# uio_oe[0] sky130_fd_pr__nfet_01v8 ad=0.1885 pd=1.88 as=0.1885 ps=1.88 w=0.65 l=0.15
X5259 a_17434_34639# a_17388_34505# uio_oe[0] uio_oe[0] sky130_fd_pr__nfet_01v8 ad=0.0693 pd=0.75 as=0.11285 ps=1.045 w=0.42 l=0.15
X5260 a_50090_41391# a_49964_41507# a_49686_41523# uio_oe[0] sky130_fd_pr__special_nfet_01v8 ad=0.0999 pd=0.985 as=0.0711 ps=0.755 w=0.36 l=0.15
X5261 VDPWR a_36447_40849# a_36455_37039# VDPWR sky130_fd_pr__pfet_01v8_hvt ad=0.2279 pd=1.74 as=0.0609 ps=0.71 w=0.42 l=0.15
X5262 VDPWR a_53636_37013# a_53574_37039# VDPWR sky130_fd_pr__pfet_01v8_hvt ad=0.1092 pd=1.36 as=0.0651 ps=0.73 w=0.42 l=0.15
X5263 VDPWR a_21156_36681# a_21107_36449# VDPWR sky130_fd_pr__pfet_01v8_hvt ad=0.15835 pd=1.395 as=0.26 ps=2.52 w=1 l=0.15
X5264 a_37410_34569# a_37310_34471# a_37328_34569# VDPWR sky130_fd_pr__pfet_01v8_hvt ad=0.0441 pd=0.63 as=0.1092 ps=1.36 w=0.42 l=0.15
X5265 uio_oe[0] a_36427_36475# a_38080_38671# uio_oe[0] sky130_fd_pr__nfet_01v8 ad=0.11285 pd=1.045 as=0.0693 ps=0.75 w=0.42 l=0.15
X5266 a_51775_38493# a_38740_38395# a_51412_38359# uio_oe[0] sky130_fd_pr__nfet_01v8 ad=0.0693 pd=0.75 as=0.09975 ps=0.895 w=0.42 l=0.15
X5267 a_40775_35925# a_40619_36193# a_40920_35951# VDPWR sky130_fd_pr__pfet_01v8_hvt ad=0.07245 pd=0.765 as=0.1155 ps=0.97 w=0.42 l=0.15
X5268 VDPWR a_37661_37052# a_42069_35657# VDPWR sky130_fd_pr__pfet_01v8_hvt ad=0.135 pd=1.27 as=0.135 ps=1.27 w=1 l=0.15
X5269 a_43244_43023# a_42329_43023# a_42897_43265# uio_oe[0] sky130_fd_pr__special_nfet_01v8 ad=0.0711 pd=0.755 as=0.0999 ps=0.985 w=0.36 l=0.15
X5270 a_45351_41909# a_39947_42997# VDPWR VDPWR sky130_fd_pr__pfet_01v8_hvt ad=0.0567 pd=0.69 as=0.0819 ps=0.81 w=0.42 l=0.15
X5271 a_62083_40342# a_54479_40316# a_61624_40535# VDPWR sky130_fd_pr__pfet_01v8_hvt ad=0.0441 pd=0.63 as=0.1932 ps=1.34 w=0.42 l=0.15
X5272 a_51554_37583# a_48677_38127# uio_oe[0] uio_oe[0] sky130_fd_pr__nfet_01v8 ad=0.0693 pd=0.75 as=0.11285 ps=1.045 w=0.42 l=0.15
X5273 ua[5] a_20620_10782# a_20490_26020# uio_oe[0] sky130_fd_pr__nfet_01v8 ad=0.1885 pd=1.88 as=0.1885 ps=1.88 w=0.65 l=0.15
X5274 a_43075_38101# a_42919_38369# a_43220_38127# VDPWR sky130_fd_pr__pfet_01v8_hvt ad=0.07245 pd=0.765 as=0.1155 ps=0.97 w=0.42 l=0.15
X5275 a_20620_14376# a_21875_35933# uio_oe[0] uio_oe[0] sky130_fd_pr__nfet_01v8 ad=0.182 pd=1.86 as=0.1118 ps=1.04 w=0.65 l=0.15
X5276 VDPWR a_38961_41689# a_38991_41430# VDPWR sky130_fd_pr__pfet_01v8_hvt ad=0.0693 pd=0.75 as=0.0441 ps=0.63 w=0.42 l=0.15
X5277 uio_oe[0] a_16812_8642# a_24482_20730# uio_oe[0] sky130_fd_pr__nfet_01v8 ad=1.4703 pd=10.72 as=1.4703 ps=10.72 w=5.07 l=1
X5278 uio_oe[0] a_21585_34571# a_21519_34639# uio_oe[0] sky130_fd_pr__nfet_01v8 ad=0.1449 pd=1.11 as=0.0693 ps=0.75 w=0.42 l=0.15
X5279 a_61175_35407# a_60729_35407# a_61079_35407# uio_oe[0] sky130_fd_pr__special_nfet_01v8 ad=0.1401 pd=1.1 as=0.0594 ps=0.69 w=0.36 l=0.15
X5280 a_53005_35407# a_52579_35734# VDPWR VDPWR sky130_fd_pr__pfet_01v8_hvt ad=0.26 pd=2.52 as=0.15835 ps=1.395 w=1 l=0.15
X5281 VDPWR a_36847_39901# a_36808_40027# VDPWR sky130_fd_pr__pfet_01v8_hvt ad=0.0864 pd=0.91 as=0.1664 ps=1.8 w=0.64 l=0.15
X5282 a_57046_38923# a_57363_38813# a_57321_38671# uio_oe[0] sky130_fd_pr__special_nfet_01v8 ad=0.0711 pd=0.755 as=0.0669 ps=0.75 w=0.36 l=0.15
X5283 a_39973_37337# a_37029_37583# VDPWR VDPWR sky130_fd_pr__pfet_01v8_hvt ad=0.1176 pd=1.4 as=0.0693 ps=0.75 w=0.42 l=0.15
X5284 uio_oe[0] a_18641_35659# a_18575_35727# uio_oe[0] sky130_fd_pr__nfet_01v8 ad=0.1449 pd=1.11 as=0.0693 ps=0.75 w=0.42 l=0.15
X5285 VDPWR a_17108_34969# a_17059_34817# VDPWR sky130_fd_pr__pfet_01v8_hvt ad=0.15835 pd=1.395 as=0.26 ps=2.52 w=1 l=0.15
X5286 a_26259_34095# a_24787_33729# uio_oe[0] uio_oe[0] sky130_fd_pr__nfet_01v8 ad=0.1092 pd=1.36 as=0.1092 ps=1.36 w=0.42 l=0.15
X5287 VDPWR a_41570_38885# a_41528_39037# VDPWR sky130_fd_pr__pfet_01v8_hvt ad=0.1092 pd=1.36 as=0.0441 ps=0.63 w=0.42 l=0.15
X5288 ua[4] a_20620_18376# a_23274_18020# uio_oe[0] sky130_fd_pr__nfet_01v8 ad=0.1885 pd=1.88 as=0.1885 ps=1.88 w=0.65 l=0.15
X5289 a_42499_34471# a_41751_34471# a_42673_34347# uio_oe[0] sky130_fd_pr__nfet_01v8 ad=0.1176 pd=1.4 as=0.0567 ps=0.69 w=0.42 l=0.15
X5290 a_26303_34639# a_18427_33198# a_25940_34505# uio_oe[0] sky130_fd_pr__nfet_01v8 ad=0.0693 pd=0.75 as=0.09975 ps=0.895 w=0.42 l=0.15
X5291 a_43244_42857# a_42329_42485# a_42897_42453# uio_oe[0] sky130_fd_pr__special_nfet_01v8 ad=0.0711 pd=0.755 as=0.0999 ps=0.985 w=0.36 l=0.15
X5292 a_60458_41391# a_60092_41391# VDPWR VDPWR sky130_fd_pr__pfet_01v8_hvt ad=0.0441 pd=0.63 as=0.1092 ps=1.36 w=0.42 l=0.15
X5293 a_38532_40999# a_38089_40623# a_38674_41174# VDPWR sky130_fd_pr__pfet_01v8_hvt ad=0.1932 pd=1.34 as=0.07665 ps=0.785 w=0.42 l=0.15
X5294 VDPWR a_48125_41935# a_52335_40277# VDPWR sky130_fd_pr__pfet_01v8_hvt ad=0.0819 pd=0.81 as=0.0567 ps=0.69 w=0.42 l=0.15
X5295 VDPWR a_37795_40535# a_37839_35773# VDPWR sky130_fd_pr__pfet_01v8_hvt ad=0.0714 pd=0.76 as=0.1092 ps=1.36 w=0.42 l=0.15
X5296 a_42793_35559# a_37851_36647# uio_oe[0] uio_oe[0] sky130_fd_pr__nfet_01v8 ad=0.0567 pd=0.69 as=0.10025 ps=0.985 w=0.42 l=0.15
X5297 a_59860_35095# a_59956_34837# uio_oe[0] uio_oe[0] sky130_fd_pr__nfet_01v8 ad=0.1092 pd=1.36 as=0.097 ps=0.975 w=0.42 l=0.15
X5298 a_42696_37557# a_47283_42783# VDPWR VDPWR sky130_fd_pr__pfet_01v8_hvt ad=0.26 pd=2.52 as=0.3012 ps=2.66 w=1 l=0.15
X5299 a_56843_41909# a_57046_42187# VDPWR VDPWR sky130_fd_pr__pfet_01v8_hvt ad=0.0567 pd=0.69 as=0.1134 ps=1.38 w=0.42 l=0.15
X5300 a_43406_41391# a_42329_41397# a_43244_41769# VDPWR sky130_fd_pr__pfet_01v8_hvt ad=0.0567 pd=0.69 as=0.0588 ps=0.7 w=0.42 l=0.15
X5301 a_51620_40821# a_54459_40821# VDPWR VDPWR sky130_fd_pr__pfet_01v8_hvt ad=0.26 pd=2.52 as=0.3012 ps=2.66 w=1 l=0.15
X5302 a_54264_38359# a_54479_38140# a_54406_38166# VDPWR sky130_fd_pr__pfet_01v8_hvt ad=0.1932 pd=1.34 as=0.07665 ps=0.785 w=0.42 l=0.15
X5303 VDPWR a_50784_35656# a_50722_35773# VDPWR sky130_fd_pr__pfet_01v8_hvt ad=0.1092 pd=1.36 as=0.0651 ps=0.73 w=0.42 l=0.15
X5304 a_57664_42479# a_57450_42479# VDPWR VDPWR sky130_fd_pr__pfet_01v8_hvt ad=0.1155 pd=0.97 as=0.07035 ps=0.755 w=0.42 l=0.15
X5305 uio_oe[0] a_58772_38359# a_58144_38101# uio_oe[0] sky130_fd_pr__nfet_01v8 ad=0.11285 pd=1.045 as=0.169 ps=1.82 w=0.65 l=0.15
X5306 a_52855_40545# a_37913_43023# uio_oe[0] uio_oe[0] sky130_fd_pr__nfet_01v8 ad=0.1092 pd=1.36 as=0.0567 ps=0.69 w=0.42 l=0.15
X5307 a_41288_38127# a_41074_38127# VDPWR VDPWR sky130_fd_pr__pfet_01v8_hvt ad=0.1155 pd=0.97 as=0.07035 ps=0.755 w=0.42 l=0.15
X5308 VDPWR a_39544_37271# a_24932_34969# VDPWR sky130_fd_pr__pfet_01v8_hvt ad=0.15835 pd=1.395 as=0.26 ps=2.52 w=1 l=0.15
X5309 uio_oe[0] a_58864_35095# a_58298_35093# uio_oe[0] sky130_fd_pr__nfet_01v8 ad=0.11285 pd=1.045 as=0.169 ps=1.82 w=0.65 l=0.15
X5310 a_47270_40303# a_46193_40309# a_47108_40681# VDPWR sky130_fd_pr__pfet_01v8_hvt ad=0.0567 pd=0.69 as=0.0588 ps=0.7 w=0.42 l=0.15
X5311 a_49721_38671# a_49686_38923# a_49483_38645# uio_oe[0] sky130_fd_pr__nfet_01v8 ad=0.06405 pd=0.725 as=0.1092 ps=1.36 w=0.42 l=0.15
X5312 a_39209_35951# a_37795_40535# a_37310_34471# VDPWR sky130_fd_pr__pfet_01v8_hvt ad=0.105 pd=1.21 as=0.26 ps=2.52 w=1 l=0.15
X5313 a_36327_34293# a_36425_34293# VDPWR VDPWR sky130_fd_pr__pfet_01v8_hvt ad=0.0609 pd=0.71 as=0.2279 ps=1.74 w=0.42 l=0.15
X5314 a_41074_39215# a_40948_39331# a_40670_39347# uio_oe[0] sky130_fd_pr__special_nfet_01v8 ad=0.0999 pd=0.985 as=0.0711 ps=0.755 w=0.36 l=0.15
X5315 a_54446_34685# a_53369_34319# a_54284_34319# VDPWR sky130_fd_pr__pfet_01v8_hvt ad=0.0567 pd=0.69 as=0.0588 ps=0.7 w=0.42 l=0.15
X5316 a_25940_34505# a_18427_33198# a_26082_34312# VDPWR sky130_fd_pr__pfet_01v8_hvt ad=0.1932 pd=1.34 as=0.07665 ps=0.785 w=0.42 l=0.15
X5317 a_59201_36469# a_48677_38127# VDPWR VDPWR sky130_fd_pr__pfet_01v8_hvt ad=0.1176 pd=1.4 as=0.0693 ps=0.75 w=0.42 l=0.15
X5318 a_42170_36317# a_37661_38140# uio_oe[0] uio_oe[0] sky130_fd_pr__nfet_01v8 ad=0.0693 pd=0.75 as=0.11285 ps=1.045 w=0.42 l=0.15
X5319 VDPWR a_50003_42077# a_49964_42203# VDPWR sky130_fd_pr__pfet_01v8_hvt ad=0.0864 pd=0.91 as=0.1664 ps=1.8 w=0.64 l=0.15
X5320 a_53005_34319# a_52579_34646# uio_oe[0] uio_oe[0] sky130_fd_pr__nfet_01v8 ad=0.169 pd=1.82 as=0.11285 ps=1.045 w=0.65 l=0.15
X5321 VDPWR a_60215_42721# a_60176_42595# VDPWR sky130_fd_pr__pfet_01v8_hvt ad=0.0864 pd=0.91 as=0.1664 ps=1.8 w=0.64 l=0.15
X5322 uio_oe[0] a_38005_41391# a_42347_39221# uio_oe[0] sky130_fd_pr__nfet_01v8 ad=0.0567 pd=0.69 as=0.1092 ps=1.36 w=0.42 l=0.15
X5323 uio_oe[0] uio_oe[0] uio_oe[0] uio_oe[0] sky130_fd_pr__nfet_01v8 ad=1.4703 pd=10.72 as=0 ps=0 w=5.07 l=1
X5324 a_37901_37307# a_37851_36647# a_39213_35407# uio_oe[0] sky130_fd_pr__nfet_01v8 ad=0.169 pd=1.82 as=0.08775 ps=0.92 w=0.65 l=0.15
X5325 a_16812_8642# a_16812_8642# uio_oe[0] uio_oe[0] sky130_fd_pr__nfet_01v8 ad=1.16 pd=8.29 as=1.16 ps=8.29 w=8 l=1
X5326 a_24978_35144# a_24932_34969# VDPWR VDPWR sky130_fd_pr__pfet_01v8_hvt ad=0.07665 pd=0.785 as=0.15835 ps=1.395 w=0.42 l=0.15
X5327 a_53719_39759# a_53369_39759# a_53624_39759# VDPWR sky130_fd_pr__pfet_01v8_hvt ad=0.07245 pd=0.765 as=0.0651 ps=0.73 w=0.42 l=0.15
X5328 VDPWR a_29804_35593# a_28908_35879# VDPWR sky130_fd_pr__pfet_01v8_hvt ad=0.15835 pd=1.395 as=0.26 ps=2.52 w=1 l=0.15
X5329 a_61819_34293# a_46193_39759# VDPWR VDPWR sky130_fd_pr__pfet_01v8_hvt ad=0.0567 pd=0.69 as=0.0819 ps=0.81 w=0.42 l=0.15
X5330 a_60371_42453# a_60215_42721# a_60516_42479# VDPWR sky130_fd_pr__pfet_01v8_hvt ad=0.07245 pd=0.765 as=0.1155 ps=0.97 w=0.42 l=0.15
X5331 a_62171_41757# a_58980_41909# a_61808_41623# uio_oe[0] sky130_fd_pr__nfet_01v8 ad=0.0693 pd=0.75 as=0.09975 ps=0.895 w=0.42 l=0.15
X5332 a_50304_41213# a_50090_41213# VDPWR VDPWR sky130_fd_pr__pfet_01v8_hvt ad=0.1155 pd=0.97 as=0.07035 ps=0.755 w=0.42 l=0.15
X5333 VDPWR a_51412_37271# a_50784_37013# VDPWR sky130_fd_pr__pfet_01v8_hvt ad=0.15835 pd=1.395 as=0.26 ps=2.52 w=1 l=0.15
X5334 a_52579_34646# a_51620_35131# a_52579_34319# uio_oe[0] sky130_fd_pr__nfet_01v8 ad=0.09975 pd=0.895 as=0.0693 ps=0.75 w=0.42 l=0.15
X5335 a_40383_42997# a_39947_42997# VDPWR VDPWR sky130_fd_pr__pfet_01v8_hvt ad=0.0567 pd=0.69 as=0.0819 ps=0.81 w=0.42 l=0.15
X5336 a_25924_14020# a_16812_8642# uio_oe[0] uio_oe[0] sky130_fd_pr__nfet_01v8 ad=1.4703 pd=10.72 as=1.4703 ps=10.72 w=5.07 l=1
X5337 a_44719_41213# a_44095_40847# a_44611_40847# VDPWR sky130_fd_pr__pfet_01v8_hvt ad=0.1155 pd=0.97 as=0.07245 ps=0.765 w=0.42 l=0.15
X5338 a_61187_41213# a_48125_41935# VDPWR VDPWR sky130_fd_pr__pfet_01v8_hvt ad=0.1092 pd=1.36 as=0.07035 ps=0.755 w=0.42 l=0.15
X5339 VDPWR a_38005_41391# a_42439_38671# VDPWR sky130_fd_pr__pfet_01v8_hvt ad=0.0864 pd=0.91 as=0.1664 ps=1.8 w=0.64 l=0.15
X5340 a_39973_41909# a_38005_40847# VDPWR VDPWR sky130_fd_pr__pfet_01v8_hvt ad=0.1176 pd=1.4 as=0.0693 ps=0.75 w=0.42 l=0.15
X5341 a_59933_40669# a_59898_40435# a_59695_40277# uio_oe[0] sky130_fd_pr__nfet_01v8 ad=0.06405 pd=0.725 as=0.1092 ps=1.36 w=0.42 l=0.15
X5342 uio_oe[0] a_56916_39447# a_39752_39483# uio_oe[0] sky130_fd_pr__nfet_01v8 ad=0.097 pd=0.975 as=0.169 ps=1.82 w=0.65 l=0.15
X5343 a_43357_37039# a_37661_37052# a_43275_37039# VDPWR sky130_fd_pr__pfet_01v8_hvt ad=0.135 pd=1.27 as=0.26 ps=2.52 w=1 l=0.15
X5344 a_57519_35925# a_57363_36193# a_57664_35951# VDPWR sky130_fd_pr__pfet_01v8_hvt ad=0.07245 pd=0.765 as=0.1155 ps=0.97 w=0.42 l=0.15
X5345 a_53574_39215# a_52816_39331# a_53011_39189# VDPWR sky130_fd_pr__pfet_01v8_hvt ad=0.0651 pd=0.73 as=0.07245 ps=0.765 w=0.42 l=0.15
X5346 a_61950_39254# a_36661_41391# VDPWR VDPWR sky130_fd_pr__pfet_01v8_hvt ad=0.07665 pd=0.785 as=0.15835 ps=1.395 w=0.42 l=0.15
X5347 a_42857_37078# a_36425_35381# a_42643_37078# VDPWR sky130_fd_pr__pfet_01v8_hvt ad=0.07665 pd=0.785 as=0.1932 ps=1.34 w=0.42 l=0.15
X5348 a_16756_14782# a_18711_36271# VDPWR VDPWR sky130_fd_pr__pfet_01v8_hvt ad=0.26 pd=2.52 as=0.2279 ps=1.74 w=1 l=0.15
X5349 a_17434_33551# a_17388_33417# uio_oe[0] uio_oe[0] sky130_fd_pr__nfet_01v8 ad=0.0693 pd=0.75 as=0.11285 ps=1.045 w=0.42 l=0.15
X5350 a_61808_41623# a_58980_41909# a_61950_41430# VDPWR sky130_fd_pr__pfet_01v8_hvt ad=0.1932 pd=1.34 as=0.07665 ps=0.785 w=0.42 l=0.15
X5351 a_50090_40303# a_49964_40419# a_49686_40435# uio_oe[0] sky130_fd_pr__special_nfet_01v8 ad=0.0999 pd=0.985 as=0.0711 ps=0.755 w=0.36 l=0.15
X5352 VDPWR a_21156_35593# a_21107_35361# VDPWR sky130_fd_pr__pfet_01v8_hvt ad=0.15835 pd=1.395 as=0.26 ps=2.52 w=1 l=0.15
X5353 a_39555_34471# a_37029_37583# VDPWR VDPWR sky130_fd_pr__pfet_01v8_hvt ad=0.0567 pd=0.69 as=0.16655 ps=1.39 w=0.42 l=0.15
X5354 a_22218_36815# a_21252_36681# uio_oe[0] uio_oe[0] sky130_fd_pr__nfet_01v8 ad=0.0693 pd=0.75 as=0.11285 ps=1.045 w=0.42 l=0.15
X5355 uio_oe[0] a_40379_35551# a_44873_43023# uio_oe[0] sky130_fd_pr__nfet_01v8 ad=0.1346 pd=1.15 as=0.0441 ps=0.63 w=0.42 l=0.15
X5356 VDPWR a_36999_38101# a_37029_38127# VDPWR sky130_fd_pr__pfet_01v8_hvt ad=0.135 pd=1.27 as=0.135 ps=1.27 w=1 l=0.15
X5357 a_22505_35659# a_21252_35593# uio_oe[0] uio_oe[0] sky130_fd_pr__nfet_01v8 ad=0.1092 pd=1.36 as=0.1449 ps=1.11 w=0.42 l=0.15
X5358 uio_oe[0] a_51841_35161# a_51775_35229# uio_oe[0] sky130_fd_pr__nfet_01v8 ad=0.1449 pd=1.11 as=0.0693 ps=0.75 w=0.42 l=0.15
X5359 a_59860_41623# a_59956_41365# VDPWR VDPWR sky130_fd_pr__pfet_01v8_hvt ad=0.1664 pd=1.8 as=0.149 ps=1.325 w=0.64 l=0.15
X5360 a_41763_37557# a_41588_37583# a_41942_37583# uio_oe[0] sky130_fd_pr__nfet_01v8 ad=0.1092 pd=1.36 as=0.06405 ps=0.725 w=0.42 l=0.15
X5361 a_49686_37171# a_49964_37155# a_49920_37039# VDPWR sky130_fd_pr__pfet_01v8_hvt ad=0.0588 pd=0.7 as=0.0567 ps=0.69 w=0.42 l=0.15
X5362 a_50003_35549# a_41685_42479# uio_oe[0] uio_oe[0] sky130_fd_pr__nfet_01v8 ad=0.1092 pd=1.36 as=0.0567 ps=0.69 w=0.42 l=0.15
X5363 a_27316_18020# a_16812_8642# uio_oe[0] uio_oe[0] sky130_fd_pr__nfet_01v8 ad=1.4703 pd=10.72 as=1.4703 ps=10.72 w=5.07 l=1
X5364 a_45338_43389# a_44261_43023# a_45176_43023# VDPWR sky130_fd_pr__pfet_01v8_hvt ad=0.0567 pd=0.69 as=0.0588 ps=0.7 w=0.42 l=0.15
X5365 a_47283_41695# a_47108_41769# a_47462_41757# uio_oe[0] sky130_fd_pr__nfet_01v8 ad=0.1092 pd=1.36 as=0.06405 ps=0.725 w=0.42 l=0.15
X5366 VDPWR a_21401_33703# a_21431_34056# VDPWR sky130_fd_pr__pfet_01v8_hvt ad=0.0693 pd=0.75 as=0.0441 ps=0.63 w=0.42 l=0.15
X5367 a_51412_34471# a_51620_34293# a_51554_34319# uio_oe[0] sky130_fd_pr__nfet_01v8 ad=0.09975 pd=0.895 as=0.0693 ps=0.75 w=0.42 l=0.15
X5368 a_59956_41365# a_60416_41669# a_60374_41757# uio_oe[0] sky130_fd_pr__nfet_01v8 ad=0.0693 pd=0.75 as=0.0441 ps=0.63 w=0.42 l=0.15
X5369 VDPWR a_46193_39759# a_59695_38101# VDPWR sky130_fd_pr__pfet_01v8_hvt ad=0.0819 pd=0.81 as=0.0567 ps=0.69 w=0.42 l=0.15
X5370 a_54459_41909# a_54284_41935# a_54638_41935# uio_oe[0] sky130_fd_pr__nfet_01v8 ad=0.1092 pd=1.36 as=0.06405 ps=0.725 w=0.42 l=0.15
X5371 a_17250_36993# a_17204_37145# uio_oe[0] uio_oe[0] sky130_fd_pr__nfet_01v8 ad=0.0693 pd=0.75 as=0.11285 ps=1.045 w=0.42 l=0.15
X5372 a_41671_37343# a_41496_37417# a_41850_37405# uio_oe[0] sky130_fd_pr__nfet_01v8 ad=0.1092 pd=1.36 as=0.06405 ps=0.725 w=0.42 l=0.15
X5373 VDPWR a_59860_39447# a_54479_39228# VDPWR sky130_fd_pr__pfet_01v8_hvt ad=0.149 pd=1.325 as=0.26 ps=2.52 w=1 l=0.15
X5374 VDPWR a_37661_37052# a_43525_37039# VDPWR sky130_fd_pr__pfet_01v8_hvt ad=0.26 pd=2.52 as=0.135 ps=1.27 w=1 l=0.15
X5375 uio_oe[0] a_21585_33483# a_21519_33551# uio_oe[0] sky130_fd_pr__nfet_01v8 ad=0.1449 pd=1.11 as=0.0693 ps=0.75 w=0.42 l=0.15
X5376 VDPWR a_36661_41391# a_52325_42262# VDPWR sky130_fd_pr__pfet_01v8_hvt ad=0.0693 pd=0.75 as=0.1176 ps=1.4 w=0.42 l=0.15
X5377 VDPWR a_40099_35925# a_36425_34293# VDPWR sky130_fd_pr__pfet_01v8_hvt ad=0.3012 pd=2.66 as=0.26 ps=2.52 w=1 l=0.15
X5378 a_56843_35381# a_57046_35659# VDPWR VDPWR sky130_fd_pr__pfet_01v8_hvt ad=0.0567 pd=0.69 as=0.1134 ps=1.38 w=0.42 l=0.15
X5379 a_41158_41757# a_38285_34863# uio_oe[0] uio_oe[0] sky130_fd_pr__nfet_01v8 ad=0.0693 pd=0.75 as=0.11285 ps=1.045 w=0.42 l=0.15
X5380 VDPWR a_25417_32641# a_25739_35933# VDPWR sky130_fd_pr__pfet_01v8_hvt ad=0.16655 pd=1.39 as=0.0567 ps=0.69 w=0.42 l=0.15
X5381 uio_oe[0] a_56843_35925# a_39783_35967# uio_oe[0] sky130_fd_pr__nfet_01v8 ad=0.2087 pd=2.02 as=0.169 ps=1.82 w=0.65 l=0.15
X5382 a_39677_34979# a_39647_34877# VDPWR VDPWR sky130_fd_pr__pfet_01v8_hvt ad=0.0441 pd=0.63 as=0.14825 ps=1.34 w=0.42 l=0.15
X5383 VDPWR a_58772_42711# a_58144_42453# VDPWR sky130_fd_pr__pfet_01v8_hvt ad=0.15835 pd=1.395 as=0.26 ps=2.52 w=1 l=0.15
X5384 VDPWR a_37913_43023# a_53203_39759# VDPWR sky130_fd_pr__pfet_01v8_hvt ad=0.0864 pd=0.91 as=0.1664 ps=1.8 w=0.64 l=0.15
X5385 uio_oe[0] a_60584_39529# a_60542_39581# uio_oe[0] sky130_fd_pr__nfet_01v8 ad=0.1092 pd=1.36 as=0.0441 ps=0.63 w=0.42 l=0.15
X5386 a_58914_34646# a_48677_38127# VDPWR VDPWR sky130_fd_pr__pfet_01v8_hvt ad=0.07665 pd=0.785 as=0.15835 ps=1.395 w=0.42 l=0.15
X5387 VDPWR a_42399_38101# a_42347_38127# VDPWR sky130_fd_pr__pfet_01v8_hvt ad=0.3012 pd=2.66 as=0.26 ps=2.52 w=1 l=0.15
X5388 a_22575_37359# a_22395_37359# VDPWR VDPWR sky130_fd_pr__pfet_01v8_hvt ad=0.0609 pd=0.71 as=0.0714 ps=0.76 w=0.42 l=0.15
X5389 uio_oe[0] a_44905_38671# a_49721_37405# uio_oe[0] sky130_fd_pr__nfet_01v8 ad=0.12495 pd=1.015 as=0.06405 ps=0.725 w=0.42 l=0.15
X5390 a_26303_33551# a_18427_33198# a_25940_33417# uio_oe[0] sky130_fd_pr__nfet_01v8 ad=0.0693 pd=0.75 as=0.09975 ps=0.895 w=0.42 l=0.15
X5391 a_38532_41623# a_38740_41659# a_38674_41757# uio_oe[0] sky130_fd_pr__nfet_01v8 ad=0.09975 pd=0.895 as=0.0693 ps=0.75 w=0.42 l=0.15
X5392 a_16812_8642# uio_oe[0] sky130_fd_pr__cap_mim_m3_1 l=22 w=22
X5393 uio_oe[0] a_49483_42453# a_38740_42747# uio_oe[0] sky130_fd_pr__nfet_01v8 ad=0.2087 pd=2.02 as=0.169 ps=1.82 w=0.65 l=0.15
X5394 a_41751_34471# a_47283_41695# VDPWR VDPWR sky130_fd_pr__pfet_01v8_hvt ad=0.26 pd=2.52 as=0.3012 ps=2.66 w=1 l=0.15
X5395 VDPWR a_49483_37557# a_39752_37557# VDPWR sky130_fd_pr__pfet_01v8_hvt ad=0.3012 pd=2.66 as=0.26 ps=2.52 w=1 l=0.15
X5396 VDPWR a_36503_36257# a_36327_35925# VDPWR sky130_fd_pr__pfet_01v8_hvt ad=0.0714 pd=0.76 as=0.0609 ps=0.71 w=0.42 l=0.15
X5397 a_44829_42177# a_44611_41935# VDPWR VDPWR sky130_fd_pr__pfet_01v8_hvt ad=0.12915 pd=1.185 as=0.2184 ps=2.2 w=0.84 l=0.15
X5398 a_43590_40125# a_42513_39759# a_43428_39759# VDPWR sky130_fd_pr__pfet_01v8_hvt ad=0.0567 pd=0.69 as=0.0588 ps=0.7 w=0.42 l=0.15
X5399 a_44339_37735# a_44327_39447# a_44513_37611# uio_oe[0] sky130_fd_pr__nfet_01v8 ad=0.1176 pd=1.4 as=0.0567 ps=0.69 w=0.42 l=0.15
X5400 uio_oe[0] a_25417_32641# a_25825_37021# uio_oe[0] sky130_fd_pr__nfet_01v8 ad=0.1118 pd=1.04 as=0.0567 ps=0.69 w=0.42 l=0.15
X5401 a_57363_40989# a_38649_43023# uio_oe[0] uio_oe[0] sky130_fd_pr__nfet_01v8 ad=0.1092 pd=1.36 as=0.0567 ps=0.69 w=0.42 l=0.15
X5402 uio_oe[0] a_50159_35925# a_50090_35951# uio_oe[0] sky130_fd_pr__nfet_01v8 ad=0.1346 pd=1.15 as=0.0999 ps=0.985 w=0.64 l=0.15
X5403 a_58914_34319# a_48677_38127# uio_oe[0] uio_oe[0] sky130_fd_pr__nfet_01v8 ad=0.0693 pd=0.75 as=0.11285 ps=1.045 w=0.42 l=0.15
X5404 a_46761_43265# a_46543_43023# VDPWR VDPWR sky130_fd_pr__pfet_01v8_hvt ad=0.12915 pd=1.185 as=0.2184 ps=2.2 w=0.84 l=0.15
X5405 uio_oe[0] a_39947_42997# a_42941_40669# uio_oe[0] sky130_fd_pr__nfet_01v8 ad=0.1346 pd=1.15 as=0.0441 ps=0.63 w=0.42 l=0.15
X5406 VDPWR a_50003_40545# a_49964_40419# VDPWR sky130_fd_pr__pfet_01v8_hvt ad=0.0864 pd=0.91 as=0.1664 ps=1.8 w=0.64 l=0.15
X5407 a_31180_14020# a_16812_8642# uio_oe[0] uio_oe[0] sky130_fd_pr__nfet_01v8 ad=1.4703 pd=10.72 as=1.4703 ps=10.72 w=5.07 l=1
X5408 a_28835_33007# a_17255_32793# uio_oe[0] uio_oe[0] sky130_fd_pr__nfet_01v8 ad=0.1092 pd=1.36 as=0.1092 ps=1.36 w=0.42 l=0.15
X5409 a_17434_34312# a_17388_34505# VDPWR VDPWR sky130_fd_pr__pfet_01v8_hvt ad=0.07665 pd=0.785 as=0.15835 ps=1.395 w=0.42 l=0.15
X5410 uio_oe[0] a_50159_39996# a_50090_40125# uio_oe[0] sky130_fd_pr__nfet_01v8 ad=0.1346 pd=1.15 as=0.0999 ps=0.985 w=0.64 l=0.15
X5411 a_50304_34685# a_50090_34685# VDPWR VDPWR sky130_fd_pr__pfet_01v8_hvt ad=0.1155 pd=0.97 as=0.07035 ps=0.755 w=0.42 l=0.15
X5412 a_60153_41174# a_51620_40821# a_59939_41174# VDPWR sky130_fd_pr__pfet_01v8_hvt ad=0.07665 pd=0.785 as=0.1932 ps=1.34 w=0.42 l=0.15
X5413 a_54459_37557# a_46193_39759# VDPWR VDPWR sky130_fd_pr__pfet_01v8_hvt ad=0.0567 pd=0.69 as=0.0819 ps=0.81 w=0.42 l=0.15
X5414 VDPWR a_36919_35951# a_37085_35951# VDPWR sky130_fd_pr__pfet_01v8_hvt ad=0.135 pd=1.27 as=0.135 ps=1.27 w=1 l=0.15
X5415 a_61187_34685# a_46193_39759# VDPWR VDPWR sky130_fd_pr__pfet_01v8_hvt ad=0.1092 pd=1.36 as=0.07035 ps=0.755 w=0.42 l=0.15
X5416 a_57450_42479# a_57363_42721# a_57046_42611# VDPWR sky130_fd_pr__pfet_01v8_hvt ad=0.12915 pd=1.185 as=0.0588 ps=0.7 w=0.42 l=0.15
X5417 uio_oe[0] a_37003_39189# a_36934_39215# uio_oe[0] sky130_fd_pr__nfet_01v8 ad=0.1346 pd=1.15 as=0.0999 ps=0.985 w=0.64 l=0.15
X5418 a_48677_38127# a_48511_38127# uio_oe[0] uio_oe[0] sky130_fd_pr__nfet_01v8 ad=0.08775 pd=0.92 as=0.08775 ps=0.92 w=0.65 l=0.15
X5419 a_42467_42650# a_43419_42997# VDPWR VDPWR sky130_fd_pr__pfet_01v8_hvt ad=0.26 pd=2.52 as=0.3012 ps=2.66 w=1 l=0.15
X5420 VDPWR a_41224_41659# a_41425_41097# VDPWR sky130_fd_pr__pfet_01v8_hvt ad=0.135 pd=1.27 as=0.135 ps=1.27 w=1 l=0.15
X5421 a_36607_39455# a_37183_40277# VDPWR VDPWR sky130_fd_pr__pfet_01v8_hvt ad=0.135 pd=1.27 as=0.26 ps=2.52 w=1 l=0.15
X5422 VDPWR a_57363_38813# a_57324_38939# VDPWR sky130_fd_pr__pfet_01v8_hvt ad=0.0864 pd=0.91 as=0.1664 ps=1.8 w=0.64 l=0.15
X5423 a_41074_38127# a_40987_38369# a_40670_38259# VDPWR sky130_fd_pr__pfet_01v8_hvt ad=0.12915 pd=1.185 as=0.0588 ps=0.7 w=0.42 l=0.15
X5424 a_18801_36993# a_18531_37359# a_18711_37359# uio_oe[0] sky130_fd_pr__nfet_01v8 ad=0.0504 pd=0.66 as=0.1092 ps=1.36 w=0.42 l=0.15
X5425 a_42643_37078# a_36425_35381# a_42643_37405# uio_oe[0] sky130_fd_pr__nfet_01v8 ad=0.09975 pd=0.895 as=0.0693 ps=0.75 w=0.42 l=0.15
X5426 VDPWR a_38532_42087# a_17388_35593# VDPWR sky130_fd_pr__pfet_01v8_hvt ad=0.15835 pd=1.395 as=0.26 ps=2.52 w=1 l=0.15
X5427 VDPWR a_41588_37583# a_41763_37557# VDPWR sky130_fd_pr__pfet_01v8_hvt ad=0.1134 pd=1.38 as=0.0567 ps=0.69 w=0.42 l=0.15
X5428 a_53719_40847# a_53203_40847# a_53624_40847# uio_oe[0] sky130_fd_pr__special_nfet_01v8 ad=0.0594 pd=0.69 as=0.066 ps=0.745 w=0.36 l=0.15
X5429 a_60729_40847# a_60563_40847# uio_oe[0] uio_oe[0] sky130_fd_pr__nfet_01v8 ad=0.1092 pd=1.36 as=0.0567 ps=0.69 w=0.42 l=0.15
X5430 uio_oe[0] a_25940_33417# a_25044_33703# uio_oe[0] sky130_fd_pr__nfet_01v8 ad=0.11285 pd=1.045 as=0.169 ps=1.82 w=0.65 l=0.15
X5431 a_21615_34312# a_17500_33453# a_21156_34505# VDPWR sky130_fd_pr__pfet_01v8_hvt ad=0.0441 pd=0.63 as=0.1932 ps=1.34 w=0.42 l=0.15
X5432 a_57664_37949# a_57450_37949# VDPWR VDPWR sky130_fd_pr__pfet_01v8_hvt ad=0.1155 pd=0.97 as=0.07035 ps=0.755 w=0.42 l=0.15
X5433 a_41605_36495# a_40415_36495# a_41496_36495# uio_oe[0] sky130_fd_pr__special_nfet_01v8 ad=0.0669 pd=0.75 as=0.0711 ps=0.755 w=0.36 l=0.15
X5434 a_37859_42845# a_37605_42518# uio_oe[0] uio_oe[0] sky130_fd_pr__nfet_01v8 ad=0.0693 pd=0.75 as=0.1449 ps=1.11 w=0.42 l=0.15
X5435 a_50003_42721# a_38649_43023# VDPWR VDPWR sky130_fd_pr__pfet_01v8_hvt ad=0.1664 pd=1.8 as=0.0864 ps=0.91 w=0.64 l=0.15
X5436 uio_oe[0] a_41537_41909# a_41471_41935# uio_oe[0] sky130_fd_pr__nfet_01v8 ad=0.1449 pd=1.11 as=0.0693 ps=0.75 w=0.42 l=0.15
X5437 VDPWR a_37795_40535# a_38005_40303# VDPWR sky130_fd_pr__pfet_01v8_hvt ad=0.26 pd=2.52 as=0.135 ps=1.27 w=1 l=0.15
X5438 a_30233_36747# a_28980_36681# uio_oe[0] uio_oe[0] sky130_fd_pr__nfet_01v8 ad=0.1092 pd=1.36 as=0.1449 ps=1.11 w=0.42 l=0.15
X5439 a_17537_35879# a_17204_36057# uio_oe[0] uio_oe[0] sky130_fd_pr__nfet_01v8 ad=0.1092 pd=1.36 as=0.1449 ps=1.11 w=0.42 l=0.15
X5440 a_18671_35400# a_18420_33453# a_18212_35593# VDPWR sky130_fd_pr__pfet_01v8_hvt ad=0.0441 pd=0.63 as=0.1932 ps=1.34 w=0.42 l=0.15
X5441 a_44261_43023# a_44095_43023# VDPWR VDPWR sky130_fd_pr__pfet_01v8_hvt ad=0.1664 pd=1.8 as=0.0864 ps=0.91 w=0.64 l=0.15
X5442 uio_oe[0] rst_n a_44739_38671# uio_oe[0] sky130_fd_pr__nfet_01v8 ad=0.08775 pd=0.92 as=0.169 ps=1.82 w=0.65 l=0.15
X5443 uio_oe[0] uio_oe[0] uio_oe[0] uio_oe[0] sky130_fd_pr__nfet_01v8 ad=0.1885 pd=1.88 as=0 ps=0 w=0.65 l=0.15
X5444 VDPWR a_51841_35161# a_51871_34902# VDPWR sky130_fd_pr__pfet_01v8_hvt ad=0.0693 pd=0.75 as=0.0441 ps=0.63 w=0.42 l=0.15
X5445 a_44261_41935# a_44095_41935# uio_oe[0] uio_oe[0] sky130_fd_pr__nfet_01v8 ad=0.1092 pd=1.36 as=0.0567 ps=0.69 w=0.42 l=0.15
X5446 a_54693_37337# a_37361_41391# uio_oe[0] uio_oe[0] sky130_fd_pr__nfet_01v8 ad=0.1092 pd=1.36 as=0.1449 ps=1.11 w=0.42 l=0.15
X5447 VDPWR a_22076_33417# a_21180_33703# VDPWR sky130_fd_pr__pfet_01v8_hvt ad=0.15835 pd=1.395 as=0.26 ps=2.52 w=1 l=0.15
X5448 a_24484_18782# a_25739_34845# VDPWR VDPWR sky130_fd_pr__pfet_01v8_hvt ad=0.475 pd=2.95 as=0.16655 ps=1.39 w=1 l=0.15
X5449 a_53249_41757# a_48125_41935# uio_oe[0] uio_oe[0] sky130_fd_pr__nfet_01v8 ad=0.0441 pd=0.63 as=0.1346 ps=1.15 w=0.42 l=0.15
X5450 uio_oe[0] a_38005_41391# a_42347_39759# uio_oe[0] sky130_fd_pr__nfet_01v8 ad=0.0567 pd=0.69 as=0.1092 ps=1.36 w=0.42 l=0.15
X5451 VDPWR a_59201_39733# a_59231_40086# VDPWR sky130_fd_pr__pfet_01v8_hvt ad=0.0693 pd=0.75 as=0.0441 ps=0.63 w=0.42 l=0.15
X5452 VDPWR a_37913_43023# a_60563_38671# VDPWR sky130_fd_pr__pfet_01v8_hvt ad=0.0864 pd=0.91 as=0.1664 ps=1.8 w=0.64 l=0.15
X5453 uio_oe[0] a_48511_38127# a_48677_38127# uio_oe[0] sky130_fd_pr__nfet_01v8 ad=0.169 pd=1.82 as=0.08775 ps=0.92 w=0.65 l=0.15
X5454 a_39907_37583# a_39759_36777# a_39544_37735# uio_oe[0] sky130_fd_pr__nfet_01v8 ad=0.0693 pd=0.75 as=0.09975 ps=0.895 w=0.42 l=0.15
X5455 uio_oe[0] a_20972_37145# a_20923_36993# uio_oe[0] sky130_fd_pr__nfet_01v8 ad=0.11285 pd=1.045 as=0.169 ps=1.82 w=0.65 l=0.15
X5456 a_59227_37405# a_39752_37307# a_58864_37271# uio_oe[0] sky130_fd_pr__nfet_01v8 ad=0.0693 pd=0.75 as=0.09975 ps=0.895 w=0.42 l=0.15
X5457 uio_oe[0] a_40619_35549# a_40580_35675# uio_oe[0] sky130_fd_pr__nfet_01v8 ad=0.0567 pd=0.69 as=0.1092 ps=1.36 w=0.42 l=0.15
X5458 a_52793_34646# a_51620_35131# a_52579_34646# VDPWR sky130_fd_pr__pfet_01v8_hvt ad=0.07665 pd=0.785 as=0.1932 ps=1.34 w=0.42 l=0.15
X5459 VDPWR a_29313_34571# a_29343_34312# VDPWR sky130_fd_pr__pfet_01v8_hvt ad=0.0693 pd=0.75 as=0.0441 ps=0.63 w=0.42 l=0.15
X5460 a_39719_34953# a_37029_37583# uio_oe[0] uio_oe[0] sky130_fd_pr__nfet_01v8 ad=0.1092 pd=1.36 as=0.1575 ps=1.17 w=0.42 l=0.15
X5461 a_50090_41213# a_50003_40989# a_49686_41099# VDPWR sky130_fd_pr__pfet_01v8_hvt ad=0.12915 pd=1.185 as=0.0588 ps=0.7 w=0.42 l=0.15
X5462 VDPWR a_51841_39733# a_51871_40086# VDPWR sky130_fd_pr__pfet_01v8_hvt ad=0.0693 pd=0.75 as=0.0441 ps=0.63 w=0.42 l=0.15
X5463 uio_oe[0] a_57012_39189# a_57148_39215# uio_oe[0] sky130_fd_pr__nfet_01v8 ad=0.1137 pd=1.01 as=0.1404 ps=1.6 w=0.54 l=0.15
X5464 a_53981_39759# a_53937_40001# a_53815_39759# uio_oe[0] sky130_fd_pr__nfet_01v8 ad=0.0441 pd=0.63 as=0.1401 ps=1.1 w=0.42 l=0.15
X5465 a_25020_35593# a_17500_33453# a_25162_35727# uio_oe[0] sky130_fd_pr__nfet_01v8 ad=0.09975 pd=0.895 as=0.0693 ps=0.75 w=0.42 l=0.15
X5466 a_58772_34471# a_38651_34471# a_58914_34646# VDPWR sky130_fd_pr__pfet_01v8_hvt ad=0.1932 pd=1.34 as=0.07665 ps=0.785 w=0.42 l=0.15
X5467 a_57046_38923# a_57324_38939# a_57280_39037# VDPWR sky130_fd_pr__pfet_01v8_hvt ad=0.0588 pd=0.7 as=0.0567 ps=0.69 w=0.42 l=0.15
X5468 uio_oe[0] a_39544_37735# a_24932_36057# uio_oe[0] sky130_fd_pr__nfet_01v8 ad=0.11285 pd=1.045 as=0.169 ps=1.82 w=0.65 l=0.15
X5469 VDPWR a_60371_35925# a_60302_35951# VDPWR sky130_fd_pr__pfet_01v8_hvt ad=0.2184 pd=2.2 as=0.12915 ps=1.185 w=0.84 l=0.15
X5470 uio_oe[0] a_38543_35095# a_28980_34505# uio_oe[0] sky130_fd_pr__nfet_01v8 ad=0.1118 pd=1.04 as=0.182 ps=1.86 w=0.65 l=0.15
X5471 a_44287_38127# a_44327_38359# uio_oe[0] uio_oe[0] sky130_fd_pr__nfet_01v8 ad=0.08775 pd=0.92 as=0.169 ps=1.82 w=0.65 l=0.15
X5472 ua[4] a_20620_10782# a_21882_10020# uio_oe[0] sky130_fd_pr__nfet_01v8 ad=0.1885 pd=1.88 as=0.1885 ps=1.88 w=0.65 l=0.15
X5473 a_17655_34639# a_17507_33198# a_17292_34505# uio_oe[0] sky130_fd_pr__nfet_01v8 ad=0.0693 pd=0.75 as=0.09975 ps=0.895 w=0.42 l=0.15
X5474 VDPWR a_25417_32641# a_25739_34845# VDPWR sky130_fd_pr__pfet_01v8_hvt ad=0.16655 pd=1.39 as=0.0567 ps=0.69 w=0.42 l=0.15
X5475 VDPWR a_50159_42453# a_50090_42479# VDPWR sky130_fd_pr__pfet_01v8_hvt ad=0.2184 pd=2.2 as=0.12915 ps=1.185 w=0.84 l=0.15
X5476 a_22575_36271# a_22395_36271# VDPWR VDPWR sky130_fd_pr__pfet_01v8_hvt ad=0.0609 pd=0.71 as=0.0714 ps=0.76 w=0.42 l=0.15
X5477 a_44399_42650# a_45351_42997# uio_oe[0] uio_oe[0] sky130_fd_pr__nfet_01v8 ad=0.169 pd=1.82 as=0.2087 ps=2.02 w=0.65 l=0.15
X5478 VDPWR a_36661_41391# a_59685_38998# VDPWR sky130_fd_pr__pfet_01v8_hvt ad=0.0693 pd=0.75 as=0.1176 ps=1.4 w=0.42 l=0.15
X5479 uio_oe[0] a_40379_35551# a_40705_38493# uio_oe[0] sky130_fd_pr__nfet_01v8 ad=0.12495 pd=1.015 as=0.06405 ps=0.725 w=0.42 l=0.15
X5480 a_51775_37583# a_39752_37557# a_51412_37735# uio_oe[0] sky130_fd_pr__nfet_01v8 ad=0.0693 pd=0.75 as=0.09975 ps=0.895 w=0.42 l=0.15
X5481 a_49686_41523# a_50003_41633# a_49961_41757# uio_oe[0] sky130_fd_pr__special_nfet_01v8 ad=0.0711 pd=0.755 as=0.0669 ps=0.75 w=0.36 l=0.15
X5482 a_17292_34505# a_17507_33198# a_17434_34312# VDPWR sky130_fd_pr__pfet_01v8_hvt ad=0.1932 pd=1.34 as=0.07665 ps=0.785 w=0.42 l=0.15
X5483 VDPWR a_36661_41391# a_60153_41174# VDPWR sky130_fd_pr__pfet_01v8_hvt ad=0.15835 pd=1.395 as=0.07665 ps=0.785 w=0.42 l=0.15
X5484 a_60132_40303# a_59695_40277# VDPWR VDPWR sky130_fd_pr__pfet_01v8_hvt ad=0.0567 pd=0.69 as=0.0819 ps=0.81 w=0.42 l=0.15
X5485 uio_oe[0] a_36327_39733# a_17500_33453# uio_oe[0] sky130_fd_pr__nfet_01v8 ad=0.2087 pd=2.02 as=0.169 ps=1.82 w=0.65 l=0.15
X5486 a_36805_39581# a_36327_39189# uio_oe[0] uio_oe[0] sky130_fd_pr__nfet_01v8 ad=0.0669 pd=0.75 as=0.12495 ps=1.015 w=0.42 l=0.15
X5487 uio_oe[0] a_51412_37735# a_50784_37832# uio_oe[0] sky130_fd_pr__nfet_01v8 ad=0.11285 pd=1.045 as=0.169 ps=1.82 w=0.65 l=0.15
X5488 a_57363_40989# a_38649_43023# VDPWR VDPWR sky130_fd_pr__pfet_01v8_hvt ad=0.1664 pd=1.8 as=0.0864 ps=0.91 w=0.64 l=0.15
X5489 ua[5] a_20620_10376# a_20490_10020# uio_oe[0] sky130_fd_pr__nfet_01v8 ad=0.1885 pd=1.88 as=0.1885 ps=1.88 w=0.65 l=0.15
X5490 a_18146_20730# ua[3] a_18018_22020# uio_oe[0] sky130_fd_pr__nfet_01v8 ad=0.2436 pd=2.26 as=0.2436 ps=2.26 w=0.84 l=0.6
X5491 a_25295_35144# a_25044_34791# a_24836_34969# VDPWR sky130_fd_pr__pfet_01v8_hvt ad=0.0441 pd=0.63 as=0.1932 ps=1.34 w=0.42 l=0.15
X5492 a_60371_42453# a_60176_42595# a_60681_42845# uio_oe[0] sky130_fd_pr__special_nfet_01v8 ad=0.0594 pd=0.69 as=0.1401 ps=1.1 w=0.36 l=0.15
X5493 VDPWR a_6359_24172# uio_oe[0] sky130_fd_pr__res_xhigh_po_1p41 l=5.88
X5494 VDPWR a_40188_35095# a_39759_38140# VDPWR sky130_fd_pr__pfet_01v8_hvt ad=0.15835 pd=1.395 as=0.26 ps=2.52 w=1 l=0.15
X5495 a_42787_41213# a_39947_42997# VDPWR VDPWR sky130_fd_pr__pfet_01v8_hvt ad=0.1092 pd=1.36 as=0.07035 ps=0.755 w=0.42 l=0.15
X5496 uio_oe[0] a_38532_39447# a_21252_34505# uio_oe[0] sky130_fd_pr__nfet_01v8 ad=0.11285 pd=1.045 as=0.169 ps=1.82 w=0.65 l=0.15
X5497 a_53827_37949# a_46193_39759# VDPWR VDPWR sky130_fd_pr__pfet_01v8_hvt ad=0.1092 pd=1.36 as=0.07035 ps=0.755 w=0.42 l=0.15
X5498 VDPWR a_24787_36993# a_26259_37359# VDPWR sky130_fd_pr__pfet_01v8_hvt ad=0.0714 pd=0.76 as=0.1092 ps=1.36 w=0.42 l=0.15
X5499 a_4259_22596# ua[3] uio_oe[0] sky130_fd_pr__res_xhigh_po_0p35 l=17.36
X5500 uio_oe[0] a_25209_32899# a_25241_32641# uio_oe[0] sky130_fd_pr__nfet_01v8 ad=0.1013 pd=0.99 as=0.0504 ps=0.66 w=0.42 l=0.15
X5501 uio_oe[0] a_50159_38908# a_50090_39037# uio_oe[0] sky130_fd_pr__nfet_01v8 ad=0.1346 pd=1.15 as=0.0999 ps=0.985 w=0.64 l=0.15
X5502 a_39973_37337# a_37029_37583# uio_oe[0] uio_oe[0] sky130_fd_pr__nfet_01v8 ad=0.1092 pd=1.36 as=0.1449 ps=1.11 w=0.42 l=0.15
X5503 a_54459_36469# a_46193_39759# VDPWR VDPWR sky130_fd_pr__pfet_01v8_hvt ad=0.0567 pd=0.69 as=0.0819 ps=0.81 w=0.42 l=0.15
X5504 a_56916_35095# a_57012_34837# uio_oe[0] uio_oe[0] sky130_fd_pr__nfet_01v8 ad=0.1092 pd=1.36 as=0.097 ps=0.975 w=0.42 l=0.15
X5505 a_46639_41769# a_46193_41397# a_46543_41769# uio_oe[0] sky130_fd_pr__special_nfet_01v8 ad=0.1401 pd=1.1 as=0.0594 ps=0.69 w=0.36 l=0.15
X5506 ua[5] a_20620_10782# a_21882_22020# uio_oe[0] sky130_fd_pr__nfet_01v8 ad=0.1885 pd=1.88 as=0.1885 ps=1.88 w=0.65 l=0.15
X5507 VDPWR a_17059_34817# a_18531_35183# VDPWR sky130_fd_pr__pfet_01v8_hvt ad=0.0714 pd=0.76 as=0.1092 ps=1.36 w=0.42 l=0.15
X5508 a_58082_42479# a_57324_42595# a_57519_42453# VDPWR sky130_fd_pr__pfet_01v8_hvt ad=0.0651 pd=0.73 as=0.07245 ps=0.765 w=0.42 l=0.15
X5509 a_22505_35659# a_21252_35593# VDPWR VDPWR sky130_fd_pr__pfet_01v8_hvt ad=0.1176 pd=1.4 as=0.0693 ps=0.75 w=0.42 l=0.15
X5510 a_38961_37557# a_37029_37583# VDPWR VDPWR sky130_fd_pr__pfet_01v8_hvt ad=0.1176 pd=1.4 as=0.0693 ps=0.75 w=0.42 l=0.15
X5511 uio_oe[0] a_58144_35925# a_58082_35951# uio_oe[0] sky130_fd_pr__nfet_01v8 ad=0.2205 pd=1.89 as=0.066 ps=0.745 w=0.42 l=0.15
X5512 VDPWR a_37452_34293# a_37410_34569# VDPWR sky130_fd_pr__pfet_01v8_hvt ad=0.14575 pd=1.335 as=0.0441 ps=0.63 w=0.42 l=0.15
X5513 VDPWR a_46761_42177# a_46651_42301# VDPWR sky130_fd_pr__pfet_01v8_hvt ad=0.07035 pd=0.755 as=0.1155 ps=0.97 w=0.42 l=0.15
X5514 VDPWR a_50784_34837# a_50722_34863# VDPWR sky130_fd_pr__pfet_01v8_hvt ad=0.1092 pd=1.36 as=0.0651 ps=0.73 w=0.42 l=0.15
X5515 VDPWR a_36427_36475# a_37839_34863# VDPWR sky130_fd_pr__pfet_01v8_hvt ad=0.0714 pd=0.76 as=0.1092 ps=1.36 w=0.42 l=0.15
X5516 a_60729_40847# a_60563_40847# VDPWR VDPWR sky130_fd_pr__pfet_01v8_hvt ad=0.1664 pd=1.8 as=0.0864 ps=0.91 w=0.64 l=0.15
X5517 ua[4] a_16756_14376# a_16626_22020# uio_oe[0] sky130_fd_pr__nfet_01v8 ad=0.1885 pd=1.88 as=0.1885 ps=1.88 w=0.65 l=0.15
X5518 uio_oe[0] a_53011_34837# a_52942_34863# uio_oe[0] sky130_fd_pr__nfet_01v8 ad=0.1346 pd=1.15 as=0.0999 ps=0.985 w=0.64 l=0.15
X5519 a_44873_40669# a_44829_40277# a_44707_40681# uio_oe[0] sky130_fd_pr__nfet_01v8 ad=0.0441 pd=0.63 as=0.1401 ps=1.1 w=0.42 l=0.15
X5520 VDPWR a_62053_40601# a_62083_40342# VDPWR sky130_fd_pr__pfet_01v8_hvt ad=0.0693 pd=0.75 as=0.0441 ps=0.63 w=0.42 l=0.15
X5521 VDPWR a_45719_39447# a_42236_36219# VDPWR sky130_fd_pr__pfet_01v8_hvt ad=0.16655 pd=1.39 as=0.475 ps=2.95 w=1 l=0.15
X5522 a_36385_38127# a_36355_38101# VDPWR VDPWR sky130_fd_pr__pfet_01v8_hvt ad=0.135 pd=1.27 as=0.135 ps=1.27 w=1 l=0.15
X5523 a_42584_43023# ena VDPWR VDPWR sky130_fd_pr__pfet_01v8_hvt ad=0.0651 pd=0.73 as=0.1092 ps=1.36 w=0.42 l=0.15
X5524 a_26369_36747# a_25116_36681# VDPWR VDPWR sky130_fd_pr__pfet_01v8_hvt ad=0.1176 pd=1.4 as=0.0693 ps=0.75 w=0.42 l=0.15
X5525 a_54638_34319# a_46193_39759# uio_oe[0] uio_oe[0] sky130_fd_pr__nfet_01v8 ad=0.06405 pd=0.725 as=0.12495 ps=1.015 w=0.42 l=0.15
X5526 VDPWR a_37361_41391# a_52793_34646# VDPWR sky130_fd_pr__pfet_01v8_hvt ad=0.15835 pd=1.395 as=0.07665 ps=0.785 w=0.42 l=0.15
X5527 a_52573_39581# a_52538_39347# a_52335_39189# uio_oe[0] sky130_fd_pr__nfet_01v8 ad=0.06405 pd=0.725 as=0.1092 ps=1.36 w=0.42 l=0.15
X5528 uio_oe[0] a_57363_38369# a_57324_38243# uio_oe[0] sky130_fd_pr__nfet_01v8 ad=0.0567 pd=0.69 as=0.1092 ps=1.36 w=0.42 l=0.15
X5529 a_57664_36861# a_57450_36861# VDPWR VDPWR sky130_fd_pr__pfet_01v8_hvt ad=0.1155 pd=0.97 as=0.07035 ps=0.755 w=0.42 l=0.15
X5530 a_42391_36317# a_36425_36166# a_42028_36183# uio_oe[0] sky130_fd_pr__nfet_01v8 ad=0.0693 pd=0.75 as=0.09975 ps=0.895 w=0.42 l=0.15
X5531 a_50090_34685# a_50003_34461# a_49686_34571# VDPWR sky130_fd_pr__pfet_01v8_hvt ad=0.12915 pd=1.185 as=0.0588 ps=0.7 w=0.42 l=0.15
X5532 a_41158_41430# a_38285_34863# VDPWR VDPWR sky130_fd_pr__pfet_01v8_hvt ad=0.07665 pd=0.785 as=0.15835 ps=1.395 w=0.42 l=0.15
X5533 uio_oe[0] a_36607_39455# a_36565_39581# uio_oe[0] sky130_fd_pr__nfet_01v8 ad=0.12495 pd=1.015 as=0.06405 ps=0.725 w=0.42 l=0.15
X5534 a_41285_37583# a_41241_37825# a_41119_37583# uio_oe[0] sky130_fd_pr__nfet_01v8 ad=0.0441 pd=0.63 as=0.1401 ps=1.1 w=0.42 l=0.15
X5535 VDPWR a_24836_36057# a_24787_35905# VDPWR sky130_fd_pr__pfet_01v8_hvt ad=0.15835 pd=1.395 as=0.26 ps=2.52 w=1 l=0.15
X5536 a_44261_41935# a_44095_41935# VDPWR VDPWR sky130_fd_pr__pfet_01v8_hvt ad=0.1664 pd=1.8 as=0.0864 ps=0.91 w=0.64 l=0.15
X5537 a_40670_39347# a_40987_39457# a_40945_39581# uio_oe[0] sky130_fd_pr__special_nfet_01v8 ad=0.0711 pd=0.755 as=0.0669 ps=0.75 w=0.36 l=0.15
X5538 a_57514_39215# a_57148_39215# VDPWR VDPWR sky130_fd_pr__pfet_01v8_hvt ad=0.0441 pd=0.63 as=0.1092 ps=1.36 w=0.42 l=0.15
X5539 a_61998_41935# a_48125_41935# uio_oe[0] uio_oe[0] sky130_fd_pr__nfet_01v8 ad=0.06405 pd=0.725 as=0.12495 ps=1.015 w=0.42 l=0.15
X5540 a_46805_41757# a_46761_41365# a_46639_41769# uio_oe[0] sky130_fd_pr__nfet_01v8 ad=0.0441 pd=0.63 as=0.1401 ps=1.1 w=0.42 l=0.15
X5541 uio_oe[0] a_59956_37013# a_60092_37039# uio_oe[0] sky130_fd_pr__nfet_01v8 ad=0.1137 pd=1.01 as=0.1404 ps=1.6 w=0.54 l=0.15
X5542 ua[4] a_16756_10376# a_18018_26020# uio_oe[0] sky130_fd_pr__nfet_01v8 ad=0.1885 pd=1.88 as=0.1885 ps=1.88 w=0.65 l=0.15
X5543 a_60984_34319# a_60365_34319# uio_oe[0] uio_oe[0] sky130_fd_pr__nfet_01v8 ad=0.066 pd=0.745 as=0.2205 ps=1.89 w=0.42 l=0.15
X5544 a_42743_38884# a_42643_37078# uio_oe[0] uio_oe[0] sky130_fd_pr__nfet_01v8 ad=0.169 pd=1.82 as=0.11285 ps=1.045 w=0.65 l=0.15
X5545 VDPWR a_46027_39759# a_46193_39759# VDPWR sky130_fd_pr__pfet_01v8_hvt ad=0.26 pd=2.52 as=0.135 ps=1.27 w=1 l=0.15
X5546 VDPWR a_40379_35551# a_40099_35925# VDPWR sky130_fd_pr__pfet_01v8_hvt ad=0.0819 pd=0.81 as=0.0567 ps=0.69 w=0.42 l=0.15
X5547 a_20914_22464# a_20620_14782# ua[4] uio_oe[0] sky130_fd_pr__nfet_01v8 ad=0.1885 pd=1.88 as=0.1885 ps=1.88 w=0.65 l=0.15
X5548 a_43217_38671# a_43173_38913# a_43051_38671# uio_oe[0] sky130_fd_pr__nfet_01v8 ad=0.0441 pd=0.63 as=0.1401 ps=1.1 w=0.42 l=0.15
X5549 a_53981_38671# a_53937_38913# a_53815_38671# uio_oe[0] sky130_fd_pr__nfet_01v8 ad=0.0441 pd=0.63 as=0.1401 ps=1.1 w=0.42 l=0.15
X5550 uio_oe[0] a_37361_41391# a_52800_34319# uio_oe[0] sky130_fd_pr__nfet_01v8 ad=0.11285 pd=1.045 as=0.0693 ps=0.75 w=0.42 l=0.15
X5551 a_62053_38425# a_37361_41391# VDPWR VDPWR sky130_fd_pr__pfet_01v8_hvt ad=0.1176 pd=1.4 as=0.0693 ps=0.75 w=0.42 l=0.15
X5552 a_53815_37583# a_53369_37583# a_53719_37583# uio_oe[0] sky130_fd_pr__special_nfet_01v8 ad=0.1401 pd=1.1 as=0.0594 ps=0.69 w=0.36 l=0.15
X5553 a_19588_14020# a_4259_22596# a_19410_14020# uio_oe[0] sky130_fd_pr__nfet_01v8 ad=0.2436 pd=2.26 as=0.2436 ps=2.26 w=0.84 l=0.6
X5554 uio_oe[0] a_37029_42479# a_42163_41397# uio_oe[0] sky130_fd_pr__nfet_01v8 ad=0.0567 pd=0.69 as=0.1092 ps=1.36 w=0.42 l=0.15
X5555 a_50304_40303# a_50090_40303# VDPWR VDPWR sky130_fd_pr__pfet_01v8_hvt ad=0.1155 pd=0.97 as=0.07035 ps=0.755 w=0.42 l=0.15
X5556 VDPWR a_40379_35551# a_42399_38101# VDPWR sky130_fd_pr__pfet_01v8_hvt ad=0.0819 pd=0.81 as=0.0567 ps=0.69 w=0.42 l=0.15
X5557 a_20620_10376# a_21875_37021# VDPWR VDPWR sky130_fd_pr__pfet_01v8_hvt ad=0.475 pd=2.95 as=0.16655 ps=1.39 w=1 l=0.15
X5558 a_29343_33224# a_17500_33453# a_28884_33417# VDPWR sky130_fd_pr__pfet_01v8_hvt ad=0.0441 pd=0.63 as=0.1932 ps=1.34 w=0.42 l=0.15
X5559 a_51871_34646# a_51620_34293# a_51412_34471# VDPWR sky130_fd_pr__pfet_01v8_hvt ad=0.0441 pd=0.63 as=0.1932 ps=1.34 w=0.42 l=0.15
X5560 a_44719_40303# a_44095_40309# a_44611_40681# VDPWR sky130_fd_pr__pfet_01v8_hvt ad=0.1155 pd=0.97 as=0.07245 ps=0.765 w=0.42 l=0.15
X5561 a_57450_37949# a_57363_37725# a_57046_37835# VDPWR sky130_fd_pr__pfet_01v8_hvt ad=0.12915 pd=1.185 as=0.0588 ps=0.7 w=0.42 l=0.15
X5562 a_22395_36271# a_20923_35905# uio_oe[0] uio_oe[0] sky130_fd_pr__nfet_01v8 ad=0.1092 pd=1.36 as=0.1092 ps=1.36 w=0.42 l=0.15
X5563 a_17655_33551# a_17507_33198# a_17292_33417# uio_oe[0] sky130_fd_pr__nfet_01v8 ad=0.0693 pd=0.75 as=0.09975 ps=0.895 w=0.42 l=0.15
X5564 uio_oe[0] a_18212_34505# a_17316_34791# uio_oe[0] sky130_fd_pr__nfet_01v8 ad=0.11285 pd=1.045 as=0.169 ps=1.82 w=0.65 l=0.15
X5565 VDPWR a_50159_41365# a_50090_41391# VDPWR sky130_fd_pr__pfet_01v8_hvt ad=0.2184 pd=2.2 as=0.12915 ps=1.185 w=0.84 l=0.15
X5566 a_52538_36083# a_52816_36067# a_52772_35951# VDPWR sky130_fd_pr__pfet_01v8_hvt ad=0.0588 pd=0.7 as=0.0567 ps=0.69 w=0.42 l=0.15
X5567 a_20914_22464# a_4259_22596# a_20618_20730# uio_oe[0] sky130_fd_pr__nfet_01v8 ad=0.2436 pd=2.26 as=0.2436 ps=2.26 w=0.84 l=0.6
X5568 ua[5] a_20620_14376# a_23274_14020# uio_oe[0] sky130_fd_pr__nfet_01v8 ad=0.1885 pd=1.88 as=0.1885 ps=1.88 w=0.65 l=0.15
X5569 a_18011_33757# a_17059_33729# VDPWR VDPWR sky130_fd_pr__pfet_01v8_hvt ad=0.0567 pd=0.69 as=0.1176 ps=1.4 w=0.42 l=0.15
X5570 uio_oe[0] a_37029_42479# a_44095_42485# uio_oe[0] sky130_fd_pr__nfet_01v8 ad=0.0567 pd=0.69 as=0.1092 ps=1.36 w=0.42 l=0.15
X5571 a_56916_41623# a_57012_41365# VDPWR VDPWR sky130_fd_pr__pfet_01v8_hvt ad=0.1664 pd=1.8 as=0.149 ps=1.325 w=0.64 l=0.15
X5572 a_38019_36861# a_37839_36861# VDPWR VDPWR sky130_fd_pr__pfet_01v8_hvt ad=0.0609 pd=0.71 as=0.0714 ps=0.76 w=0.42 l=0.15
X5573 a_22306_26464# a_20620_10782# ua[4] uio_oe[0] sky130_fd_pr__nfet_01v8 ad=0.1885 pd=1.88 as=0.1885 ps=1.88 w=0.65 l=0.15
X5574 a_58248_41391# a_57556_41365# a_57640_41705# VDPWR sky130_fd_pr__pfet_01v8_hvt ad=0.12495 pd=1.175 as=0.0567 ps=0.69 w=0.42 l=0.15
X5575 a_52800_39759# a_51620_39733# a_52579_40086# uio_oe[0] sky130_fd_pr__nfet_01v8 ad=0.0693 pd=0.75 as=0.09975 ps=0.895 w=0.42 l=0.15
X5576 VDPWR a_61808_37271# a_61242_37269# VDPWR sky130_fd_pr__pfet_01v8_hvt ad=0.15835 pd=1.395 as=0.26 ps=2.52 w=1 l=0.15
X5577 a_40096_34471# a_38285_36495# a_40238_34646# VDPWR sky130_fd_pr__pfet_01v8_hvt ad=0.1932 pd=1.34 as=0.07665 ps=0.785 w=0.42 l=0.15
X5578 a_49686_40435# a_50003_40545# a_49961_40669# uio_oe[0] sky130_fd_pr__special_nfet_01v8 ad=0.0711 pd=0.755 as=0.0669 ps=0.75 w=0.36 l=0.15
X5579 VDPWR a_61819_37557# a_61806_37949# VDPWR sky130_fd_pr__pfet_01v8_hvt ad=0.0819 pd=0.81 as=0.0567 ps=0.69 w=0.42 l=0.15
X5580 VDPWR a_56843_34293# a_38651_34471# VDPWR sky130_fd_pr__pfet_01v8_hvt ad=0.3012 pd=2.66 as=0.26 ps=2.52 w=1 l=0.15
X5581 VDPWR a_58144_41096# a_58082_41213# VDPWR sky130_fd_pr__pfet_01v8_hvt ad=0.1092 pd=1.36 as=0.0651 ps=0.73 w=0.42 l=0.15
X5582 a_16756_14376# a_18011_35933# uio_oe[0] uio_oe[0] sky130_fd_pr__nfet_01v8 ad=0.182 pd=1.86 as=0.1118 ps=1.04 w=0.65 l=0.15
X5583 VDPWR a_57519_34556# a_57450_34685# VDPWR sky130_fd_pr__pfet_01v8_hvt ad=0.2184 pd=2.2 as=0.12915 ps=1.185 w=0.84 l=0.15
X5584 uio_oe[0] a_51841_34293# a_51775_34319# uio_oe[0] sky130_fd_pr__nfet_01v8 ad=0.1449 pd=1.11 as=0.0693 ps=0.75 w=0.42 l=0.15
X5585 a_45338_42479# a_44261_42485# a_45176_42857# VDPWR sky130_fd_pr__pfet_01v8_hvt ad=0.0567 pd=0.69 as=0.0588 ps=0.7 w=0.42 l=0.15
X5586 uio_oe[0] a_61819_41909# a_61753_41935# uio_oe[0] sky130_fd_pr__nfet_01v8 ad=0.12495 pd=1.015 as=0.0669 ps=0.75 w=0.42 l=0.15
X5587 a_47283_40821# a_47108_40847# a_47462_40847# uio_oe[0] sky130_fd_pr__nfet_01v8 ad=0.1092 pd=1.36 as=0.06405 ps=0.725 w=0.42 l=0.15
X5588 uio_oe[0] a_42696_37557# a_44557_39759# uio_oe[0] sky130_fd_pr__nfet_01v8 ad=0.08775 pd=0.92 as=0.08775 ps=0.92 w=0.65 l=0.15
X5589 a_17471_36993# a_17243_36449# a_17108_37145# uio_oe[0] sky130_fd_pr__nfet_01v8 ad=0.0693 pd=0.75 as=0.09975 ps=0.895 w=0.42 l=0.15
X5590 uio_oe[0] a_59860_37271# a_54479_37052# uio_oe[0] sky130_fd_pr__nfet_01v8 ad=0.097 pd=0.975 as=0.169 ps=1.82 w=0.65 l=0.15
X5591 uio_oe[0] a_38077_34837# a_38109_35229# uio_oe[0] sky130_fd_pr__nfet_01v8 ad=0.1013 pd=0.99 as=0.0504 ps=0.66 w=0.42 l=0.15
X5592 a_39686_41757# a_38005_40847# uio_oe[0] uio_oe[0] sky130_fd_pr__nfet_01v8 ad=0.0693 pd=0.75 as=0.11285 ps=1.045 w=0.42 l=0.15
X5593 a_61192_41391# a_60416_41669# a_60584_41705# uio_oe[0] sky130_fd_pr__special_nfet_01v8 ad=0.0935 pd=0.965 as=0.072 ps=0.76 w=0.36 l=0.15
X5594 uio_oe[0] a_29129_35879# a_29063_35905# uio_oe[0] sky130_fd_pr__nfet_01v8 ad=0.1449 pd=1.11 as=0.0693 ps=0.75 w=0.42 l=0.15
X5595 a_22306_26464# a_4259_22596# a_22010_24730# uio_oe[0] sky130_fd_pr__nfet_01v8 ad=0.2436 pd=2.26 as=0.2436 ps=2.26 w=0.84 l=0.6
X5596 uio_oe[0] a_36425_34293# a_41711_34569# uio_oe[0] sky130_fd_pr__nfet_01v8 ad=0.08775 pd=0.92 as=0.08775 ps=0.92 w=0.65 l=0.15
X5597 VDPWR a_37661_37052# a_37605_37910# VDPWR sky130_fd_pr__pfet_01v8_hvt ad=0.0693 pd=0.75 as=0.1176 ps=1.4 w=0.42 l=0.15
X5598 a_61297_42177# a_61079_41935# VDPWR VDPWR sky130_fd_pr__pfet_01v8_hvt ad=0.12915 pd=1.185 as=0.2184 ps=2.2 w=0.84 l=0.15
X5599 a_41379_41757# a_37795_40535# a_41016_41623# uio_oe[0] sky130_fd_pr__nfet_01v8 ad=0.0693 pd=0.75 as=0.09975 ps=0.895 w=0.42 l=0.15
X5600 VDPWR a_58772_35559# a_58144_35656# VDPWR sky130_fd_pr__pfet_01v8_hvt ad=0.15835 pd=1.395 as=0.26 ps=2.52 w=1 l=0.15
X5601 VDPWR a_44909_37735# a_44511_38645# VDPWR sky130_fd_pr__pfet_01v8_hvt ad=0.14575 pd=1.335 as=0.34 ps=2.68 w=1 l=0.15
X5602 uio_oe[0] a_37361_41391# a_59685_37910# uio_oe[0] sky130_fd_pr__nfet_01v8 ad=0.1449 pd=1.11 as=0.1092 ps=1.36 w=0.42 l=0.15
X5603 uio_oe[0] a_17108_37145# a_17059_36993# uio_oe[0] sky130_fd_pr__nfet_01v8 ad=0.11285 pd=1.045 as=0.169 ps=1.82 w=0.65 l=0.15
X5604 a_53827_36861# a_46193_39759# VDPWR VDPWR sky130_fd_pr__pfet_01v8_hvt ad=0.1092 pd=1.36 as=0.07035 ps=0.755 w=0.42 l=0.15
X5605 VDPWR a_24787_35905# a_26259_36271# VDPWR sky130_fd_pr__pfet_01v8_hvt ad=0.0714 pd=0.76 as=0.1092 ps=1.36 w=0.42 l=0.15
X5606 VDPWR a_57640_35177# a_57694_34863# VDPWR sky130_fd_pr__pfet_01v8_hvt ad=0.0567 pd=0.69 as=0.0483 ps=0.65 w=0.42 l=0.15
X5607 a_46639_40681# a_46193_40309# a_46543_40681# uio_oe[0] sky130_fd_pr__special_nfet_01v8 ad=0.1401 pd=1.1 as=0.0594 ps=0.69 w=0.36 l=0.15
X5608 ua[4] a_16756_18376# a_19410_18020# uio_oe[0] sky130_fd_pr__nfet_01v8 ad=0.1885 pd=1.88 as=0.1885 ps=1.88 w=0.65 l=0.15
X5609 uio_oe[0] a_38961_41689# a_38895_41757# uio_oe[0] sky130_fd_pr__nfet_01v8 ad=0.1449 pd=1.11 as=0.0693 ps=0.75 w=0.42 l=0.15
X5610 a_38961_40601# a_38005_40847# uio_oe[0] uio_oe[0] sky130_fd_pr__nfet_01v8 ad=0.1092 pd=1.36 as=0.1449 ps=1.11 w=0.42 l=0.15
X5611 a_50397_36495# a_44905_38671# uio_oe[0] uio_oe[0] sky130_fd_pr__nfet_01v8 ad=0.0441 pd=0.63 as=0.1346 ps=1.15 w=0.42 l=0.15
X5612 a_57321_36495# a_56843_36469# uio_oe[0] uio_oe[0] sky130_fd_pr__nfet_01v8 ad=0.0669 pd=0.75 as=0.12495 ps=1.015 w=0.42 l=0.15
X5613 a_21961_35933# a_20923_35905# a_21875_35933# uio_oe[0] sky130_fd_pr__nfet_01v8 ad=0.0567 pd=0.69 as=0.1176 ps=1.4 w=0.42 l=0.15
X5614 a_60365_36495# a_59939_36822# VDPWR VDPWR sky130_fd_pr__pfet_01v8_hvt ad=0.26 pd=2.52 as=0.15835 ps=1.395 w=1 l=0.15
X5615 VDPWR a_57363_36193# a_57324_36067# VDPWR sky130_fd_pr__pfet_01v8_hvt ad=0.0864 pd=0.91 as=0.1664 ps=1.8 w=0.64 l=0.15
X5616 a_38532_40999# a_38740_40821# a_38674_40847# uio_oe[0] sky130_fd_pr__nfet_01v8 ad=0.09975 pd=0.895 as=0.0693 ps=0.75 w=0.42 l=0.15
X5617 uio_oe[0] a_38285_36495# a_43897_36647# uio_oe[0] sky130_fd_pr__nfet_01v8 ad=0.1092 pd=1.36 as=0.0567 ps=0.69 w=0.42 l=0.15
X5618 a_42069_35657# a_37851_36647# VDPWR VDPWR sky130_fd_pr__pfet_01v8_hvt ad=0.135 pd=1.27 as=0.26 ps=2.52 w=1 l=0.15
X5619 uio_oe[0] a_37085_35951# a_38080_42845# uio_oe[0] sky130_fd_pr__nfet_01v8 ad=0.11285 pd=1.045 as=0.0693 ps=0.75 w=0.42 l=0.15
X5620 a_51554_41757# a_48677_39759# uio_oe[0] uio_oe[0] sky130_fd_pr__nfet_01v8 ad=0.0693 pd=0.75 as=0.11285 ps=1.045 w=0.42 l=0.15
X5621 a_36805_39759# a_36327_39733# uio_oe[0] uio_oe[0] sky130_fd_pr__nfet_01v8 ad=0.0669 pd=0.75 as=0.12495 ps=1.015 w=0.42 l=0.15
X5622 a_50722_39037# a_49964_38939# a_50159_38908# VDPWR sky130_fd_pr__pfet_01v8_hvt ad=0.0651 pd=0.73 as=0.07245 ps=0.765 w=0.42 l=0.15
X5623 a_58980_37557# a_61819_37557# VDPWR VDPWR sky130_fd_pr__pfet_01v8_hvt ad=0.26 pd=2.52 as=0.3012 ps=2.66 w=1 l=0.15
X5624 uio_oe[0] a_37839_41391# a_38005_41391# uio_oe[0] sky130_fd_pr__nfet_01v8 ad=0.169 pd=1.82 as=0.08775 ps=0.92 w=0.65 l=0.15
X5625 a_44261_40309# a_44095_40309# VDPWR VDPWR sky130_fd_pr__pfet_01v8_hvt ad=0.1664 pd=1.8 as=0.0864 ps=0.91 w=0.64 l=0.15
X5626 a_30263_33224# a_18420_33453# a_29804_33417# VDPWR sky130_fd_pr__pfet_01v8_hvt ad=0.0441 pd=0.63 as=0.1932 ps=1.34 w=0.42 l=0.15
X5627 a_42329_42485# a_42163_42485# VDPWR VDPWR sky130_fd_pr__pfet_01v8_hvt ad=0.1664 pd=1.8 as=0.0864 ps=0.91 w=0.64 l=0.15
X5628 a_57757_39759# a_48125_43023# uio_oe[0] uio_oe[0] sky130_fd_pr__nfet_01v8 ad=0.0441 pd=0.63 as=0.1346 ps=1.15 w=0.42 l=0.15
X5629 a_23698_18464# a_20620_18782# ua[4] uio_oe[0] sky130_fd_pr__nfet_01v8 ad=0.1885 pd=1.88 as=0.1885 ps=1.88 w=0.65 l=0.15
X5630 a_50159_34556# a_49964_34587# a_50469_34319# uio_oe[0] sky130_fd_pr__special_nfet_01v8 ad=0.0594 pd=0.69 as=0.1401 ps=1.1 w=0.36 l=0.15
X5631 a_38109_35229# a_37839_34863# a_38019_34863# uio_oe[0] sky130_fd_pr__nfet_01v8 ad=0.0504 pd=0.66 as=0.1092 ps=1.36 w=0.42 l=0.15
X5632 a_57450_42301# a_57324_42203# a_57046_42187# uio_oe[0] sky130_fd_pr__special_nfet_01v8 ad=0.0999 pd=0.985 as=0.0711 ps=0.755 w=0.36 l=0.15
X5633 a_61624_40535# a_54479_40316# a_61766_40669# uio_oe[0] sky130_fd_pr__nfet_01v8 ad=0.09975 pd=0.895 as=0.0693 ps=0.75 w=0.42 l=0.15
X5634 a_46448_40847# ui_in[7] VDPWR VDPWR sky130_fd_pr__pfet_01v8_hvt ad=0.0651 pd=0.73 as=0.1092 ps=1.36 w=0.42 l=0.15
X5635 a_61297_34561# a_61079_34319# uio_oe[0] uio_oe[0] sky130_fd_pr__nfet_01v8 ad=0.0999 pd=0.985 as=0.1346 ps=1.15 w=0.64 l=0.15
X5636 uio_oe[0] a_58772_34471# a_58144_34568# uio_oe[0] sky130_fd_pr__nfet_01v8 ad=0.11285 pd=1.045 as=0.169 ps=1.82 w=0.65 l=0.15
X5637 a_36721_37583# a_36455_37949# VDPWR VDPWR sky130_fd_pr__pfet_01v8_hvt ad=0.26 pd=2.52 as=0.2279 ps=1.74 w=1 l=0.15
X5638 a_42039_35592# a_37851_36647# a_42425_35657# VDPWR sky130_fd_pr__pfet_01v8_hvt ad=0.26 pd=2.52 as=0.135 ps=1.27 w=1 l=0.15
X5639 a_28346_20730# ua[0] a_28218_22020# uio_oe[0] sky130_fd_pr__nfet_01v8 ad=0.2436 pd=2.26 as=0.2436 ps=2.26 w=0.84 l=0.6
X5640 uio_oe[0] a_53636_34837# a_53574_34863# uio_oe[0] sky130_fd_pr__nfet_01v8 ad=0.2205 pd=1.89 as=0.066 ps=0.745 w=0.42 l=0.15
X5641 a_39549_34837# a_39719_34953# a_39677_34979# VDPWR sky130_fd_pr__pfet_01v8_hvt ad=0.1092 pd=1.36 as=0.0441 ps=0.63 w=0.42 l=0.15
X5642 uio_oe[0] a_48125_41935# a_53981_41935# uio_oe[0] sky130_fd_pr__nfet_01v8 ad=0.1346 pd=1.15 as=0.0441 ps=0.63 w=0.42 l=0.15
X5643 a_23698_18464# ua[2] a_23452_18020# uio_oe[0] sky130_fd_pr__nfet_01v8 ad=0.2436 pd=2.26 as=0.2436 ps=2.26 w=0.84 l=0.6
X5644 uio_oe[0] a_44905_38671# a_57081_36495# uio_oe[0] sky130_fd_pr__nfet_01v8 ad=0.12495 pd=1.015 as=0.06405 ps=0.725 w=0.42 l=0.15
X5645 a_60365_35407# a_59939_35734# uio_oe[0] uio_oe[0] sky130_fd_pr__nfet_01v8 ad=0.169 pd=1.82 as=0.11285 ps=1.045 w=0.65 l=0.15
X5646 uio_oe[0] a_57519_35644# a_57450_35773# uio_oe[0] sky130_fd_pr__nfet_01v8 ad=0.1346 pd=1.15 as=0.0999 ps=0.985 w=0.64 l=0.15
X5647 a_39686_42518# a_37029_38127# VDPWR VDPWR sky130_fd_pr__pfet_01v8_hvt ad=0.07665 pd=0.785 as=0.15835 ps=1.395 w=0.42 l=0.15
X5648 VDPWR a_38961_40821# a_38991_41174# VDPWR sky130_fd_pr__pfet_01v8_hvt ad=0.0693 pd=0.75 as=0.0441 ps=0.63 w=0.42 l=0.15
X5649 a_37787_37078# a_37605_37078# VDPWR VDPWR sky130_fd_pr__pfet_01v8_hvt ad=0.0441 pd=0.63 as=0.0693 ps=0.75 w=0.42 l=0.15
X5650 a_58082_37949# a_57324_37851# a_57519_37820# VDPWR sky130_fd_pr__pfet_01v8_hvt ad=0.0651 pd=0.73 as=0.07245 ps=0.765 w=0.42 l=0.15
X5651 a_57450_36861# a_57363_36637# a_57046_36747# VDPWR sky130_fd_pr__pfet_01v8_hvt ad=0.12915 pd=1.185 as=0.0588 ps=0.7 w=0.42 l=0.15
X5652 a_61079_40847# a_60729_40847# a_60984_40847# VDPWR sky130_fd_pr__pfet_01v8_hvt ad=0.07245 pd=0.765 as=0.0651 ps=0.73 w=0.42 l=0.15
X5653 VDPWR a_58144_34568# a_58082_34685# VDPWR sky130_fd_pr__pfet_01v8_hvt ad=0.1092 pd=1.36 as=0.0651 ps=0.73 w=0.42 l=0.15
X5654 uio_oe[0] a_44905_38671# a_57858_35229# uio_oe[0] sky130_fd_pr__nfet_01v8 ad=0.0882 pd=0.84 as=0.0441 ps=0.63 w=0.42 l=0.15
X5655 a_49721_42845# a_49686_42611# a_49483_42453# uio_oe[0] sky130_fd_pr__nfet_01v8 ad=0.06405 pd=0.725 as=0.1092 ps=1.36 w=0.42 l=0.15
X5656 VDPWR a_48125_41935# a_53156_39215# VDPWR sky130_fd_pr__pfet_01v8_hvt ad=0.07035 pd=0.755 as=0.1092 ps=1.36 w=0.42 l=0.15
X5657 a_37042_34863# a_36956_35095# uio_oe[0] uio_oe[0] sky130_fd_pr__nfet_01v8 ad=0.169 pd=1.82 as=0.169 ps=1.82 w=0.65 l=0.15
X5658 a_59939_35734# a_51620_35381# a_59939_35407# uio_oe[0] sky130_fd_pr__nfet_01v8 ad=0.09975 pd=0.895 as=0.0693 ps=0.75 w=0.42 l=0.15
X5659 a_51620_35381# a_54459_35381# VDPWR VDPWR sky130_fd_pr__pfet_01v8_hvt ad=0.26 pd=2.52 as=0.3012 ps=2.66 w=1 l=0.15
X5660 a_38991_42518# a_38740_42747# a_38532_42711# VDPWR sky130_fd_pr__pfet_01v8_hvt ad=0.0441 pd=0.63 as=0.1932 ps=1.34 w=0.42 l=0.15
X5661 VDPWR a_53937_42177# a_53827_42301# VDPWR sky130_fd_pr__pfet_01v8_hvt ad=0.07035 pd=0.755 as=0.1155 ps=0.97 w=0.42 l=0.15
X5662 uio_oe[0] a_36607_39455# a_36565_39759# uio_oe[0] sky130_fd_pr__nfet_01v8 ad=0.12495 pd=1.015 as=0.06405 ps=0.725 w=0.42 l=0.15
X5663 a_52800_38671# a_51620_38645# a_52579_38998# uio_oe[0] sky130_fd_pr__nfet_01v8 ad=0.0693 pd=0.75 as=0.09975 ps=0.895 w=0.42 l=0.15
X5664 a_41496_36495# a_40581_36495# a_41149_36737# uio_oe[0] sky130_fd_pr__special_nfet_01v8 ad=0.0711 pd=0.755 as=0.0999 ps=0.985 w=0.36 l=0.15
X5665 a_43390_35657# a_41677_40847# a_43308_35657# VDPWR sky130_fd_pr__pfet_01v8_hvt ad=0.0441 pd=0.63 as=0.1092 ps=1.36 w=0.42 l=0.15
X5666 a_44611_43023# a_44261_43023# a_44516_43023# VDPWR sky130_fd_pr__pfet_01v8_hvt ad=0.07245 pd=0.765 as=0.0651 ps=0.73 w=0.42 l=0.15
X5667 uio_oe[0] a_42488_37735# a_41768_40008# uio_oe[0] sky130_fd_pr__nfet_01v8 ad=0.11285 pd=1.045 as=0.169 ps=1.82 w=0.65 l=0.15
X5668 VDPWR a_61819_36469# a_61806_36861# VDPWR sky130_fd_pr__pfet_01v8_hvt ad=0.0819 pd=0.81 as=0.0567 ps=0.69 w=0.42 l=0.15
X5669 a_61297_35649# a_61079_35407# VDPWR VDPWR sky130_fd_pr__pfet_01v8_hvt ad=0.12915 pd=1.185 as=0.2184 ps=2.2 w=0.84 l=0.15
X5670 uio_oe[0] a_25449_35659# a_25383_35727# uio_oe[0] sky130_fd_pr__nfet_01v8 ad=0.1449 pd=1.11 as=0.0693 ps=0.75 w=0.42 l=0.15
X5671 a_45338_41391# a_44261_41397# a_45176_41769# VDPWR sky130_fd_pr__pfet_01v8_hvt ad=0.0567 pd=0.69 as=0.0588 ps=0.7 w=0.42 l=0.15
X5672 VDPWR a_40775_35925# a_40706_35951# VDPWR sky130_fd_pr__pfet_01v8_hvt ad=0.2184 pd=2.2 as=0.12915 ps=1.185 w=0.84 l=0.15
X5673 a_50090_40303# a_50003_40545# a_49686_40435# VDPWR sky130_fd_pr__pfet_01v8_hvt ad=0.12915 pd=1.185 as=0.0588 ps=0.7 w=0.42 l=0.15
X5674 a_51554_42518# a_48677_39759# VDPWR VDPWR sky130_fd_pr__pfet_01v8_hvt ad=0.07665 pd=0.785 as=0.15835 ps=1.395 w=0.42 l=0.15
X5675 VDPWR a_36847_39457# a_36808_39331# VDPWR sky130_fd_pr__pfet_01v8_hvt ad=0.0864 pd=0.91 as=0.1664 ps=1.8 w=0.64 l=0.15
X5676 a_57046_38259# a_57324_38243# a_57280_38127# VDPWR sky130_fd_pr__pfet_01v8_hvt ad=0.0588 pd=0.7 as=0.0567 ps=0.69 w=0.42 l=0.15
X5677 VDPWR a_50003_36637# a_49964_36763# VDPWR sky130_fd_pr__pfet_01v8_hvt ad=0.0864 pd=0.91 as=0.1664 ps=1.8 w=0.64 l=0.15
X5678 ua[4] a_28348_10376# a_28218_26020# uio_oe[0] sky130_fd_pr__nfet_01v8 ad=0.1885 pd=1.88 as=0.1885 ps=1.88 w=0.65 l=0.15
X5679 a_53369_37583# a_53203_37583# VDPWR VDPWR sky130_fd_pr__pfet_01v8_hvt ad=0.1664 pd=1.8 as=0.0864 ps=0.91 w=0.64 l=0.15
X5680 a_61753_36495# a_60563_36495# a_61644_36495# uio_oe[0] sky130_fd_pr__special_nfet_01v8 ad=0.0669 pd=0.75 as=0.0711 ps=0.755 w=0.36 l=0.15
X5681 a_40706_35951# a_40580_36067# a_40302_36083# uio_oe[0] sky130_fd_pr__special_nfet_01v8 ad=0.0999 pd=0.985 as=0.0711 ps=0.755 w=0.36 l=0.15
X5682 a_17050_22464# a_16756_14782# ua[4] uio_oe[0] sky130_fd_pr__nfet_01v8 ad=0.1885 pd=1.88 as=0.1885 ps=1.88 w=0.65 l=0.15
X5683 a_41343_41097# a_37795_40535# uio_oe[0] uio_oe[0] sky130_fd_pr__nfet_01v8 ad=0.08775 pd=0.92 as=0.169 ps=1.82 w=0.65 l=0.15
X5684 a_49920_39037# a_49483_38645# VDPWR VDPWR sky130_fd_pr__pfet_01v8_hvt ad=0.0567 pd=0.69 as=0.0819 ps=0.81 w=0.42 l=0.15
X5685 a_29788_14020# a_4259_22596# a_29610_14020# uio_oe[0] sky130_fd_pr__nfet_01v8 ad=0.2436 pd=2.26 as=0.2436 ps=2.26 w=0.84 l=0.6
X5686 VDPWR a_21585_34571# a_21615_34312# VDPWR sky130_fd_pr__pfet_01v8_hvt ad=0.0693 pd=0.75 as=0.0441 ps=0.63 w=0.42 l=0.15
X5687 VDPWR a_54284_40847# a_54459_40821# VDPWR sky130_fd_pr__pfet_01v8_hvt ad=0.1134 pd=1.38 as=0.0567 ps=0.69 w=0.42 l=0.15
X5688 uio_oe[0] a_50003_37281# a_49964_37155# uio_oe[0] sky130_fd_pr__nfet_01v8 ad=0.0567 pd=0.69 as=0.1092 ps=1.36 w=0.42 l=0.15
X5689 a_45285_40847# a_44095_40847# a_45176_40847# uio_oe[0] sky130_fd_pr__special_nfet_01v8 ad=0.0669 pd=0.75 as=0.0711 ps=0.755 w=0.36 l=0.15
X5690 a_53827_37949# a_53203_37583# a_53719_37583# VDPWR sky130_fd_pr__pfet_01v8_hvt ad=0.1155 pd=0.97 as=0.07245 ps=0.765 w=0.42 l=0.15
X5691 a_50722_37039# a_50003_37281# a_50159_37013# uio_oe[0] sky130_fd_pr__special_nfet_01v8 ad=0.066 pd=0.745 as=0.0594 ps=0.69 w=0.36 l=0.15
X5692 a_49961_36317# a_49483_35925# uio_oe[0] uio_oe[0] sky130_fd_pr__nfet_01v8 ad=0.0669 pd=0.75 as=0.12495 ps=1.015 w=0.42 l=0.15
X5693 VDPWR a_18641_35659# a_18671_35400# VDPWR sky130_fd_pr__pfet_01v8_hvt ad=0.0693 pd=0.75 as=0.0441 ps=0.63 w=0.42 l=0.15
X5694 a_51620_34293# a_54459_34293# uio_oe[0] uio_oe[0] sky130_fd_pr__nfet_01v8 ad=0.169 pd=1.82 as=0.2087 ps=2.02 w=0.65 l=0.15
X5695 a_39544_38359# a_39752_38395# a_39686_38493# uio_oe[0] sky130_fd_pr__nfet_01v8 ad=0.09975 pd=0.895 as=0.0693 ps=0.75 w=0.42 l=0.15
X5696 a_39973_36469# a_37029_37583# VDPWR VDPWR sky130_fd_pr__pfet_01v8_hvt ad=0.1176 pd=1.4 as=0.0693 ps=0.75 w=0.42 l=0.15
X5697 a_44621_39535# a_44327_39447# a_44537_39535# uio_oe[0] sky130_fd_pr__nfet_01v8 ad=0.25025 pd=1.42 as=0.08775 ps=0.92 w=0.65 l=0.15
X5698 a_17050_22464# a_4259_22596# a_16754_20730# uio_oe[0] sky130_fd_pr__nfet_01v8 ad=0.2436 pd=2.26 as=0.2436 ps=2.26 w=0.84 l=0.6
X5699 uio_oe[0] a_54459_39733# a_54393_39759# uio_oe[0] sky130_fd_pr__nfet_01v8 ad=0.12495 pd=1.015 as=0.0669 ps=0.75 w=0.42 l=0.15
X5700 a_47217_41935# a_46027_41935# a_47108_41935# uio_oe[0] sky130_fd_pr__special_nfet_01v8 ad=0.0669 pd=0.75 as=0.0711 ps=0.755 w=0.36 l=0.15
X5701 a_53011_39189# a_52816_39331# a_53321_39581# uio_oe[0] sky130_fd_pr__special_nfet_01v8 ad=0.0594 pd=0.69 as=0.1401 ps=1.1 w=0.36 l=0.15
X5702 a_57757_38671# a_48125_43023# uio_oe[0] uio_oe[0] sky130_fd_pr__nfet_01v8 ad=0.0441 pd=0.63 as=0.1346 ps=1.15 w=0.42 l=0.15
X5703 a_29281_32641# a_29015_33007# uio_oe[0] uio_oe[0] sky130_fd_pr__nfet_01v8 ad=0.169 pd=1.82 as=0.1013 ps=0.99 w=0.65 l=0.15
X5704 a_41225_34319# a_37851_36647# uio_oe[0] uio_oe[0] sky130_fd_pr__nfet_01v8 ad=0.08775 pd=0.92 as=0.08775 ps=0.92 w=0.65 l=0.15
X5705 a_39544_42711# a_39759_42492# a_39686_42518# VDPWR sky130_fd_pr__pfet_01v8_hvt ad=0.1932 pd=1.34 as=0.07665 ps=0.785 w=0.42 l=0.15
X5706 a_42787_40303# a_39947_42997# VDPWR VDPWR sky130_fd_pr__pfet_01v8_hvt ad=0.1092 pd=1.36 as=0.07035 ps=0.755 w=0.42 l=0.15
X5707 VDPWR a_52855_35105# a_52816_34979# VDPWR sky130_fd_pr__pfet_01v8_hvt ad=0.0864 pd=0.91 as=0.1664 ps=1.8 w=0.64 l=0.15
X5708 uio_oe[0] a_57472_37317# a_57556_37013# uio_oe[0] sky130_fd_pr__nfet_01v8 ad=0.0567 pd=0.69 as=0.1092 ps=1.36 w=0.42 l=0.15
X5709 a_40495_42453# rst_n VDPWR VDPWR sky130_fd_pr__pfet_01v8_hvt ad=0.26 pd=2.52 as=0.135 ps=1.27 w=1 l=0.15
X5710 uio_oe[0] a_36327_34837# a_25209_32899# uio_oe[0] sky130_fd_pr__nfet_01v8 ad=0.1013 pd=0.99 as=0.169 ps=1.82 w=0.65 l=0.15
X5711 a_54406_40669# a_36661_41391# uio_oe[0] uio_oe[0] sky130_fd_pr__nfet_01v8 ad=0.0693 pd=0.75 as=0.11285 ps=1.045 w=0.42 l=0.15
X5712 a_50003_39457# a_38649_43023# uio_oe[0] uio_oe[0] sky130_fd_pr__nfet_01v8 ad=0.1092 pd=1.36 as=0.0567 ps=0.69 w=0.42 l=0.15
X5713 a_36425_35078# a_41671_36469# VDPWR VDPWR sky130_fd_pr__pfet_01v8_hvt ad=0.26 pd=2.52 as=0.3012 ps=2.66 w=1 l=0.15
X5714 a_39555_36183# a_39783_35967# a_39729_36289# uio_oe[0] sky130_fd_pr__nfet_01v8 ad=0.1176 pd=1.4 as=0.0567 ps=0.69 w=0.42 l=0.15
X5715 a_61079_34319# a_60729_34319# a_60984_34319# VDPWR sky130_fd_pr__pfet_01v8_hvt ad=0.07245 pd=0.765 as=0.0651 ps=0.73 w=0.42 l=0.15
X5716 uio_oe[0] a_57519_42453# a_57450_42479# uio_oe[0] sky130_fd_pr__nfet_01v8 ad=0.1346 pd=1.15 as=0.0999 ps=0.985 w=0.64 l=0.15
X5717 a_51412_38359# a_51620_38395# a_51554_38493# uio_oe[0] sky130_fd_pr__nfet_01v8 ad=0.09975 pd=0.895 as=0.0693 ps=0.75 w=0.42 l=0.15
X5718 VDPWR a_37361_41391# a_52325_36822# VDPWR sky130_fd_pr__pfet_01v8_hvt ad=0.0693 pd=0.75 as=0.1176 ps=1.4 w=0.42 l=0.15
X5719 a_40670_39347# a_40948_39331# a_40904_39215# VDPWR sky130_fd_pr__pfet_01v8_hvt ad=0.0588 pd=0.7 as=0.0567 ps=0.69 w=0.42 l=0.15
X5720 uio_oe[0] a_58144_35656# a_58082_35773# uio_oe[0] sky130_fd_pr__nfet_01v8 ad=0.2205 pd=1.89 as=0.066 ps=0.745 w=0.42 l=0.15
X5721 a_39686_41430# a_38005_40847# VDPWR VDPWR sky130_fd_pr__pfet_01v8_hvt ad=0.07665 pd=0.785 as=0.15835 ps=1.395 w=0.42 l=0.15
X5722 uio_oe[0] a_61242_39445# a_61192_39215# uio_oe[0] sky130_fd_pr__nfet_01v8 ad=0.1664 pd=1.8 as=0.0935 ps=0.965 w=0.64 l=0.15
X5723 ua[4] a_29740_18782# a_29610_18020# uio_oe[0] sky130_fd_pr__nfet_01v8 ad=0.1885 pd=1.88 as=0.1885 ps=1.88 w=0.65 l=0.15
X5724 VDPWR a_37913_41935# a_53203_34319# VDPWR sky130_fd_pr__pfet_01v8_hvt ad=0.0864 pd=0.91 as=0.1664 ps=1.8 w=0.64 l=0.15
X5725 a_41567_42262# a_41316_41909# a_41108_42087# VDPWR sky130_fd_pr__pfet_01v8_hvt ad=0.0441 pd=0.63 as=0.1932 ps=1.34 w=0.42 l=0.15
X5726 a_60681_40669# a_60302_40303# a_60609_40669# uio_oe[0] sky130_fd_pr__nfet_01v8 ad=0.1401 pd=1.1 as=0.0441 ps=0.63 w=0.42 l=0.15
X5727 uio_oe[0] a_61624_38359# a_60996_38101# uio_oe[0] sky130_fd_pr__nfet_01v8 ad=0.11285 pd=1.045 as=0.169 ps=1.82 w=0.65 l=0.15
X5728 a_58082_36861# a_57324_36763# a_57519_36732# VDPWR sky130_fd_pr__pfet_01v8_hvt ad=0.0651 pd=0.73 as=0.07245 ps=0.765 w=0.42 l=0.15
X5729 a_21114_34817# a_21068_34969# uio_oe[0] uio_oe[0] sky130_fd_pr__nfet_01v8 ad=0.0693 pd=0.75 as=0.11285 ps=1.045 w=0.42 l=0.15
X5730 VDPWR a_53937_35649# a_53827_35773# VDPWR sky130_fd_pr__pfet_01v8_hvt ad=0.07035 pd=0.755 as=0.1155 ps=0.97 w=0.42 l=0.15
X5731 a_36999_37013# clk VDPWR VDPWR sky130_fd_pr__pfet_01v8_hvt ad=0.26 pd=2.52 as=0.135 ps=1.27 w=1 l=0.15
X5732 a_26369_36747# a_25116_36681# uio_oe[0] uio_oe[0] sky130_fd_pr__nfet_01v8 ad=0.1092 pd=1.36 as=0.1449 ps=1.11 w=0.42 l=0.15
X5733 a_37639_36495# a_37387_36745# uio_oe[0] uio_oe[0] sky130_fd_pr__nfet_01v8 ad=0.1755 pd=1.84 as=0.10187 ps=0.99 w=0.65 l=0.15
X5734 a_17537_35879# a_17204_36057# VDPWR VDPWR sky130_fd_pr__pfet_01v8_hvt ad=0.1176 pd=1.4 as=0.0693 ps=0.75 w=0.42 l=0.15
X5735 a_18442_14464# a_16756_10376# ua[4] uio_oe[0] sky130_fd_pr__nfet_01v8 ad=0.1885 pd=1.88 as=0.1885 ps=1.88 w=0.65 l=0.15
X5736 a_42584_42845# a_42467_42650# VDPWR VDPWR sky130_fd_pr__pfet_01v8_hvt ad=0.0651 pd=0.73 as=0.1092 ps=1.36 w=0.42 l=0.15
X5737 a_41706_38127# a_40987_38369# a_41143_38101# uio_oe[0] sky130_fd_pr__special_nfet_01v8 ad=0.066 pd=0.745 as=0.0594 ps=0.69 w=0.36 l=0.15
X5738 VDPWR a_28884_36681# a_28835_36449# VDPWR sky130_fd_pr__pfet_01v8_hvt ad=0.15835 pd=1.395 as=0.26 ps=2.52 w=1 l=0.15
X5739 a_51412_42711# a_38740_42747# a_51554_42518# VDPWR sky130_fd_pr__pfet_01v8_hvt ad=0.1932 pd=1.34 as=0.07665 ps=0.785 w=0.42 l=0.15
X5740 uio_oe[0] a_57363_37725# a_57324_37851# uio_oe[0] sky130_fd_pr__nfet_01v8 ad=0.0567 pd=0.69 as=0.1092 ps=1.36 w=0.42 l=0.15
X5741 a_24484_10376# a_25739_37021# uio_oe[0] uio_oe[0] sky130_fd_pr__nfet_01v8 ad=0.182 pd=1.86 as=0.1118 ps=1.04 w=0.65 l=0.15
X5742 a_59006_37078# a_48677_38127# VDPWR VDPWR sky130_fd_pr__pfet_01v8_hvt ad=0.07665 pd=0.785 as=0.15835 ps=1.395 w=0.42 l=0.15
X5743 a_57664_35951# a_57450_35951# VDPWR VDPWR sky130_fd_pr__pfet_01v8_hvt ad=0.1155 pd=0.97 as=0.07035 ps=0.755 w=0.42 l=0.15
X5744 VDPWR a_25265_34791# a_25295_35144# VDPWR sky130_fd_pr__pfet_01v8_hvt ad=0.0693 pd=0.75 as=0.0441 ps=0.63 w=0.42 l=0.15
X5745 a_61079_41935# a_60563_41935# a_60984_41935# uio_oe[0] sky130_fd_pr__special_nfet_01v8 ad=0.0594 pd=0.69 as=0.066 ps=0.745 w=0.36 l=0.15
X5746 a_38991_41430# a_38740_41659# a_38532_41623# VDPWR sky130_fd_pr__pfet_01v8_hvt ad=0.0441 pd=0.63 as=0.1932 ps=1.34 w=0.42 l=0.15
X5747 a_38961_40601# a_38005_40847# VDPWR VDPWR sky130_fd_pr__pfet_01v8_hvt ad=0.1176 pd=1.4 as=0.0693 ps=0.75 w=0.42 l=0.15
X5748 a_46805_40847# a_46761_41089# a_46639_40847# uio_oe[0] sky130_fd_pr__nfet_01v8 ad=0.0441 pd=0.63 as=0.1401 ps=1.1 w=0.42 l=0.15
X5749 a_25876_18376# a_26439_34095# uio_oe[0] uio_oe[0] sky130_fd_pr__nfet_01v8 ad=0.169 pd=1.82 as=0.1013 ps=0.99 w=0.65 l=0.15
X5750 a_43161_34863# a_42895_34863# uio_oe[0] uio_oe[0] sky130_fd_pr__nfet_01v8 ad=0.169 pd=1.82 as=0.1013 ps=0.99 w=0.65 l=0.15
X5751 a_42857_36822# a_42685_36611# a_42643_36822# VDPWR sky130_fd_pr__pfet_01v8_hvt ad=0.07665 pd=0.785 as=0.1932 ps=1.34 w=0.42 l=0.15
X5752 a_28348_14376# a_29603_35933# uio_oe[0] uio_oe[0] sky130_fd_pr__nfet_01v8 ad=0.182 pd=1.86 as=0.1118 ps=1.04 w=0.65 l=0.15
X5753 a_18442_14464# ua[3] a_18196_14020# uio_oe[0] sky130_fd_pr__nfet_01v8 ad=0.2436 pd=2.26 as=0.2436 ps=2.26 w=0.84 l=0.6
X5754 ua[4] a_16756_10782# a_18018_10020# uio_oe[0] sky130_fd_pr__nfet_01v8 ad=0.1885 pd=1.88 as=0.1885 ps=1.88 w=0.65 l=0.15
X5755 a_51554_41430# a_48677_39759# VDPWR VDPWR sky130_fd_pr__pfet_01v8_hvt ad=0.07665 pd=0.785 as=0.15835 ps=1.395 w=0.42 l=0.15
X5756 a_61192_41391# a_60500_41365# a_60584_41705# VDPWR sky130_fd_pr__pfet_01v8_hvt ad=0.12495 pd=1.175 as=0.0567 ps=0.69 w=0.42 l=0.15
X5757 uio_oe[0] a_37029_42479# a_42163_40847# uio_oe[0] sky130_fd_pr__nfet_01v8 ad=0.0567 pd=0.69 as=0.1092 ps=1.36 w=0.42 l=0.15
X5758 a_41570_38885# a_41420_39037# uio_oe[0] uio_oe[0] sky130_fd_pr__nfet_01v8 ad=0.1404 pd=1.6 as=0.1137 ps=1.01 w=0.54 l=0.15
X5759 a_58914_38493# a_48677_38127# uio_oe[0] uio_oe[0] sky130_fd_pr__nfet_01v8 ad=0.0693 pd=0.75 as=0.11285 ps=1.045 w=0.42 l=0.15
X5760 VDPWR a_54284_34319# a_54459_34293# VDPWR sky130_fd_pr__pfet_01v8_hvt ad=0.1134 pd=1.38 as=0.0567 ps=0.69 w=0.42 l=0.15
X5761 a_60153_35734# a_51620_35381# a_59939_35734# VDPWR sky130_fd_pr__pfet_01v8_hvt ad=0.07665 pd=0.785 as=0.1932 ps=1.34 w=0.42 l=0.15
X5762 a_36447_40849# a_43419_42783# uio_oe[0] uio_oe[0] sky130_fd_pr__nfet_01v8 ad=0.169 pd=1.82 as=0.2087 ps=2.02 w=0.65 l=0.15
X5763 a_53624_40847# a_53005_40847# VDPWR VDPWR sky130_fd_pr__pfet_01v8_hvt ad=0.0651 pd=0.73 as=0.1092 ps=1.36 w=0.42 l=0.15
X5764 VDPWR a_37003_39996# a_36934_40125# VDPWR sky130_fd_pr__pfet_01v8_hvt ad=0.2184 pd=2.2 as=0.12915 ps=1.185 w=0.84 l=0.15
X5765 uio_oe[0] a_37913_41935# a_60563_37583# uio_oe[0] sky130_fd_pr__nfet_01v8 ad=0.0567 pd=0.69 as=0.1092 ps=1.36 w=0.42 l=0.15
X5766 uio_oe[0] a_39947_42997# a_44873_40669# uio_oe[0] sky130_fd_pr__nfet_01v8 ad=0.1346 pd=1.15 as=0.0441 ps=0.63 w=0.42 l=0.15
X5767 a_61175_39759# a_60729_39759# a_61079_39759# uio_oe[0] sky130_fd_pr__special_nfet_01v8 ad=0.1401 pd=1.1 as=0.0594 ps=0.69 w=0.36 l=0.15
X5768 a_37859_38998# a_37433_35665# a_37859_38671# uio_oe[0] sky130_fd_pr__nfet_01v8 ad=0.09975 pd=0.895 as=0.0693 ps=0.75 w=0.42 l=0.15
X5769 uio_oe[0] a_18427_33198# a_36545_37583# uio_oe[0] sky130_fd_pr__nfet_01v8 ad=0.1013 pd=0.99 as=0.0504 ps=0.66 w=0.42 l=0.15
X5770 a_52813_37405# a_52335_37013# uio_oe[0] uio_oe[0] sky130_fd_pr__nfet_01v8 ad=0.0669 pd=0.75 as=0.12495 ps=1.015 w=0.42 l=0.15
X5771 VDPWR a_59956_37013# a_60092_37039# VDPWR sky130_fd_pr__pfet_01v8_hvt ad=0.12285 pd=1.17 as=0.2184 ps=2.2 w=0.84 l=0.15
X5772 a_60371_35925# a_60215_36193# a_60516_35951# VDPWR sky130_fd_pr__pfet_01v8_hvt ad=0.07245 pd=0.765 as=0.1155 ps=0.97 w=0.42 l=0.15
X5773 VDPWR a_38005_41391# a_44095_43023# VDPWR sky130_fd_pr__pfet_01v8_hvt ad=0.0864 pd=0.91 as=0.1664 ps=1.8 w=0.64 l=0.15
X5774 a_46193_43023# a_46027_43023# uio_oe[0] uio_oe[0] sky130_fd_pr__nfet_01v8 ad=0.1092 pd=1.36 as=0.0567 ps=0.69 w=0.42 l=0.15
X5775 VDPWR a_38532_36647# a_25116_33417# VDPWR sky130_fd_pr__pfet_01v8_hvt ad=0.15835 pd=1.395 as=0.26 ps=2.52 w=1 l=0.15
X5776 a_18442_26464# a_16756_10376# ua[5] uio_oe[0] sky130_fd_pr__nfet_01v8 ad=0.1885 pd=1.88 as=0.1885 ps=1.88 w=0.65 l=0.15
X5777 a_60638_34863# a_60416_35141# a_59956_34837# VDPWR sky130_fd_pr__pfet_01v8_hvt ad=0.0483 pd=0.65 as=0.0819 ps=0.81 w=0.42 l=0.15
X5778 a_40597_42185# a_37851_36647# VDPWR VDPWR sky130_fd_pr__pfet_01v8_hvt ad=0.0441 pd=0.63 as=0.14825 ps=1.34 w=0.42 l=0.15
X5779 uio_oe[0] a_37029_42479# a_44095_41935# uio_oe[0] sky130_fd_pr__nfet_01v8 ad=0.0567 pd=0.69 as=0.1092 ps=1.36 w=0.42 l=0.15
X5780 uio_oe[0] a_40379_35551# a_41285_37583# uio_oe[0] sky130_fd_pr__nfet_01v8 ad=0.1346 pd=1.15 as=0.0441 ps=0.63 w=0.42 l=0.15
X5781 uio_oe[0] a_42445_36469# a_42864_36495# uio_oe[0] sky130_fd_pr__nfet_01v8 ad=0.11285 pd=1.045 as=0.0693 ps=0.75 w=0.42 l=0.15
X5782 a_53827_36861# a_53203_36495# a_53719_36495# VDPWR sky130_fd_pr__pfet_01v8_hvt ad=0.1155 pd=0.97 as=0.07245 ps=0.765 w=0.42 l=0.15
X5783 a_38019_35951# a_37839_35951# VDPWR VDPWR sky130_fd_pr__pfet_01v8_hvt ad=0.0609 pd=0.71 as=0.0714 ps=0.76 w=0.42 l=0.15
X5784 a_57012_39189# a_57556_39189# a_57514_39215# VDPWR sky130_fd_pr__pfet_01v8_hvt ad=0.0819 pd=0.81 as=0.0441 ps=0.63 w=0.42 l=0.15
X5785 a_41023_37583# a_40507_37583# a_40928_37583# uio_oe[0] sky130_fd_pr__special_nfet_01v8 ad=0.0594 pd=0.69 as=0.066 ps=0.745 w=0.36 l=0.15
X5786 a_39907_41757# a_38285_37039# a_39544_41623# uio_oe[0] sky130_fd_pr__nfet_01v8 ad=0.0693 pd=0.75 as=0.09975 ps=0.895 w=0.42 l=0.15
X5787 uio_oe[0] a_39947_42997# a_46805_41757# uio_oe[0] sky130_fd_pr__nfet_01v8 ad=0.1346 pd=1.15 as=0.0441 ps=0.63 w=0.42 l=0.15
X5788 VDPWR a_58144_40277# a_58082_40303# VDPWR sky130_fd_pr__pfet_01v8_hvt ad=0.1092 pd=1.36 as=0.0651 ps=0.73 w=0.42 l=0.15
X5789 a_49686_40011# a_49964_40027# a_49920_40125# VDPWR sky130_fd_pr__pfet_01v8_hvt ad=0.0588 pd=0.7 as=0.0567 ps=0.69 w=0.42 l=0.15
X5790 a_57430_37405# a_57148_37039# a_57354_37405# uio_oe[0] sky130_fd_pr__nfet_01v8 ad=0.0441 pd=0.63 as=0.0483 ps=0.65 w=0.42 l=0.15
X5791 a_22306_10464# a_20620_10376# ua[4] uio_oe[0] sky130_fd_pr__nfet_01v8 ad=0.1885 pd=1.88 as=0.1885 ps=1.88 w=0.65 l=0.15
X5792 a_42045_34319# a_41751_34471# a_41961_34319# uio_oe[0] sky130_fd_pr__nfet_01v8 ad=0.25025 pd=1.42 as=0.08775 ps=0.92 w=0.65 l=0.15
X5793 uio_oe[0] a_54459_38645# a_54393_38671# uio_oe[0] sky130_fd_pr__nfet_01v8 ad=0.12495 pd=1.015 as=0.0669 ps=0.75 w=0.42 l=0.15
X5794 a_52538_37171# a_52816_37155# a_52772_37039# VDPWR sky130_fd_pr__pfet_01v8_hvt ad=0.0588 pd=0.7 as=0.0567 ps=0.69 w=0.42 l=0.15
X5795 a_39686_40847# a_38005_40847# uio_oe[0] uio_oe[0] sky130_fd_pr__nfet_01v8 ad=0.0693 pd=0.75 as=0.11285 ps=1.045 w=0.42 l=0.15
X5796 uio_oe[0] a_38077_34577# a_38109_34319# uio_oe[0] sky130_fd_pr__nfet_01v8 ad=0.1013 pd=0.99 as=0.0504 ps=0.66 w=0.42 l=0.15
X5797 a_52579_40847# a_52325_41174# uio_oe[0] uio_oe[0] sky130_fd_pr__nfet_01v8 ad=0.0693 pd=0.75 as=0.1449 ps=1.11 w=0.42 l=0.15
X5798 uio_oe[0] a_36425_35078# a_36835_38921# uio_oe[0] sky130_fd_pr__nfet_01v8 ad=0.08775 pd=0.92 as=0.08775 ps=0.92 w=0.65 l=0.15
X5799 uio_oe[0] a_40379_35551# a_43217_38671# uio_oe[0] sky130_fd_pr__nfet_01v8 ad=0.1346 pd=1.15 as=0.0441 ps=0.63 w=0.42 l=0.15
X5800 a_58044_39215# a_57776_39581# VDPWR VDPWR sky130_fd_pr__pfet_01v8_hvt ad=0.0945 pd=0.87 as=0.0798 ps=0.8 w=0.42 l=0.15
X5801 a_42877_38493# a_42399_38101# uio_oe[0] uio_oe[0] sky130_fd_pr__nfet_01v8 ad=0.0669 pd=0.75 as=0.12495 ps=1.015 w=0.42 l=0.15
X5802 VDPWR a_59201_34293# a_59231_34646# VDPWR sky130_fd_pr__pfet_01v8_hvt ad=0.0693 pd=0.75 as=0.0441 ps=0.63 w=0.42 l=0.15
X5803 a_39544_41623# a_38285_37039# a_39686_41430# VDPWR sky130_fd_pr__pfet_01v8_hvt ad=0.1932 pd=1.34 as=0.07665 ps=0.785 w=0.42 l=0.15
X5804 a_42679_40847# a_42329_40847# a_42584_40847# VDPWR sky130_fd_pr__pfet_01v8_hvt ad=0.07245 pd=0.765 as=0.0651 ps=0.73 w=0.42 l=0.15
X5805 a_53574_35951# a_52855_36193# a_53011_35925# uio_oe[0] sky130_fd_pr__special_nfet_01v8 ad=0.066 pd=0.745 as=0.0594 ps=0.69 w=0.36 l=0.15
X5806 a_22306_10464# ua[2] a_22060_10020# uio_oe[0] sky130_fd_pr__nfet_01v8 ad=0.2436 pd=2.26 as=0.2436 ps=2.26 w=0.84 l=0.6
X5807 ua[5] a_16756_10782# a_18018_22020# uio_oe[0] sky130_fd_pr__nfet_01v8 ad=0.1885 pd=1.88 as=0.1885 ps=1.88 w=0.65 l=0.15
X5808 VDPWR a_51841_34293# a_51871_34646# VDPWR sky130_fd_pr__pfet_01v8_hvt ad=0.0693 pd=0.75 as=0.0441 ps=0.63 w=0.42 l=0.15
X5809 VDPWR a_41149_36737# a_41039_36861# VDPWR sky130_fd_pr__pfet_01v8_hvt ad=0.07035 pd=0.755 as=0.1155 ps=0.97 w=0.42 l=0.15
X5810 uio_oe[0] a_38961_40821# a_38895_40847# uio_oe[0] sky130_fd_pr__nfet_01v8 ad=0.1449 pd=1.11 as=0.0693 ps=0.75 w=0.42 l=0.15
X5811 a_52942_38127# a_52816_38243# a_52538_38259# uio_oe[0] sky130_fd_pr__special_nfet_01v8 ad=0.0999 pd=0.985 as=0.0711 ps=0.755 w=0.36 l=0.15
X5812 uio_oe[0] a_16812_8642# a_20618_16730# uio_oe[0] sky130_fd_pr__nfet_01v8 ad=1.4703 pd=10.72 as=1.4703 ps=10.72 w=5.07 l=1
X5813 VDPWR a_45176_43023# a_45351_42997# VDPWR sky130_fd_pr__pfet_01v8_hvt ad=0.1134 pd=1.38 as=0.0567 ps=0.69 w=0.42 l=0.15
X5814 VDPWR a_61624_42711# a_60996_42453# VDPWR sky130_fd_pr__pfet_01v8_hvt ad=0.15835 pd=1.395 as=0.26 ps=2.52 w=1 l=0.15
X5815 uio_oe[0] a_41143_39996# a_41074_40125# uio_oe[0] sky130_fd_pr__nfet_01v8 ad=0.1346 pd=1.15 as=0.0999 ps=0.985 w=0.64 l=0.15
X5816 uio_oe[0] a_46193_39759# a_52573_37405# uio_oe[0] sky130_fd_pr__nfet_01v8 ad=0.12495 pd=1.015 as=0.06405 ps=0.725 w=0.42 l=0.15
X5817 a_25479_35400# a_17500_33453# a_25020_35593# VDPWR sky130_fd_pr__pfet_01v8_hvt ad=0.0441 pd=0.63 as=0.1932 ps=1.34 w=0.42 l=0.15
X5818 a_51775_41757# a_38740_41659# a_51412_41623# uio_oe[0] sky130_fd_pr__nfet_01v8 ad=0.0693 pd=0.75 as=0.09975 ps=0.895 w=0.42 l=0.15
X5819 uio_oe[0] a_52335_42453# a_51620_42747# uio_oe[0] sky130_fd_pr__nfet_01v8 ad=0.2087 pd=2.02 as=0.169 ps=1.82 w=0.65 l=0.15
X5820 a_59293_39513# a_48677_39759# uio_oe[0] uio_oe[0] sky130_fd_pr__nfet_01v8 ad=0.1092 pd=1.36 as=0.1449 ps=1.11 w=0.42 l=0.15
X5821 VDPWR a_58772_36183# a_58144_35925# VDPWR sky130_fd_pr__pfet_01v8_hvt ad=0.15835 pd=1.395 as=0.26 ps=2.52 w=1 l=0.15
X5822 a_39861_43265# a_39643_43023# VDPWR VDPWR sky130_fd_pr__pfet_01v8_hvt ad=0.12915 pd=1.185 as=0.2184 ps=2.2 w=0.84 l=0.15
X5823 a_51554_40847# a_48677_39759# uio_oe[0] uio_oe[0] sky130_fd_pr__nfet_01v8 ad=0.0693 pd=0.75 as=0.11285 ps=1.045 w=0.42 l=0.15
X5824 a_59135_36495# a_38740_36469# a_58772_36647# uio_oe[0] sky130_fd_pr__nfet_01v8 ad=0.0693 pd=0.75 as=0.09975 ps=0.895 w=0.42 l=0.15
X5825 a_50722_38127# a_49964_38243# a_50159_38101# VDPWR sky130_fd_pr__pfet_01v8_hvt ad=0.0651 pd=0.73 as=0.07245 ps=0.765 w=0.42 l=0.15
X5826 a_22306_22464# a_20620_10376# ua[5] uio_oe[0] sky130_fd_pr__nfet_01v8 ad=0.1885 pd=1.88 as=0.1885 ps=1.88 w=0.65 l=0.15
X5827 VDPWR a_39549_34837# a_28796_34969# VDPWR sky130_fd_pr__pfet_01v8_hvt ad=0.14825 pd=1.34 as=0.27 ps=2.54 w=1 l=0.15
X5828 a_42584_41757# a_42467_41562# VDPWR VDPWR sky130_fd_pr__pfet_01v8_hvt ad=0.0651 pd=0.73 as=0.1092 ps=1.36 w=0.42 l=0.15
X5829 VDPWR a_28884_35593# a_28835_35361# VDPWR sky130_fd_pr__pfet_01v8_hvt ad=0.15835 pd=1.395 as=0.26 ps=2.52 w=1 l=0.15
X5830 a_51412_41623# a_38740_41659# a_51554_41430# VDPWR sky130_fd_pr__pfet_01v8_hvt ad=0.1932 pd=1.34 as=0.07665 ps=0.785 w=0.42 l=0.15
X5831 VDPWR a_36327_39733# a_17500_33453# VDPWR sky130_fd_pr__pfet_01v8_hvt ad=0.3012 pd=2.66 as=0.26 ps=2.52 w=1 l=0.15
X5832 a_53937_37825# a_53719_37583# VDPWR VDPWR sky130_fd_pr__pfet_01v8_hvt ad=0.12915 pd=1.185 as=0.2184 ps=2.2 w=0.84 l=0.15
X5833 uio_oe[0] a_29281_32641# a_30393_35905# uio_oe[0] sky130_fd_pr__nfet_01v8 ad=0.1013 pd=0.99 as=0.0504 ps=0.66 w=0.42 l=0.15
X5834 a_19834_18464# a_16756_18376# ua[5] uio_oe[0] sky130_fd_pr__nfet_01v8 ad=0.1885 pd=1.88 as=0.1885 ps=1.88 w=0.65 l=0.15
X5835 a_38109_34319# a_37839_34685# a_38019_34685# uio_oe[0] sky130_fd_pr__nfet_01v8 ad=0.0504 pd=0.66 as=0.1092 ps=1.36 w=0.42 l=0.15
X5836 VDPWR a_37361_41391# a_60153_35734# VDPWR sky130_fd_pr__pfet_01v8_hvt ad=0.15835 pd=1.395 as=0.07665 ps=0.785 w=0.42 l=0.15
X5837 a_61950_41757# a_36661_41391# uio_oe[0] uio_oe[0] sky130_fd_pr__nfet_01v8 ad=0.0693 pd=0.75 as=0.11285 ps=1.045 w=0.42 l=0.15
X5838 a_52507_41174# a_52325_41174# VDPWR VDPWR sky130_fd_pr__pfet_01v8_hvt ad=0.0441 pd=0.63 as=0.0693 ps=0.75 w=0.42 l=0.15
X5839 a_46448_40669# a_46331_40474# VDPWR VDPWR sky130_fd_pr__pfet_01v8_hvt ad=0.0651 pd=0.73 as=0.1092 ps=1.36 w=0.42 l=0.15
X5840 a_57046_42187# a_57363_42077# a_57321_41935# uio_oe[0] sky130_fd_pr__special_nfet_01v8 ad=0.0711 pd=0.755 as=0.0669 ps=0.75 w=0.36 l=0.15
X5841 VDPWR a_59695_40277# a_54479_40316# VDPWR sky130_fd_pr__pfet_01v8_hvt ad=0.3012 pd=2.66 as=0.26 ps=2.52 w=1 l=0.15
X5842 a_53624_34319# a_53005_34319# VDPWR VDPWR sky130_fd_pr__pfet_01v8_hvt ad=0.0651 pd=0.73 as=0.1092 ps=1.36 w=0.42 l=0.15
X5843 a_57363_35549# a_41685_42479# VDPWR VDPWR sky130_fd_pr__pfet_01v8_hvt ad=0.1664 pd=1.8 as=0.0864 ps=0.91 w=0.64 l=0.15
X5844 a_50469_36495# a_50090_36861# a_50397_36495# uio_oe[0] sky130_fd_pr__nfet_01v8 ad=0.1401 pd=1.1 as=0.0441 ps=0.63 w=0.42 l=0.15
X5845 a_50003_39901# a_38649_43023# uio_oe[0] uio_oe[0] sky130_fd_pr__nfet_01v8 ad=0.1092 pd=1.36 as=0.0567 ps=0.69 w=0.42 l=0.15
X5846 a_16756_10376# a_18011_37021# VDPWR VDPWR sky130_fd_pr__pfet_01v8_hvt ad=0.475 pd=2.95 as=0.16655 ps=1.39 w=1 l=0.15
X5847 VDPWR a_37029_42479# a_42163_40847# VDPWR sky130_fd_pr__pfet_01v8_hvt ad=0.0864 pd=0.91 as=0.1664 ps=1.8 w=0.64 l=0.15
X5848 VDPWR a_49483_39189# a_38740_39483# VDPWR sky130_fd_pr__pfet_01v8_hvt ad=0.3012 pd=2.66 as=0.26 ps=2.52 w=1 l=0.15
X5849 VDPWR a_36355_38101# a_36385_38127# VDPWR sky130_fd_pr__pfet_01v8_hvt ad=0.135 pd=1.27 as=0.135 ps=1.27 w=1 l=0.15
X5850 uio_oe[0] a_48125_41935# a_59933_42845# uio_oe[0] sky130_fd_pr__nfet_01v8 ad=0.12495 pd=1.015 as=0.06405 ps=0.725 w=0.42 l=0.15
X5851 a_40606_40847# a_37661_37052# uio_oe[0] uio_oe[0] sky130_fd_pr__nfet_01v8 ad=0.0693 pd=0.75 as=0.11285 ps=1.045 w=0.42 l=0.15
X5852 VDPWR a_42347_38127# a_45195_39215# VDPWR sky130_fd_pr__pfet_01v8_hvt ad=0.2279 pd=1.74 as=0.0609 ps=0.71 w=0.42 l=0.15
X5853 a_57450_35951# a_57363_36193# a_57046_36083# VDPWR sky130_fd_pr__pfet_01v8_hvt ad=0.12915 pd=1.185 as=0.0588 ps=0.7 w=0.42 l=0.15
X5854 a_57363_36193# a_41685_42479# uio_oe[0] uio_oe[0] sky130_fd_pr__nfet_01v8 ad=0.1092 pd=1.36 as=0.0567 ps=0.69 w=0.42 l=0.15
X5855 ua[5] a_16756_14376# a_19410_14020# uio_oe[0] sky130_fd_pr__nfet_01v8 ad=0.1885 pd=1.88 as=0.1885 ps=1.88 w=0.65 l=0.15
X5856 uio_oe[0] a_37361_41391# a_60160_35407# uio_oe[0] sky130_fd_pr__nfet_01v8 ad=0.11285 pd=1.045 as=0.0693 ps=0.75 w=0.42 l=0.15
X5857 VDPWR a_53011_39189# a_52942_39215# VDPWR sky130_fd_pr__pfet_01v8_hvt ad=0.2184 pd=2.2 as=0.12915 ps=1.185 w=0.84 l=0.15
X5858 a_61175_38671# a_60729_38671# a_61079_38671# uio_oe[0] sky130_fd_pr__special_nfet_01v8 ad=0.1401 pd=1.1 as=0.0594 ps=0.69 w=0.36 l=0.15
X5859 VDPWR a_41316_41909# a_42069_34863# VDPWR sky130_fd_pr__pfet_01v8_hvt ad=0.135 pd=1.27 as=0.135 ps=1.27 w=1 l=0.15
X5860 a_49721_41935# a_49686_42187# a_49483_41909# uio_oe[0] sky130_fd_pr__nfet_01v8 ad=0.06405 pd=0.725 as=0.1092 ps=1.36 w=0.42 l=0.15
X5861 a_44719_41213# a_39947_42997# VDPWR VDPWR sky130_fd_pr__pfet_01v8_hvt ad=0.1092 pd=1.36 as=0.07035 ps=0.755 w=0.42 l=0.15
X5862 a_20618_20730# ua[2] a_20490_22020# uio_oe[0] sky130_fd_pr__nfet_01v8 ad=0.2436 pd=2.26 as=0.2436 ps=2.26 w=0.84 l=0.6
X5863 a_45530_43023# a_40379_35551# uio_oe[0] uio_oe[0] sky130_fd_pr__nfet_01v8 ad=0.06405 pd=0.725 as=0.12495 ps=1.015 w=0.42 l=0.15
X5864 VDPWR a_37029_42479# a_44095_41935# VDPWR sky130_fd_pr__pfet_01v8_hvt ad=0.0864 pd=0.91 as=0.1664 ps=1.8 w=0.64 l=0.15
X5865 a_59956_41365# a_48125_41935# VDPWR VDPWR sky130_fd_pr__pfet_01v8_hvt ad=0.1092 pd=1.36 as=0.12285 ps=1.17 w=0.42 l=0.15
X5866 a_26259_37359# a_24787_36993# uio_oe[0] uio_oe[0] sky130_fd_pr__nfet_01v8 ad=0.1092 pd=1.36 as=0.1092 ps=1.36 w=0.42 l=0.15
X5867 VDPWR a_30233_33483# a_30263_33224# VDPWR sky130_fd_pr__pfet_01v8_hvt ad=0.0693 pd=0.75 as=0.0441 ps=0.63 w=0.42 l=0.15
X5868 a_44327_38359# a_47283_40607# uio_oe[0] uio_oe[0] sky130_fd_pr__nfet_01v8 ad=0.169 pd=1.82 as=0.2087 ps=2.02 w=0.65 l=0.15
X5869 a_58914_38998# a_48677_39759# VDPWR VDPWR sky130_fd_pr__pfet_01v8_hvt ad=0.07665 pd=0.785 as=0.15835 ps=1.395 w=0.42 l=0.15
X5870 a_43867_37910# a_42445_36469# a_43408_37735# VDPWR sky130_fd_pr__pfet_01v8_hvt ad=0.0441 pd=0.63 as=0.1932 ps=1.34 w=0.42 l=0.15
X5871 a_60729_35407# a_60563_35407# VDPWR VDPWR sky130_fd_pr__pfet_01v8_hvt ad=0.1664 pd=1.8 as=0.0864 ps=0.91 w=0.64 l=0.15
X5872 a_54406_40342# a_36661_41391# VDPWR VDPWR sky130_fd_pr__pfet_01v8_hvt ad=0.07665 pd=0.785 as=0.15835 ps=1.395 w=0.42 l=0.15
X5873 a_29159_36232# a_28908_35879# a_28700_36057# VDPWR sky130_fd_pr__pfet_01v8_hvt ad=0.0441 pd=0.63 as=0.1932 ps=1.34 w=0.42 l=0.15
X5874 a_30393_35905# a_30123_36271# a_30303_36271# uio_oe[0] sky130_fd_pr__nfet_01v8 ad=0.0504 pd=0.66 as=0.1092 ps=1.36 w=0.42 l=0.15
X5875 a_28642_14464# a_28348_14376# ua[4] uio_oe[0] sky130_fd_pr__nfet_01v8 ad=0.1885 pd=1.88 as=0.1885 ps=1.88 w=0.65 l=0.15
X5876 a_44611_42857# a_44261_42485# a_44516_42845# VDPWR sky130_fd_pr__pfet_01v8_hvt ad=0.07245 pd=0.765 as=0.0651 ps=0.73 w=0.42 l=0.15
X5877 a_44621_38447# a_44287_38127# a_44537_38127# VDPWR sky130_fd_pr__pfet_01v8_hvt ad=0.3 pd=2.6 as=0.26 ps=2.52 w=1 l=0.15
X5878 a_60458_37039# a_60092_37039# VDPWR VDPWR sky130_fd_pr__pfet_01v8_hvt ad=0.0441 pd=0.63 as=0.1092 ps=1.36 w=0.42 l=0.15
X5879 a_37579_34319# a_37328_34569# VDPWR VDPWR sky130_fd_pr__pfet_01v8_hvt ad=0.34 pd=2.68 as=0.14575 ps=1.335 w=1 l=0.15
X5880 a_46651_42301# a_39947_42997# VDPWR VDPWR sky130_fd_pr__pfet_01v8_hvt ad=0.1092 pd=1.36 as=0.07035 ps=0.755 w=0.42 l=0.15
X5881 a_23698_14464# a_20620_14782# ua[5] uio_oe[0] sky130_fd_pr__nfet_01v8 ad=0.1885 pd=1.88 as=0.1885 ps=1.88 w=0.65 l=0.15
X5882 a_43081_40001# a_42863_39759# uio_oe[0] uio_oe[0] sky130_fd_pr__nfet_01v8 ad=0.0999 pd=0.985 as=0.1346 ps=1.15 w=0.64 l=0.15
X5883 a_36999_37557# a_37335_37557# uio_oe[0] uio_oe[0] sky130_fd_pr__nfet_01v8 ad=0.169 pd=1.82 as=0.08775 ps=0.92 w=0.65 l=0.15
X5884 a_37859_37078# a_37452_34953# a_37787_37078# VDPWR sky130_fd_pr__pfet_01v8_hvt ad=0.1932 pd=1.34 as=0.0441 ps=0.63 w=0.42 l=0.15
X5885 a_28642_14464# ua[0] a_28396_14020# uio_oe[0] sky130_fd_pr__nfet_01v8 ad=0.2436 pd=2.26 as=0.2436 ps=2.26 w=0.84 l=0.6
X5886 a_53574_34863# a_52855_35105# a_53011_34837# uio_oe[0] sky130_fd_pr__special_nfet_01v8 ad=0.066 pd=0.745 as=0.0594 ps=0.69 w=0.36 l=0.15
X5887 a_42584_41757# a_42467_41562# uio_oe[0] uio_oe[0] sky130_fd_pr__nfet_01v8 ad=0.066 pd=0.745 as=0.2205 ps=1.89 w=0.42 l=0.15
X5888 a_37839_36861# a_37851_36647# uio_oe[0] uio_oe[0] sky130_fd_pr__nfet_01v8 ad=0.1092 pd=1.36 as=0.1092 ps=1.36 w=0.42 l=0.15
X5889 a_36764_40125# a_36327_39733# VDPWR VDPWR sky130_fd_pr__pfet_01v8_hvt ad=0.0567 pd=0.69 as=0.0819 ps=0.81 w=0.42 l=0.15
X5890 a_49920_38127# a_49483_38101# VDPWR VDPWR sky130_fd_pr__pfet_01v8_hvt ad=0.0567 pd=0.69 as=0.0819 ps=0.81 w=0.42 l=0.15
X5891 ua[4] a_28348_10782# a_28218_10020# uio_oe[0] sky130_fd_pr__nfet_01v8 ad=0.1885 pd=1.88 as=0.1885 ps=1.88 w=0.65 l=0.15
X5892 a_42679_41935# a_42163_41935# a_42584_41935# uio_oe[0] sky130_fd_pr__special_nfet_01v8 ad=0.0594 pd=0.69 as=0.066 ps=0.745 w=0.36 l=0.15
X5893 a_53005_37583# a_52579_37910# uio_oe[0] uio_oe[0] sky130_fd_pr__nfet_01v8 ad=0.169 pd=1.82 as=0.11285 ps=1.045 w=0.65 l=0.15
X5894 a_61644_36495# a_60729_36495# a_61297_36737# uio_oe[0] sky130_fd_pr__special_nfet_01v8 ad=0.0711 pd=0.755 as=0.0999 ps=0.985 w=0.36 l=0.15
X5895 a_40302_36083# a_40619_36193# a_40577_36317# uio_oe[0] sky130_fd_pr__special_nfet_01v8 ad=0.0711 pd=0.755 as=0.0669 ps=0.75 w=0.36 l=0.15
X5896 a_57640_41705# a_57556_41365# a_58044_41757# uio_oe[0] sky130_fd_pr__special_nfet_01v8 ad=0.072 pd=0.76 as=0.06705 ps=0.75 w=0.36 l=0.15
X5897 uio_oe[0] a_39973_38425# a_39907_38493# uio_oe[0] sky130_fd_pr__nfet_01v8 ad=0.1449 pd=1.11 as=0.0693 ps=0.75 w=0.42 l=0.15
X5898 a_61806_37949# a_60729_37583# a_61644_37583# VDPWR sky130_fd_pr__pfet_01v8_hvt ad=0.0567 pd=0.69 as=0.0588 ps=0.7 w=0.42 l=0.15
X5899 a_59323_37078# a_54479_37052# a_58864_37271# VDPWR sky130_fd_pr__pfet_01v8_hvt ad=0.0441 pd=0.63 as=0.1932 ps=1.34 w=0.42 l=0.15
X5900 VDPWR a_25449_36747# a_25479_36488# VDPWR sky130_fd_pr__pfet_01v8_hvt ad=0.0693 pd=0.75 as=0.0441 ps=0.63 w=0.42 l=0.15
X5901 VDPWR a_43432_35381# a_43390_35657# VDPWR sky130_fd_pr__pfet_01v8_hvt ad=0.14575 pd=1.335 as=0.0441 ps=0.63 w=0.42 l=0.15
X5902 a_49961_35407# a_49483_35381# uio_oe[0] uio_oe[0] sky130_fd_pr__nfet_01v8 ad=0.0669 pd=0.75 as=0.12495 ps=1.015 w=0.42 l=0.15
X5903 a_44516_42845# a_44399_42650# uio_oe[0] uio_oe[0] sky130_fd_pr__nfet_01v8 ad=0.066 pd=0.745 as=0.2205 ps=1.89 w=0.42 l=0.15
X5904 a_57354_41757# a_48125_43023# uio_oe[0] uio_oe[0] sky130_fd_pr__nfet_01v8 ad=0.0483 pd=0.65 as=0.1137 ps=1.01 w=0.42 l=0.15
X5905 a_44557_39759# a_37851_36647# a_43432_35381# uio_oe[0] sky130_fd_pr__nfet_01v8 ad=0.08775 pd=0.92 as=0.25025 ps=1.42 w=0.65 l=0.15
X5906 a_39544_37735# a_39752_37557# a_39686_37583# uio_oe[0] sky130_fd_pr__nfet_01v8 ad=0.09975 pd=0.895 as=0.0693 ps=0.75 w=0.42 l=0.15
X5907 a_58864_37271# a_54479_37052# a_59006_37405# uio_oe[0] sky130_fd_pr__nfet_01v8 ad=0.09975 pd=0.895 as=0.0693 ps=0.75 w=0.42 l=0.15
X5908 VDPWR a_50159_35925# a_50090_35951# VDPWR sky130_fd_pr__pfet_01v8_hvt ad=0.2184 pd=2.2 as=0.12915 ps=1.185 w=0.84 l=0.15
X5909 a_22439_35727# a_18427_33198# a_22076_35593# uio_oe[0] sky130_fd_pr__nfet_01v8 ad=0.0693 pd=0.75 as=0.09975 ps=0.895 w=0.42 l=0.15
X5910 ua[4] a_20620_10376# a_20490_26020# uio_oe[0] sky130_fd_pr__nfet_01v8 ad=0.1885 pd=1.88 as=0.1885 ps=1.88 w=0.65 l=0.15
X5911 a_22010_20730# ua[2] a_21882_22020# uio_oe[0] sky130_fd_pr__nfet_01v8 ad=0.2436 pd=2.26 as=0.2436 ps=2.26 w=0.84 l=0.6
X5912 a_46651_42301# a_46027_41935# a_46543_41935# VDPWR sky130_fd_pr__pfet_01v8_hvt ad=0.1155 pd=0.97 as=0.07245 ps=0.765 w=0.42 l=0.15
X5913 a_45176_40847# a_44261_40847# a_44829_41089# uio_oe[0] sky130_fd_pr__special_nfet_01v8 ad=0.0711 pd=0.755 as=0.0999 ps=0.985 w=0.36 l=0.15
X5914 a_44339_37735# a_36447_40849# VDPWR VDPWR sky130_fd_pr__pfet_01v8_hvt ad=0.0567 pd=0.69 as=0.16655 ps=1.39 w=0.42 l=0.15
X5915 a_52579_37910# a_51620_38395# a_52579_37583# uio_oe[0] sky130_fd_pr__nfet_01v8 ad=0.09975 pd=0.895 as=0.0693 ps=0.75 w=0.42 l=0.15
X5916 a_26399_33224# a_18420_33453# a_25940_33417# VDPWR sky130_fd_pr__pfet_01v8_hvt ad=0.0441 pd=0.63 as=0.1932 ps=1.34 w=0.42 l=0.15
X5917 a_52335_34837# a_52538_34995# VDPWR VDPWR sky130_fd_pr__pfet_01v8_hvt ad=0.0567 pd=0.69 as=0.1134 ps=1.38 w=0.42 l=0.15
X5918 a_25739_37021# a_24787_36993# VDPWR VDPWR sky130_fd_pr__pfet_01v8_hvt ad=0.0567 pd=0.69 as=0.1176 ps=1.4 w=0.42 l=0.15
X5919 a_28842_37320# a_28796_37145# VDPWR VDPWR sky130_fd_pr__pfet_01v8_hvt ad=0.07665 pd=0.785 as=0.15835 ps=1.395 w=0.42 l=0.15
X5920 a_28642_26464# a_28348_10376# ua[5] uio_oe[0] sky130_fd_pr__nfet_01v8 ad=0.1885 pd=1.88 as=0.1885 ps=1.88 w=0.65 l=0.15
X5921 VDPWR a_42696_37557# a_44369_40009# VDPWR sky130_fd_pr__pfet_01v8_hvt ad=0.135 pd=1.27 as=0.135 ps=1.27 w=1 l=0.15
X5922 VDPWR a_48125_43023# a_50304_39037# VDPWR sky130_fd_pr__pfet_01v8_hvt ad=0.07035 pd=0.755 as=0.1092 ps=1.36 w=0.42 l=0.15
X5923 a_42768_39759# a_42149_37039# VDPWR VDPWR sky130_fd_pr__pfet_01v8_hvt ad=0.0651 pd=0.73 as=0.1092 ps=1.36 w=0.42 l=0.15
X5924 VDPWR a_61297_38913# a_61187_39037# VDPWR sky130_fd_pr__pfet_01v8_hvt ad=0.07035 pd=0.755 as=0.1155 ps=0.97 w=0.42 l=0.15
X5925 a_47108_41935# a_46193_41935# a_46761_42177# uio_oe[0] sky130_fd_pr__special_nfet_01v8 ad=0.0711 pd=0.755 as=0.0999 ps=0.985 w=0.36 l=0.15
X5926 a_50090_35951# a_49964_36067# a_49686_36083# uio_oe[0] sky130_fd_pr__special_nfet_01v8 ad=0.0999 pd=0.985 as=0.0711 ps=0.755 w=0.36 l=0.15
X5927 a_54627_40669# a_54479_40316# a_54264_40535# uio_oe[0] sky130_fd_pr__nfet_01v8 ad=0.0693 pd=0.75 as=0.09975 ps=0.895 w=0.42 l=0.15
X5928 a_17292_34505# a_17500_33453# a_17434_34639# uio_oe[0] sky130_fd_pr__nfet_01v8 ad=0.09975 pd=0.895 as=0.0693 ps=0.75 w=0.42 l=0.15
X5929 a_50397_40669# a_48125_43023# uio_oe[0] uio_oe[0] sky130_fd_pr__nfet_01v8 ad=0.0441 pd=0.63 as=0.1346 ps=1.15 w=0.42 l=0.15
X5930 uio_oe[0] a_41671_36469# a_41605_36495# uio_oe[0] sky130_fd_pr__nfet_01v8 ad=0.12495 pd=1.015 as=0.0669 ps=0.75 w=0.42 l=0.15
X5931 a_23402_24730# ua[2] a_23274_26020# uio_oe[0] sky130_fd_pr__nfet_01v8 ad=0.2436 pd=2.26 as=0.2436 ps=2.26 w=0.84 l=0.6
X5932 a_57321_40669# a_56843_40277# uio_oe[0] uio_oe[0] sky130_fd_pr__nfet_01v8 ad=0.0669 pd=0.75 as=0.12495 ps=1.015 w=0.42 l=0.15
X5933 a_50003_38813# a_38649_43023# uio_oe[0] uio_oe[0] sky130_fd_pr__nfet_01v8 ad=0.1092 pd=1.36 as=0.0567 ps=0.69 w=0.42 l=0.15
X5934 uio_oe[0] a_51841_38425# a_51775_38493# uio_oe[0] sky130_fd_pr__nfet_01v8 ad=0.1449 pd=1.11 as=0.0693 ps=0.75 w=0.42 l=0.15
X5935 a_59860_37271# a_59956_37013# VDPWR VDPWR sky130_fd_pr__pfet_01v8_hvt ad=0.1664 pd=1.8 as=0.149 ps=1.325 w=0.64 l=0.15
X5936 VDPWR a_42613_36724# a_43157_35951# VDPWR sky130_fd_pr__pfet_01v8_hvt ad=0.26 pd=2.52 as=0.135 ps=1.27 w=1 l=0.15
X5937 a_36307_40875# a_17500_33453# VDPWR VDPWR sky130_fd_pr__pfet_01v8_hvt ad=0.0567 pd=0.69 as=0.1176 ps=1.4 w=0.42 l=0.15
X5938 a_52793_38998# a_51620_39483# a_52579_38998# VDPWR sky130_fd_pr__pfet_01v8_hvt ad=0.07665 pd=0.785 as=0.1932 ps=1.34 w=0.42 l=0.15
X5939 ua[5] a_28348_14782# a_28218_22020# uio_oe[0] sky130_fd_pr__nfet_01v8 ad=0.1885 pd=1.88 as=0.1885 ps=1.88 w=0.65 l=0.15
X5940 uio_oe[0] a_37851_36647# a_44339_39944# uio_oe[0] sky130_fd_pr__nfet_01v8 ad=0.169 pd=1.82 as=0.08775 ps=0.92 w=0.65 l=0.15
X5941 a_58772_38823# a_38740_38645# a_58914_38998# VDPWR sky130_fd_pr__pfet_01v8_hvt ad=0.1932 pd=1.34 as=0.07665 ps=0.785 w=0.42 l=0.15
X5942 a_51412_37735# a_51620_37557# a_51554_37583# uio_oe[0] sky130_fd_pr__nfet_01v8 ad=0.09975 pd=0.895 as=0.0693 ps=0.75 w=0.42 l=0.15
X5943 VDPWR a_50159_36732# a_50090_36861# VDPWR sky130_fd_pr__pfet_01v8_hvt ad=0.2184 pd=2.2 as=0.12915 ps=1.185 w=0.84 l=0.15
X5944 uio_oe[0] a_60996_35925# a_60934_35951# uio_oe[0] sky130_fd_pr__nfet_01v8 ad=0.2205 pd=1.89 as=0.066 ps=0.745 w=0.42 l=0.15
X5945 a_54264_40535# a_54479_40316# a_54406_40342# VDPWR sky130_fd_pr__pfet_01v8_hvt ad=0.1932 pd=1.34 as=0.07665 ps=0.785 w=0.42 l=0.15
X5946 a_21553_32641# a_21287_33007# uio_oe[0] uio_oe[0] sky130_fd_pr__nfet_01v8 ad=0.169 pd=1.82 as=0.1013 ps=0.99 w=0.65 l=0.15
X5947 uio_oe[0] a_58772_40535# a_58144_40277# uio_oe[0] sky130_fd_pr__nfet_01v8 ad=0.11285 pd=1.045 as=0.169 ps=1.82 w=0.65 l=0.15
X5948 a_58082_35951# a_57324_36067# a_57519_35925# VDPWR sky130_fd_pr__pfet_01v8_hvt ad=0.0651 pd=0.73 as=0.07245 ps=0.765 w=0.42 l=0.15
X5949 VDPWR a_37029_42479# a_44095_40309# VDPWR sky130_fd_pr__pfet_01v8_hvt ad=0.0864 pd=0.91 as=0.1664 ps=1.8 w=0.64 l=0.15
X5950 VDPWR a_38771_35409# a_38543_35559# VDPWR sky130_fd_pr__pfet_01v8_hvt ad=0.1176 pd=1.4 as=0.0567 ps=0.69 w=0.42 l=0.15
X5951 a_60416_39493# a_37913_43023# uio_oe[0] uio_oe[0] sky130_fd_pr__nfet_01v8 ad=0.1092 pd=1.36 as=0.0567 ps=0.69 w=0.42 l=0.15
X5952 a_59006_37405# a_48677_38127# uio_oe[0] uio_oe[0] sky130_fd_pr__nfet_01v8 ad=0.0693 pd=0.75 as=0.11285 ps=1.045 w=0.42 l=0.15
X5953 VDPWR a_29073_32899# a_29015_33007# VDPWR sky130_fd_pr__pfet_01v8_hvt ad=0.2279 pd=1.74 as=0.0609 ps=0.71 w=0.42 l=0.15
X5954 a_38674_39581# a_38005_40847# uio_oe[0] uio_oe[0] sky130_fd_pr__nfet_01v8 ad=0.0693 pd=0.75 as=0.11285 ps=1.045 w=0.42 l=0.15
X5955 uio_oe[0] a_37913_41935# a_53203_34319# uio_oe[0] sky130_fd_pr__nfet_01v8 ad=0.0567 pd=0.69 as=0.1092 ps=1.36 w=0.42 l=0.15
X5956 a_44611_41769# a_44261_41397# a_44516_41757# VDPWR sky130_fd_pr__pfet_01v8_hvt ad=0.07245 pd=0.765 as=0.0651 ps=0.73 w=0.42 l=0.15
X5957 VDPWR a_40379_35551# a_40467_39733# VDPWR sky130_fd_pr__pfet_01v8_hvt ad=0.0819 pd=0.81 as=0.0567 ps=0.69 w=0.42 l=0.15
X5958 a_40003_39254# a_39752_39483# a_39544_39447# VDPWR sky130_fd_pr__pfet_01v8_hvt ad=0.0441 pd=0.63 as=0.1932 ps=1.34 w=0.42 l=0.15
X5959 VDPWR a_46289_39447# a_43156_34293# VDPWR sky130_fd_pr__pfet_01v8_hvt ad=0.14575 pd=1.335 as=0.34 ps=2.68 w=1 l=0.15
X5960 a_29313_34571# a_28980_34505# uio_oe[0] uio_oe[0] sky130_fd_pr__nfet_01v8 ad=0.1092 pd=1.36 as=0.1449 ps=1.11 w=0.42 l=0.15
X5961 uio_oe[0] a_45351_41695# a_45285_41769# uio_oe[0] sky130_fd_pr__nfet_01v8 ad=0.12495 pd=1.015 as=0.0669 ps=0.75 w=0.42 l=0.15
X5962 a_52855_35105# a_37913_41935# uio_oe[0] uio_oe[0] sky130_fd_pr__nfet_01v8 ad=0.1092 pd=1.36 as=0.0567 ps=0.69 w=0.42 l=0.15
X5963 a_52942_34863# a_52855_35105# a_52538_34995# VDPWR sky130_fd_pr__pfet_01v8_hvt ad=0.12915 pd=1.185 as=0.0588 ps=0.7 w=0.42 l=0.15
X5964 uio_oe[0] a_48125_43023# a_57081_40669# uio_oe[0] sky130_fd_pr__nfet_01v8 ad=0.12495 pd=1.015 as=0.06405 ps=0.725 w=0.42 l=0.15
X5965 a_54284_39759# a_53203_39759# a_53937_40001# VDPWR sky130_fd_pr__pfet_01v8_hvt ad=0.0588 pd=0.7 as=0.12915 ps=1.185 w=0.42 l=0.15
X5966 a_21875_33757# a_20923_33729# VDPWR VDPWR sky130_fd_pr__pfet_01v8_hvt ad=0.0567 pd=0.69 as=0.1176 ps=1.4 w=0.42 l=0.15
X5967 VDPWR a_42919_38369# a_42880_38243# VDPWR sky130_fd_pr__pfet_01v8_hvt ad=0.0864 pd=0.91 as=0.1664 ps=1.8 w=0.64 l=0.15
X5968 a_58914_37583# a_48677_38127# uio_oe[0] uio_oe[0] sky130_fd_pr__nfet_01v8 ad=0.0693 pd=0.75 as=0.11285 ps=1.045 w=0.42 l=0.15
X5969 uio_oe[0] a_56916_41623# a_39752_41659# uio_oe[0] sky130_fd_pr__nfet_01v8 ad=0.097 pd=0.975 as=0.169 ps=1.82 w=0.65 l=0.15
X5970 a_38073_37078# a_37901_37307# a_37859_37078# VDPWR sky130_fd_pr__pfet_01v8_hvt ad=0.07665 pd=0.785 as=0.1932 ps=1.34 w=0.42 l=0.15
X5971 uio_oe[0] a_47283_42783# a_47217_42857# uio_oe[0] sky130_fd_pr__nfet_01v8 ad=0.12495 pd=1.015 as=0.0669 ps=0.75 w=0.42 l=0.15
X5972 VDPWR a_41537_41909# a_41567_42262# VDPWR sky130_fd_pr__pfet_01v8_hvt ad=0.0693 pd=0.75 as=0.0441 ps=0.63 w=0.42 l=0.15
X5973 VDPWR a_45351_40821# a_45338_41213# VDPWR sky130_fd_pr__pfet_01v8_hvt ad=0.0819 pd=0.81 as=0.0567 ps=0.69 w=0.42 l=0.15
X5974 a_41381_38493# a_40379_35551# uio_oe[0] uio_oe[0] sky130_fd_pr__nfet_01v8 ad=0.0441 pd=0.63 as=0.1346 ps=1.15 w=0.42 l=0.15
X5975 a_28700_37145# a_28835_36449# a_28842_37320# VDPWR sky130_fd_pr__pfet_01v8_hvt ad=0.1932 pd=1.34 as=0.07665 ps=0.785 w=0.42 l=0.15
X5976 a_61950_41430# a_36661_41391# VDPWR VDPWR sky130_fd_pr__pfet_01v8_hvt ad=0.07665 pd=0.785 as=0.15835 ps=1.395 w=0.42 l=0.15
X5977 a_52855_39457# a_37913_43023# VDPWR VDPWR sky130_fd_pr__pfet_01v8_hvt ad=0.1664 pd=1.8 as=0.0864 ps=0.91 w=0.64 l=0.15
X5978 a_18354_36488# a_17388_36681# VDPWR VDPWR sky130_fd_pr__pfet_01v8_hvt ad=0.07665 pd=0.785 as=0.15835 ps=1.395 w=0.42 l=0.15
X5979 a_53369_36495# a_53203_36495# uio_oe[0] uio_oe[0] sky130_fd_pr__nfet_01v8 ad=0.1092 pd=1.36 as=0.0567 ps=0.69 w=0.42 l=0.15
X5980 a_61806_36861# a_60729_36495# a_61644_36495# VDPWR sky130_fd_pr__pfet_01v8_hvt ad=0.0567 pd=0.69 as=0.0588 ps=0.7 w=0.42 l=0.15
X5981 ua[5] a_28348_10376# a_29610_14020# uio_oe[0] sky130_fd_pr__nfet_01v8 ad=0.1885 pd=1.88 as=0.1885 ps=1.88 w=0.65 l=0.15
X5982 a_51871_39254# a_51620_39483# a_51412_39447# VDPWR sky130_fd_pr__pfet_01v8_hvt ad=0.0441 pd=0.63 as=0.1932 ps=1.34 w=0.42 l=0.15
X5983 a_41420_39037# a_40581_38671# a_41444_38671# uio_oe[0] sky130_fd_pr__nfet_01v8 ad=0.0693 pd=0.75 as=0.0441 ps=0.63 w=0.42 l=0.15
X5984 a_51841_38425# a_48677_38127# VDPWR VDPWR sky130_fd_pr__pfet_01v8_hvt ad=0.1176 pd=1.4 as=0.0693 ps=0.75 w=0.42 l=0.15
X5985 uio_oe[0] a_39947_42997# a_46805_40847# uio_oe[0] sky130_fd_pr__nfet_01v8 ad=0.1346 pd=1.15 as=0.0441 ps=0.63 w=0.42 l=0.15
X5986 a_57519_39996# a_57363_39901# a_57664_40125# VDPWR sky130_fd_pr__pfet_01v8_hvt ad=0.07245 pd=0.765 as=0.1155 ps=0.97 w=0.42 l=0.15
X5987 a_18442_10464# a_16756_10782# ua[5] uio_oe[0] sky130_fd_pr__nfet_01v8 ad=0.1885 pd=1.88 as=0.1885 ps=1.88 w=0.65 l=0.15
X5988 a_41250_34902# a_37661_38140# VDPWR VDPWR sky130_fd_pr__pfet_01v8_hvt ad=0.07665 pd=0.785 as=0.15835 ps=1.395 w=0.42 l=0.15
X5989 VDPWR a_61644_41935# a_61819_41909# VDPWR sky130_fd_pr__pfet_01v8_hvt ad=0.1134 pd=1.38 as=0.0567 ps=0.69 w=0.42 l=0.15
X5990 a_39907_40847# a_39759_41129# a_39544_40999# uio_oe[0] sky130_fd_pr__nfet_01v8 ad=0.0693 pd=0.75 as=0.09975 ps=0.895 w=0.42 l=0.15
X5991 a_18641_34571# a_17388_34505# uio_oe[0] uio_oe[0] sky130_fd_pr__nfet_01v8 ad=0.1092 pd=1.36 as=0.1449 ps=1.11 w=0.42 l=0.15
X5992 a_40003_38998# a_39752_38645# a_39544_38823# VDPWR sky130_fd_pr__pfet_01v8_hvt ad=0.0441 pd=0.63 as=0.1932 ps=1.34 w=0.42 l=0.15
X5993 VDPWR a_48125_41935# a_59695_40277# VDPWR sky130_fd_pr__pfet_01v8_hvt ad=0.0819 pd=0.81 as=0.0567 ps=0.69 w=0.42 l=0.15
X5994 VDPWR a_36661_41391# a_52793_38998# VDPWR sky130_fd_pr__pfet_01v8_hvt ad=0.15835 pd=1.395 as=0.07665 ps=0.785 w=0.42 l=0.15
X5995 uio_oe[0] a_39544_40999# a_17204_33881# uio_oe[0] sky130_fd_pr__nfet_01v8 ad=0.11285 pd=1.045 as=0.169 ps=1.82 w=0.65 l=0.15
X5996 VDPWR a_38077_34577# a_38019_34685# VDPWR sky130_fd_pr__pfet_01v8_hvt ad=0.2279 pd=1.74 as=0.0609 ps=0.71 w=0.42 l=0.15
X5997 a_50090_34863# a_49964_34979# a_49686_34995# uio_oe[0] sky130_fd_pr__special_nfet_01v8 ad=0.0999 pd=0.985 as=0.0711 ps=0.755 w=0.36 l=0.15
X5998 a_42679_40681# a_42329_40309# a_42584_40669# VDPWR sky130_fd_pr__pfet_01v8_hvt ad=0.07245 pd=0.765 as=0.0651 ps=0.73 w=0.42 l=0.15
X5999 uio_oe[0] a_16812_8642# a_25874_24730# uio_oe[0] sky130_fd_pr__nfet_01v8 ad=1.4703 pd=10.72 as=1.4703 ps=10.72 w=5.07 l=1
X6000 a_17292_33417# a_17500_33453# a_17434_33551# uio_oe[0] sky130_fd_pr__nfet_01v8 ad=0.09975 pd=0.895 as=0.0693 ps=0.75 w=0.42 l=0.15
X6001 VDPWR a_48125_43023# a_49483_39189# VDPWR sky130_fd_pr__pfet_01v8_hvt ad=0.0819 pd=0.81 as=0.0567 ps=0.69 w=0.42 l=0.15
X6002 a_22076_36681# a_18420_33453# a_22218_36815# uio_oe[0] sky130_fd_pr__nfet_01v8 ad=0.09975 pd=0.895 as=0.0693 ps=0.75 w=0.42 l=0.15
X6003 a_46543_43023# a_46193_43023# a_46448_43023# VDPWR sky130_fd_pr__pfet_01v8_hvt ad=0.07245 pd=0.765 as=0.0651 ps=0.73 w=0.42 l=0.15
X6004 VDPWR a_45176_42857# a_45351_42783# VDPWR sky130_fd_pr__pfet_01v8_hvt ad=0.1134 pd=1.38 as=0.0567 ps=0.69 w=0.42 l=0.15
X6005 a_52538_38259# a_52855_38369# a_52813_38493# uio_oe[0] sky130_fd_pr__special_nfet_01v8 ad=0.0711 pd=0.755 as=0.0669 ps=0.75 w=0.36 l=0.15
X6006 uio_oe[0] a_25417_32641# a_25825_33757# uio_oe[0] sky130_fd_pr__nfet_01v8 ad=0.1118 pd=1.04 as=0.0567 ps=0.69 w=0.42 l=0.15
X6007 a_24484_18376# a_26439_35183# VDPWR VDPWR sky130_fd_pr__pfet_01v8_hvt ad=0.26 pd=2.52 as=0.2279 ps=1.74 w=1 l=0.15
X6008 a_40469_41909# a_40639_42087# a_40597_42185# VDPWR sky130_fd_pr__pfet_01v8_hvt ad=0.1092 pd=1.36 as=0.0441 ps=0.63 w=0.42 l=0.15
X6009 a_51775_40847# a_39752_40821# a_51412_40999# uio_oe[0] sky130_fd_pr__nfet_01v8 ad=0.0693 pd=0.75 as=0.09975 ps=0.895 w=0.42 l=0.15
X6010 a_28348_10376# a_29603_37021# VDPWR VDPWR sky130_fd_pr__pfet_01v8_hvt ad=0.475 pd=2.95 as=0.16655 ps=1.39 w=1 l=0.15
X6011 a_21114_35144# a_21068_34969# VDPWR VDPWR sky130_fd_pr__pfet_01v8_hvt ad=0.07665 pd=0.785 as=0.15835 ps=1.395 w=0.42 l=0.15
X6012 a_60542_41757# a_60500_41365# a_59956_41365# uio_oe[0] sky130_fd_pr__nfet_01v8 ad=0.0441 pd=0.63 as=0.0693 ps=0.75 w=0.42 l=0.15
X6013 a_51871_38998# a_51620_38645# a_51412_38823# VDPWR sky130_fd_pr__pfet_01v8_hvt ad=0.0441 pd=0.63 as=0.1932 ps=1.34 w=0.42 l=0.15
X6014 a_62053_40601# a_36661_41391# uio_oe[0] uio_oe[0] sky130_fd_pr__nfet_01v8 ad=0.1092 pd=1.36 as=0.1449 ps=1.11 w=0.42 l=0.15
X6015 a_37241_39581# a_36607_39455# uio_oe[0] uio_oe[0] sky130_fd_pr__nfet_01v8 ad=0.0441 pd=0.63 as=0.1346 ps=1.15 w=0.42 l=0.15
X6016 uio_oe[0] a_51412_40999# a_50784_41096# uio_oe[0] sky130_fd_pr__nfet_01v8 ad=0.11285 pd=1.045 as=0.169 ps=1.82 w=0.65 l=0.15
X6017 a_42630_37910# a_38285_34863# VDPWR VDPWR sky130_fd_pr__pfet_01v8_hvt ad=0.07665 pd=0.785 as=0.15835 ps=1.395 w=0.42 l=0.15
X6018 a_38077_34577# a_36447_40849# a_39213_35183# uio_oe[0] sky130_fd_pr__nfet_01v8 ad=0.169 pd=1.82 as=0.08775 ps=0.92 w=0.65 l=0.15
X6019 a_57757_42845# a_48125_43023# uio_oe[0] uio_oe[0] sky130_fd_pr__nfet_01v8 ad=0.0441 pd=0.63 as=0.1346 ps=1.15 w=0.42 l=0.15
X6020 a_41016_41623# a_41224_41659# a_41158_41757# uio_oe[0] sky130_fd_pr__nfet_01v8 ad=0.09975 pd=0.895 as=0.0693 ps=0.75 w=0.42 l=0.15
X6021 a_60516_38127# a_60302_38127# VDPWR VDPWR sky130_fd_pr__pfet_01v8_hvt ad=0.1155 pd=0.97 as=0.07035 ps=0.755 w=0.42 l=0.15
X6022 uio_oe[0] a_25020_36681# a_24971_36449# uio_oe[0] sky130_fd_pr__nfet_01v8 ad=0.11285 pd=1.045 as=0.169 ps=1.82 w=0.65 l=0.15
X6023 a_47217_41769# a_46027_41397# a_47108_41769# uio_oe[0] sky130_fd_pr__special_nfet_01v8 ad=0.0669 pd=0.75 as=0.0711 ps=0.755 w=0.36 l=0.15
X6024 uio_oe[0] a_40975_34569# a_41309_34319# uio_oe[0] sky130_fd_pr__nfet_01v8 ad=0.208 pd=1.94 as=0.25025 ps=1.42 w=0.65 l=0.15
X6025 VDPWR a_40495_42453# a_40379_35551# VDPWR sky130_fd_pr__pfet_01v8_hvt ad=0.135 pd=1.27 as=0.135 ps=1.27 w=1 l=0.15
X6026 uio_oe[0] a_50159_42172# a_50090_42301# uio_oe[0] sky130_fd_pr__nfet_01v8 ad=0.1346 pd=1.15 as=0.0999 ps=0.985 w=0.64 l=0.15
X6027 VDPWR a_37661_37052# a_38073_37078# VDPWR sky130_fd_pr__pfet_01v8_hvt ad=0.15835 pd=1.395 as=0.07665 ps=0.785 w=0.42 l=0.15
X6028 uio_oe[0] a_49483_37013# a_38740_37307# uio_oe[0] sky130_fd_pr__nfet_01v8 ad=0.2087 pd=2.02 as=0.169 ps=1.82 w=0.65 l=0.15
X6029 a_39729_36289# a_37029_37583# uio_oe[0] uio_oe[0] sky130_fd_pr__nfet_01v8 ad=0.0567 pd=0.69 as=0.1118 ps=1.04 w=0.42 l=0.15
X6030 uio_oe[0] a_17292_34505# a_17243_34273# uio_oe[0] sky130_fd_pr__nfet_01v8 ad=0.11285 pd=1.045 as=0.169 ps=1.82 w=0.65 l=0.15
X6031 a_57450_40303# a_57324_40419# a_57046_40435# uio_oe[0] sky130_fd_pr__special_nfet_01v8 ad=0.0999 pd=0.985 as=0.0711 ps=0.755 w=0.36 l=0.15
X6032 VDPWR a_57519_38908# a_57450_39037# VDPWR sky130_fd_pr__pfet_01v8_hvt ad=0.2184 pd=2.2 as=0.12915 ps=1.185 w=0.84 l=0.15
X6033 a_41605_37417# a_40415_37045# a_41496_37417# uio_oe[0] sky130_fd_pr__special_nfet_01v8 ad=0.0669 pd=0.75 as=0.0711 ps=0.755 w=0.36 l=0.15
X6034 a_29313_33483# a_28980_33417# uio_oe[0] uio_oe[0] sky130_fd_pr__nfet_01v8 ad=0.1092 pd=1.36 as=0.1449 ps=1.11 w=0.42 l=0.15
X6035 a_29063_33729# a_28835_33185# a_28700_33881# uio_oe[0] sky130_fd_pr__nfet_01v8 ad=0.0693 pd=0.75 as=0.09975 ps=0.895 w=0.42 l=0.15
X6036 a_42989_35951# a_42613_36724# a_42907_35951# VDPWR sky130_fd_pr__pfet_01v8_hvt ad=0.135 pd=1.27 as=0.26 ps=2.52 w=1 l=0.15
