* NGSPICE file created from v3_channel_selector_late_promotion.ext - technology: sky130A

X0 v3_channel_input_bias_late_promotion_0/a_4678_23422# v3_selector_route_pilot_0/group3_lo_p row_outn VGND sky130_fd_pr__nfet_01v8 ad=0.1885 pd=1.88 as=0.1885 ps=1.88 w=0.65 l=0.15
X1 row_outn v3_selector_route_pilot_0/group3_lo_p v3_channel_input_bias_late_promotion_0/a_4254_6978# VGND sky130_fd_pr__nfet_01v8 ad=0.1885 pd=1.88 as=0.1885 ps=1.88 w=0.65 l=0.15
X2 v3_channel_input_bias_late_promotion_0/a_4678_23422# ref v3_channel_input_bias_late_promotion_0/a_4382_21688# VGND sky130_fd_pr__nfet_01v8 ad=0.2436 pd=2.26 as=0.2436 ps=2.26 w=0.84 l=0.6
X3 row_outn v3_selector_route_pilot_0/group3_lo_n v3_channel_input_bias_late_promotion_0/a_7038_22978# VGND sky130_fd_pr__nfet_01v8 ad=0.1885 pd=1.88 as=0.1885 ps=1.88 w=0.65 l=0.15
X4 row_outn v3_selector_route_pilot_0/group3_lo_p v3_channel_input_bias_late_promotion_0/a_7038_6978# VGND sky130_fd_pr__nfet_01v8 ad=0.1885 pd=1.88 as=0.1885 ps=1.88 w=0.65 l=0.15
X5 v3_channel_input_bias_late_promotion_0/a_7462_11422# element_input v3_channel_input_bias_late_promotion_0/a_7216_10978# VGND sky130_fd_pr__nfet_01v8 ad=0.2436 pd=2.26 as=0.2436 ps=2.26 w=0.84 l=0.6
X6 v3_channel_input_bias_late_promotion_0/a_7462_11422# v3_selector_route_pilot_0/group2_lo_n row_outn VGND sky130_fd_pr__nfet_01v8 ad=0.1885 pd=1.88 as=0.1885 ps=1.88 w=0.65 l=0.15
X7 v3_channel_input_bias_late_promotion_0/a_5774_21688# element_input v3_channel_input_bias_late_promotion_0/a_5646_22978# VGND sky130_fd_pr__nfet_01v8 ad=0.2436 pd=2.26 as=0.2436 ps=2.26 w=0.84 l=0.6
X8 VGND vbias v3_channel_input_bias_late_promotion_0/a_5774_17688# VGND sky130_fd_pr__nfet_01v8 ad=1.4703 pd=10.72 as=1.4703 ps=10.72 w=5.07 l=1
X9 v3_channel_input_bias_late_promotion_0/a_6070_7422# element_input v3_channel_input_bias_late_promotion_0/a_5824_6978# VGND sky130_fd_pr__nfet_01v8 ad=0.2436 pd=2.26 as=0.2436 ps=2.26 w=0.84 l=0.6
X10 v3_channel_input_bias_late_promotion_0/a_6070_7422# v3_selector_route_pilot_0/group3_lo_n row_outn VGND sky130_fd_pr__nfet_01v8 ad=0.1885 pd=1.88 as=0.1885 ps=1.88 w=0.65 l=0.15
X11 ref element_input VGND sky130_fd_pr__res_xhigh_po_0p35 l=17.36
X12 v3_channel_input_bias_late_promotion_0/a_7462_23422# ref v3_channel_input_bias_late_promotion_0/a_7166_21688# VGND sky130_fd_pr__nfet_01v8 ad=0.2436 pd=2.26 as=0.2436 ps=2.26 w=0.84 l=0.6
X13 v3_channel_input_bias_late_promotion_0/a_7462_23422# v3_selector_route_pilot_0/group3_lo_p row_outn VGND sky130_fd_pr__nfet_01v8 ad=0.1885 pd=1.88 as=0.1885 ps=1.88 w=0.65 l=0.15
X14 VGND vbias v3_channel_input_bias_late_promotion_0/a_4382_21688# VGND sky130_fd_pr__nfet_01v8 ad=1.4703 pd=10.72 as=1.4703 ps=10.72 w=5.07 l=1
X15 VGND vbias v3_channel_input_bias_late_promotion_0/a_5774_13688# VGND sky130_fd_pr__nfet_01v8 ad=1.4703 pd=10.72 as=1.4703 ps=10.72 w=5.07 l=1
X16 VGND vbias v3_channel_input_bias_late_promotion_0/a_7166_17688# VGND sky130_fd_pr__nfet_01v8 ad=1.4703 pd=10.72 as=1.4703 ps=10.72 w=5.07 l=1
X17 VGND VGND VGND VGND sky130_fd_pr__nfet_01v8 ad=0.1885 pd=1.88 as=41.7777 ps=324.42001 w=0.65 l=0.15
X18 row_outp v3_selector_route_pilot_0/group3_lo_p v3_channel_input_bias_late_promotion_0/a_5646_18978# VGND sky130_fd_pr__nfet_01v8 ad=0.1885 pd=1.88 as=0.1885 ps=1.88 w=0.65 l=0.15
X19 VGND VGND VGND VGND sky130_fd_pr__nfet_01v8 ad=0.1885 pd=1.88 as=0 ps=0 w=0.65 l=0.15
X20 v3_channel_input_bias_late_promotion_0/a_6070_19422# v3_selector_route_pilot_0/group3_lo_n row_outp VGND sky130_fd_pr__nfet_01v8 ad=0.1885 pd=1.88 as=0.1885 ps=1.88 w=0.65 l=0.15
X21 VGND VGND VGND VGND sky130_fd_pr__nfet_01v8 ad=0.1885 pd=1.88 as=0 ps=0 w=0.65 l=0.15
X22 row_outp v3_selector_route_pilot_0/group2_lo_p v3_channel_input_bias_late_promotion_0/a_4254_18978# VGND sky130_fd_pr__nfet_01v8 ad=0.1885 pd=1.88 as=0.1885 ps=1.88 w=0.65 l=0.15
X23 v3_channel_input_bias_late_promotion_0/a_7216_14978# vbias VGND VGND sky130_fd_pr__nfet_01v8 ad=1.4703 pd=10.72 as=1.4703 ps=10.72 w=5.07 l=1
X24 VGND VGND VGND VGND sky130_fd_pr__nfet_01v8 ad=0.1885 pd=1.88 as=0 ps=0 w=0.65 l=0.15
X25 VGND VGND VGND VGND sky130_fd_pr__nfet_01v8 ad=0.1885 pd=1.88 as=0 ps=0 w=0.65 l=0.15
X26 v3_channel_input_bias_late_promotion_0/a_4382_17688# element_input v3_channel_input_bias_late_promotion_0/a_4254_18978# VGND sky130_fd_pr__nfet_01v8 ad=0.2436 pd=2.26 as=0.2436 ps=2.26 w=0.84 l=0.6
X27 v3_channel_input_bias_late_promotion_0/a_4678_19422# v3_selector_route_pilot_0/group2_lo_n row_outp VGND sky130_fd_pr__nfet_01v8 ad=0.1885 pd=1.88 as=0.1885 ps=1.88 w=0.65 l=0.15
X28 row_outp v3_selector_route_pilot_0/group0_lo_p v3_channel_input_bias_late_promotion_0/a_5646_14978# VGND sky130_fd_pr__nfet_01v8 ad=0.1885 pd=1.88 as=0.1885 ps=1.88 w=0.65 l=0.15
X29 row_outp v3_selector_route_pilot_0/group2_lo_p v3_channel_input_bias_late_promotion_0/a_7038_18978# VGND sky130_fd_pr__nfet_01v8 ad=0.1885 pd=1.88 as=0.1885 ps=1.88 w=0.65 l=0.15
X30 VGND VGND VGND VGND sky130_fd_pr__nfet_01v8 ad=1.4703 pd=10.72 as=0 ps=0 w=5.07 l=1
X31 v3_channel_input_bias_late_promotion_0/a_6070_15422# v3_selector_route_pilot_0/group0_lo_n row_outp VGND sky130_fd_pr__nfet_01v8 ad=0.1885 pd=1.88 as=0.1885 ps=1.88 w=0.65 l=0.15
X32 v3_channel_input_bias_late_promotion_0/a_7166_17688# element_input v3_channel_input_bias_late_promotion_0/a_7038_18978# VGND sky130_fd_pr__nfet_01v8 ad=0.2436 pd=2.26 as=0.2436 ps=2.26 w=0.84 l=0.6
X33 row_outn v3_selector_route_pilot_0/group3_lo_n v3_channel_input_bias_late_promotion_0/a_5646_18978# VGND sky130_fd_pr__nfet_01v8 ad=0.1885 pd=1.88 as=0.1885 ps=1.88 w=0.65 l=0.15
X34 VGND vbias v3_channel_input_bias_late_promotion_0/a_5774_21688# VGND sky130_fd_pr__nfet_01v8 ad=1.4703 pd=10.72 as=1.4703 ps=10.72 w=5.07 l=1
X35 v3_channel_input_bias_late_promotion_0/a_6070_19422# ref v3_channel_input_bias_late_promotion_0/a_5774_17688# VGND sky130_fd_pr__nfet_01v8 ad=0.2436 pd=2.26 as=0.2436 ps=2.26 w=0.84 l=0.6
X36 VGND VGND VGND VGND sky130_fd_pr__nfet_01v8 ad=1.4703 pd=10.72 as=0 ps=0 w=5.07 l=1
X37 row_outp v3_selector_route_pilot_0/group1_lo_p v3_channel_input_bias_late_promotion_0/a_4254_14978# VGND sky130_fd_pr__nfet_01v8 ad=0.1885 pd=1.88 as=0.1885 ps=1.88 w=0.65 l=0.15
X38 v3_channel_input_bias_late_promotion_0/a_6070_19422# v3_selector_route_pilot_0/group3_lo_p row_outn VGND sky130_fd_pr__nfet_01v8 ad=0.1885 pd=1.88 as=0.1885 ps=1.88 w=0.65 l=0.15
X39 VGND VGND VGND VGND sky130_fd_pr__nfet_01v8 ad=0.1885 pd=1.88 as=0 ps=0 w=0.65 l=0.15
X40 v3_channel_input_bias_late_promotion_0/a_5824_10978# vbias VGND VGND sky130_fd_pr__nfet_01v8 ad=1.4703 pd=10.72 as=1.4703 ps=10.72 w=5.07 l=1
X41 v3_channel_input_bias_late_promotion_0/a_4382_13688# element_input v3_channel_input_bias_late_promotion_0/a_4254_14978# VGND sky130_fd_pr__nfet_01v8 ad=0.2436 pd=2.26 as=0.2436 ps=2.26 w=0.84 l=0.6
X42 v3_channel_input_bias_late_promotion_0/a_4678_15422# v3_selector_route_pilot_0/group1_lo_n row_outp VGND sky130_fd_pr__nfet_01v8 ad=0.1885 pd=1.88 as=0.1885 ps=1.88 w=0.65 l=0.15
X43 row_outn v3_selector_route_pilot_0/group2_lo_n v3_channel_input_bias_late_promotion_0/a_4254_18978# VGND sky130_fd_pr__nfet_01v8 ad=0.1885 pd=1.88 as=0.1885 ps=1.88 w=0.65 l=0.15
X44 row_outp v3_selector_route_pilot_0/group3_lo_n v3_channel_input_bias_late_promotion_0/a_5646_10978# VGND sky130_fd_pr__nfet_01v8 ad=0.1885 pd=1.88 as=0.1885 ps=1.88 w=0.65 l=0.15
X45 row_outp v3_selector_route_pilot_0/group1_lo_n v3_channel_input_bias_late_promotion_0/a_7038_14978# VGND sky130_fd_pr__nfet_01v8 ad=0.1885 pd=1.88 as=0.1885 ps=1.88 w=0.65 l=0.15
X46 v3_channel_input_bias_late_promotion_0/a_7462_19422# v3_selector_route_pilot_0/group2_lo_n row_outp VGND sky130_fd_pr__nfet_01v8 ad=0.1885 pd=1.88 as=0.1885 ps=1.88 w=0.65 l=0.15
X47 v3_channel_input_bias_late_promotion_0/a_4678_7422# v3_selector_route_pilot_0/group3_lo_p row_outp VGND sky130_fd_pr__nfet_01v8 ad=0.1885 pd=1.88 as=0.1885 ps=1.88 w=0.65 l=0.15
X48 v3_channel_input_bias_late_promotion_0/a_6070_11422# v3_selector_route_pilot_0/group3_lo_p row_outp VGND sky130_fd_pr__nfet_01v8 ad=0.1885 pd=1.88 as=0.1885 ps=1.88 w=0.65 l=0.15
X49 v3_channel_input_bias_late_promotion_0/a_7216_10978# vbias VGND VGND sky130_fd_pr__nfet_01v8 ad=1.4703 pd=10.72 as=1.4703 ps=10.72 w=5.07 l=1
X50 v3_channel_input_bias_late_promotion_0/a_7216_14978# ref v3_channel_input_bias_late_promotion_0/a_7038_14978# VGND sky130_fd_pr__nfet_01v8 ad=0.2436 pd=2.26 as=0.2436 ps=2.26 w=0.84 l=0.6
X51 v3_channel_input_bias_late_promotion_0/a_4678_19422# ref v3_channel_input_bias_late_promotion_0/a_4382_17688# VGND sky130_fd_pr__nfet_01v8 ad=0.2436 pd=2.26 as=0.2436 ps=2.26 w=0.84 l=0.6
X52 v3_channel_input_bias_late_promotion_0/a_4678_19422# v3_selector_route_pilot_0/group2_lo_p row_outn VGND sky130_fd_pr__nfet_01v8 ad=0.1885 pd=1.88 as=0.1885 ps=1.88 w=0.65 l=0.15
X53 row_outn v3_selector_route_pilot_0/group0_lo_n v3_channel_input_bias_late_promotion_0/a_5646_14978# VGND sky130_fd_pr__nfet_01v8 ad=0.1885 pd=1.88 as=0.1885 ps=1.88 w=0.65 l=0.15
X54 row_outn v3_selector_route_pilot_0/group2_lo_n v3_channel_input_bias_late_promotion_0/a_7038_18978# VGND sky130_fd_pr__nfet_01v8 ad=0.1885 pd=1.88 as=0.1885 ps=1.88 w=0.65 l=0.15
X55 v3_channel_input_bias_late_promotion_0/a_7462_7422# v3_selector_route_pilot_0/group3_lo_p row_outp VGND sky130_fd_pr__nfet_01v8 ad=0.1885 pd=1.88 as=0.1885 ps=1.88 w=0.65 l=0.15
X56 VGND vbias v3_channel_input_bias_late_promotion_0/a_7166_21688# VGND sky130_fd_pr__nfet_01v8 ad=1.4703 pd=10.72 as=1.4703 ps=10.72 w=5.07 l=1
X57 v3_channel_input_bias_late_promotion_0/a_6070_15422# ref v3_channel_input_bias_late_promotion_0/a_5774_13688# VGND sky130_fd_pr__nfet_01v8 ad=0.2436 pd=2.26 as=0.2436 ps=2.26 w=0.84 l=0.6
X58 row_outp v3_selector_route_pilot_0/group2_lo_n v3_channel_input_bias_late_promotion_0/a_4254_10978# VGND sky130_fd_pr__nfet_01v8 ad=0.1885 pd=1.88 as=0.1885 ps=1.88 w=0.65 l=0.15
X59 v3_channel_input_bias_late_promotion_0/a_6070_15422# v3_selector_route_pilot_0/group0_lo_p row_outn VGND sky130_fd_pr__nfet_01v8 ad=0.1885 pd=1.88 as=0.1885 ps=1.88 w=0.65 l=0.15
X60 v3_channel_input_bias_late_promotion_0/a_5824_6978# ref v3_channel_input_bias_late_promotion_0/a_5646_6978# VGND sky130_fd_pr__nfet_01v8 ad=0.2436 pd=2.26 as=0.2436 ps=2.26 w=0.84 l=0.6
X61 v3_channel_input_bias_late_promotion_0/a_5774_17688# element_input v3_channel_input_bias_late_promotion_0/a_5646_18978# VGND sky130_fd_pr__nfet_01v8 ad=0.2436 pd=2.26 as=0.2436 ps=2.26 w=0.84 l=0.6
X62 row_outp v3_selector_route_pilot_0/group3_lo_p v3_channel_input_bias_late_promotion_0/a_5646_22978# VGND sky130_fd_pr__nfet_01v8 ad=0.1885 pd=1.88 as=0.1885 ps=1.88 w=0.65 l=0.15
X63 v3_channel_input_bias_late_promotion_0/a_5824_6978# vbias VGND VGND sky130_fd_pr__nfet_01v8 ad=1.4703 pd=10.72 as=1.4703 ps=10.72 w=5.07 l=1
X64 v3_channel_input_bias_late_promotion_0/a_4432_10978# ref v3_channel_input_bias_late_promotion_0/a_4254_10978# VGND sky130_fd_pr__nfet_01v8 ad=0.2436 pd=2.26 as=0.2436 ps=2.26 w=0.84 l=0.6
X65 v3_channel_input_bias_late_promotion_0/a_4678_11422# v3_selector_route_pilot_0/group2_lo_p row_outp VGND sky130_fd_pr__nfet_01v8 ad=0.1885 pd=1.88 as=0.1885 ps=1.88 w=0.65 l=0.15
X66 v3_channel_input_bias_late_promotion_0/a_6070_23422# v3_selector_route_pilot_0/group3_lo_n row_outp VGND sky130_fd_pr__nfet_01v8 ad=0.1885 pd=1.88 as=0.1885 ps=1.88 w=0.65 l=0.15
X67 row_outn v3_selector_route_pilot_0/group1_lo_n v3_channel_input_bias_late_promotion_0/a_4254_14978# VGND sky130_fd_pr__nfet_01v8 ad=0.1885 pd=1.88 as=0.1885 ps=1.88 w=0.65 l=0.15
X68 row_outp v3_selector_route_pilot_0/group2_lo_n v3_channel_input_bias_late_promotion_0/a_7038_10978# VGND sky130_fd_pr__nfet_01v8 ad=0.1885 pd=1.88 as=0.1885 ps=1.88 w=0.65 l=0.15
X69 v3_channel_input_bias_late_promotion_0/a_7462_15422# v3_selector_route_pilot_0/group1_lo_p row_outp VGND sky130_fd_pr__nfet_01v8 ad=0.1885 pd=1.88 as=0.1885 ps=1.88 w=0.65 l=0.15
X70 VGND VGND VGND VGND sky130_fd_pr__nfet_01v8 ad=1.4703 pd=10.72 as=0 ps=0 w=5.07 l=1
X71 v3_channel_input_bias_late_promotion_0/a_7216_6978# vbias VGND VGND sky130_fd_pr__nfet_01v8 ad=1.4703 pd=10.72 as=1.4703 ps=10.72 w=5.07 l=1
X72 v3_channel_input_bias_late_promotion_0/a_7216_10978# ref v3_channel_input_bias_late_promotion_0/a_7038_10978# VGND sky130_fd_pr__nfet_01v8 ad=0.2436 pd=2.26 as=0.2436 ps=2.26 w=0.84 l=0.6
X73 v3_channel_input_bias_late_promotion_0/a_4678_15422# ref v3_channel_input_bias_late_promotion_0/a_4382_13688# VGND sky130_fd_pr__nfet_01v8 ad=0.2436 pd=2.26 as=0.2436 ps=2.26 w=0.84 l=0.6
X74 v3_channel_input_bias_late_promotion_0/a_4678_15422# v3_selector_route_pilot_0/group1_lo_p row_outn VGND sky130_fd_pr__nfet_01v8 ad=0.1885 pd=1.88 as=0.1885 ps=1.88 w=0.65 l=0.15
X75 row_outp v3_selector_route_pilot_0/group3_lo_p v3_channel_input_bias_late_promotion_0/a_4254_22978# VGND sky130_fd_pr__nfet_01v8 ad=0.1885 pd=1.88 as=0.1885 ps=1.88 w=0.65 l=0.15
X76 v3_channel_input_bias_late_promotion_0/a_7462_19422# ref v3_channel_input_bias_late_promotion_0/a_7166_17688# VGND sky130_fd_pr__nfet_01v8 ad=0.2436 pd=2.26 as=0.2436 ps=2.26 w=0.84 l=0.6
X77 row_outn v3_selector_route_pilot_0/group3_lo_p v3_channel_input_bias_late_promotion_0/a_5646_10978# VGND sky130_fd_pr__nfet_01v8 ad=0.1885 pd=1.88 as=0.1885 ps=1.88 w=0.65 l=0.15
X78 row_outn v3_selector_route_pilot_0/group1_lo_p v3_channel_input_bias_late_promotion_0/a_7038_14978# VGND sky130_fd_pr__nfet_01v8 ad=0.1885 pd=1.88 as=0.1885 ps=1.88 w=0.65 l=0.15
X79 v3_channel_input_bias_late_promotion_0/a_7462_19422# v3_selector_route_pilot_0/group2_lo_p row_outn VGND sky130_fd_pr__nfet_01v8 ad=0.1885 pd=1.88 as=0.1885 ps=1.88 w=0.65 l=0.15
X80 v3_channel_input_bias_late_promotion_0/a_4678_7422# element_input v3_channel_input_bias_late_promotion_0/a_4432_6978# VGND sky130_fd_pr__nfet_01v8 ad=0.2436 pd=2.26 as=0.2436 ps=2.26 w=0.84 l=0.6
X81 row_outp v3_selector_route_pilot_0/group3_lo_n v3_channel_input_bias_late_promotion_0/a_5646_6978# VGND sky130_fd_pr__nfet_01v8 ad=0.1885 pd=1.88 as=0.1885 ps=1.88 w=0.65 l=0.15
X82 v3_channel_input_bias_late_promotion_0/a_4678_7422# v3_selector_route_pilot_0/group3_lo_n row_outn VGND sky130_fd_pr__nfet_01v8 ad=0.1885 pd=1.88 as=0.1885 ps=1.88 w=0.65 l=0.15
X83 v3_channel_input_bias_late_promotion_0/a_6070_11422# element_input v3_channel_input_bias_late_promotion_0/a_5824_10978# VGND sky130_fd_pr__nfet_01v8 ad=0.2436 pd=2.26 as=0.2436 ps=2.26 w=0.84 l=0.6
X84 v3_channel_input_bias_late_promotion_0/a_6070_11422# v3_selector_route_pilot_0/group3_lo_n row_outn VGND sky130_fd_pr__nfet_01v8 ad=0.1885 pd=1.88 as=0.1885 ps=1.88 w=0.65 l=0.15
X85 v3_channel_input_bias_late_promotion_0/a_4382_21688# element_input v3_channel_input_bias_late_promotion_0/a_4254_22978# VGND sky130_fd_pr__nfet_01v8 ad=0.2436 pd=2.26 as=0.2436 ps=2.26 w=0.84 l=0.6
X86 v3_channel_input_bias_late_promotion_0/a_4678_23422# v3_selector_route_pilot_0/group3_lo_n row_outp VGND sky130_fd_pr__nfet_01v8 ad=0.1885 pd=1.88 as=0.1885 ps=1.88 w=0.65 l=0.15
X87 row_outp v3_selector_route_pilot_0/group3_lo_n v3_channel_input_bias_late_promotion_0/a_4254_6978# VGND sky130_fd_pr__nfet_01v8 ad=0.1885 pd=1.88 as=0.1885 ps=1.88 w=0.65 l=0.15
X88 v3_channel_input_bias_late_promotion_0/a_5774_13688# element_input v3_channel_input_bias_late_promotion_0/a_5646_14978# VGND sky130_fd_pr__nfet_01v8 ad=0.2436 pd=2.26 as=0.2436 ps=2.26 w=0.84 l=0.6
X89 row_outp v3_selector_route_pilot_0/group3_lo_p v3_channel_input_bias_late_promotion_0/a_7038_22978# VGND sky130_fd_pr__nfet_01v8 ad=0.1885 pd=1.88 as=0.1885 ps=1.88 w=0.65 l=0.15
X90 v3_channel_input_bias_late_promotion_0/a_7462_7422# element_input v3_channel_input_bias_late_promotion_0/a_7216_6978# VGND sky130_fd_pr__nfet_01v8 ad=0.2436 pd=2.26 as=0.2436 ps=2.26 w=0.84 l=0.6
X91 v3_channel_input_bias_late_promotion_0/a_4432_10978# vbias VGND VGND sky130_fd_pr__nfet_01v8 ad=1.4703 pd=10.72 as=1.4703 ps=10.72 w=5.07 l=1
X92 v3_channel_input_bias_late_promotion_0/a_7462_7422# v3_selector_route_pilot_0/group3_lo_n row_outn VGND sky130_fd_pr__nfet_01v8 ad=0.1885 pd=1.88 as=0.1885 ps=1.88 w=0.65 l=0.15
X93 VGND vbias v3_channel_input_bias_late_promotion_0/a_4382_17688# VGND sky130_fd_pr__nfet_01v8 ad=1.4703 pd=10.72 as=1.4703 ps=10.72 w=5.07 l=1
X94 row_outp v3_selector_route_pilot_0/group3_lo_n v3_channel_input_bias_late_promotion_0/a_7038_6978# VGND sky130_fd_pr__nfet_01v8 ad=0.1885 pd=1.88 as=0.1885 ps=1.88 w=0.65 l=0.15
X95 row_outn v3_selector_route_pilot_0/group2_lo_p v3_channel_input_bias_late_promotion_0/a_4254_10978# VGND sky130_fd_pr__nfet_01v8 ad=0.1885 pd=1.88 as=0.1885 ps=1.88 w=0.65 l=0.15
X96 v3_channel_input_bias_late_promotion_0/a_7462_11422# v3_selector_route_pilot_0/group2_lo_p row_outp VGND sky130_fd_pr__nfet_01v8 ad=0.1885 pd=1.88 as=0.1885 ps=1.88 w=0.65 l=0.15
X97 v3_channel_input_bias_late_promotion_0/a_7166_21688# element_input v3_channel_input_bias_late_promotion_0/a_7038_22978# VGND sky130_fd_pr__nfet_01v8 ad=0.2436 pd=2.26 as=0.2436 ps=2.26 w=0.84 l=0.6
X98 row_outn v3_selector_route_pilot_0/group3_lo_n v3_channel_input_bias_late_promotion_0/a_5646_22978# VGND sky130_fd_pr__nfet_01v8 ad=0.1885 pd=1.88 as=0.1885 ps=1.88 w=0.65 l=0.15
X99 v3_channel_input_bias_late_promotion_0/a_4678_11422# element_input v3_channel_input_bias_late_promotion_0/a_4432_10978# VGND sky130_fd_pr__nfet_01v8 ad=0.2436 pd=2.26 as=0.2436 ps=2.26 w=0.84 l=0.6
X100 v3_channel_input_bias_late_promotion_0/a_6070_23422# ref v3_channel_input_bias_late_promotion_0/a_5774_21688# VGND sky130_fd_pr__nfet_01v8 ad=0.2436 pd=2.26 as=0.2436 ps=2.26 w=0.84 l=0.6
X101 v3_channel_input_bias_late_promotion_0/a_6070_23422# v3_selector_route_pilot_0/group3_lo_p row_outn VGND sky130_fd_pr__nfet_01v8 ad=0.1885 pd=1.88 as=0.1885 ps=1.88 w=0.65 l=0.15
X102 v3_channel_input_bias_late_promotion_0/a_4678_11422# v3_selector_route_pilot_0/group2_lo_n row_outn VGND sky130_fd_pr__nfet_01v8 ad=0.1885 pd=1.88 as=0.1885 ps=1.88 w=0.65 l=0.15
X103 v3_channel_input_bias_late_promotion_0/a_7462_15422# element_input v3_channel_input_bias_late_promotion_0/a_7216_14978# VGND sky130_fd_pr__nfet_01v8 ad=0.2436 pd=2.26 as=0.2436 ps=2.26 w=0.84 l=0.6
X104 v3_channel_input_bias_late_promotion_0/a_6070_7422# v3_selector_route_pilot_0/group3_lo_p row_outp VGND sky130_fd_pr__nfet_01v8 ad=0.1885 pd=1.88 as=0.1885 ps=1.88 w=0.65 l=0.15
X105 row_outn v3_selector_route_pilot_0/group2_lo_p v3_channel_input_bias_late_promotion_0/a_7038_10978# VGND sky130_fd_pr__nfet_01v8 ad=0.1885 pd=1.88 as=0.1885 ps=1.88 w=0.65 l=0.15
X106 v3_channel_input_bias_late_promotion_0/a_7462_15422# v3_selector_route_pilot_0/group1_lo_n row_outn VGND sky130_fd_pr__nfet_01v8 ad=0.1885 pd=1.88 as=0.1885 ps=1.88 w=0.65 l=0.15
X107 v3_channel_input_bias_late_promotion_0/a_4432_6978# ref v3_channel_input_bias_late_promotion_0/a_4254_6978# VGND sky130_fd_pr__nfet_01v8 ad=0.2436 pd=2.26 as=0.2436 ps=2.26 w=0.84 l=0.6
X108 v3_channel_input_bias_late_promotion_0/a_5824_10978# ref v3_channel_input_bias_late_promotion_0/a_5646_10978# VGND sky130_fd_pr__nfet_01v8 ad=0.2436 pd=2.26 as=0.2436 ps=2.26 w=0.84 l=0.6
X109 row_outn v3_selector_route_pilot_0/group3_lo_n v3_channel_input_bias_late_promotion_0/a_4254_22978# VGND sky130_fd_pr__nfet_01v8 ad=0.1885 pd=1.88 as=0.1885 ps=1.88 w=0.65 l=0.15
X110 v3_channel_input_bias_late_promotion_0/a_7462_23422# v3_selector_route_pilot_0/group3_lo_n row_outp VGND sky130_fd_pr__nfet_01v8 ad=0.1885 pd=1.88 as=0.1885 ps=1.88 w=0.65 l=0.15
X111 v3_channel_input_bias_late_promotion_0/a_4432_6978# vbias VGND VGND sky130_fd_pr__nfet_01v8 ad=1.4703 pd=10.72 as=1.4703 ps=10.72 w=5.07 l=1
X112 v3_channel_input_bias_late_promotion_0/a_7216_6978# ref v3_channel_input_bias_late_promotion_0/a_7038_6978# VGND sky130_fd_pr__nfet_01v8 ad=0.2436 pd=2.26 as=0.2436 ps=2.26 w=0.84 l=0.6
X113 row_outn v3_selector_route_pilot_0/group3_lo_p v3_channel_input_bias_late_promotion_0/a_5646_6978# VGND sky130_fd_pr__nfet_01v8 ad=0.1885 pd=1.88 as=0.1885 ps=1.88 w=0.65 l=0.15
X114 VGND vbias v3_channel_input_bias_late_promotion_0/a_4382_13688# VGND sky130_fd_pr__nfet_01v8 ad=1.4703 pd=10.72 as=1.4703 ps=10.72 w=5.07 l=1
X115 VPWR v3_selector_route_pilot_0/G1_MUX_POS/a_505_21# v3_selector_route_pilot_0/G1_MUX_POS/a_535_374# VPWR sky130_fd_pr__pfet_01v8_hvt ad=0.0693 pd=0.75 as=0.0441 ps=0.63 w=0.42 l=0.15
X116 v3_selector_route_pilot_0/G1_MUX_POS/a_505_21# group1_bit0 VPWR VPWR sky130_fd_pr__pfet_01v8_hvt ad=0.1176 pd=1.4 as=0.0693 ps=0.75 w=0.42 l=0.15
X117 v3_selector_route_pilot_0/G1_MUX_POS/a_218_374# group1_bit0 VPWR VPWR sky130_fd_pr__pfet_01v8_hvt ad=0.07665 pd=0.785 as=0.15835 ps=1.395 w=0.42 l=0.15
X118 VGND v3_selector_route_pilot_0/G1_MUX_POS/a_505_21# v3_selector_route_pilot_0/G1_MUX_POS/a_439_47# VGND sky130_fd_pr__nfet_01v8 ad=0.1449 pd=1.11 as=0.0693 ps=0.75 w=0.42 l=0.15
X119 v3_selector_route_pilot_0/G1_MUX_POS/a_76_199# phase_0 v3_selector_route_pilot_0/G1_MUX_POS/a_218_374# VPWR sky130_fd_pr__pfet_01v8_hvt ad=0.1932 pd=1.34 as=0.07665 ps=0.785 w=0.42 l=0.15
X120 v3_selector_route_pilot_0/G1_MUX_POS/a_505_21# group1_bit0 VGND VGND sky130_fd_pr__nfet_01v8 ad=0.1092 pd=1.36 as=0.1449 ps=1.11 w=0.42 l=0.15
X121 v3_selector_route_pilot_0/G1_MUX_POS/a_439_47# phase_0 v3_selector_route_pilot_0/G1_MUX_POS/a_76_199# VGND sky130_fd_pr__nfet_01v8 ad=0.0693 pd=0.75 as=0.09975 ps=0.895 w=0.42 l=0.15
X122 v3_selector_route_pilot_0/G1_MUX_POS/a_535_374# phase_90 v3_selector_route_pilot_0/G1_MUX_POS/a_76_199# VPWR sky130_fd_pr__pfet_01v8_hvt ad=0.0441 pd=0.63 as=0.1932 ps=1.34 w=0.42 l=0.15
X123 v3_selector_route_pilot_0/G1_MUX_POS/a_76_199# phase_90 v3_selector_route_pilot_0/G1_MUX_POS/a_218_47# VGND sky130_fd_pr__nfet_01v8 ad=0.09975 pd=0.895 as=0.0693 ps=0.75 w=0.42 l=0.15
X124 v3_selector_route_pilot_0/G1_MUX_POS/a_218_47# group1_bit0 VGND VGND sky130_fd_pr__nfet_01v8 ad=0.0693 pd=0.75 as=0.11285 ps=1.045 w=0.42 l=0.15
X125 VPWR v3_selector_route_pilot_0/G1_MUX_POS/a_76_199# v3_selector_route_pilot_0/G1_MUX_POS/X VPWR sky130_fd_pr__pfet_01v8_hvt ad=0.15835 pd=1.395 as=0.26 ps=2.52 w=1 l=0.15
X126 VGND v3_selector_route_pilot_0/G1_MUX_POS/a_76_199# v3_selector_route_pilot_0/G1_MUX_POS/X VGND sky130_fd_pr__nfet_01v8 ad=0.11285 pd=1.045 as=0.169 ps=1.82 w=0.65 l=0.15
X127 VPWR v3_selector_route_pilot_0/G3_MUX_AXIS/a_505_21# v3_selector_route_pilot_0/G3_MUX_AXIS/a_535_374# VPWR sky130_fd_pr__pfet_01v8_hvt ad=10.2594 pd=93.2 as=0.0882 ps=1.26 w=0.42 l=0.15
X128 v3_selector_route_pilot_0/G3_MUX_AXIS/a_505_21# group3_bit1 VPWR VPWR sky130_fd_pr__pfet_01v8_hvt ad=0.1176 pd=1.4 as=0 ps=0 w=0.42 l=0.15
X129 v3_selector_route_pilot_0/G3_MUX_AXIS/a_218_374# group3_bit1 VPWR VPWR sky130_fd_pr__pfet_01v8_hvt ad=0.1533 pd=1.57 as=0 ps=0 w=0.42 l=0.15
X130 VGND v3_selector_route_pilot_0/G3_MUX_AXIS/a_505_21# v3_selector_route_pilot_0/G3_MUX_AXIS/a_439_47# VGND sky130_fd_pr__nfet_01v8 ad=0 pd=0 as=0.1386 ps=1.5 w=0.42 l=0.15
X131 v3_selector_route_pilot_0/G3_MUX_AXIS/a_76_199# v3_selector_route_pilot_0/G3_MUX_POS/X v3_selector_route_pilot_0/G3_MUX_AXIS/a_218_374# VPWR sky130_fd_pr__pfet_01v8_hvt ad=0.3864 pd=2.68 as=0 ps=0 w=0.42 l=0.15
X132 v3_selector_route_pilot_0/G3_MUX_AXIS/a_505_21# group3_bit1 VGND VGND sky130_fd_pr__nfet_01v8 ad=0.1092 pd=1.36 as=0 ps=0 w=0.42 l=0.15
X133 v3_selector_route_pilot_0/G3_MUX_AXIS/a_439_47# v3_selector_route_pilot_0/G3_MUX_POS/X v3_selector_route_pilot_0/G3_MUX_AXIS/a_76_199# VGND sky130_fd_pr__nfet_01v8 ad=0 pd=0 as=0.1995 ps=1.79 w=0.42 l=0.15
X134 v3_selector_route_pilot_0/G3_MUX_AXIS/a_535_374# v3_selector_route_pilot_0/G3_MUX_NEG/X v3_selector_route_pilot_0/G3_MUX_AXIS/a_76_199# VPWR sky130_fd_pr__pfet_01v8_hvt ad=0 pd=0 as=0 ps=0 w=0.42 l=0.15
X135 v3_selector_route_pilot_0/G3_MUX_AXIS/a_76_199# v3_selector_route_pilot_0/G3_MUX_NEG/X v3_selector_route_pilot_0/G3_MUX_AXIS/a_218_47# VGND sky130_fd_pr__nfet_01v8 ad=0 pd=0 as=0.1386 ps=1.5 w=0.42 l=0.15
X136 v3_selector_route_pilot_0/G3_MUX_AXIS/a_218_47# group3_bit1 VGND VGND sky130_fd_pr__nfet_01v8 ad=0 pd=0 as=0 ps=0 w=0.42 l=0.15
X137 VPWR v3_selector_route_pilot_0/G3_MUX_AXIS/a_76_199# v3_selector_route_pilot_0/G3_MUX_AXIS/X VPWR sky130_fd_pr__pfet_01v8_hvt ad=0 pd=0 as=0.26 ps=2.52 w=1 l=0.15
X138 VGND v3_selector_route_pilot_0/G3_MUX_AXIS/a_76_199# v3_selector_route_pilot_0/G3_MUX_AXIS/X VGND sky130_fd_pr__nfet_01v8 ad=0 pd=0 as=0.169 ps=1.82 w=0.65 l=0.15
X139 VPWR channel_enable v3_selector_route_pilot_0/ENABLE_ANDNOT/a_207_413# VPWR sky130_fd_pr__pfet_01v8_hvt ad=0.2279 pd=1.74 as=0.0609 ps=0.71 w=0.42 l=0.15
X140 v3_selector_route_pilot_0/G3_LO_P_AND/B v3_selector_route_pilot_0/ENABLE_ANDNOT/a_207_413# VPWR VPWR sky130_fd_pr__pfet_01v8_hvt ad=0.26 pd=2.52 as=0.2279 ps=1.74 w=1 l=0.15
X141 v3_selector_route_pilot_0/ENABLE_ANDNOT/a_297_47# v3_selector_route_pilot_0/ENABLE_ANDNOT/a_27_413# v3_selector_route_pilot_0/ENABLE_ANDNOT/a_207_413# VGND sky130_fd_pr__nfet_01v8 ad=0.0504 pd=0.66 as=0.1092 ps=1.36 w=0.42 l=0.15
X142 v3_selector_route_pilot_0/G3_LO_P_AND/B v3_selector_route_pilot_0/ENABLE_ANDNOT/a_207_413# VGND VGND sky130_fd_pr__nfet_01v8 ad=0.169 pd=1.82 as=0.1013 ps=0.99 w=0.65 l=0.15
X143 v3_selector_route_pilot_0/ENABLE_ANDNOT/a_207_413# v3_selector_route_pilot_0/ENABLE_ANDNOT/a_27_413# VPWR VPWR sky130_fd_pr__pfet_01v8_hvt ad=0.0609 pd=0.71 as=0.0714 ps=0.76 w=0.42 l=0.15
X144 VPWR mixers_blank v3_selector_route_pilot_0/ENABLE_ANDNOT/a_27_413# VPWR sky130_fd_pr__pfet_01v8_hvt ad=0.0714 pd=0.76 as=0.1092 ps=1.36 w=0.42 l=0.15
X145 VGND channel_enable v3_selector_route_pilot_0/ENABLE_ANDNOT/a_297_47# VGND sky130_fd_pr__nfet_01v8 ad=0.1013 pd=0.99 as=0.0504 ps=0.66 w=0.42 l=0.15
X146 v3_selector_route_pilot_0/ENABLE_ANDNOT/a_27_413# mixers_blank VGND VGND sky130_fd_pr__nfet_01v8 ad=0.1092 pd=1.36 as=0.1092 ps=1.36 w=0.42 l=0.15
X147 VPWR v3_selector_route_pilot_0/G1_MUX_NEG/a_505_21# v3_selector_route_pilot_0/G1_MUX_NEG/a_535_374# VPWR sky130_fd_pr__pfet_01v8_hvt ad=0 pd=0 as=0.0882 ps=1.26 w=0.42 l=0.15
X148 v3_selector_route_pilot_0/G1_MUX_NEG/a_505_21# group1_bit0 VPWR VPWR sky130_fd_pr__pfet_01v8_hvt ad=0.1176 pd=1.4 as=0 ps=0 w=0.42 l=0.15
X149 v3_selector_route_pilot_0/G1_MUX_NEG/a_218_374# group1_bit0 VPWR VPWR sky130_fd_pr__pfet_01v8_hvt ad=0.1533 pd=1.57 as=0 ps=0 w=0.42 l=0.15
X150 VGND v3_selector_route_pilot_0/G1_MUX_NEG/a_505_21# v3_selector_route_pilot_0/G1_MUX_NEG/a_439_47# VGND sky130_fd_pr__nfet_01v8 ad=0 pd=0 as=0.1386 ps=1.5 w=0.42 l=0.15
X151 v3_selector_route_pilot_0/G1_MUX_NEG/a_76_199# phase_180 v3_selector_route_pilot_0/G1_MUX_NEG/a_218_374# VPWR sky130_fd_pr__pfet_01v8_hvt ad=0.3864 pd=2.68 as=0 ps=0 w=0.42 l=0.15
X152 v3_selector_route_pilot_0/G1_MUX_NEG/a_505_21# group1_bit0 VGND VGND sky130_fd_pr__nfet_01v8 ad=0.1092 pd=1.36 as=0 ps=0 w=0.42 l=0.15
X153 v3_selector_route_pilot_0/G1_MUX_NEG/a_439_47# phase_180 v3_selector_route_pilot_0/G1_MUX_NEG/a_76_199# VGND sky130_fd_pr__nfet_01v8 ad=0 pd=0 as=0.1995 ps=1.79 w=0.42 l=0.15
X154 v3_selector_route_pilot_0/G1_MUX_NEG/a_535_374# phase_270 v3_selector_route_pilot_0/G1_MUX_NEG/a_76_199# VPWR sky130_fd_pr__pfet_01v8_hvt ad=0 pd=0 as=0 ps=0 w=0.42 l=0.15
X155 v3_selector_route_pilot_0/G1_MUX_NEG/a_76_199# phase_270 v3_selector_route_pilot_0/G1_MUX_NEG/a_218_47# VGND sky130_fd_pr__nfet_01v8 ad=0 pd=0 as=0.1386 ps=1.5 w=0.42 l=0.15
X156 v3_selector_route_pilot_0/G1_MUX_NEG/a_218_47# group1_bit0 VGND VGND sky130_fd_pr__nfet_01v8 ad=0 pd=0 as=0 ps=0 w=0.42 l=0.15
X157 VPWR v3_selector_route_pilot_0/G1_MUX_NEG/a_76_199# v3_selector_route_pilot_0/G1_MUX_NEG/X VPWR sky130_fd_pr__pfet_01v8_hvt ad=0 pd=0 as=0.26 ps=2.52 w=1 l=0.15
X158 VGND v3_selector_route_pilot_0/G1_MUX_NEG/a_76_199# v3_selector_route_pilot_0/G1_MUX_NEG/X VGND sky130_fd_pr__nfet_01v8 ad=0 pd=0 as=0.169 ps=1.82 w=0.65 l=0.15
X159 VPWR v3_selector_route_pilot_0/G3_LO_P_AND/B v3_selector_route_pilot_0/G1_LO_P_AND/a_59_75# VPWR sky130_fd_pr__pfet_01v8_hvt ad=0.16655 pd=1.39 as=0.0567 ps=0.69 w=0.42 l=0.15
X160 v3_selector_route_pilot_0/group1_lo_p v3_selector_route_pilot_0/G1_LO_P_AND/a_59_75# VPWR VPWR sky130_fd_pr__pfet_01v8_hvt ad=0.475 pd=2.95 as=0.16655 ps=1.39 w=1 l=0.15
X161 VGND v3_selector_route_pilot_0/G3_LO_P_AND/B v3_selector_route_pilot_0/G1_LO_P_AND/a_145_75# VGND sky130_fd_pr__nfet_01v8 ad=0.1118 pd=1.04 as=0.0567 ps=0.69 w=0.42 l=0.15
X162 v3_selector_route_pilot_0/G1_LO_P_AND/a_59_75# v3_selector_route_pilot_0/G1_MUX_AXIS/X VPWR VPWR sky130_fd_pr__pfet_01v8_hvt ad=0.0567 pd=0.69 as=0.1176 ps=1.4 w=0.42 l=0.15
X163 v3_selector_route_pilot_0/group1_lo_p v3_selector_route_pilot_0/G1_LO_P_AND/a_59_75# VGND VGND sky130_fd_pr__nfet_01v8 ad=0.182 pd=1.86 as=0.1118 ps=1.04 w=0.65 l=0.15
X164 v3_selector_route_pilot_0/G1_LO_P_AND/a_145_75# v3_selector_route_pilot_0/G1_MUX_AXIS/X v3_selector_route_pilot_0/G1_LO_P_AND/a_59_75# VGND sky130_fd_pr__nfet_01v8 ad=0.0567 pd=0.69 as=0.1176 ps=1.4 w=0.42 l=0.15
X165 VPWR v3_selector_route_pilot_0/G0_MUX_POS/a_505_21# v3_selector_route_pilot_0/G0_MUX_POS/a_535_374# VPWR sky130_fd_pr__pfet_01v8_hvt ad=0 pd=0 as=0.0882 ps=1.26 w=0.42 l=0.15
X166 v3_selector_route_pilot_0/G0_MUX_POS/a_505_21# group0_bit0 VPWR VPWR sky130_fd_pr__pfet_01v8_hvt ad=0.1176 pd=1.4 as=0 ps=0 w=0.42 l=0.15
X167 v3_selector_route_pilot_0/G0_MUX_POS/a_218_374# group0_bit0 VPWR VPWR sky130_fd_pr__pfet_01v8_hvt ad=0.1533 pd=1.57 as=0 ps=0 w=0.42 l=0.15
X168 VGND v3_selector_route_pilot_0/G0_MUX_POS/a_505_21# v3_selector_route_pilot_0/G0_MUX_POS/a_439_47# VGND sky130_fd_pr__nfet_01v8 ad=0 pd=0 as=0.1386 ps=1.5 w=0.42 l=0.15
X169 v3_selector_route_pilot_0/G0_MUX_POS/a_76_199# phase_0 v3_selector_route_pilot_0/G0_MUX_POS/a_218_374# VPWR sky130_fd_pr__pfet_01v8_hvt ad=0.3864 pd=2.68 as=0 ps=0 w=0.42 l=0.15
X170 v3_selector_route_pilot_0/G0_MUX_POS/a_505_21# group0_bit0 VGND VGND sky130_fd_pr__nfet_01v8 ad=0.1092 pd=1.36 as=0 ps=0 w=0.42 l=0.15
X171 v3_selector_route_pilot_0/G0_MUX_POS/a_439_47# phase_0 v3_selector_route_pilot_0/G0_MUX_POS/a_76_199# VGND sky130_fd_pr__nfet_01v8 ad=0 pd=0 as=0.1995 ps=1.79 w=0.42 l=0.15
X172 v3_selector_route_pilot_0/G0_MUX_POS/a_535_374# phase_90 v3_selector_route_pilot_0/G0_MUX_POS/a_76_199# VPWR sky130_fd_pr__pfet_01v8_hvt ad=0 pd=0 as=0 ps=0 w=0.42 l=0.15
X173 v3_selector_route_pilot_0/G0_MUX_POS/a_76_199# phase_90 v3_selector_route_pilot_0/G0_MUX_POS/a_218_47# VGND sky130_fd_pr__nfet_01v8 ad=0 pd=0 as=0.1386 ps=1.5 w=0.42 l=0.15
X174 v3_selector_route_pilot_0/G0_MUX_POS/a_218_47# group0_bit0 VGND VGND sky130_fd_pr__nfet_01v8 ad=0 pd=0 as=0 ps=0 w=0.42 l=0.15
X175 VPWR v3_selector_route_pilot_0/G0_MUX_POS/a_76_199# v3_selector_route_pilot_0/G0_MUX_POS/X VPWR sky130_fd_pr__pfet_01v8_hvt ad=0 pd=0 as=0.26 ps=2.52 w=1 l=0.15
X176 VGND v3_selector_route_pilot_0/G0_MUX_POS/a_76_199# v3_selector_route_pilot_0/G0_MUX_POS/X VGND sky130_fd_pr__nfet_01v8 ad=0 pd=0 as=0.169 ps=1.82 w=0.65 l=0.15
X177 VPWR v3_selector_route_pilot_0/G0_MUX_NEG/a_505_21# v3_selector_route_pilot_0/G0_MUX_NEG/a_535_374# VPWR sky130_fd_pr__pfet_01v8_hvt ad=0 pd=0 as=0.0882 ps=1.26 w=0.42 l=0.15
X178 v3_selector_route_pilot_0/G0_MUX_NEG/a_505_21# group0_bit0 VPWR VPWR sky130_fd_pr__pfet_01v8_hvt ad=0.1176 pd=1.4 as=0 ps=0 w=0.42 l=0.15
X179 v3_selector_route_pilot_0/G0_MUX_NEG/a_218_374# group0_bit0 VPWR VPWR sky130_fd_pr__pfet_01v8_hvt ad=0.1533 pd=1.57 as=0 ps=0 w=0.42 l=0.15
X180 VGND v3_selector_route_pilot_0/G0_MUX_NEG/a_505_21# v3_selector_route_pilot_0/G0_MUX_NEG/a_439_47# VGND sky130_fd_pr__nfet_01v8 ad=0 pd=0 as=0.1386 ps=1.5 w=0.42 l=0.15
X181 v3_selector_route_pilot_0/G0_MUX_NEG/a_76_199# phase_180 v3_selector_route_pilot_0/G0_MUX_NEG/a_218_374# VPWR sky130_fd_pr__pfet_01v8_hvt ad=0.3864 pd=2.68 as=0 ps=0 w=0.42 l=0.15
X182 v3_selector_route_pilot_0/G0_MUX_NEG/a_505_21# group0_bit0 VGND VGND sky130_fd_pr__nfet_01v8 ad=0.1092 pd=1.36 as=0 ps=0 w=0.42 l=0.15
X183 v3_selector_route_pilot_0/G0_MUX_NEG/a_439_47# phase_180 v3_selector_route_pilot_0/G0_MUX_NEG/a_76_199# VGND sky130_fd_pr__nfet_01v8 ad=0 pd=0 as=0.1995 ps=1.79 w=0.42 l=0.15
X184 v3_selector_route_pilot_0/G0_MUX_NEG/a_535_374# phase_270 v3_selector_route_pilot_0/G0_MUX_NEG/a_76_199# VPWR sky130_fd_pr__pfet_01v8_hvt ad=0 pd=0 as=0 ps=0 w=0.42 l=0.15
X185 v3_selector_route_pilot_0/G0_MUX_NEG/a_76_199# phase_270 v3_selector_route_pilot_0/G0_MUX_NEG/a_218_47# VGND sky130_fd_pr__nfet_01v8 ad=0 pd=0 as=0.1386 ps=1.5 w=0.42 l=0.15
X186 v3_selector_route_pilot_0/G0_MUX_NEG/a_218_47# group0_bit0 VGND VGND sky130_fd_pr__nfet_01v8 ad=0 pd=0 as=0 ps=0 w=0.42 l=0.15
X187 VPWR v3_selector_route_pilot_0/G0_MUX_NEG/a_76_199# v3_selector_route_pilot_0/G0_MUX_NEG/X VPWR sky130_fd_pr__pfet_01v8_hvt ad=0 pd=0 as=0.26 ps=2.52 w=1 l=0.15
X188 VGND v3_selector_route_pilot_0/G0_MUX_NEG/a_76_199# v3_selector_route_pilot_0/G0_MUX_NEG/X VGND sky130_fd_pr__nfet_01v8 ad=0 pd=0 as=0.169 ps=1.82 w=0.65 l=0.15
X189 VPWR v3_selector_route_pilot_0/G2_MUX_AXIS/a_505_21# v3_selector_route_pilot_0/G2_MUX_AXIS/a_535_374# VPWR sky130_fd_pr__pfet_01v8_hvt ad=0 pd=0 as=0.0882 ps=1.26 w=0.42 l=0.15
X190 v3_selector_route_pilot_0/G2_MUX_AXIS/a_505_21# group2_bit1 VPWR VPWR sky130_fd_pr__pfet_01v8_hvt ad=0.1176 pd=1.4 as=0 ps=0 w=0.42 l=0.15
X191 v3_selector_route_pilot_0/G2_MUX_AXIS/a_218_374# group2_bit1 VPWR VPWR sky130_fd_pr__pfet_01v8_hvt ad=0.1533 pd=1.57 as=0 ps=0 w=0.42 l=0.15
X192 VGND v3_selector_route_pilot_0/G2_MUX_AXIS/a_505_21# v3_selector_route_pilot_0/G2_MUX_AXIS/a_439_47# VGND sky130_fd_pr__nfet_01v8 ad=0 pd=0 as=0.1386 ps=1.5 w=0.42 l=0.15
X193 v3_selector_route_pilot_0/G2_MUX_AXIS/a_76_199# v3_selector_route_pilot_0/G2_MUX_POS/X v3_selector_route_pilot_0/G2_MUX_AXIS/a_218_374# VPWR sky130_fd_pr__pfet_01v8_hvt ad=0.3864 pd=2.68 as=0 ps=0 w=0.42 l=0.15
X194 v3_selector_route_pilot_0/G2_MUX_AXIS/a_505_21# group2_bit1 VGND VGND sky130_fd_pr__nfet_01v8 ad=0.1092 pd=1.36 as=0 ps=0 w=0.42 l=0.15
X195 v3_selector_route_pilot_0/G2_MUX_AXIS/a_439_47# v3_selector_route_pilot_0/G2_MUX_POS/X v3_selector_route_pilot_0/G2_MUX_AXIS/a_76_199# VGND sky130_fd_pr__nfet_01v8 ad=0 pd=0 as=0.1995 ps=1.79 w=0.42 l=0.15
X196 v3_selector_route_pilot_0/G2_MUX_AXIS/a_535_374# v3_selector_route_pilot_0/G2_MUX_NEG/X v3_selector_route_pilot_0/G2_MUX_AXIS/a_76_199# VPWR sky130_fd_pr__pfet_01v8_hvt ad=0 pd=0 as=0 ps=0 w=0.42 l=0.15
X197 v3_selector_route_pilot_0/G2_MUX_AXIS/a_76_199# v3_selector_route_pilot_0/G2_MUX_NEG/X v3_selector_route_pilot_0/G2_MUX_AXIS/a_218_47# VGND sky130_fd_pr__nfet_01v8 ad=0 pd=0 as=0.1386 ps=1.5 w=0.42 l=0.15
X198 v3_selector_route_pilot_0/G2_MUX_AXIS/a_218_47# group2_bit1 VGND VGND sky130_fd_pr__nfet_01v8 ad=0 pd=0 as=0 ps=0 w=0.42 l=0.15
X199 VPWR v3_selector_route_pilot_0/G2_MUX_AXIS/a_76_199# v3_selector_route_pilot_0/G2_MUX_AXIS/X VPWR sky130_fd_pr__pfet_01v8_hvt ad=0 pd=0 as=0.26 ps=2.52 w=1 l=0.15
X200 VGND v3_selector_route_pilot_0/G2_MUX_AXIS/a_76_199# v3_selector_route_pilot_0/G2_MUX_AXIS/X VGND sky130_fd_pr__nfet_01v8 ad=0 pd=0 as=0.169 ps=1.82 w=0.65 l=0.15
X201 VPWR v3_selector_route_pilot_0/G3_MUX_POS/a_505_21# v3_selector_route_pilot_0/G3_MUX_POS/a_535_374# VPWR sky130_fd_pr__pfet_01v8_hvt ad=0 pd=0 as=0.0882 ps=1.26 w=0.42 l=0.15
X202 v3_selector_route_pilot_0/G3_MUX_POS/a_505_21# group3_bit0 VPWR VPWR sky130_fd_pr__pfet_01v8_hvt ad=0.1176 pd=1.4 as=0 ps=0 w=0.42 l=0.15
X203 v3_selector_route_pilot_0/G3_MUX_POS/a_218_374# group3_bit0 VPWR VPWR sky130_fd_pr__pfet_01v8_hvt ad=0.1533 pd=1.57 as=0 ps=0 w=0.42 l=0.15
X204 VGND v3_selector_route_pilot_0/G3_MUX_POS/a_505_21# v3_selector_route_pilot_0/G3_MUX_POS/a_439_47# VGND sky130_fd_pr__nfet_01v8 ad=0 pd=0 as=0.1386 ps=1.5 w=0.42 l=0.15
X205 v3_selector_route_pilot_0/G3_MUX_POS/a_76_199# phase_0 v3_selector_route_pilot_0/G3_MUX_POS/a_218_374# VPWR sky130_fd_pr__pfet_01v8_hvt ad=0.3864 pd=2.68 as=0 ps=0 w=0.42 l=0.15
X206 v3_selector_route_pilot_0/G3_MUX_POS/a_505_21# group3_bit0 VGND VGND sky130_fd_pr__nfet_01v8 ad=0.1092 pd=1.36 as=0 ps=0 w=0.42 l=0.15
X207 v3_selector_route_pilot_0/G3_MUX_POS/a_439_47# phase_0 v3_selector_route_pilot_0/G3_MUX_POS/a_76_199# VGND sky130_fd_pr__nfet_01v8 ad=0 pd=0 as=0.1995 ps=1.79 w=0.42 l=0.15
X208 v3_selector_route_pilot_0/G3_MUX_POS/a_535_374# phase_90 v3_selector_route_pilot_0/G3_MUX_POS/a_76_199# VPWR sky130_fd_pr__pfet_01v8_hvt ad=0 pd=0 as=0 ps=0 w=0.42 l=0.15
X209 v3_selector_route_pilot_0/G3_MUX_POS/a_76_199# phase_90 v3_selector_route_pilot_0/G3_MUX_POS/a_218_47# VGND sky130_fd_pr__nfet_01v8 ad=0 pd=0 as=0.1386 ps=1.5 w=0.42 l=0.15
X210 v3_selector_route_pilot_0/G3_MUX_POS/a_218_47# group3_bit0 VGND VGND sky130_fd_pr__nfet_01v8 ad=0 pd=0 as=0 ps=0 w=0.42 l=0.15
X211 VPWR v3_selector_route_pilot_0/G3_MUX_POS/a_76_199# v3_selector_route_pilot_0/G3_MUX_POS/X VPWR sky130_fd_pr__pfet_01v8_hvt ad=0 pd=0 as=0.26 ps=2.52 w=1 l=0.15
X212 VGND v3_selector_route_pilot_0/G3_MUX_POS/a_76_199# v3_selector_route_pilot_0/G3_MUX_POS/X VGND sky130_fd_pr__nfet_01v8 ad=0 pd=0 as=0.169 ps=1.82 w=0.65 l=0.15
X213 VPWR v3_selector_route_pilot_0/G3_MUX_NEG/a_505_21# v3_selector_route_pilot_0/G3_MUX_NEG/a_535_374# VPWR sky130_fd_pr__pfet_01v8_hvt ad=0 pd=0 as=0.0882 ps=1.26 w=0.42 l=0.15
X214 v3_selector_route_pilot_0/G3_MUX_NEG/a_505_21# group3_bit0 VPWR VPWR sky130_fd_pr__pfet_01v8_hvt ad=0.1176 pd=1.4 as=0 ps=0 w=0.42 l=0.15
X215 v3_selector_route_pilot_0/G3_MUX_NEG/a_218_374# group3_bit0 VPWR VPWR sky130_fd_pr__pfet_01v8_hvt ad=0.1533 pd=1.57 as=0 ps=0 w=0.42 l=0.15
X216 VGND v3_selector_route_pilot_0/G3_MUX_NEG/a_505_21# v3_selector_route_pilot_0/G3_MUX_NEG/a_439_47# VGND sky130_fd_pr__nfet_01v8 ad=0 pd=0 as=0.1386 ps=1.5 w=0.42 l=0.15
X217 v3_selector_route_pilot_0/G3_MUX_NEG/a_76_199# phase_180 v3_selector_route_pilot_0/G3_MUX_NEG/a_218_374# VPWR sky130_fd_pr__pfet_01v8_hvt ad=0.3864 pd=2.68 as=0 ps=0 w=0.42 l=0.15
X218 v3_selector_route_pilot_0/G3_MUX_NEG/a_505_21# group3_bit0 VGND VGND sky130_fd_pr__nfet_01v8 ad=0.1092 pd=1.36 as=0 ps=0 w=0.42 l=0.15
X219 v3_selector_route_pilot_0/G3_MUX_NEG/a_439_47# phase_180 v3_selector_route_pilot_0/G3_MUX_NEG/a_76_199# VGND sky130_fd_pr__nfet_01v8 ad=0 pd=0 as=0.1995 ps=1.79 w=0.42 l=0.15
X220 v3_selector_route_pilot_0/G3_MUX_NEG/a_535_374# phase_270 v3_selector_route_pilot_0/G3_MUX_NEG/a_76_199# VPWR sky130_fd_pr__pfet_01v8_hvt ad=0 pd=0 as=0 ps=0 w=0.42 l=0.15
X221 v3_selector_route_pilot_0/G3_MUX_NEG/a_76_199# phase_270 v3_selector_route_pilot_0/G3_MUX_NEG/a_218_47# VGND sky130_fd_pr__nfet_01v8 ad=0 pd=0 as=0.1386 ps=1.5 w=0.42 l=0.15
X222 v3_selector_route_pilot_0/G3_MUX_NEG/a_218_47# group3_bit0 VGND VGND sky130_fd_pr__nfet_01v8 ad=0 pd=0 as=0 ps=0 w=0.42 l=0.15
X223 VPWR v3_selector_route_pilot_0/G3_MUX_NEG/a_76_199# v3_selector_route_pilot_0/G3_MUX_NEG/X VPWR sky130_fd_pr__pfet_01v8_hvt ad=0 pd=0 as=0.26 ps=2.52 w=1 l=0.15
X224 VGND v3_selector_route_pilot_0/G3_MUX_NEG/a_76_199# v3_selector_route_pilot_0/G3_MUX_NEG/X VGND sky130_fd_pr__nfet_01v8 ad=0 pd=0 as=0.169 ps=1.82 w=0.65 l=0.15
X225 VPWR v3_selector_route_pilot_0/G3_LO_P_AND/B v3_selector_route_pilot_0/G0_LO_P_AND/a_59_75# VPWR sky130_fd_pr__pfet_01v8_hvt ad=0 pd=0 as=0.1134 ps=1.38 w=0.42 l=0.15
X226 v3_selector_route_pilot_0/group0_lo_p v3_selector_route_pilot_0/G0_LO_P_AND/a_59_75# VPWR VPWR sky130_fd_pr__pfet_01v8_hvt ad=0.475 pd=2.95 as=0 ps=0 w=1 l=0.15
X227 VGND v3_selector_route_pilot_0/G3_LO_P_AND/B v3_selector_route_pilot_0/G0_LO_P_AND/a_145_75# VGND sky130_fd_pr__nfet_01v8 ad=0 pd=0 as=0.1134 ps=1.38 w=0.42 l=0.15
X228 v3_selector_route_pilot_0/G0_LO_P_AND/a_59_75# v3_selector_route_pilot_0/G0_MUX_AXIS/X VPWR VPWR sky130_fd_pr__pfet_01v8_hvt ad=0 pd=0 as=0 ps=0 w=0.42 l=0.15
X229 v3_selector_route_pilot_0/group0_lo_p v3_selector_route_pilot_0/G0_LO_P_AND/a_59_75# VGND VGND sky130_fd_pr__nfet_01v8 ad=0.182 pd=1.86 as=0 ps=0 w=0.65 l=0.15
X230 v3_selector_route_pilot_0/G0_LO_P_AND/a_145_75# v3_selector_route_pilot_0/G0_MUX_AXIS/X v3_selector_route_pilot_0/G0_LO_P_AND/a_59_75# VGND sky130_fd_pr__nfet_01v8 ad=0 pd=0 as=0.1176 ps=1.4 w=0.42 l=0.15
X231 VPWR v3_selector_route_pilot_0/G3_LO_P_AND/B v3_selector_route_pilot_0/G3_LO_N_ANDNOT/a_207_413# VPWR sky130_fd_pr__pfet_01v8_hvt ad=0 pd=0 as=0.1218 ps=1.42 w=0.42 l=0.15
X232 v3_selector_route_pilot_0/group3_lo_n v3_selector_route_pilot_0/G3_LO_N_ANDNOT/a_207_413# VPWR VPWR sky130_fd_pr__pfet_01v8_hvt ad=0.26 pd=2.52 as=0 ps=0 w=1 l=0.15
X233 v3_selector_route_pilot_0/G3_LO_N_ANDNOT/a_297_47# v3_selector_route_pilot_0/G3_LO_N_ANDNOT/a_27_413# v3_selector_route_pilot_0/G3_LO_N_ANDNOT/a_207_413# VGND sky130_fd_pr__nfet_01v8 ad=0.1008 pd=1.32 as=0.1092 ps=1.36 w=0.42 l=0.15
X234 v3_selector_route_pilot_0/group3_lo_n v3_selector_route_pilot_0/G3_LO_N_ANDNOT/a_207_413# VGND VGND sky130_fd_pr__nfet_01v8 ad=0.169 pd=1.82 as=0 ps=0 w=0.65 l=0.15
X235 v3_selector_route_pilot_0/G3_LO_N_ANDNOT/a_207_413# v3_selector_route_pilot_0/G3_LO_N_ANDNOT/a_27_413# VPWR VPWR sky130_fd_pr__pfet_01v8_hvt ad=0 pd=0 as=0 ps=0 w=0.42 l=0.15
X236 VPWR v3_selector_route_pilot_0/G3_MUX_AXIS/X v3_selector_route_pilot_0/G3_LO_N_ANDNOT/a_27_413# VPWR sky130_fd_pr__pfet_01v8_hvt ad=0 pd=0 as=0.1092 ps=1.36 w=0.42 l=0.15
X237 VGND v3_selector_route_pilot_0/G3_LO_P_AND/B v3_selector_route_pilot_0/G3_LO_N_ANDNOT/a_297_47# VGND sky130_fd_pr__nfet_01v8 ad=0 pd=0 as=0 ps=0 w=0.42 l=0.15
X238 v3_selector_route_pilot_0/G3_LO_N_ANDNOT/a_27_413# v3_selector_route_pilot_0/G3_MUX_AXIS/X VGND VGND sky130_fd_pr__nfet_01v8 ad=0.1092 pd=1.36 as=0 ps=0 w=0.42 l=0.15
X239 VPWR v3_selector_route_pilot_0/G3_LO_P_AND/B v3_selector_route_pilot_0/G2_LO_N_ANDNOT/a_207_413# VPWR sky130_fd_pr__pfet_01v8_hvt ad=0 pd=0 as=0.1218 ps=1.42 w=0.42 l=0.15
X240 v3_selector_route_pilot_0/group2_lo_n v3_selector_route_pilot_0/G2_LO_N_ANDNOT/a_207_413# VPWR VPWR sky130_fd_pr__pfet_01v8_hvt ad=0.26 pd=2.52 as=0 ps=0 w=1 l=0.15
X241 v3_selector_route_pilot_0/G2_LO_N_ANDNOT/a_297_47# v3_selector_route_pilot_0/G2_LO_N_ANDNOT/a_27_413# v3_selector_route_pilot_0/G2_LO_N_ANDNOT/a_207_413# VGND sky130_fd_pr__nfet_01v8 ad=0.1008 pd=1.32 as=0.1092 ps=1.36 w=0.42 l=0.15
X242 v3_selector_route_pilot_0/group2_lo_n v3_selector_route_pilot_0/G2_LO_N_ANDNOT/a_207_413# VGND VGND sky130_fd_pr__nfet_01v8 ad=0.169 pd=1.82 as=0 ps=0 w=0.65 l=0.15
X243 v3_selector_route_pilot_0/G2_LO_N_ANDNOT/a_207_413# v3_selector_route_pilot_0/G2_LO_N_ANDNOT/a_27_413# VPWR VPWR sky130_fd_pr__pfet_01v8_hvt ad=0 pd=0 as=0 ps=0 w=0.42 l=0.15
X244 VPWR v3_selector_route_pilot_0/G2_MUX_AXIS/X v3_selector_route_pilot_0/G2_LO_N_ANDNOT/a_27_413# VPWR sky130_fd_pr__pfet_01v8_hvt ad=0 pd=0 as=0.1092 ps=1.36 w=0.42 l=0.15
X245 VGND v3_selector_route_pilot_0/G3_LO_P_AND/B v3_selector_route_pilot_0/G2_LO_N_ANDNOT/a_297_47# VGND sky130_fd_pr__nfet_01v8 ad=0 pd=0 as=0 ps=0 w=0.42 l=0.15
X246 v3_selector_route_pilot_0/G2_LO_N_ANDNOT/a_27_413# v3_selector_route_pilot_0/G2_MUX_AXIS/X VGND VGND sky130_fd_pr__nfet_01v8 ad=0.1092 pd=1.36 as=0 ps=0 w=0.42 l=0.15
X247 VPWR v3_selector_route_pilot_0/G3_LO_P_AND/B v3_selector_route_pilot_0/G0_LO_N_ANDNOT/a_207_413# VPWR sky130_fd_pr__pfet_01v8_hvt ad=0 pd=0 as=0.1218 ps=1.42 w=0.42 l=0.15
X248 v3_selector_route_pilot_0/group0_lo_n v3_selector_route_pilot_0/G0_LO_N_ANDNOT/a_207_413# VPWR VPWR sky130_fd_pr__pfet_01v8_hvt ad=0.26 pd=2.52 as=0 ps=0 w=1 l=0.15
X249 v3_selector_route_pilot_0/G0_LO_N_ANDNOT/a_297_47# v3_selector_route_pilot_0/G0_LO_N_ANDNOT/a_27_413# v3_selector_route_pilot_0/G0_LO_N_ANDNOT/a_207_413# VGND sky130_fd_pr__nfet_01v8 ad=0.1008 pd=1.32 as=0.1092 ps=1.36 w=0.42 l=0.15
X250 v3_selector_route_pilot_0/group0_lo_n v3_selector_route_pilot_0/G0_LO_N_ANDNOT/a_207_413# VGND VGND sky130_fd_pr__nfet_01v8 ad=0.169 pd=1.82 as=0 ps=0 w=0.65 l=0.15
X251 v3_selector_route_pilot_0/G0_LO_N_ANDNOT/a_207_413# v3_selector_route_pilot_0/G0_LO_N_ANDNOT/a_27_413# VPWR VPWR sky130_fd_pr__pfet_01v8_hvt ad=0 pd=0 as=0 ps=0 w=0.42 l=0.15
X252 VPWR v3_selector_route_pilot_0/G0_MUX_AXIS/X v3_selector_route_pilot_0/G0_LO_N_ANDNOT/a_27_413# VPWR sky130_fd_pr__pfet_01v8_hvt ad=0 pd=0 as=0.1092 ps=1.36 w=0.42 l=0.15
X253 VGND v3_selector_route_pilot_0/G3_LO_P_AND/B v3_selector_route_pilot_0/G0_LO_N_ANDNOT/a_297_47# VGND sky130_fd_pr__nfet_01v8 ad=0 pd=0 as=0 ps=0 w=0.42 l=0.15
X254 v3_selector_route_pilot_0/G0_LO_N_ANDNOT/a_27_413# v3_selector_route_pilot_0/G0_MUX_AXIS/X VGND VGND sky130_fd_pr__nfet_01v8 ad=0.1092 pd=1.36 as=0 ps=0 w=0.42 l=0.15
X255 VPWR v3_selector_route_pilot_0/G1_MUX_AXIS/a_505_21# v3_selector_route_pilot_0/G1_MUX_AXIS/a_535_374# VPWR sky130_fd_pr__pfet_01v8_hvt ad=0 pd=0 as=0.0882 ps=1.26 w=0.42 l=0.15
X256 v3_selector_route_pilot_0/G1_MUX_AXIS/a_505_21# group1_bit1 VPWR VPWR sky130_fd_pr__pfet_01v8_hvt ad=0.1176 pd=1.4 as=0 ps=0 w=0.42 l=0.15
X257 v3_selector_route_pilot_0/G1_MUX_AXIS/a_218_374# group1_bit1 VPWR VPWR sky130_fd_pr__pfet_01v8_hvt ad=0.1533 pd=1.57 as=0 ps=0 w=0.42 l=0.15
X258 VGND v3_selector_route_pilot_0/G1_MUX_AXIS/a_505_21# v3_selector_route_pilot_0/G1_MUX_AXIS/a_439_47# VGND sky130_fd_pr__nfet_01v8 ad=0 pd=0 as=0.1386 ps=1.5 w=0.42 l=0.15
X259 v3_selector_route_pilot_0/G1_MUX_AXIS/a_76_199# v3_selector_route_pilot_0/G1_MUX_POS/X v3_selector_route_pilot_0/G1_MUX_AXIS/a_218_374# VPWR sky130_fd_pr__pfet_01v8_hvt ad=0.3864 pd=2.68 as=0 ps=0 w=0.42 l=0.15
X260 v3_selector_route_pilot_0/G1_MUX_AXIS/a_505_21# group1_bit1 VGND VGND sky130_fd_pr__nfet_01v8 ad=0.1092 pd=1.36 as=0 ps=0 w=0.42 l=0.15
X261 v3_selector_route_pilot_0/G1_MUX_AXIS/a_439_47# v3_selector_route_pilot_0/G1_MUX_POS/X v3_selector_route_pilot_0/G1_MUX_AXIS/a_76_199# VGND sky130_fd_pr__nfet_01v8 ad=0 pd=0 as=0.1995 ps=1.79 w=0.42 l=0.15
X262 v3_selector_route_pilot_0/G1_MUX_AXIS/a_535_374# v3_selector_route_pilot_0/G1_MUX_NEG/X v3_selector_route_pilot_0/G1_MUX_AXIS/a_76_199# VPWR sky130_fd_pr__pfet_01v8_hvt ad=0 pd=0 as=0 ps=0 w=0.42 l=0.15
X263 v3_selector_route_pilot_0/G1_MUX_AXIS/a_76_199# v3_selector_route_pilot_0/G1_MUX_NEG/X v3_selector_route_pilot_0/G1_MUX_AXIS/a_218_47# VGND sky130_fd_pr__nfet_01v8 ad=0 pd=0 as=0.1386 ps=1.5 w=0.42 l=0.15
X264 v3_selector_route_pilot_0/G1_MUX_AXIS/a_218_47# group1_bit1 VGND VGND sky130_fd_pr__nfet_01v8 ad=0 pd=0 as=0 ps=0 w=0.42 l=0.15
X265 VPWR v3_selector_route_pilot_0/G1_MUX_AXIS/a_76_199# v3_selector_route_pilot_0/G1_MUX_AXIS/X VPWR sky130_fd_pr__pfet_01v8_hvt ad=0 pd=0 as=0.26 ps=2.52 w=1 l=0.15
X266 VGND v3_selector_route_pilot_0/G1_MUX_AXIS/a_76_199# v3_selector_route_pilot_0/G1_MUX_AXIS/X VGND sky130_fd_pr__nfet_01v8 ad=0 pd=0 as=0.169 ps=1.82 w=0.65 l=0.15
X267 VPWR v3_selector_route_pilot_0/G3_LO_P_AND/B v3_selector_route_pilot_0/G1_LO_N_ANDNOT/a_207_413# VPWR sky130_fd_pr__pfet_01v8_hvt ad=0 pd=0 as=0.1218 ps=1.42 w=0.42 l=0.15
X268 v3_selector_route_pilot_0/group1_lo_n v3_selector_route_pilot_0/G1_LO_N_ANDNOT/a_207_413# VPWR VPWR sky130_fd_pr__pfet_01v8_hvt ad=0.26 pd=2.52 as=0 ps=0 w=1 l=0.15
X269 v3_selector_route_pilot_0/G1_LO_N_ANDNOT/a_297_47# v3_selector_route_pilot_0/G1_LO_N_ANDNOT/a_27_413# v3_selector_route_pilot_0/G1_LO_N_ANDNOT/a_207_413# VGND sky130_fd_pr__nfet_01v8 ad=0.1008 pd=1.32 as=0.1092 ps=1.36 w=0.42 l=0.15
X270 v3_selector_route_pilot_0/group1_lo_n v3_selector_route_pilot_0/G1_LO_N_ANDNOT/a_207_413# VGND VGND sky130_fd_pr__nfet_01v8 ad=0.169 pd=1.82 as=0 ps=0 w=0.65 l=0.15
X271 v3_selector_route_pilot_0/G1_LO_N_ANDNOT/a_207_413# v3_selector_route_pilot_0/G1_LO_N_ANDNOT/a_27_413# VPWR VPWR sky130_fd_pr__pfet_01v8_hvt ad=0 pd=0 as=0 ps=0 w=0.42 l=0.15
X272 VPWR v3_selector_route_pilot_0/G1_MUX_AXIS/X v3_selector_route_pilot_0/G1_LO_N_ANDNOT/a_27_413# VPWR sky130_fd_pr__pfet_01v8_hvt ad=0 pd=0 as=0.1092 ps=1.36 w=0.42 l=0.15
X273 VGND v3_selector_route_pilot_0/G3_LO_P_AND/B v3_selector_route_pilot_0/G1_LO_N_ANDNOT/a_297_47# VGND sky130_fd_pr__nfet_01v8 ad=0 pd=0 as=0 ps=0 w=0.42 l=0.15
X274 v3_selector_route_pilot_0/G1_LO_N_ANDNOT/a_27_413# v3_selector_route_pilot_0/G1_MUX_AXIS/X VGND VGND sky130_fd_pr__nfet_01v8 ad=0.1092 pd=1.36 as=0 ps=0 w=0.42 l=0.15
X275 VPWR v3_selector_route_pilot_0/G3_LO_P_AND/B v3_selector_route_pilot_0/G3_LO_P_AND/a_59_75# VPWR sky130_fd_pr__pfet_01v8_hvt ad=0 pd=0 as=0.1134 ps=1.38 w=0.42 l=0.15
X276 v3_selector_route_pilot_0/group3_lo_p v3_selector_route_pilot_0/G3_LO_P_AND/a_59_75# VPWR VPWR sky130_fd_pr__pfet_01v8_hvt ad=0.475 pd=2.95 as=0 ps=0 w=1 l=0.15
X277 VGND v3_selector_route_pilot_0/G3_LO_P_AND/B v3_selector_route_pilot_0/G3_LO_P_AND/a_145_75# VGND sky130_fd_pr__nfet_01v8 ad=0 pd=0 as=0.1134 ps=1.38 w=0.42 l=0.15
X278 v3_selector_route_pilot_0/G3_LO_P_AND/a_59_75# v3_selector_route_pilot_0/G3_MUX_AXIS/X VPWR VPWR sky130_fd_pr__pfet_01v8_hvt ad=0 pd=0 as=0 ps=0 w=0.42 l=0.15
X279 v3_selector_route_pilot_0/group3_lo_p v3_selector_route_pilot_0/G3_LO_P_AND/a_59_75# VGND VGND sky130_fd_pr__nfet_01v8 ad=0.182 pd=1.86 as=0 ps=0 w=0.65 l=0.15
X280 v3_selector_route_pilot_0/G3_LO_P_AND/a_145_75# v3_selector_route_pilot_0/G3_MUX_AXIS/X v3_selector_route_pilot_0/G3_LO_P_AND/a_59_75# VGND sky130_fd_pr__nfet_01v8 ad=0 pd=0 as=0.1176 ps=1.4 w=0.42 l=0.15
X281 VPWR v3_selector_route_pilot_0/G2_MUX_POS/a_505_21# v3_selector_route_pilot_0/G2_MUX_POS/a_535_374# VPWR sky130_fd_pr__pfet_01v8_hvt ad=0 pd=0 as=0.0882 ps=1.26 w=0.42 l=0.15
X282 v3_selector_route_pilot_0/G2_MUX_POS/a_505_21# group2_bit0 VPWR VPWR sky130_fd_pr__pfet_01v8_hvt ad=0.1176 pd=1.4 as=0 ps=0 w=0.42 l=0.15
X283 v3_selector_route_pilot_0/G2_MUX_POS/a_218_374# group2_bit0 VPWR VPWR sky130_fd_pr__pfet_01v8_hvt ad=0.1533 pd=1.57 as=0 ps=0 w=0.42 l=0.15
X284 VGND v3_selector_route_pilot_0/G2_MUX_POS/a_505_21# v3_selector_route_pilot_0/G2_MUX_POS/a_439_47# VGND sky130_fd_pr__nfet_01v8 ad=0 pd=0 as=0.1386 ps=1.5 w=0.42 l=0.15
X285 v3_selector_route_pilot_0/G2_MUX_POS/a_76_199# phase_0 v3_selector_route_pilot_0/G2_MUX_POS/a_218_374# VPWR sky130_fd_pr__pfet_01v8_hvt ad=0.3864 pd=2.68 as=0 ps=0 w=0.42 l=0.15
X286 v3_selector_route_pilot_0/G2_MUX_POS/a_505_21# group2_bit0 VGND VGND sky130_fd_pr__nfet_01v8 ad=0.1092 pd=1.36 as=0 ps=0 w=0.42 l=0.15
X287 v3_selector_route_pilot_0/G2_MUX_POS/a_439_47# phase_0 v3_selector_route_pilot_0/G2_MUX_POS/a_76_199# VGND sky130_fd_pr__nfet_01v8 ad=0 pd=0 as=0.1995 ps=1.79 w=0.42 l=0.15
X288 v3_selector_route_pilot_0/G2_MUX_POS/a_535_374# phase_90 v3_selector_route_pilot_0/G2_MUX_POS/a_76_199# VPWR sky130_fd_pr__pfet_01v8_hvt ad=0 pd=0 as=0 ps=0 w=0.42 l=0.15
X289 v3_selector_route_pilot_0/G2_MUX_POS/a_76_199# phase_90 v3_selector_route_pilot_0/G2_MUX_POS/a_218_47# VGND sky130_fd_pr__nfet_01v8 ad=0 pd=0 as=0.1386 ps=1.5 w=0.42 l=0.15
X290 v3_selector_route_pilot_0/G2_MUX_POS/a_218_47# group2_bit0 VGND VGND sky130_fd_pr__nfet_01v8 ad=0 pd=0 as=0 ps=0 w=0.42 l=0.15
X291 VPWR v3_selector_route_pilot_0/G2_MUX_POS/a_76_199# v3_selector_route_pilot_0/G2_MUX_POS/X VPWR sky130_fd_pr__pfet_01v8_hvt ad=0 pd=0 as=0.26 ps=2.52 w=1 l=0.15
X292 VGND v3_selector_route_pilot_0/G2_MUX_POS/a_76_199# v3_selector_route_pilot_0/G2_MUX_POS/X VGND sky130_fd_pr__nfet_01v8 ad=0 pd=0 as=0.169 ps=1.82 w=0.65 l=0.15
X293 VPWR v3_selector_route_pilot_0/G2_MUX_NEG/a_505_21# v3_selector_route_pilot_0/G2_MUX_NEG/a_535_374# VPWR sky130_fd_pr__pfet_01v8_hvt ad=0 pd=0 as=0.0882 ps=1.26 w=0.42 l=0.15
X294 v3_selector_route_pilot_0/G2_MUX_NEG/a_505_21# group2_bit0 VPWR VPWR sky130_fd_pr__pfet_01v8_hvt ad=0.1176 pd=1.4 as=0 ps=0 w=0.42 l=0.15
X295 v3_selector_route_pilot_0/G2_MUX_NEG/a_218_374# group2_bit0 VPWR VPWR sky130_fd_pr__pfet_01v8_hvt ad=0.1533 pd=1.57 as=0 ps=0 w=0.42 l=0.15
X296 VGND v3_selector_route_pilot_0/G2_MUX_NEG/a_505_21# v3_selector_route_pilot_0/G2_MUX_NEG/a_439_47# VGND sky130_fd_pr__nfet_01v8 ad=0 pd=0 as=0.1386 ps=1.5 w=0.42 l=0.15
X297 v3_selector_route_pilot_0/G2_MUX_NEG/a_76_199# phase_180 v3_selector_route_pilot_0/G2_MUX_NEG/a_218_374# VPWR sky130_fd_pr__pfet_01v8_hvt ad=0.3864 pd=2.68 as=0 ps=0 w=0.42 l=0.15
X298 v3_selector_route_pilot_0/G2_MUX_NEG/a_505_21# group2_bit0 VGND VGND sky130_fd_pr__nfet_01v8 ad=0.1092 pd=1.36 as=0 ps=0 w=0.42 l=0.15
X299 v3_selector_route_pilot_0/G2_MUX_NEG/a_439_47# phase_180 v3_selector_route_pilot_0/G2_MUX_NEG/a_76_199# VGND sky130_fd_pr__nfet_01v8 ad=0 pd=0 as=0.1995 ps=1.79 w=0.42 l=0.15
X300 v3_selector_route_pilot_0/G2_MUX_NEG/a_535_374# phase_270 v3_selector_route_pilot_0/G2_MUX_NEG/a_76_199# VPWR sky130_fd_pr__pfet_01v8_hvt ad=0 pd=0 as=0 ps=0 w=0.42 l=0.15
X301 v3_selector_route_pilot_0/G2_MUX_NEG/a_76_199# phase_270 v3_selector_route_pilot_0/G2_MUX_NEG/a_218_47# VGND sky130_fd_pr__nfet_01v8 ad=0 pd=0 as=0.1386 ps=1.5 w=0.42 l=0.15
X302 v3_selector_route_pilot_0/G2_MUX_NEG/a_218_47# group2_bit0 VGND VGND sky130_fd_pr__nfet_01v8 ad=0 pd=0 as=0 ps=0 w=0.42 l=0.15
X303 VPWR v3_selector_route_pilot_0/G2_MUX_NEG/a_76_199# v3_selector_route_pilot_0/G2_MUX_NEG/X VPWR sky130_fd_pr__pfet_01v8_hvt ad=0 pd=0 as=0.26 ps=2.52 w=1 l=0.15
X304 VGND v3_selector_route_pilot_0/G2_MUX_NEG/a_76_199# v3_selector_route_pilot_0/G2_MUX_NEG/X VGND sky130_fd_pr__nfet_01v8 ad=0 pd=0 as=0.169 ps=1.82 w=0.65 l=0.15
X305 VPWR v3_selector_route_pilot_0/G0_MUX_AXIS/a_505_21# v3_selector_route_pilot_0/G0_MUX_AXIS/a_535_374# VPWR sky130_fd_pr__pfet_01v8_hvt ad=0 pd=0 as=0.0882 ps=1.26 w=0.42 l=0.15
X306 v3_selector_route_pilot_0/G0_MUX_AXIS/a_505_21# group0_bit1 VPWR VPWR sky130_fd_pr__pfet_01v8_hvt ad=0.1176 pd=1.4 as=0 ps=0 w=0.42 l=0.15
X307 v3_selector_route_pilot_0/G0_MUX_AXIS/a_218_374# group0_bit1 VPWR VPWR sky130_fd_pr__pfet_01v8_hvt ad=0.1533 pd=1.57 as=0 ps=0 w=0.42 l=0.15
X308 VGND v3_selector_route_pilot_0/G0_MUX_AXIS/a_505_21# v3_selector_route_pilot_0/G0_MUX_AXIS/a_439_47# VGND sky130_fd_pr__nfet_01v8 ad=0 pd=0 as=0.1386 ps=1.5 w=0.42 l=0.15
X309 v3_selector_route_pilot_0/G0_MUX_AXIS/a_76_199# v3_selector_route_pilot_0/G0_MUX_POS/X v3_selector_route_pilot_0/G0_MUX_AXIS/a_218_374# VPWR sky130_fd_pr__pfet_01v8_hvt ad=0.3864 pd=2.68 as=0 ps=0 w=0.42 l=0.15
X310 v3_selector_route_pilot_0/G0_MUX_AXIS/a_505_21# group0_bit1 VGND VGND sky130_fd_pr__nfet_01v8 ad=0.1092 pd=1.36 as=0 ps=0 w=0.42 l=0.15
X311 v3_selector_route_pilot_0/G0_MUX_AXIS/a_439_47# v3_selector_route_pilot_0/G0_MUX_POS/X v3_selector_route_pilot_0/G0_MUX_AXIS/a_76_199# VGND sky130_fd_pr__nfet_01v8 ad=0 pd=0 as=0.1995 ps=1.79 w=0.42 l=0.15
X312 v3_selector_route_pilot_0/G0_MUX_AXIS/a_535_374# v3_selector_route_pilot_0/G0_MUX_NEG/X v3_selector_route_pilot_0/G0_MUX_AXIS/a_76_199# VPWR sky130_fd_pr__pfet_01v8_hvt ad=0 pd=0 as=0 ps=0 w=0.42 l=0.15
X313 v3_selector_route_pilot_0/G0_MUX_AXIS/a_76_199# v3_selector_route_pilot_0/G0_MUX_NEG/X v3_selector_route_pilot_0/G0_MUX_AXIS/a_218_47# VGND sky130_fd_pr__nfet_01v8 ad=0 pd=0 as=0.1386 ps=1.5 w=0.42 l=0.15
X314 v3_selector_route_pilot_0/G0_MUX_AXIS/a_218_47# group0_bit1 VGND VGND sky130_fd_pr__nfet_01v8 ad=0 pd=0 as=0 ps=0 w=0.42 l=0.15
X315 VPWR v3_selector_route_pilot_0/G0_MUX_AXIS/a_76_199# v3_selector_route_pilot_0/G0_MUX_AXIS/X VPWR sky130_fd_pr__pfet_01v8_hvt ad=0 pd=0 as=0.26 ps=2.52 w=1 l=0.15
X316 VGND v3_selector_route_pilot_0/G0_MUX_AXIS/a_76_199# v3_selector_route_pilot_0/G0_MUX_AXIS/X VGND sky130_fd_pr__nfet_01v8 ad=0 pd=0 as=0.169 ps=1.82 w=0.65 l=0.15
X317 VPWR v3_selector_route_pilot_0/G3_LO_P_AND/B v3_selector_route_pilot_0/G2_LO_P_AND/a_59_75# VPWR sky130_fd_pr__pfet_01v8_hvt ad=0 pd=0 as=0.1134 ps=1.38 w=0.42 l=0.15
X318 v3_selector_route_pilot_0/group2_lo_p v3_selector_route_pilot_0/G2_LO_P_AND/a_59_75# VPWR VPWR sky130_fd_pr__pfet_01v8_hvt ad=0.475 pd=2.95 as=0 ps=0 w=1 l=0.15
X319 VGND v3_selector_route_pilot_0/G3_LO_P_AND/B v3_selector_route_pilot_0/G2_LO_P_AND/a_145_75# VGND sky130_fd_pr__nfet_01v8 ad=0 pd=0 as=0.1134 ps=1.38 w=0.42 l=0.15
X320 v3_selector_route_pilot_0/G2_LO_P_AND/a_59_75# v3_selector_route_pilot_0/G2_MUX_AXIS/X VPWR VPWR sky130_fd_pr__pfet_01v8_hvt ad=0 pd=0 as=0 ps=0 w=0.42 l=0.15
X321 v3_selector_route_pilot_0/group2_lo_p v3_selector_route_pilot_0/G2_LO_P_AND/a_59_75# VGND VGND sky130_fd_pr__nfet_01v8 ad=0.182 pd=1.86 as=0 ps=0 w=0.65 l=0.15
X322 v3_selector_route_pilot_0/G2_LO_P_AND/a_145_75# v3_selector_route_pilot_0/G2_MUX_AXIS/X v3_selector_route_pilot_0/G2_LO_P_AND/a_59_75# VGND sky130_fd_pr__nfet_01v8 ad=0 pd=0 as=0.1176 ps=1.4 w=0.42 l=0.15
