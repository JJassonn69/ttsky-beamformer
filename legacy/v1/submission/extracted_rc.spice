* NGSPICE file created from tt_um_jjassonn69_beamformer.ext - technology: sky130A

X0 XCH1LN_P/S1.t0 XCH1LN_P/G.t4 XCH1LN_P/D0.t0 XCH1LN_P/B.t0 sky130_fd_pr__pfet_01v8 ad=0.528 pd=3.53 as=0.992 ps=7.02 w=3.2 l=0.15
X1 XCH1LN_P/S4.t0 XCH1LN_P/G.t0 XCH1LN_P/D4.t1 XCH1LN_P/B.t4 sky130_fd_pr__pfet_01v8 ad=0.992 pd=7.02 as=0.528 ps=3.53 w=3.2 l=0.15
X2 XCH1LN_P/D4.t0 XCH1LN_P/G.t1 XCH1LN_P/S3.t1 XCH1LN_P/B.t3 sky130_fd_pr__pfet_01v8 ad=0.528 pd=3.53 as=0.528 ps=3.53 w=3.2 l=0.15
X3 XCH1LN_P/D2.t1 XCH1LN_P/G.t3 XCH1LN_P/S1.t1 XCH1LN_P/B.t1 sky130_fd_pr__pfet_01v8 ad=0.528 pd=3.53 as=0.528 ps=3.53 w=3.2 l=0.15
X4 XCH1LN_P/S3.t0 XCH1LN_P/G.t2 XCH1LN_P/D2.t0 XCH1LN_P/B.t2 sky130_fd_pr__pfet_01v8 ad=0.528 pd=3.53 as=0.528 ps=3.53 w=3.2 l=0.15
X5 XXN_P/D2.t1 XXN_P/G.t3 XXN_P/S1.t1 XXN_P/B.t1 sky130_fd_pr__pfet_01v8 ad=0.264 pd=1.93 as=0.264 ps=1.93 w=1.6 l=0.15
X6 XXN_P/S3.t1 XXN_P/G.t2 XXN_P/D2.t0 XXN_P/B.t2 sky130_fd_pr__pfet_01v8 ad=0.264 pd=1.93 as=0.264 ps=1.93 w=1.6 l=0.15
X7 XXN_P/S4.t0 XXN_P/G.t0 XXN_P/D4.t1 XXN_P/B.t4 sky130_fd_pr__pfet_01v8 ad=0.496 pd=3.82 as=0.264 ps=1.93 w=1.6 l=0.15
X8 XXN_P/S1.t0 XXN_P/G.t4 XXN_P/D0.t0 XXN_P/B.t0 sky130_fd_pr__pfet_01v8 ad=0.264 pd=1.93 as=0.496 ps=3.82 w=1.6 l=0.15
X9 XXN_P/D4.t0 XXN_P/G.t1 XXN_P/S3.t0 XXN_P/B.t3 sky130_fd_pr__pfet_01v8 ad=0.264 pd=1.93 as=0.264 ps=1.93 w=1.6 l=0.15
X10 XLP2_N/D4.t0 XLP2_N/G.t5 XLP2_N/S3.t0 XLP2_N/B.t3 sky130_fd_pr__nfet_01v8 ad=0.2937 pd=2.11 as=0.2937 ps=2.11 w=1.78 l=0.15
X11 XLP2_N/S5.t0 XLP2_N/G.t4 XLP2_N/D4.t1 XLP2_N/B.t4 sky130_fd_pr__nfet_01v8 ad=0.2937 pd=2.11 as=0.2937 ps=2.11 w=1.78 l=0.15
X12 XLP2_N/S1.t1 XLP2_N/G.t8 XLP2_N/D0.t0 XLP2_N/B.t0 sky130_fd_pr__nfet_01v8 ad=0.2937 pd=2.11 as=0.5518 ps=4.18 w=1.78 l=0.15
X13 XLP2_N/D2.t0 XLP2_N/G.t7 XLP2_N/S1.t0 XLP2_N/B.t1 sky130_fd_pr__nfet_01v8 ad=0.2937 pd=2.11 as=0.2937 ps=2.11 w=1.78 l=0.15
X14 XLP2_N/D8.t0 XLP2_N/G.t1 XLP2_N/S7.t1 XLP2_N/B.t7 sky130_fd_pr__nfet_01v8 ad=0.2937 pd=2.11 as=0.2937 ps=2.11 w=1.78 l=0.15
X15 XLP2_N/S7.t0 XLP2_N/G.t2 XLP2_N/D6.t0 XLP2_N/B.t6 sky130_fd_pr__nfet_01v8 ad=0.2937 pd=2.11 as=0.2937 ps=2.11 w=1.78 l=0.15
X16 XLP2_N/S3.t1 XLP2_N/G.t6 XLP2_N/D2.t1 XLP2_N/B.t2 sky130_fd_pr__nfet_01v8 ad=0.2937 pd=2.11 as=0.2937 ps=2.11 w=1.78 l=0.15
X17 XLP2_N/D6.t1 XLP2_N/G.t3 XLP2_N/S5.t1 XLP2_N/B.t5 sky130_fd_pr__nfet_01v8 ad=0.2937 pd=2.11 as=0.2937 ps=2.11 w=1.78 l=0.15
X18 XLP2_N/S8.t0 XLP2_N/G.t0 XLP2_N/D8.t1 XLP2_N/B.t8 sky130_fd_pr__nfet_01v8 ad=0.5518 pd=4.18 as=0.2937 ps=2.11 w=1.78 l=0.15
X19 X1DN_P/D2.t1 X1DN_P/G.t3 X1DN_P/S1.t1 X1DN_P/B.t1 sky130_fd_pr__pfet_01v8 ad=0 pd=0 as=0 ps=0 w=1.6 l=0.15
X20 X1DN_P/S3.t1 X1DN_P/G.t2 X1DN_P/D2.t0 X1DN_P/B.t2 sky130_fd_pr__pfet_01v8 ad=0 pd=0 as=0 ps=0 w=1.6 l=0.15
X21 X1DN_P/S4.t0 X1DN_P/G.t0 X1DN_P/D4.t1 X1DN_P/B.t4 sky130_fd_pr__pfet_01v8 ad=0 pd=0 as=0 ps=0 w=1.6 l=0.15
X22 X1DN_P/S1.t0 X1DN_P/G.t4 X1DN_P/D0.t0 X1DN_P/B.t0 sky130_fd_pr__pfet_01v8 ad=0 pd=0 as=0 ps=0 w=1.6 l=0.15
X23 X1DN_P/D4.t0 X1DN_P/G.t1 X1DN_P/S3.t0 X1DN_P/B.t3 sky130_fd_pr__pfet_01v8 ad=0 pd=0 as=0 ps=0 w=1.6 l=0.15
X24 XRLOADP/R1.t0 XRLOADP/R2.t0 XRLOADP/B.t0 sky130_fd_pr__res_high_po_1p41 l=11.61
X25 XDP_N/S3.t0 XDP_N/G.t2 XDP_N/D2.t1 XDP_N/B.t2 sky130_fd_pr__nfet_01v8 ad=0.132 pd=1.13 as=0.132 ps=1.13 w=0.8 l=0.15
X26 XDP_N/D4.t1 XDP_N/G.t1 XDP_N/S3.t1 XDP_N/B.t3 sky130_fd_pr__nfet_01v8 ad=0.132 pd=1.13 as=0.132 ps=1.13 w=0.8 l=0.15
X27 XDP_N/S1.t0 XDP_N/G.t4 XDP_N/D0.t0 XDP_N/B.t0 sky130_fd_pr__nfet_01v8 ad=0.132 pd=1.13 as=0.248 ps=2.22 w=0.8 l=0.15
X28 XDP_N/D2.t0 XDP_N/G.t3 XDP_N/S1.t1 XDP_N/B.t1 sky130_fd_pr__nfet_01v8 ad=0.132 pd=1.13 as=0.132 ps=1.13 w=0.8 l=0.15
X29 XDP_N/S4.t0 XDP_N/G.t0 XDP_N/D4.t0 XDP_N/B.t4 sky130_fd_pr__nfet_01v8 ad=0.248 pd=2.22 as=0.132 ps=1.13 w=0.8 l=0.15
X30 XLP2_P/D4.t1 XLP2_P/G.t5 XLP2_P/S3.t0 XLP2_P/B.t3 sky130_fd_pr__pfet_01v8 ad=0.5874 pd=3.89 as=0.5874 ps=3.89 w=3.56 l=0.15
X31 XLP2_P/S5.t0 XLP2_P/G.t4 XLP2_P/D4.t0 XLP2_P/B.t4 sky130_fd_pr__pfet_01v8 ad=0.5874 pd=3.89 as=0.5874 ps=3.89 w=3.56 l=0.15
X32 XLP2_P/S1.t0 XLP2_P/G.t8 XLP2_P/D0.t0 XLP2_P/B.t0 sky130_fd_pr__pfet_01v8 ad=0.5874 pd=3.89 as=1.1036 ps=7.74 w=3.56 l=0.15
X33 XLP2_P/D2.t1 XLP2_P/G.t7 XLP2_P/S1.t1 XLP2_P/B.t1 sky130_fd_pr__pfet_01v8 ad=0.5874 pd=3.89 as=0.5874 ps=3.89 w=3.56 l=0.15
X34 XLP2_P/D8.t0 XLP2_P/G.t1 XLP2_P/S7.t0 XLP2_P/B.t7 sky130_fd_pr__pfet_01v8 ad=0.5874 pd=3.89 as=0.5874 ps=3.89 w=3.56 l=0.15
X35 XLP2_P/S3.t1 XLP2_P/G.t6 XLP2_P/D2.t0 XLP2_P/B.t2 sky130_fd_pr__pfet_01v8 ad=0.5874 pd=3.89 as=0.5874 ps=3.89 w=3.56 l=0.15
X36 XLP2_P/S7.t1 XLP2_P/G.t2 XLP2_P/D6.t0 XLP2_P/B.t6 sky130_fd_pr__pfet_01v8 ad=0.5874 pd=3.89 as=0.5874 ps=3.89 w=3.56 l=0.15
X37 XLP2_P/D6.t1 XLP2_P/G.t3 XLP2_P/S5.t1 XLP2_P/B.t5 sky130_fd_pr__pfet_01v8 ad=0.5874 pd=3.89 as=0.5874 ps=3.89 w=3.56 l=0.15
X38 XLP2_P/S8.t0 XLP2_P/G.t0 XLP2_P/D8.t1 XLP2_P/B.t8 sky130_fd_pr__pfet_01v8 ad=1.1036 pd=7.74 as=0.5874 ps=3.89 w=3.56 l=0.15
X39 XRVCMB/R1.t0 XRVCMB/R2.t0 XRVCMB/B.t0 sky130_fd_pr__res_xhigh_po_1p41 l=94
X40 XDP_P/D2.t1 XDP_P/G.t3 XDP_P/S1.t1 XDP_P/B.t1 sky130_fd_pr__pfet_01v8 ad=0 pd=0 as=0 ps=0 w=1.6 l=0.15
X41 XDP_P/S3.t1 XDP_P/G.t2 XDP_P/D2.t0 XDP_P/B.t2 sky130_fd_pr__pfet_01v8 ad=0 pd=0 as=0 ps=0 w=1.6 l=0.15
X42 XDP_P/S4.t0 XDP_P/G.t0 XDP_P/D4.t1 XDP_P/B.t4 sky130_fd_pr__pfet_01v8 ad=0 pd=0 as=0 ps=0 w=1.6 l=0.15
X43 XDP_P/S1.t0 XDP_P/G.t4 XDP_P/D0.t0 XDP_P/B.t0 sky130_fd_pr__pfet_01v8 ad=0 pd=0 as=0 ps=0 w=1.6 l=0.15
X44 XDP_P/D4.t0 XDP_P/G.t1 XDP_P/S3.t0 XDP_P/B.t3 sky130_fd_pr__pfet_01v8 ad=0 pd=0 as=0 ps=0 w=1.6 l=0.15
X45 XDN_N/S3.t0 XDN_N/G.t2 XDN_N/D2.t1 XDN_N/B.t2 sky130_fd_pr__nfet_01v8 ad=0 pd=0 as=0 ps=0 w=0.8 l=0.15
X46 XDN_N/D4.t1 XDN_N/G.t1 XDN_N/S3.t1 XDN_N/B.t3 sky130_fd_pr__nfet_01v8 ad=0 pd=0 as=0 ps=0 w=0.8 l=0.15
X47 XDN_N/S1.t0 XDN_N/G.t4 XDN_N/D0.t0 XDN_N/B.t0 sky130_fd_pr__nfet_01v8 ad=0 pd=0 as=0 ps=0 w=0.8 l=0.15
X48 XDN_N/D2.t0 XDN_N/G.t3 XDN_N/S1.t1 XDN_N/B.t1 sky130_fd_pr__nfet_01v8 ad=0 pd=0 as=0 ps=0 w=0.8 l=0.15
X49 XDN_N/S4.t0 XDN_N/G.t0 XDN_N/D4.t0 XDN_N/B.t4 sky130_fd_pr__nfet_01v8 ad=0 pd=0 as=0 ps=0 w=0.8 l=0.15
X50 XDN_P/D2.t1 XDN_P/G.t3 XDN_P/S1.t1 XDN_P/B.t1 sky130_fd_pr__pfet_01v8 ad=0 pd=0 as=0 ps=0 w=1.6 l=0.15
X51 XDN_P/S3.t1 XDN_P/G.t2 XDN_P/D2.t0 XDN_P/B.t2 sky130_fd_pr__pfet_01v8 ad=0 pd=0 as=0 ps=0 w=1.6 l=0.15
X52 XDN_P/S4.t0 XDN_P/G.t0 XDN_P/D4.t1 XDN_P/B.t4 sky130_fd_pr__pfet_01v8 ad=0 pd=0 as=0 ps=0 w=1.6 l=0.15
X53 XDN_P/S1.t0 XDN_P/G.t4 XDN_P/D0.t0 XDN_P/B.t0 sky130_fd_pr__pfet_01v8 ad=0 pd=0 as=0 ps=0 w=1.6 l=0.15
X54 XDN_P/D4.t0 XDN_P/G.t1 XDN_P/S3.t0 XDN_P/B.t3 sky130_fd_pr__pfet_01v8 ad=0 pd=0 as=0 ps=0 w=1.6 l=0.15
X55 vcm XCVCM/C2.t0 sky130_fd_pr__cap_mim_m3_1 l=22 w=22
X56 XCH1_GM2A/D4.t1 XCH1_GM2A/G.t1 XCH1_GM2A/S3.t1 XCH1_GM2A/B.t3 sky130_fd_pr__nfet_01v8 ad=0.232 pd=1.89 as=0.232 ps=1.89 w=1.6 l=0.3
X57 XCH1_GM2A/S1.t0 XCH1_GM2A/G.t4 XCH1_GM2A/D0.t0 XCH1_GM2A/B.t0 sky130_fd_pr__nfet_01v8 ad=0.232 pd=1.89 as=0.464 ps=3.78 w=1.6 l=0.3
X58 XCH1_GM2A/D2.t1 XCH1_GM2A/G.t3 XCH1_GM2A/S1.t1 XCH1_GM2A/B.t1 sky130_fd_pr__nfet_01v8 ad=0.232 pd=1.89 as=0.232 ps=1.89 w=1.6 l=0.3
X59 XCH1_GM2A/S3.t0 XCH1_GM2A/G.t2 XCH1_GM2A/D2.t0 XCH1_GM2A/B.t2 sky130_fd_pr__nfet_01v8 ad=0.232 pd=1.89 as=0.232 ps=1.89 w=1.6 l=0.3
X60 XCH1_GM2A/S4.t0 XCH1_GM2A/G.t0 XCH1_GM2A/D4.t0 XCH1_GM2A/B.t4 sky130_fd_pr__nfet_01v8 ad=0.464 pd=3.78 as=0.232 ps=1.89 w=1.6 l=0.3
X61 XCH1_GM2B/D4.t1 XCH1_GM2B/G.t1 XCH1_GM2B/S3.t1 XCH1_GM2B/B.t3 sky130_fd_pr__nfet_01v8 ad=0 pd=0 as=0 ps=0 w=1.6 l=0.3
X62 XCH1_GM2B/S1.t0 XCH1_GM2B/G.t4 XCH1_GM2B/D0.t0 XCH1_GM2B/B.t0 sky130_fd_pr__nfet_01v8 ad=0 pd=0 as=0 ps=0 w=1.6 l=0.3
X63 XCH1_GM2B/D2.t1 XCH1_GM2B/G.t3 XCH1_GM2B/S1.t1 XCH1_GM2B/B.t1 sky130_fd_pr__nfet_01v8 ad=0 pd=0 as=0 ps=0 w=1.6 l=0.3
X64 XCH1_GM2B/S3.t0 XCH1_GM2B/G.t2 XCH1_GM2B/D2.t0 XCH1_GM2B/B.t2 sky130_fd_pr__nfet_01v8 ad=0 pd=0 as=0 ps=0 w=1.6 l=0.3
X65 XCH1_GM2B/S4.t0 XCH1_GM2B/G.t0 XCH1_GM2B/D4.t0 XCH1_GM2B/B.t4 sky130_fd_pr__nfet_01v8 ad=0 pd=0 as=0 ps=0 w=1.6 l=0.3
X66 XCH1_GM1A/D4.t1 XCH1_GM1A/G.t1 XCH1_GM1A/S3.t1 XCH1_GM1A/B.t3 sky130_fd_pr__nfet_01v8 ad=0 pd=0 as=0 ps=0 w=1.6 l=0.3
X67 XCH1_GM1A/S1.t0 XCH1_GM1A/G.t4 XCH1_GM1A/D0.t0 XCH1_GM1A/B.t0 sky130_fd_pr__nfet_01v8 ad=0 pd=0 as=0 ps=0 w=1.6 l=0.3
X68 XCH1_GM1A/D2.t1 XCH1_GM1A/G.t3 XCH1_GM1A/S1.t1 XCH1_GM1A/B.t1 sky130_fd_pr__nfet_01v8 ad=0 pd=0 as=0 ps=0 w=1.6 l=0.3
X69 XCH1_GM1A/S3.t0 XCH1_GM1A/G.t2 XCH1_GM1A/D2.t0 XCH1_GM1A/B.t2 sky130_fd_pr__nfet_01v8 ad=0 pd=0 as=0 ps=0 w=1.6 l=0.3
X70 XCH1_GM1A/S4.t0 XCH1_GM1A/G.t0 XCH1_GM1A/D4.t0 XCH1_GM1A/B.t4 sky130_fd_pr__nfet_01v8 ad=0 pd=0 as=0 ps=0 w=1.6 l=0.3
X71 XCH1_GM1B/D4.t1 XCH1_GM1B/G.t1 XCH1_GM1B/S3.t1 XCH1_GM1B/B.t3 sky130_fd_pr__nfet_01v8 ad=0 pd=0 as=0 ps=0 w=1.6 l=0.3
X72 XCH1_GM1B/S1.t0 XCH1_GM1B/G.t4 XCH1_GM1B/D0.t0 XCH1_GM1B/B.t0 sky130_fd_pr__nfet_01v8 ad=0 pd=0 as=0 ps=0 w=1.6 l=0.3
X73 XCH1_GM1B/D2.t1 XCH1_GM1B/G.t3 XCH1_GM1B/S1.t1 XCH1_GM1B/B.t1 sky130_fd_pr__nfet_01v8 ad=0 pd=0 as=0 ps=0 w=1.6 l=0.3
X74 XCH1_GM1B/S3.t0 XCH1_GM1B/G.t2 XCH1_GM1B/D2.t0 XCH1_GM1B/B.t2 sky130_fd_pr__nfet_01v8 ad=0 pd=0 as=0 ps=0 w=1.6 l=0.3
X75 XCH1_GM1B/S4.t0 XCH1_GM1B/G.t0 XCH1_GM1B/D4.t0 XCH1_GM1B/B.t4 sky130_fd_pr__nfet_01v8 ad=0 pd=0 as=0 ps=0 w=1.6 l=0.3
X76 XLN2_N/S3.t0 XLN2_N/G.t2 XLN2_N/D2.t1 XLN2_N/B.t2 sky130_fd_pr__nfet_01v8 ad=0 pd=0 as=0 ps=0 w=0.8 l=0.15
X77 XLN2_N/D4.t1 XLN2_N/G.t1 XLN2_N/S3.t1 XLN2_N/B.t3 sky130_fd_pr__nfet_01v8 ad=0 pd=0 as=0 ps=0 w=0.8 l=0.15
X78 XLN2_N/S1.t0 XLN2_N/G.t4 XLN2_N/D0.t0 XLN2_N/B.t0 sky130_fd_pr__nfet_01v8 ad=0 pd=0 as=0 ps=0 w=0.8 l=0.15
X79 XLN2_N/D2.t0 XLN2_N/G.t3 XLN2_N/S1.t1 XLN2_N/B.t1 sky130_fd_pr__nfet_01v8 ad=0 pd=0 as=0 ps=0 w=0.8 l=0.15
X80 XLN2_N/S4.t0 XLN2_N/G.t0 XLN2_N/D4.t0 XLN2_N/B.t4 sky130_fd_pr__nfet_01v8 ad=0 pd=0 as=0 ps=0 w=0.8 l=0.15
X81 XRIN1/R1.t0 XRIN1/R2.t0 XRIN1/B.t0 sky130_fd_pr__res_xhigh_po_1p41 l=70.5
X82 XRIN2/R1.t0 XRIN2/R2.t0 XRIN2/B.t0 sky130_fd_pr__res_xhigh_po_1p41 l=70.5
X83 XLN2_P/D2.t1 XLN2_P/G.t3 XLN2_P/S1.t1 XLN2_P/B.t1 sky130_fd_pr__pfet_01v8 ad=0 pd=0 as=0 ps=0 w=1.6 l=0.15
X84 XLN2_P/S3.t1 XLN2_P/G.t2 XLN2_P/D2.t0 XLN2_P/B.t2 sky130_fd_pr__pfet_01v8 ad=0 pd=0 as=0 ps=0 w=1.6 l=0.15
X85 XLN2_P/S4.t0 XLN2_P/G.t0 XLN2_P/D4.t1 XLN2_P/B.t4 sky130_fd_pr__pfet_01v8 ad=0 pd=0 as=0 ps=0 w=1.6 l=0.15
X86 XLN2_P/S1.t0 XLN2_P/G.t4 XLN2_P/D0.t0 XLN2_P/B.t0 sky130_fd_pr__pfet_01v8 ad=0 pd=0 as=0 ps=0 w=1.6 l=0.15
X87 XLN2_P/D4.t0 XLN2_P/G.t1 XLN2_P/S3.t0 XLN2_P/B.t3 sky130_fd_pr__pfet_01v8 ad=0 pd=0 as=0 ps=0 w=1.6 l=0.15
X88 XCH2_SW4A/D2.t0 XCH2_SW4A/G.t3 XCH2_SW4A/S1.t1 XCH2_SW4A/B.t1 sky130_fd_pr__nfet_01v8 ad=0.264 pd=1.93 as=0.264 ps=1.93 w=1.6 l=0.15
X89 XCH2_SW4A/S3.t1 XCH2_SW4A/G.t2 XCH2_SW4A/D2.t1 XCH2_SW4A/B.t2 sky130_fd_pr__nfet_01v8 ad=0.264 pd=1.93 as=0.264 ps=1.93 w=1.6 l=0.15
X90 XCH2_SW4A/S4.t0 XCH2_SW4A/G.t0 XCH2_SW4A/D4.t1 XCH2_SW4A/B.t4 sky130_fd_pr__nfet_01v8 ad=0.496 pd=3.82 as=0.264 ps=1.93 w=1.6 l=0.15
X91 XCH2_SW4A/S1.t0 XCH2_SW4A/G.t4 XCH2_SW4A/D0.t0 XCH2_SW4A/B.t0 sky130_fd_pr__nfet_01v8 ad=0.264 pd=1.93 as=0.496 ps=3.82 w=1.6 l=0.15
X92 XCH2_SW4A/D4.t0 XCH2_SW4A/G.t1 XCH2_SW4A/S3.t0 XCH2_SW4A/B.t3 sky130_fd_pr__nfet_01v8 ad=0.264 pd=1.93 as=0.264 ps=1.93 w=1.6 l=0.15
X93 XSELB_N/D2.t0 XSELB_N/G.t1 XSELB_N/S1.t0 XSELB_N/B.t1 sky130_fd_pr__nfet_01v8 ad=0.132 pd=1.13 as=0.132 ps=1.13 w=0.8 l=0.15
X94 XSELB_N/S2.t0 XSELB_N/G.t0 XSELB_N/D2.t1 XSELB_N/B.t2 sky130_fd_pr__nfet_01v8 ad=0.248 pd=2.22 as=0.132 ps=1.13 w=0.8 l=0.15
X95 XSELB_N/S1.t1 XSELB_N/G.t2 XSELB_N/D0.t0 XSELB_N/B.t0 sky130_fd_pr__nfet_01v8 ad=0.132 pd=1.13 as=0.248 ps=2.22 w=0.8 l=0.15
X96 XCH2_SW3A/D2.t0 XCH2_SW3A/G.t3 XCH2_SW3A/S1.t1 XCH2_SW3A/B.t1 sky130_fd_pr__nfet_01v8 ad=0 pd=0 as=0 ps=0 w=1.6 l=0.15
X97 XCH2_SW3A/S3.t1 XCH2_SW3A/G.t2 XCH2_SW3A/D2.t1 XCH2_SW3A/B.t2 sky130_fd_pr__nfet_01v8 ad=0 pd=0 as=0 ps=0 w=1.6 l=0.15
X98 XCH2_SW3A/S4.t0 XCH2_SW3A/G.t0 XCH2_SW3A/D4.t1 XCH2_SW3A/B.t4 sky130_fd_pr__nfet_01v8 ad=0 pd=0 as=0 ps=0 w=1.6 l=0.15
X99 XCH2_SW3A/S1.t0 XCH2_SW3A/G.t4 XCH2_SW3A/D0.t0 XCH2_SW3A/B.t0 sky130_fd_pr__nfet_01v8 ad=0 pd=0 as=0 ps=0 w=1.6 l=0.15
X100 XCH2_SW3A/D4.t0 XCH2_SW3A/G.t1 XCH2_SW3A/S3.t0 XCH2_SW3A/B.t3 sky130_fd_pr__nfet_01v8 ad=0 pd=0 as=0 ps=0 w=1.6 l=0.15
X101 XCH2_SW4B/D2.t0 XCH2_SW4B/G.t3 XCH2_SW4B/S1.t1 XCH2_SW4B/B.t1 sky130_fd_pr__nfet_01v8 ad=0 pd=0 as=0 ps=0 w=1.6 l=0.15
X102 XCH2_SW4B/S3.t1 XCH2_SW4B/G.t2 XCH2_SW4B/D2.t1 XCH2_SW4B/B.t2 sky130_fd_pr__nfet_01v8 ad=0 pd=0 as=0 ps=0 w=1.6 l=0.15
X103 XCH2_SW4B/S4.t0 XCH2_SW4B/G.t0 XCH2_SW4B/D4.t1 XCH2_SW4B/B.t4 sky130_fd_pr__nfet_01v8 ad=0 pd=0 as=0 ps=0 w=1.6 l=0.15
X104 XCH2_SW4B/S1.t0 XCH2_SW4B/G.t4 XCH2_SW4B/D0.t0 XCH2_SW4B/B.t0 sky130_fd_pr__nfet_01v8 ad=0 pd=0 as=0 ps=0 w=1.6 l=0.15
X105 XCH2_SW4B/D4.t0 XCH2_SW4B/G.t1 XCH2_SW4B/S3.t0 XCH2_SW4B/B.t3 sky130_fd_pr__nfet_01v8 ad=0 pd=0 as=0 ps=0 w=1.6 l=0.15
X106 XBIASA/D2.t1 XBIASA/G.t7 XBIASA/S1.t1 XBIASA/B.t1 sky130_fd_pr__nfet_01v8 ad=0.2581 pd=2.07 as=0.2581 ps=2.07 w=1.78 l=0.5
X107 XBIASA/D8.t0 XBIASA/G.t1 XBIASA/S7.t0 XBIASA/B.t7 sky130_fd_pr__nfet_01v8 ad=0.2581 pd=2.07 as=0.2581 ps=2.07 w=1.78 l=0.5
X108 XBIASA/D4.t1 XBIASA/G.t5 XBIASA/S3.t0 XBIASA/B.t3 sky130_fd_pr__nfet_01v8 ad=0.2581 pd=2.07 as=0.2581 ps=2.07 w=1.78 l=0.5
X109 XBIASA/D6.t1 XBIASA/G.t3 XBIASA/S5.t0 XBIASA/B.t5 sky130_fd_pr__nfet_01v8 ad=0.2581 pd=2.07 as=0.2581 ps=2.07 w=1.78 l=0.5
X110 XBIASA/S1.t0 XBIASA/G.t8 XBIASA/D0.t0 XBIASA/B.t0 sky130_fd_pr__nfet_01v8 ad=0.2581 pd=2.07 as=0.5162 ps=4.14 w=1.78 l=0.5
X111 XBIASA/S8.t0 XBIASA/G.t0 XBIASA/D8.t1 XBIASA/B.t8 sky130_fd_pr__nfet_01v8 ad=0.5162 pd=4.14 as=0.2581 ps=2.07 w=1.78 l=0.5
X112 XBIASA/S3.t1 XBIASA/G.t6 XBIASA/D2.t0 XBIASA/B.t2 sky130_fd_pr__nfet_01v8 ad=0.2581 pd=2.07 as=0.2581 ps=2.07 w=1.78 l=0.5
X113 XBIASA/S7.t1 XBIASA/G.t2 XBIASA/D6.t0 XBIASA/B.t6 sky130_fd_pr__nfet_01v8 ad=0.2581 pd=2.07 as=0.2581 ps=2.07 w=1.78 l=0.5
X114 XBIASA/S5.t1 XBIASA/G.t4 XBIASA/D4.t0 XBIASA/B.t4 sky130_fd_pr__nfet_01v8 ad=0.2581 pd=2.07 as=0.2581 ps=2.07 w=1.78 l=0.5
X115 XCH2LP_N/D2.t0 XCH2LP_N/G.t3 XCH2LP_N/S1.t1 XCH2LP_N/B.t1 sky130_fd_pr__nfet_01v8 ad=0 pd=0 as=0 ps=0 w=1.6 l=0.15
X116 XCH2LP_N/S3.t1 XCH2LP_N/G.t2 XCH2LP_N/D2.t1 XCH2LP_N/B.t2 sky130_fd_pr__nfet_01v8 ad=0 pd=0 as=0 ps=0 w=1.6 l=0.15
X117 XCH2LP_N/S4.t0 XCH2LP_N/G.t0 XCH2LP_N/D4.t1 XCH2LP_N/B.t4 sky130_fd_pr__nfet_01v8 ad=0 pd=0 as=0 ps=0 w=1.6 l=0.15
X118 XCH2LP_N/S1.t0 XCH2LP_N/G.t4 XCH2LP_N/D0.t0 XCH2LP_N/B.t0 sky130_fd_pr__nfet_01v8 ad=0 pd=0 as=0 ps=0 w=1.6 l=0.15
X119 XCH2LP_N/D4.t0 XCH2LP_N/G.t1 XCH2LP_N/S3.t0 XCH2LP_N/B.t3 sky130_fd_pr__nfet_01v8 ad=0 pd=0 as=0 ps=0 w=1.6 l=0.15
X120 XSELB_P/S2.t0 XSELB_P/G.t0 XSELB_P/D2.t0 XSELB_P/B.t2 sky130_fd_pr__pfet_01v8 ad=0.4123 pd=3.28 as=0.21945 ps=1.66 w=1.33 l=0.15
X121 XSELB_P/S1.t1 XSELB_P/G.t2 XSELB_P/D0.t0 XSELB_P/B.t0 sky130_fd_pr__pfet_01v8 ad=0.21945 pd=1.66 as=0.4123 ps=3.28 w=1.33 l=0.15
X122 XSELB_P/D2.t1 XSELB_P/G.t1 XSELB_P/S1.t0 XSELB_P/B.t1 sky130_fd_pr__pfet_01v8 ad=0.21945 pd=1.66 as=0.21945 ps=1.66 w=1.33 l=0.15
X123 XLP1_N/D2.t0 XLP1_N/G.t1 XLP1_N/S1.t0 XLP1_N/B.t1 sky130_fd_pr__nfet_01v8 ad=0 pd=0 as=0 ps=0 w=0.8 l=0.15
X124 XLP1_N/S2.t0 XLP1_N/G.t0 XLP1_N/D2.t1 XLP1_N/B.t2 sky130_fd_pr__nfet_01v8 ad=0 pd=0 as=0 ps=0 w=0.8 l=0.15
X125 XLP1_N/S1.t1 XLP1_N/G.t2 XLP1_N/D0.t0 XLP1_N/B.t0 sky130_fd_pr__nfet_01v8 ad=0 pd=0 as=0 ps=0 w=0.8 l=0.15
X126 XCH2_TAILA/S7.t0 XCH2_TAILA/G.t2 XCH2_TAILA/D6.t0 XCH2_TAILA/B.t6 sky130_fd_pr__nfet_01v8 ad=0.30595 pd=2.4 as=0.30595 ps=2.4 w=2.11 l=0.5
X127 XCH2_TAILA/S5.t0 XCH2_TAILA/G.t4 XCH2_TAILA/D4.t0 XCH2_TAILA/B.t4 sky130_fd_pr__nfet_01v8 ad=0.30595 pd=2.4 as=0.30595 ps=2.4 w=2.11 l=0.5
X128 XCH2_TAILA/D2.t1 XCH2_TAILA/G.t7 XCH2_TAILA/S1.t1 XCH2_TAILA/B.t1 sky130_fd_pr__nfet_01v8 ad=0.30595 pd=2.4 as=0.30595 ps=2.4 w=2.11 l=0.5
X129 XCH2_TAILA/D8.t1 XCH2_TAILA/G.t1 XCH2_TAILA/S7.t1 XCH2_TAILA/B.t7 sky130_fd_pr__nfet_01v8 ad=0.30595 pd=2.4 as=0.30595 ps=2.4 w=2.11 l=0.5
X130 XCH2_TAILA/D4.t1 XCH2_TAILA/G.t5 XCH2_TAILA/S3.t0 XCH2_TAILA/B.t3 sky130_fd_pr__nfet_01v8 ad=0.30595 pd=2.4 as=0.30595 ps=2.4 w=2.11 l=0.5
X131 XCH2_TAILA/D6.t1 XCH2_TAILA/G.t3 XCH2_TAILA/S5.t1 XCH2_TAILA/B.t5 sky130_fd_pr__nfet_01v8 ad=0.30595 pd=2.4 as=0.30595 ps=2.4 w=2.11 l=0.5
X132 XCH2_TAILA/S1.t0 XCH2_TAILA/G.t8 XCH2_TAILA/D0.t0 XCH2_TAILA/B.t0 sky130_fd_pr__nfet_01v8 ad=0.30595 pd=2.4 as=0.6119 ps=4.8 w=2.11 l=0.5
X133 XCH2_TAILA/S8.t0 XCH2_TAILA/G.t0 XCH2_TAILA/D8.t0 XCH2_TAILA/B.t8 sky130_fd_pr__nfet_01v8 ad=0.6119 pd=4.8 as=0.30595 ps=2.4 w=2.11 l=0.5
X134 XCH2_TAILA/S3.t1 XCH2_TAILA/G.t6 XCH2_TAILA/D2.t0 XCH2_TAILA/B.t2 sky130_fd_pr__nfet_01v8 ad=0.30595 pd=2.4 as=0.30595 ps=2.4 w=2.11 l=0.5
X135 XCH2_SW3B/D2.t0 XCH2_SW3B/G.t3 XCH2_SW3B/S1.t1 XCH2_SW3B/B.t1 sky130_fd_pr__nfet_01v8 ad=0 pd=0 as=0 ps=0 w=1.6 l=0.15
X136 XCH2_SW3B/S3.t1 XCH2_SW3B/G.t2 XCH2_SW3B/D2.t1 XCH2_SW3B/B.t2 sky130_fd_pr__nfet_01v8 ad=0 pd=0 as=0 ps=0 w=1.6 l=0.15
X137 XCH2_SW3B/S4.t0 XCH2_SW3B/G.t0 XCH2_SW3B/D4.t1 XCH2_SW3B/B.t4 sky130_fd_pr__nfet_01v8 ad=0 pd=0 as=0 ps=0 w=1.6 l=0.15
X138 XCH2_SW3B/S1.t0 XCH2_SW3B/G.t4 XCH2_SW3B/D0.t0 XCH2_SW3B/B.t0 sky130_fd_pr__nfet_01v8 ad=0 pd=0 as=0 ps=0 w=1.6 l=0.15
X139 XCH2_SW3B/D4.t0 XCH2_SW3B/G.t1 XCH2_SW3B/S3.t0 XCH2_SW3B/B.t3 sky130_fd_pr__nfet_01v8 ad=0 pd=0 as=0 ps=0 w=1.6 l=0.15
X140 XCH2_SW2A/D2.t0 XCH2_SW2A/G.t3 XCH2_SW2A/S1.t1 XCH2_SW2A/B.t1 sky130_fd_pr__nfet_01v8 ad=0 pd=0 as=0 ps=0 w=1.6 l=0.15
X141 XCH2_SW2A/S3.t1 XCH2_SW2A/G.t2 XCH2_SW2A/D2.t1 XCH2_SW2A/B.t2 sky130_fd_pr__nfet_01v8 ad=0 pd=0 as=0 ps=0 w=1.6 l=0.15
X142 XCH2_SW2A/S4.t0 XCH2_SW2A/G.t0 XCH2_SW2A/D4.t1 XCH2_SW2A/B.t4 sky130_fd_pr__nfet_01v8 ad=0 pd=0 as=0 ps=0 w=1.6 l=0.15
X143 XCH2_SW2A/S1.t0 XCH2_SW2A/G.t4 XCH2_SW2A/D0.t0 XCH2_SW2A/B.t0 sky130_fd_pr__nfet_01v8 ad=0 pd=0 as=0 ps=0 w=1.6 l=0.15
X144 XCH2_SW2A/D4.t0 XCH2_SW2A/G.t1 XCH2_SW2A/S3.t0 XCH2_SW2A/B.t3 sky130_fd_pr__nfet_01v8 ad=0 pd=0 as=0 ps=0 w=1.6 l=0.15
X145 XBIASB/D2.t1 XBIASB/G.t7 XBIASB/S1.t1 XBIASB/B.t1 sky130_fd_pr__nfet_01v8 ad=0 pd=0 as=0 ps=0 w=1.78 l=0.5
X146 XBIASB/D8.t0 XBIASB/G.t1 XBIASB/S7.t0 XBIASB/B.t7 sky130_fd_pr__nfet_01v8 ad=0 pd=0 as=0 ps=0 w=1.78 l=0.5
X147 XBIASB/D4.t1 XBIASB/G.t5 XBIASB/S3.t0 XBIASB/B.t3 sky130_fd_pr__nfet_01v8 ad=0 pd=0 as=0 ps=0 w=1.78 l=0.5
X148 XBIASB/D6.t1 XBIASB/G.t3 XBIASB/S5.t0 XBIASB/B.t5 sky130_fd_pr__nfet_01v8 ad=0 pd=0 as=0 ps=0 w=1.78 l=0.5
X149 XBIASB/S1.t0 XBIASB/G.t8 XBIASB/D0.t0 XBIASB/B.t0 sky130_fd_pr__nfet_01v8 ad=0 pd=0 as=0 ps=0 w=1.78 l=0.5
X150 XBIASB/S8.t0 XBIASB/G.t0 XBIASB/D8.t1 XBIASB/B.t8 sky130_fd_pr__nfet_01v8 ad=0 pd=0 as=0 ps=0 w=1.78 l=0.5
X151 XBIASB/S3.t1 XBIASB/G.t6 XBIASB/D2.t0 XBIASB/B.t2 sky130_fd_pr__nfet_01v8 ad=0 pd=0 as=0 ps=0 w=1.78 l=0.5
X152 XBIASB/S7.t1 XBIASB/G.t2 XBIASB/D6.t0 XBIASB/B.t6 sky130_fd_pr__nfet_01v8 ad=0 pd=0 as=0 ps=0 w=1.78 l=0.5
X153 XBIASB/S5.t1 XBIASB/G.t4 XBIASB/D4.t0 XBIASB/B.t4 sky130_fd_pr__nfet_01v8 ad=0 pd=0 as=0 ps=0 w=1.78 l=0.5
X154 XCH2_TAILB/S7.t0 XCH2_TAILB/G.t2 XCH2_TAILB/D6.t0 XCH2_TAILB/B.t6 sky130_fd_pr__nfet_01v8 ad=0 pd=0 as=0 ps=0 w=2.11 l=0.5
X155 XCH2_TAILB/S5.t0 XCH2_TAILB/G.t4 XCH2_TAILB/D4.t0 XCH2_TAILB/B.t4 sky130_fd_pr__nfet_01v8 ad=0 pd=0 as=0 ps=0 w=2.11 l=0.5
X156 XCH2_TAILB/D2.t1 XCH2_TAILB/G.t7 XCH2_TAILB/S1.t1 XCH2_TAILB/B.t1 sky130_fd_pr__nfet_01v8 ad=0 pd=0 as=0 ps=0 w=2.11 l=0.5
X157 XCH2_TAILB/D8.t1 XCH2_TAILB/G.t1 XCH2_TAILB/S7.t1 XCH2_TAILB/B.t7 sky130_fd_pr__nfet_01v8 ad=0 pd=0 as=0 ps=0 w=2.11 l=0.5
X158 XCH2_TAILB/D4.t1 XCH2_TAILB/G.t5 XCH2_TAILB/S3.t0 XCH2_TAILB/B.t3 sky130_fd_pr__nfet_01v8 ad=0 pd=0 as=0 ps=0 w=2.11 l=0.5
X159 XCH2_TAILB/D6.t1 XCH2_TAILB/G.t3 XCH2_TAILB/S5.t1 XCH2_TAILB/B.t5 sky130_fd_pr__nfet_01v8 ad=0 pd=0 as=0 ps=0 w=2.11 l=0.5
X160 XCH2_TAILB/S1.t0 XCH2_TAILB/G.t8 XCH2_TAILB/D0.t0 XCH2_TAILB/B.t0 sky130_fd_pr__nfet_01v8 ad=0 pd=0 as=0 ps=0 w=2.11 l=0.5
X161 XCH2_TAILB/S8.t0 XCH2_TAILB/G.t0 XCH2_TAILB/D8.t0 XCH2_TAILB/B.t8 sky130_fd_pr__nfet_01v8 ad=0 pd=0 as=0 ps=0 w=2.11 l=0.5
X162 XCH2_TAILB/S3.t1 XCH2_TAILB/G.t6 XCH2_TAILB/D2.t0 XCH2_TAILB/B.t2 sky130_fd_pr__nfet_01v8 ad=0 pd=0 as=0 ps=0 w=2.11 l=0.5
X163 XCH1_TAILA/S7.t0 XCH1_TAILA/G.t2 XCH1_TAILA/D6.t0 XCH1_TAILA/B.t6 sky130_fd_pr__nfet_01v8 ad=0 pd=0 as=0 ps=0 w=2.11 l=0.5
X164 XCH1_TAILA/S5.t0 XCH1_TAILA/G.t4 XCH1_TAILA/D4.t0 XCH1_TAILA/B.t4 sky130_fd_pr__nfet_01v8 ad=0 pd=0 as=0 ps=0 w=2.11 l=0.5
X165 XCH1_TAILA/D2.t1 XCH1_TAILA/G.t7 XCH1_TAILA/S1.t1 XCH1_TAILA/B.t1 sky130_fd_pr__nfet_01v8 ad=0 pd=0 as=0 ps=0 w=2.11 l=0.5
X166 XCH1_TAILA/D8.t1 XCH1_TAILA/G.t1 XCH1_TAILA/S7.t1 XCH1_TAILA/B.t7 sky130_fd_pr__nfet_01v8 ad=0 pd=0 as=0 ps=0 w=2.11 l=0.5
X167 XCH1_TAILA/D4.t1 XCH1_TAILA/G.t5 XCH1_TAILA/S3.t0 XCH1_TAILA/B.t3 sky130_fd_pr__nfet_01v8 ad=0 pd=0 as=0 ps=0 w=2.11 l=0.5
X168 XCH1_TAILA/D6.t1 XCH1_TAILA/G.t3 XCH1_TAILA/S5.t1 XCH1_TAILA/B.t5 sky130_fd_pr__nfet_01v8 ad=0 pd=0 as=0 ps=0 w=2.11 l=0.5
X169 XCH1_TAILA/S1.t0 XCH1_TAILA/G.t8 XCH1_TAILA/D0.t0 XCH1_TAILA/B.t0 sky130_fd_pr__nfet_01v8 ad=0 pd=0 as=0 ps=0 w=2.11 l=0.5
X170 XCH1_TAILA/S8.t0 XCH1_TAILA/G.t0 XCH1_TAILA/D8.t0 XCH1_TAILA/B.t8 sky130_fd_pr__nfet_01v8 ad=0 pd=0 as=0 ps=0 w=2.11 l=0.5
X171 XCH1_TAILA/S3.t1 XCH1_TAILA/G.t6 XCH1_TAILA/D2.t0 XCH1_TAILA/B.t2 sky130_fd_pr__nfet_01v8 ad=0 pd=0 as=0 ps=0 w=2.11 l=0.5
X172 XCH2_SW1A/D2.t0 XCH2_SW1A/G.t3 XCH2_SW1A/S1.t1 XCH2_SW1A/B.t1 sky130_fd_pr__nfet_01v8 ad=0 pd=0 as=0 ps=0 w=1.6 l=0.15
X173 XCH2_SW1A/S3.t1 XCH2_SW1A/G.t2 XCH2_SW1A/D2.t1 XCH2_SW1A/B.t2 sky130_fd_pr__nfet_01v8 ad=0 pd=0 as=0 ps=0 w=1.6 l=0.15
X174 XCH2_SW1A/S4.t0 XCH2_SW1A/G.t0 XCH2_SW1A/D4.t1 XCH2_SW1A/B.t4 sky130_fd_pr__nfet_01v8 ad=0 pd=0 as=0 ps=0 w=1.6 l=0.15
X175 XCH2_SW1A/S1.t0 XCH2_SW1A/G.t4 XCH2_SW1A/D0.t0 XCH2_SW1A/B.t0 sky130_fd_pr__nfet_01v8 ad=0 pd=0 as=0 ps=0 w=1.6 l=0.15
X176 XCH2_SW1A/D4.t0 XCH2_SW1A/G.t1 XCH2_SW1A/S3.t0 XCH2_SW1A/B.t3 sky130_fd_pr__nfet_01v8 ad=0 pd=0 as=0 ps=0 w=1.6 l=0.15
X177 XCH2_SW2B/D2.t0 XCH2_SW2B/G.t3 XCH2_SW2B/S1.t1 XCH2_SW2B/B.t1 sky130_fd_pr__nfet_01v8 ad=0 pd=0 as=0 ps=0 w=1.6 l=0.15
X178 XCH2_SW2B/S3.t1 XCH2_SW2B/G.t2 XCH2_SW2B/D2.t1 XCH2_SW2B/B.t2 sky130_fd_pr__nfet_01v8 ad=0 pd=0 as=0 ps=0 w=1.6 l=0.15
X179 XCH2_SW2B/S4.t0 XCH2_SW2B/G.t0 XCH2_SW2B/D4.t1 XCH2_SW2B/B.t4 sky130_fd_pr__nfet_01v8 ad=0 pd=0 as=0 ps=0 w=1.6 l=0.15
X180 XCH2_SW2B/S1.t0 XCH2_SW2B/G.t4 XCH2_SW2B/D0.t0 XCH2_SW2B/B.t0 sky130_fd_pr__nfet_01v8 ad=0 pd=0 as=0 ps=0 w=1.6 l=0.15
X181 XCH2_SW2B/D4.t0 XCH2_SW2B/G.t1 XCH2_SW2B/S3.t0 XCH2_SW2B/B.t3 sky130_fd_pr__nfet_01v8 ad=0 pd=0 as=0 ps=0 w=1.6 l=0.15
X182 XCH2LP_P/S1.t0 XCH2LP_P/G.t4 XCH2LP_P/D0.t0 XCH2LP_P/B.t0 sky130_fd_pr__pfet_01v8 ad=0 pd=0 as=0 ps=0 w=3.2 l=0.15
X183 XCH2LP_P/S4.t0 XCH2LP_P/G.t0 XCH2LP_P/D4.t1 XCH2LP_P/B.t4 sky130_fd_pr__pfet_01v8 ad=0 pd=0 as=0 ps=0 w=3.2 l=0.15
X184 XCH2LP_P/D4.t0 XCH2LP_P/G.t1 XCH2LP_P/S3.t1 XCH2LP_P/B.t3 sky130_fd_pr__pfet_01v8 ad=0 pd=0 as=0 ps=0 w=3.2 l=0.15
X185 XCH2LP_P/D2.t1 XCH2LP_P/G.t3 XCH2LP_P/S1.t1 XCH2LP_P/B.t1 sky130_fd_pr__pfet_01v8 ad=0 pd=0 as=0 ps=0 w=3.2 l=0.15
X186 XCH2LP_P/S3.t0 XCH2LP_P/G.t2 XCH2LP_P/D2.t0 XCH2LP_P/B.t2 sky130_fd_pr__pfet_01v8 ad=0 pd=0 as=0 ps=0 w=3.2 l=0.15
X187 XLP1_P/S2.t0 XLP1_P/G.t0 XLP1_P/D2.t0 XLP1_P/B.t2 sky130_fd_pr__pfet_01v8 ad=0 pd=0 as=0 ps=0 w=1.33 l=0.15
X188 XLP1_P/S1.t1 XLP1_P/G.t2 XLP1_P/D0.t0 XLP1_P/B.t0 sky130_fd_pr__pfet_01v8 ad=0 pd=0 as=0 ps=0 w=1.33 l=0.15
X189 XLP1_P/D2.t1 XLP1_P/G.t1 XLP1_P/S1.t0 XLP1_P/B.t1 sky130_fd_pr__pfet_01v8 ad=0 pd=0 as=0 ps=0 w=1.33 l=0.15
X190 XRVCMT/R1.t0 XRVCMT/R2.t0 XRVCMT/B.t0 sky130_fd_pr__res_xhigh_po_1p41 l=47
X191 XCH1_TAILB/S7.t0 XCH1_TAILB/G.t2 XCH1_TAILB/D6.t0 XCH1_TAILB/B.t6 sky130_fd_pr__nfet_01v8 ad=0 pd=0 as=0 ps=0 w=2.11 l=0.5
X192 XCH1_TAILB/S5.t0 XCH1_TAILB/G.t4 XCH1_TAILB/D4.t0 XCH1_TAILB/B.t4 sky130_fd_pr__nfet_01v8 ad=0 pd=0 as=0 ps=0 w=2.11 l=0.5
X193 XCH1_TAILB/D2.t1 XCH1_TAILB/G.t7 XCH1_TAILB/S1.t1 XCH1_TAILB/B.t1 sky130_fd_pr__nfet_01v8 ad=0 pd=0 as=0 ps=0 w=2.11 l=0.5
X194 XCH1_TAILB/D8.t1 XCH1_TAILB/G.t1 XCH1_TAILB/S7.t1 XCH1_TAILB/B.t7 sky130_fd_pr__nfet_01v8 ad=0 pd=0 as=0 ps=0 w=2.11 l=0.5
X195 XCH1_TAILB/D4.t1 XCH1_TAILB/G.t5 XCH1_TAILB/S3.t0 XCH1_TAILB/B.t3 sky130_fd_pr__nfet_01v8 ad=0 pd=0 as=0 ps=0 w=2.11 l=0.5
X196 XCH1_TAILB/D6.t1 XCH1_TAILB/G.t3 XCH1_TAILB/S5.t1 XCH1_TAILB/B.t5 sky130_fd_pr__nfet_01v8 ad=0 pd=0 as=0 ps=0 w=2.11 l=0.5
X197 XCH1_TAILB/S1.t0 XCH1_TAILB/G.t8 XCH1_TAILB/D0.t0 XCH1_TAILB/B.t0 sky130_fd_pr__nfet_01v8 ad=0 pd=0 as=0 ps=0 w=2.11 l=0.5
X198 XCH1_TAILB/S8.t0 XCH1_TAILB/G.t0 XCH1_TAILB/D8.t0 XCH1_TAILB/B.t8 sky130_fd_pr__nfet_01v8 ad=0 pd=0 as=0 ps=0 w=2.11 l=0.5
X199 XCH1_TAILB/S3.t1 XCH1_TAILB/G.t6 XCH1_TAILB/D2.t0 XCH1_TAILB/B.t2 sky130_fd_pr__nfet_01v8 ad=0 pd=0 as=0 ps=0 w=2.11 l=0.5
X200 XCH2_SW1B/D2.t0 XCH2_SW1B/G.t3 XCH2_SW1B/S1.t1 XCH2_SW1B/B.t1 sky130_fd_pr__nfet_01v8 ad=0 pd=0 as=0 ps=0 w=1.6 l=0.15
X201 XCH2_SW1B/S3.t1 XCH2_SW1B/G.t2 XCH2_SW1B/D2.t1 XCH2_SW1B/B.t2 sky130_fd_pr__nfet_01v8 ad=0 pd=0 as=0 ps=0 w=1.6 l=0.15
X202 XCH2_SW1B/S4.t0 XCH2_SW1B/G.t0 XCH2_SW1B/D4.t1 XCH2_SW1B/B.t4 sky130_fd_pr__nfet_01v8 ad=0 pd=0 as=0 ps=0 w=1.6 l=0.15
X203 XCH2_SW1B/S1.t0 XCH2_SW1B/G.t4 XCH2_SW1B/D0.t0 XCH2_SW1B/B.t0 sky130_fd_pr__nfet_01v8 ad=0 pd=0 as=0 ps=0 w=1.6 l=0.15
X204 XCH2_SW1B/D4.t0 XCH2_SW1B/G.t1 XCH2_SW1B/S3.t0 XCH2_SW1B/B.t3 sky130_fd_pr__nfet_01v8 ad=0 pd=0 as=0 ps=0 w=1.6 l=0.15
X205 XCH2LN_N/D2.t0 XCH2LN_N/G.t3 XCH2LN_N/S1.t1 XCH2LN_N/B.t1 sky130_fd_pr__nfet_01v8 ad=0 pd=0 as=0 ps=0 w=1.6 l=0.15
X206 XCH2LN_N/S3.t1 XCH2LN_N/G.t2 XCH2LN_N/D2.t1 XCH2LN_N/B.t2 sky130_fd_pr__nfet_01v8 ad=0 pd=0 as=0 ps=0 w=1.6 l=0.15
X207 XCH2LN_N/S4.t0 XCH2LN_N/G.t0 XCH2LN_N/D4.t1 XCH2LN_N/B.t4 sky130_fd_pr__nfet_01v8 ad=0 pd=0 as=0 ps=0 w=1.6 l=0.15
X208 XCH2LN_N/S1.t0 XCH2LN_N/G.t4 XCH2LN_N/D0.t0 XCH2LN_N/B.t0 sky130_fd_pr__nfet_01v8 ad=0 pd=0 as=0 ps=0 w=1.6 l=0.15
X209 XCH2LN_N/D4.t0 XCH2LN_N/G.t1 XCH2LN_N/S3.t0 XCH2LN_N/B.t3 sky130_fd_pr__nfet_01v8 ad=0 pd=0 as=0 ps=0 w=1.6 l=0.15
X210 XCH2LN_P/S1.t0 XCH2LN_P/G.t4 XCH2LN_P/D0.t0 XCH2LN_P/B.t0 sky130_fd_pr__pfet_01v8 ad=0 pd=0 as=0 ps=0 w=3.2 l=0.15
X211 XCH2LN_P/S4.t0 XCH2LN_P/G.t0 XCH2LN_P/D4.t1 XCH2LN_P/B.t4 sky130_fd_pr__pfet_01v8 ad=0 pd=0 as=0 ps=0 w=3.2 l=0.15
X212 XCH2LN_P/D4.t0 XCH2LN_P/G.t1 XCH2LN_P/S3.t1 XCH2LN_P/B.t3 sky130_fd_pr__pfet_01v8 ad=0 pd=0 as=0 ps=0 w=3.2 l=0.15
X213 XCH2LN_P/D2.t1 XCH2LN_P/G.t3 XCH2LN_P/S1.t1 XCH2LN_P/B.t1 sky130_fd_pr__pfet_01v8 ad=0 pd=0 as=0 ps=0 w=3.2 l=0.15
X214 XCH2LN_P/S3.t0 XCH2LN_P/G.t2 XCH2LN_P/D2.t0 XCH2LN_P/B.t2 sky130_fd_pr__pfet_01v8 ad=0 pd=0 as=0 ps=0 w=3.2 l=0.15
X215 XLN3_N/D4.t0 XLN3_N/G.t5 XLN3_N/S3.t0 XLN3_N/B.t3 sky130_fd_pr__nfet_01v8 ad=0 pd=0 as=0 ps=0 w=1.78 l=0.15
X216 XLN3_N/S5.t0 XLN3_N/G.t4 XLN3_N/D4.t1 XLN3_N/B.t4 sky130_fd_pr__nfet_01v8 ad=0 pd=0 as=0 ps=0 w=1.78 l=0.15
X217 XLN3_N/S1.t1 XLN3_N/G.t8 XLN3_N/D0.t0 XLN3_N/B.t0 sky130_fd_pr__nfet_01v8 ad=0 pd=0 as=0 ps=0 w=1.78 l=0.15
X218 XLN3_N/D2.t0 XLN3_N/G.t7 XLN3_N/S1.t0 XLN3_N/B.t1 sky130_fd_pr__nfet_01v8 ad=0 pd=0 as=0 ps=0 w=1.78 l=0.15
X219 XLN3_N/D8.t0 XLN3_N/G.t1 XLN3_N/S7.t1 XLN3_N/B.t7 sky130_fd_pr__nfet_01v8 ad=0 pd=0 as=0 ps=0 w=1.78 l=0.15
X220 XLN3_N/S7.t0 XLN3_N/G.t2 XLN3_N/D6.t0 XLN3_N/B.t6 sky130_fd_pr__nfet_01v8 ad=0 pd=0 as=0 ps=0 w=1.78 l=0.15
X221 XLN3_N/S3.t1 XLN3_N/G.t6 XLN3_N/D2.t1 XLN3_N/B.t2 sky130_fd_pr__nfet_01v8 ad=0 pd=0 as=0 ps=0 w=1.78 l=0.15
X222 XLN3_N/D6.t1 XLN3_N/G.t3 XLN3_N/S5.t1 XLN3_N/B.t5 sky130_fd_pr__nfet_01v8 ad=0 pd=0 as=0 ps=0 w=1.78 l=0.15
X223 XLN3_N/S8.t0 XLN3_N/G.t0 XLN3_N/D8.t1 XLN3_N/B.t8 sky130_fd_pr__nfet_01v8 ad=0 pd=0 as=0 ps=0 w=1.78 l=0.15
X224 XCH1_SW4A/D2.t0 XCH1_SW4A/G.t3 XCH1_SW4A/S1.t1 XCH1_SW4A/B.t1 sky130_fd_pr__nfet_01v8 ad=0 pd=0 as=0 ps=0 w=1.6 l=0.15
X225 XCH1_SW4A/S3.t1 XCH1_SW4A/G.t2 XCH1_SW4A/D2.t1 XCH1_SW4A/B.t2 sky130_fd_pr__nfet_01v8 ad=0 pd=0 as=0 ps=0 w=1.6 l=0.15
X226 XCH1_SW4A/S4.t0 XCH1_SW4A/G.t0 XCH1_SW4A/D4.t1 XCH1_SW4A/B.t4 sky130_fd_pr__nfet_01v8 ad=0 pd=0 as=0 ps=0 w=1.6 l=0.15
X227 XCH1_SW4A/S1.t0 XCH1_SW4A/G.t4 XCH1_SW4A/D0.t0 XCH1_SW4A/B.t0 sky130_fd_pr__nfet_01v8 ad=0 pd=0 as=0 ps=0 w=1.6 l=0.15
X228 XCH1_SW4A/D4.t0 XCH1_SW4A/G.t1 XCH1_SW4A/S3.t0 XCH1_SW4A/B.t3 sky130_fd_pr__nfet_01v8 ad=0 pd=0 as=0 ps=0 w=1.6 l=0.15
X229 XCH1_SW4B/D2.t0 XCH1_SW4B/G.t3 XCH1_SW4B/S1.t1 XCH1_SW4B/B.t1 sky130_fd_pr__nfet_01v8 ad=0 pd=0 as=0 ps=0 w=1.6 l=0.15
X230 XCH1_SW4B/S3.t1 XCH1_SW4B/G.t2 XCH1_SW4B/D2.t1 XCH1_SW4B/B.t2 sky130_fd_pr__nfet_01v8 ad=0 pd=0 as=0 ps=0 w=1.6 l=0.15
X231 XCH1_SW4B/S4.t0 XCH1_SW4B/G.t0 XCH1_SW4B/D4.t1 XCH1_SW4B/B.t4 sky130_fd_pr__nfet_01v8 ad=0 pd=0 as=0 ps=0 w=1.6 l=0.15
X232 XCH1_SW4B/S1.t0 XCH1_SW4B/G.t4 XCH1_SW4B/D0.t0 XCH1_SW4B/B.t0 sky130_fd_pr__nfet_01v8 ad=0 pd=0 as=0 ps=0 w=1.6 l=0.15
X233 XCH1_SW4B/D4.t0 XCH1_SW4B/G.t1 XCH1_SW4B/S3.t0 XCH1_SW4B/B.t3 sky130_fd_pr__nfet_01v8 ad=0 pd=0 as=0 ps=0 w=1.6 l=0.15
X234 XCH1_SW3A/D2.t0 XCH1_SW3A/G.t3 XCH1_SW3A/S1.t1 XCH1_SW3A/B.t1 sky130_fd_pr__nfet_01v8 ad=0 pd=0 as=0 ps=0 w=1.6 l=0.15
X235 XCH1_SW3A/S3.t1 XCH1_SW3A/G.t2 XCH1_SW3A/D2.t1 XCH1_SW3A/B.t2 sky130_fd_pr__nfet_01v8 ad=0 pd=0 as=0 ps=0 w=1.6 l=0.15
X236 XCH1_SW3A/S4.t0 XCH1_SW3A/G.t0 XCH1_SW3A/D4.t1 XCH1_SW3A/B.t4 sky130_fd_pr__nfet_01v8 ad=0 pd=0 as=0 ps=0 w=1.6 l=0.15
X237 XCH1_SW3A/S1.t0 XCH1_SW3A/G.t4 XCH1_SW3A/D0.t0 XCH1_SW3A/B.t0 sky130_fd_pr__nfet_01v8 ad=0 pd=0 as=0 ps=0 w=1.6 l=0.15
X238 XCH1_SW3A/D4.t0 XCH1_SW3A/G.t1 XCH1_SW3A/S3.t0 XCH1_SW3A/B.t3 sky130_fd_pr__nfet_01v8 ad=0 pd=0 as=0 ps=0 w=1.6 l=0.15
X239 XCH1LP_N/D2.t0 XCH1LP_N/G.t3 XCH1LP_N/S1.t1 XCH1LP_N/B.t1 sky130_fd_pr__nfet_01v8 ad=0 pd=0 as=0 ps=0 w=1.6 l=0.15
X240 XCH1LP_N/S3.t1 XCH1LP_N/G.t2 XCH1LP_N/D2.t1 XCH1LP_N/B.t2 sky130_fd_pr__nfet_01v8 ad=0 pd=0 as=0 ps=0 w=1.6 l=0.15
X241 XCH1LP_N/S4.t0 XCH1LP_N/G.t0 XCH1LP_N/D4.t1 XCH1LP_N/B.t4 sky130_fd_pr__nfet_01v8 ad=0 pd=0 as=0 ps=0 w=1.6 l=0.15
X242 XCH1LP_N/S1.t0 XCH1LP_N/G.t4 XCH1LP_N/D0.t0 XCH1LP_N/B.t0 sky130_fd_pr__nfet_01v8 ad=0 pd=0 as=0 ps=0 w=1.6 l=0.15
X243 XCH1LP_N/D4.t0 XCH1LP_N/G.t1 XCH1LP_N/S3.t0 XCH1LP_N/B.t3 sky130_fd_pr__nfet_01v8 ad=0 pd=0 as=0 ps=0 w=1.6 l=0.15
X244 XXP_N/S3.t0 XXP_N/G.t2 XXP_N/D2.t1 XXP_N/B.t2 sky130_fd_pr__nfet_01v8 ad=0 pd=0 as=0 ps=0 w=0.8 l=0.15
X245 XXP_N/D4.t1 XXP_N/G.t1 XXP_N/S3.t1 XXP_N/B.t3 sky130_fd_pr__nfet_01v8 ad=0 pd=0 as=0 ps=0 w=0.8 l=0.15
X246 XXP_N/S1.t0 XXP_N/G.t4 XXP_N/D0.t0 XXP_N/B.t0 sky130_fd_pr__nfet_01v8 ad=0 pd=0 as=0 ps=0 w=0.8 l=0.15
X247 XXP_N/D2.t0 XXP_N/G.t3 XXP_N/S1.t1 XXP_N/B.t1 sky130_fd_pr__nfet_01v8 ad=0 pd=0 as=0 ps=0 w=0.8 l=0.15
X248 XXP_N/S4.t0 XXP_N/G.t0 XXP_N/D4.t0 XXP_N/B.t4 sky130_fd_pr__nfet_01v8 ad=0 pd=0 as=0 ps=0 w=0.8 l=0.15
X249 XLN3_P/D4.t1 XLN3_P/G.t5 XLN3_P/S3.t0 XLN3_P/B.t3 sky130_fd_pr__pfet_01v8 ad=0 pd=0 as=0 ps=0 w=3.56 l=0.15
X250 XLN3_P/S5.t0 XLN3_P/G.t4 XLN3_P/D4.t0 XLN3_P/B.t4 sky130_fd_pr__pfet_01v8 ad=0 pd=0 as=0 ps=0 w=3.56 l=0.15
X251 XLN3_P/S1.t0 XLN3_P/G.t8 XLN3_P/D0.t0 XLN3_P/B.t0 sky130_fd_pr__pfet_01v8 ad=0 pd=0 as=0 ps=0 w=3.56 l=0.15
X252 XLN3_P/D2.t1 XLN3_P/G.t7 XLN3_P/S1.t1 XLN3_P/B.t1 sky130_fd_pr__pfet_01v8 ad=0 pd=0 as=0 ps=0 w=3.56 l=0.15
X253 XLN3_P/D8.t0 XLN3_P/G.t1 XLN3_P/S7.t0 XLN3_P/B.t7 sky130_fd_pr__pfet_01v8 ad=0 pd=0 as=0 ps=0 w=3.56 l=0.15
X254 XLN3_P/S3.t1 XLN3_P/G.t6 XLN3_P/D2.t0 XLN3_P/B.t2 sky130_fd_pr__pfet_01v8 ad=0 pd=0 as=0 ps=0 w=3.56 l=0.15
X255 XLN3_P/S7.t1 XLN3_P/G.t2 XLN3_P/D6.t0 XLN3_P/B.t6 sky130_fd_pr__pfet_01v8 ad=0 pd=0 as=0 ps=0 w=3.56 l=0.15
X256 XLN3_P/D6.t1 XLN3_P/G.t3 XLN3_P/S5.t1 XLN3_P/B.t5 sky130_fd_pr__pfet_01v8 ad=0 pd=0 as=0 ps=0 w=3.56 l=0.15
X257 XLN3_P/S8.t0 XLN3_P/G.t0 XLN3_P/D8.t1 XLN3_P/B.t8 sky130_fd_pr__pfet_01v8 ad=0 pd=0 as=0 ps=0 w=3.56 l=0.15
X258 XRBIAS/R1.t0 XRBIAS/R2.t0 XRBIAS/B.t0 sky130_fd_pr__res_high_po_1p41 l=44.98
X259 XCH1_SW3B/D2.t0 XCH1_SW3B/G.t3 XCH1_SW3B/S1.t1 XCH1_SW3B/B.t1 sky130_fd_pr__nfet_01v8 ad=0 pd=0 as=0 ps=0 w=1.6 l=0.15
X260 XCH1_SW3B/S3.t1 XCH1_SW3B/G.t2 XCH1_SW3B/D2.t1 XCH1_SW3B/B.t2 sky130_fd_pr__nfet_01v8 ad=0 pd=0 as=0 ps=0 w=1.6 l=0.15
X261 XCH1_SW3B/S4.t0 XCH1_SW3B/G.t0 XCH1_SW3B/D4.t1 XCH1_SW3B/B.t4 sky130_fd_pr__nfet_01v8 ad=0 pd=0 as=0 ps=0 w=1.6 l=0.15
X262 XCH1_SW3B/S1.t0 XCH1_SW3B/G.t4 XCH1_SW3B/D0.t0 XCH1_SW3B/B.t0 sky130_fd_pr__nfet_01v8 ad=0 pd=0 as=0 ps=0 w=1.6 l=0.15
X263 XCH1_SW3B/D4.t0 XCH1_SW3B/G.t1 XCH1_SW3B/S3.t0 XCH1_SW3B/B.t3 sky130_fd_pr__nfet_01v8 ad=0 pd=0 as=0 ps=0 w=1.6 l=0.15
X264 XCH1_SW2A/D2.t0 XCH1_SW2A/G.t3 XCH1_SW2A/S1.t1 XCH1_SW2A/B.t1 sky130_fd_pr__nfet_01v8 ad=0 pd=0 as=0 ps=0 w=1.6 l=0.15
X265 XCH1_SW2A/S3.t1 XCH1_SW2A/G.t2 XCH1_SW2A/D2.t1 XCH1_SW2A/B.t2 sky130_fd_pr__nfet_01v8 ad=0 pd=0 as=0 ps=0 w=1.6 l=0.15
X266 XCH1_SW2A/S4.t0 XCH1_SW2A/G.t0 XCH1_SW2A/D4.t1 XCH1_SW2A/B.t4 sky130_fd_pr__nfet_01v8 ad=0 pd=0 as=0 ps=0 w=1.6 l=0.15
X267 XCH1_SW2A/S1.t0 XCH1_SW2A/G.t4 XCH1_SW2A/D0.t0 XCH1_SW2A/B.t0 sky130_fd_pr__nfet_01v8 ad=0 pd=0 as=0 ps=0 w=1.6 l=0.15
X268 XCH1_SW2A/D4.t0 XCH1_SW2A/G.t1 XCH1_SW2A/S3.t0 XCH1_SW2A/B.t3 sky130_fd_pr__nfet_01v8 ad=0 pd=0 as=0 ps=0 w=1.6 l=0.15
X269 X1DP_N/S3.t0 X1DP_N/G.t2 X1DP_N/D2.t1 X1DP_N/B.t2 sky130_fd_pr__nfet_01v8 ad=0 pd=0 as=0 ps=0 w=0.8 l=0.15
X270 X1DP_N/D4.t1 X1DP_N/G.t1 X1DP_N/S3.t1 X1DP_N/B.t3 sky130_fd_pr__nfet_01v8 ad=0 pd=0 as=0 ps=0 w=0.8 l=0.15
X271 X1DP_N/S1.t0 X1DP_N/G.t4 X1DP_N/D0.t0 X1DP_N/B.t0 sky130_fd_pr__nfet_01v8 ad=0 pd=0 as=0 ps=0 w=0.8 l=0.15
X272 X1DP_N/D2.t0 X1DP_N/G.t3 X1DP_N/S1.t1 X1DP_N/B.t1 sky130_fd_pr__nfet_01v8 ad=0 pd=0 as=0 ps=0 w=0.8 l=0.15
X273 X1DP_N/S4.t0 X1DP_N/G.t0 X1DP_N/D4.t0 X1DP_N/B.t4 sky130_fd_pr__nfet_01v8 ad=0 pd=0 as=0 ps=0 w=0.8 l=0.15
X274 XLN1_N/D2.t0 XLN1_N/G.t1 XLN1_N/S1.t0 XLN1_N/B.t1 sky130_fd_pr__nfet_01v8 ad=0 pd=0 as=0 ps=0 w=0.8 l=0.15
X275 XLN1_N/S2.t0 XLN1_N/G.t0 XLN1_N/D2.t1 XLN1_N/B.t2 sky130_fd_pr__nfet_01v8 ad=0 pd=0 as=0 ps=0 w=0.8 l=0.15
X276 XLN1_N/S1.t1 XLN1_N/G.t2 XLN1_N/D0.t0 XLN1_N/B.t0 sky130_fd_pr__nfet_01v8 ad=0 pd=0 as=0 ps=0 w=0.8 l=0.15
X277 XCH1_SW2B/D2.t0 XCH1_SW2B/G.t3 XCH1_SW2B/S1.t1 XCH1_SW2B/B.t1 sky130_fd_pr__nfet_01v8 ad=0 pd=0 as=0 ps=0 w=1.6 l=0.15
X278 XCH1_SW2B/S3.t1 XCH1_SW2B/G.t2 XCH1_SW2B/D2.t1 XCH1_SW2B/B.t2 sky130_fd_pr__nfet_01v8 ad=0 pd=0 as=0 ps=0 w=1.6 l=0.15
X279 XCH1_SW2B/S4.t0 XCH1_SW2B/G.t0 XCH1_SW2B/D4.t1 XCH1_SW2B/B.t4 sky130_fd_pr__nfet_01v8 ad=0 pd=0 as=0 ps=0 w=1.6 l=0.15
X280 XCH1_SW2B/S1.t0 XCH1_SW2B/G.t4 XCH1_SW2B/D0.t0 XCH1_SW2B/B.t0 sky130_fd_pr__nfet_01v8 ad=0 pd=0 as=0 ps=0 w=1.6 l=0.15
X281 XCH1_SW2B/D4.t0 XCH1_SW2B/G.t1 XCH1_SW2B/S3.t0 XCH1_SW2B/B.t3 sky130_fd_pr__nfet_01v8 ad=0 pd=0 as=0 ps=0 w=1.6 l=0.15
X282 XCH1_SW1A/D2.t0 XCH1_SW1A/G.t3 XCH1_SW1A/S1.t1 XCH1_SW1A/B.t1 sky130_fd_pr__nfet_01v8 ad=0 pd=0 as=0 ps=0 w=1.6 l=0.15
X283 XCH1_SW1A/S3.t1 XCH1_SW1A/G.t2 XCH1_SW1A/D2.t1 XCH1_SW1A/B.t2 sky130_fd_pr__nfet_01v8 ad=0 pd=0 as=0 ps=0 w=1.6 l=0.15
X284 XCH1_SW1A/S4.t0 XCH1_SW1A/G.t0 XCH1_SW1A/D4.t1 XCH1_SW1A/B.t4 sky130_fd_pr__nfet_01v8 ad=0 pd=0 as=0 ps=0 w=1.6 l=0.15
X285 XCH1_SW1A/S1.t0 XCH1_SW1A/G.t4 XCH1_SW1A/D0.t0 XCH1_SW1A/B.t0 sky130_fd_pr__nfet_01v8 ad=0 pd=0 as=0 ps=0 w=1.6 l=0.15
X286 XCH1_SW1A/D4.t0 XCH1_SW1A/G.t1 XCH1_SW1A/S3.t0 XCH1_SW1A/B.t3 sky130_fd_pr__nfet_01v8 ad=0 pd=0 as=0 ps=0 w=1.6 l=0.15
X287 XCH1LP_P/S1.t0 XCH1LP_P/G.t4 XCH1LP_P/D0.t0 XCH1LP_P/B.t0 sky130_fd_pr__pfet_01v8 ad=0 pd=0 as=0 ps=0 w=3.2 l=0.15
X288 XCH1LP_P/S4.t0 XCH1LP_P/G.t0 XCH1LP_P/D4.t1 XCH1LP_P/B.t4 sky130_fd_pr__pfet_01v8 ad=0 pd=0 as=0 ps=0 w=3.2 l=0.15
X289 XCH1LP_P/D4.t0 XCH1LP_P/G.t1 XCH1LP_P/S3.t1 XCH1LP_P/B.t3 sky130_fd_pr__pfet_01v8 ad=0 pd=0 as=0 ps=0 w=3.2 l=0.15
X290 XCH1LP_P/D2.t1 XCH1LP_P/G.t3 XCH1LP_P/S1.t1 XCH1LP_P/B.t1 sky130_fd_pr__pfet_01v8 ad=0 pd=0 as=0 ps=0 w=3.2 l=0.15
X291 XCH1LP_P/S3.t0 XCH1LP_P/G.t2 XCH1LP_P/D2.t0 XCH1LP_P/B.t2 sky130_fd_pr__pfet_01v8 ad=0 pd=0 as=0 ps=0 w=3.2 l=0.15
X292 XXP_P/D2.t1 XXP_P/G.t3 XXP_P/S1.t1 XXP_P/B.t1 sky130_fd_pr__pfet_01v8 ad=0 pd=0 as=0 ps=0 w=1.6 l=0.15
X293 XXP_P/S3.t1 XXP_P/G.t2 XXP_P/D2.t0 XXP_P/B.t2 sky130_fd_pr__pfet_01v8 ad=0 pd=0 as=0 ps=0 w=1.6 l=0.15
X294 XXP_P/S4.t0 XXP_P/G.t0 XXP_P/D4.t1 XXP_P/B.t4 sky130_fd_pr__pfet_01v8 ad=0 pd=0 as=0 ps=0 w=1.6 l=0.15
X295 XXP_P/S1.t0 XXP_P/G.t4 XXP_P/D0.t0 XXP_P/B.t0 sky130_fd_pr__pfet_01v8 ad=0 pd=0 as=0 ps=0 w=1.6 l=0.15
X296 XXP_P/D4.t0 XXP_P/G.t1 XXP_P/S3.t0 XXP_P/B.t3 sky130_fd_pr__pfet_01v8 ad=0 pd=0 as=0 ps=0 w=1.6 l=0.15
X297 XLN1_P/S1.t0 XLN1_P/G.t2 XLN1_P/D0.t0 XLN1_P/B.t0 sky130_fd_pr__pfet_01v8 ad=0.132 pd=1.13 as=0.248 ps=2.22 w=0.8 l=0.15
X298 XLN1_P/S2.t0 XLN1_P/G.t0 XLN1_P/D2.t1 XLN1_P/B.t2 sky130_fd_pr__pfet_01v8 ad=0.248 pd=2.22 as=0.132 ps=1.13 w=0.8 l=0.15
X299 XLN1_P/D2.t0 XLN1_P/G.t1 XLN1_P/S1.t1 XLN1_P/B.t1 sky130_fd_pr__pfet_01v8 ad=0.132 pd=1.13 as=0.132 ps=1.13 w=0.8 l=0.15
X300 XCH2_GM2A/D4.t1 XCH2_GM2A/G.t1 XCH2_GM2A/S3.t1 XCH2_GM2A/B.t3 sky130_fd_pr__nfet_01v8 ad=0 pd=0 as=0 ps=0 w=1.6 l=0.3
X301 XCH2_GM2A/S1.t0 XCH2_GM2A/G.t4 XCH2_GM2A/D0.t0 XCH2_GM2A/B.t0 sky130_fd_pr__nfet_01v8 ad=0 pd=0 as=0 ps=0 w=1.6 l=0.3
X302 XCH2_GM2A/D2.t1 XCH2_GM2A/G.t3 XCH2_GM2A/S1.t1 XCH2_GM2A/B.t1 sky130_fd_pr__nfet_01v8 ad=0 pd=0 as=0 ps=0 w=1.6 l=0.3
X303 XCH2_GM2A/S3.t0 XCH2_GM2A/G.t2 XCH2_GM2A/D2.t0 XCH2_GM2A/B.t2 sky130_fd_pr__nfet_01v8 ad=0 pd=0 as=0 ps=0 w=1.6 l=0.3
X304 XCH2_GM2A/S4.t0 XCH2_GM2A/G.t0 XCH2_GM2A/D4.t0 XCH2_GM2A/B.t4 sky130_fd_pr__nfet_01v8 ad=0 pd=0 as=0 ps=0 w=1.6 l=0.3
X305 XCH1_SW1B/D2.t0 XCH1_SW1B/G.t3 XCH1_SW1B/S1.t1 XCH1_SW1B/B.t1 sky130_fd_pr__nfet_01v8 ad=0 pd=0 as=0 ps=0 w=1.6 l=0.15
X306 XCH1_SW1B/S3.t1 XCH1_SW1B/G.t2 XCH1_SW1B/D2.t1 XCH1_SW1B/B.t2 sky130_fd_pr__nfet_01v8 ad=0 pd=0 as=0 ps=0 w=1.6 l=0.15
X307 XCH1_SW1B/S4.t0 XCH1_SW1B/G.t0 XCH1_SW1B/D4.t1 XCH1_SW1B/B.t4 sky130_fd_pr__nfet_01v8 ad=0 pd=0 as=0 ps=0 w=1.6 l=0.15
X308 XCH1_SW1B/S1.t0 XCH1_SW1B/G.t4 XCH1_SW1B/D0.t0 XCH1_SW1B/B.t0 sky130_fd_pr__nfet_01v8 ad=0 pd=0 as=0 ps=0 w=1.6 l=0.15
X309 XCH1_SW1B/D4.t0 XCH1_SW1B/G.t1 XCH1_SW1B/S3.t0 XCH1_SW1B/B.t3 sky130_fd_pr__nfet_01v8 ad=0 pd=0 as=0 ps=0 w=1.6 l=0.15
X310 XCH1LN_N/D2.t0 XCH1LN_N/G.t3 XCH1LN_N/S1.t1 XCH1LN_N/B.t1 sky130_fd_pr__nfet_01v8 ad=0 pd=0 as=0 ps=0 w=1.6 l=0.15
X311 XCH1LN_N/S3.t1 XCH1LN_N/G.t2 XCH1LN_N/D2.t1 XCH1LN_N/B.t2 sky130_fd_pr__nfet_01v8 ad=0 pd=0 as=0 ps=0 w=1.6 l=0.15
X312 XCH1LN_N/S4.t0 XCH1LN_N/G.t0 XCH1LN_N/D4.t1 XCH1LN_N/B.t4 sky130_fd_pr__nfet_01v8 ad=0 pd=0 as=0 ps=0 w=1.6 l=0.15
X313 XCH1LN_N/S1.t0 XCH1LN_N/G.t4 XCH1LN_N/D0.t0 XCH1LN_N/B.t0 sky130_fd_pr__nfet_01v8 ad=0 pd=0 as=0 ps=0 w=1.6 l=0.15
X314 XCH1LN_N/D4.t0 XCH1LN_N/G.t1 XCH1LN_N/S3.t0 XCH1LN_N/B.t3 sky130_fd_pr__nfet_01v8 ad=0 pd=0 as=0 ps=0 w=1.6 l=0.15
X315 XXN_N/S3.t0 XXN_N/G.t2 XXN_N/D2.t1 XXN_N/B.t2 sky130_fd_pr__nfet_01v8 ad=0 pd=0 as=0 ps=0 w=0.8 l=0.15
X316 XXN_N/D4.t1 XXN_N/G.t1 XXN_N/S3.t1 XXN_N/B.t3 sky130_fd_pr__nfet_01v8 ad=0 pd=0 as=0 ps=0 w=0.8 l=0.15
X317 XXN_N/S1.t0 XXN_N/G.t4 XXN_N/D0.t0 XXN_N/B.t0 sky130_fd_pr__nfet_01v8 ad=0 pd=0 as=0 ps=0 w=0.8 l=0.15
X318 XXN_N/D2.t0 XXN_N/G.t3 XXN_N/S1.t1 XXN_N/B.t1 sky130_fd_pr__nfet_01v8 ad=0 pd=0 as=0 ps=0 w=0.8 l=0.15
X319 XXN_N/S4.t0 XXN_N/G.t0 XXN_N/D4.t0 XXN_N/B.t4 sky130_fd_pr__nfet_01v8 ad=0 pd=0 as=0 ps=0 w=0.8 l=0.15
X320 X1DP_P/D2.t1 X1DP_P/G.t3 X1DP_P/S1.t1 X1DP_P/B.t1 sky130_fd_pr__pfet_01v8 ad=0 pd=0 as=0 ps=0 w=1.6 l=0.15
X321 X1DP_P/S3.t1 X1DP_P/G.t2 X1DP_P/D2.t0 X1DP_P/B.t2 sky130_fd_pr__pfet_01v8 ad=0 pd=0 as=0 ps=0 w=1.6 l=0.15
X322 X1DP_P/S4.t0 X1DP_P/G.t0 X1DP_P/D4.t1 X1DP_P/B.t4 sky130_fd_pr__pfet_01v8 ad=0 pd=0 as=0 ps=0 w=1.6 l=0.15
X323 X1DP_P/S1.t0 X1DP_P/G.t4 X1DP_P/D0.t0 X1DP_P/B.t0 sky130_fd_pr__pfet_01v8 ad=0 pd=0 as=0 ps=0 w=1.6 l=0.15
X324 X1DP_P/D4.t0 X1DP_P/G.t1 X1DP_P/S3.t0 X1DP_P/B.t3 sky130_fd_pr__pfet_01v8 ad=0 pd=0 as=0 ps=0 w=1.6 l=0.15
X325 XCH2_GM2B/D4.t1 XCH2_GM2B/G.t1 XCH2_GM2B/S3.t1 XCH2_GM2B/B.t3 sky130_fd_pr__nfet_01v8 ad=0 pd=0 as=0 ps=0 w=1.6 l=0.3
X326 XCH2_GM2B/S1.t0 XCH2_GM2B/G.t4 XCH2_GM2B/D0.t0 XCH2_GM2B/B.t0 sky130_fd_pr__nfet_01v8 ad=0 pd=0 as=0 ps=0 w=1.6 l=0.3
X327 XCH2_GM2B/D2.t1 XCH2_GM2B/G.t3 XCH2_GM2B/S1.t1 XCH2_GM2B/B.t1 sky130_fd_pr__nfet_01v8 ad=0 pd=0 as=0 ps=0 w=1.6 l=0.3
X328 XCH2_GM2B/S3.t0 XCH2_GM2B/G.t2 XCH2_GM2B/D2.t0 XCH2_GM2B/B.t2 sky130_fd_pr__nfet_01v8 ad=0 pd=0 as=0 ps=0 w=1.6 l=0.3
X329 XCH2_GM2B/S4.t0 XCH2_GM2B/G.t0 XCH2_GM2B/D4.t0 XCH2_GM2B/B.t4 sky130_fd_pr__nfet_01v8 ad=0 pd=0 as=0 ps=0 w=1.6 l=0.3
X330 XCH2_GM1A/D4.t1 XCH2_GM1A/G.t1 XCH2_GM1A/S3.t1 XCH2_GM1A/B.t3 sky130_fd_pr__nfet_01v8 ad=0 pd=0 as=0 ps=0 w=1.6 l=0.3
X331 XCH2_GM1A/S1.t0 XCH2_GM1A/G.t4 XCH2_GM1A/D0.t0 XCH2_GM1A/B.t0 sky130_fd_pr__nfet_01v8 ad=0 pd=0 as=0 ps=0 w=1.6 l=0.3
X332 XCH2_GM1A/D2.t1 XCH2_GM1A/G.t3 XCH2_GM1A/S1.t1 XCH2_GM1A/B.t1 sky130_fd_pr__nfet_01v8 ad=0 pd=0 as=0 ps=0 w=1.6 l=0.3
X333 XCH2_GM1A/S3.t0 XCH2_GM1A/G.t2 XCH2_GM1A/D2.t0 XCH2_GM1A/B.t2 sky130_fd_pr__nfet_01v8 ad=0 pd=0 as=0 ps=0 w=1.6 l=0.3
X334 XCH2_GM1A/S4.t0 XCH2_GM1A/G.t0 XCH2_GM1A/D4.t0 XCH2_GM1A/B.t4 sky130_fd_pr__nfet_01v8 ad=0 pd=0 as=0 ps=0 w=1.6 l=0.3
X335 X1DN_N/S3.t0 X1DN_N/G.t2 X1DN_N/D2.t1 X1DN_N/B.t2 sky130_fd_pr__nfet_01v8 ad=0 pd=0 as=0 ps=0 w=0.8 l=0.15
X336 X1DN_N/D4.t1 X1DN_N/G.t1 X1DN_N/S3.t1 X1DN_N/B.t3 sky130_fd_pr__nfet_01v8 ad=0 pd=0 as=0 ps=0 w=0.8 l=0.15
X337 X1DN_N/S1.t0 X1DN_N/G.t4 X1DN_N/D0.t0 X1DN_N/B.t0 sky130_fd_pr__nfet_01v8 ad=0 pd=0 as=0 ps=0 w=0.8 l=0.15
X338 X1DN_N/D2.t0 X1DN_N/G.t3 X1DN_N/S1.t1 X1DN_N/B.t1 sky130_fd_pr__nfet_01v8 ad=0 pd=0 as=0 ps=0 w=0.8 l=0.15
X339 X1DN_N/S4.t0 X1DN_N/G.t0 X1DN_N/D4.t0 X1DN_N/B.t4 sky130_fd_pr__nfet_01v8 ad=0 pd=0 as=0 ps=0 w=0.8 l=0.15
X340 XRLOADN/R1.t0 XRLOADN/R2.t0 XRLOADN/B.t0 sky130_fd_pr__res_high_po_1p41 l=11.61
X341 XCH2_GM1B/D4.t1 XCH2_GM1B/G.t1 XCH2_GM1B/S3.t1 XCH2_GM1B/B.t3 sky130_fd_pr__nfet_01v8 ad=0 pd=0 as=0 ps=0 w=1.6 l=0.3
X342 XCH2_GM1B/S1.t0 XCH2_GM1B/G.t4 XCH2_GM1B/D0.t0 XCH2_GM1B/B.t0 sky130_fd_pr__nfet_01v8 ad=0 pd=0 as=0 ps=0 w=1.6 l=0.3
X343 XCH2_GM1B/D2.t1 XCH2_GM1B/G.t3 XCH2_GM1B/S1.t1 XCH2_GM1B/B.t1 sky130_fd_pr__nfet_01v8 ad=0 pd=0 as=0 ps=0 w=1.6 l=0.3
X344 XCH2_GM1B/S3.t0 XCH2_GM1B/G.t2 XCH2_GM1B/D2.t0 XCH2_GM1B/B.t2 sky130_fd_pr__nfet_01v8 ad=0 pd=0 as=0 ps=0 w=1.6 l=0.3
X345 XCH2_GM1B/S4.t0 XCH2_GM1B/G.t0 XCH2_GM1B/D4.t0 XCH2_GM1B/B.t4 sky130_fd_pr__nfet_01v8 ad=0 pd=0 as=0 ps=0 w=1.6 l=0.3
C0 clk ch2_lon 0.06628f
C1 ch2_lop ch1_lop 0.44237f
C2 ch2_lop_raw uio_out[6] 0
C3 uio_in[6] ch1_lop 0
C4 ui_in[0] uio_oe[0] 0
C5 ch2_lop_raw select_b 1.32256f
C6 ua[3] gm2_p 3.24375f
C7 gm2_p gm1_n 0.07576f
C8 uio_in[1] uio_in[0] 0.03102f
C9 ua[0] ch2_lop 0.173f
C10 vcm ua[5] 0
C11 ch2_lon_raw ui_in[0] 2.15847f
C12 tail2 ua[2] 0.54366f
C13 clk ena 0.03139f
C14 vcm gm2_p 0.26747f
C15 clk ch1_lon_raw 0.00445f
C16 gm2_n ua[1] 0
C17 VDPWR ch1_lop 3.55056f
C18 clk uio_out[4] 0.00355f
C19 ch2_lop_raw uo_out[4] 0
C20 uo_out[0] uio_in[7] 0.03102f
C21 ch2_lon_raw uio_oe[0] 0
C22 ui_in[0] uo_out[6] 0
C23 gm1_p tail2 0.61193f
C24 ch2_lon ui_in[4] 0
C25 VDPWR ua[0] 0.09574f
C26 clk uio_in[3] 0.00355f
C27 ch2_lop_raw ch2_lon 0.93245f
C28 lop uio_oe[4] 0
C29 lop clk 2.19721f
C30 clk uo_out[2] 0.00355f
C31 ui_in[0] rst_n 0.03128f
C32 uo_out[0] lon 0
C33 ua[3] gm2_n 4.59042f
C34 gm2_n gm1_n 10.4655f
C35 ua[1] ua[4] 0
C36 uio_oe[7] uio_oe[6] 0.03102f
C37 vcm gm2_n 2.13702f
C38 ch2_lop_raw ch1_lon_raw 0.10683f
C39 ch2_lop_raw uio_out[4] 0
C40 ch1_lon ch1_lop 9.27329f
C41 ui_in[0] uio_out[6] 0
C42 uio_in[0] ui_in[7] 0.03102f
C43 ua[0] ch1_lon 0.23418f
C44 ui_in[0] select_b 6.85511f
C45 ch1_lon uio_in[2] 0
C46 ch2_lop_raw uio_in[3] 0
C47 lop ch2_lop_raw 4.18104f
C48 ch2_lop ua[2] 1.76795f
C49 ch1_lop ln2 0.19075f
C50 ch2_lop_raw uo_out[2] 0
C51 uio_in[7] uio_in[6] 0.03102f
C52 select_b uio_oe[0] 0
C53 ch2_lon_raw uio_out[6] 0
C54 ui_in[0] uo_out[4] 0
C55 gm1_p ch2_lop 0.04486f
C56 vcm ua[4] 0
C57 ch2_lon ui_in[2] 0
C58 ch2_lon_raw select_b 6.1361f
C59 clk uio_in[1] 0.00355f
C60 lop uio_oe[2] 0
C61 gm2_n gm2_p 0.00165f
C62 VDPWR ua[2] 0.09602f
C63 clk uo_out[0] 0.00355f
C64 ui_in[0] ch2_lon 0.32362f
C65 ch2_lop lon 5.21704f
C66 uio_in[6] lon 0
C67 tail1 tail2 2.74412f
C68 ua[1] ch1_lop 0.0848f
C69 VDPWR uio_oe[6] 0
C70 uio_oe[6] uio_oe[5] 0.03102f
C71 lp1 clk 1.87908f
C72 ch2_lon_raw ch2_lon 1.7526f
C73 VDPWR lon 10.706f
C74 ua[0] ua[1] 10.08878f
C75 ui_in[0] ch1_lon_raw 0.90386f
C76 ui_in[0] uio_out[4] 0
C77 ui_in[7] ui_in[6] 0.03102f
C78 ch1_lon uio_in[0] 0
C79 ch2_lop_raw uio_in[1] 0
C80 ua[3] ch1_lop 3.37973f
C81 ch1_lon ua[2] 9.01618f
C82 gm1_n ch1_lop 1.41185f
C83 ui_in[0] uio_in[3] 0
C84 ch2_lop_raw uo_out[0] 0
C85 uo_out[3] ch1_lop_raw 0
C86 uio_in[6] uio_in[5] 0.03102f
C87 ch2_lon_raw ch1_lon_raw 4.14925f
C88 lop ui_in[0] 4.5598f
C89 select_b uio_out[6] 0
C90 ch2_lon_raw uio_out[4] 0
C91 ui_in[0] uo_out[2] 0
C92 vcm ch1_lop 0.17627f
C93 ch2_lon rst_n 0
C94 vbias ch2_lon 0.12085f
C95 ua[0] ua[3] 1.56688f
C96 gm1_p ch1_lon 1.20815f
C97 ua[0] gm1_n 0.00174f
C98 clk ui_in[7] 0.00355f
C99 lop uio_oe[0] 0
C100 ch2_lop clk 0.00172f
C101 ch2_lop_raw uio_oe[7] 0
C102 lp1 ch2_lop_raw 0.00252f
C103 clk uio_in[6] 0.00355f
C104 ua[0] vcm 5.02821f
C105 ch1_lon lon 1.85811f
C106 lop ch2_lon_raw 5.81689f
C107 uio_in[4] lon 0
C108 uio_oe[5] uio_oe[4] 0.03102f
C109 VDPWR clk 3.79234f
C110 select_b ch2_lon 0
C111 ln2 lon 5.12159f
C112 ch1_lop_raw ch1_lop 1.49371f
C113 gm2_p ch1_lop 0.31051f
C114 ua[1] ua[2] 0.52682f
C115 ui_in[6] ui_in[5] 0.03102f
C116 ch2_lop_raw ui_in[7] 0
C117 ua[0] ua[5] 0.00411f
C118 ch2_lop ch2_lop_raw 2.3844f
C119 ua[0] gm2_p 0.99462f
C120 gm1_p ua[1] 0.16888f
C121 ch2_lop_raw uio_in[6] 0
C122 ui_in[0] uio_in[1] 0
C123 select_b ch1_lon_raw 0.28177f
C124 uio_out[1] lon 0
C125 uio_in[5] uio_in[4] 0.03102f
C126 select_b uio_out[4] 0
C127 ui_in[0] uo_out[0] 0
C128 clk ui_in[5] 0.00355f
C129 VDPWR ch2_lop_raw 10.08965f
C130 ch2_lop_raw uio_oe[5] 0
C131 ua[3] ua[2] 15.30744f
C132 ch1_lon clk 0.00103f
C133 gm1_n ua[2] 3.78485f
C134 clk uio_in[4] 0.00355f
C135 lop select_b 6.85275f
C136 ui_in[0] uio_oe[7] 0
C137 lp1 ui_in[0] 0.00117f
C138 vcm ua[2] 0.31713f
C139 gm2_n ch1_lop 0.1567f
C140 ch2_lon ch1_lon_raw 0.18814f
C141 gm1_p ua[3] 4.03392f
C142 gm1_p gm1_n 0.03737f
C143 uio_oe[4] uio_oe[3] 0.03102f
C144 gm1_p vcm 0.18418f
C145 ua[0] gm2_n 0.00174f
C146 lp1 ch2_lon_raw 0.00479f
C147 lop ch2_lon 0.13526f
C148 ui_in[5] ui_in[4] 0.03102f
C149 tail2 vbias 4.1826f
C150 ch2_lop_raw ui_in[5] 0.00196f
C151 VDPWR uio_out[0] 0.00113f
C152 clk uio_out[1] 0.00355f
C153 ch1_lon ch2_lop_raw 0.30172f
C154 ch2_lop_raw uio_in[4] 0
C155 ui_in[0] ui_in[7] 0
C156 uo_out[7] lon 0
C157 ch2_lop ui_in[0] 0.97811f
C158 gm2_p ua[2] 2.98342f
C159 ui_in[0] uio_in[6] 0
C160 uio_in[3] ch1_lon_raw 0
C161 lop ch1_lon_raw 3.54012f
C162 clk ui_in[3] 0.00355f
C163 ua[0] ua[4] 0.00411f
C164 uio_out[2] uio_out[1] 0.03102f
C165 ch2_lop_raw uio_oe[3] 0
C166 tail1 ua[1] 0.08869f
C167 gm1_p gm2_p 6.39413f
C168 ch2_lop ch2_lon_raw 0.27823f
C169 VDPWR ui_in[0] 10.36689f
C170 ui_in[0] uio_oe[5] 0
C171 ch1_lop_raw lon 3.17642f
C172 uio_oe[3] uio_oe[2] 0.03102f
C173 ch2_lop_raw uio_out[1] 0
C174 clk ln1 0.84173f
C175 VDPWR ch2_lon_raw 4.13077f
C176 lp1 select_b 0.36452f
C177 gm2_n ua[2] 3.68247f
C178 ch2_lon uio_in[1] 0
C179 tail1 ua[3] 0.32718f
C180 tail1 gm1_n 4.77151f
C181 ui_in[4] ui_in[3] 0.03102f
C182 ch2_lop vbias 0.14501f
C183 gm1_p gm2_n 0.00711f
C184 clk uo_out[7] 0.00355f
C185 tail1 vcm 4.11952f
C186 ui_in[0] ui_in[5] 0
C187 uo_out[5] lon 0
C188 ch1_lon ui_in[0] 0.39699f
C189 ui_in[0] uio_in[4] 0
C190 ua[0] ch1_lop 0.30598f
C191 VDPWR rst_n 0.00259f
C192 VDPWR vbias 0.36752f
C193 clk ui_in[1] 0.00355f
C194 uio_out[1] uio_out[0] 0.03102f
C195 ch2_lop_raw uio_oe[1] 0
C196 uo_out[1] ch1_lop 0
C197 clk ch1_lop_raw 0.00445f
C198 ch2_lop_raw ln1 0
C199 ch2_lop select_b 0.1722f
C200 ui_in[0] uio_oe[3] 0
C201 ui_in[0] ln2 0.23011f
C202 ch1_lon ch2_lon_raw 0.08738f
C203 uio_oe[2] uio_oe[1] 0.03102f
C204 clk uio_out[7] 0.00355f
C205 tail1 gm2_p 0.52893f
C206 ch2_lop_raw uo_out[7] 0
C207 VDPWR select_b 3.98106f
C208 ch2_lon_raw ln2 0.00503f
C209 ui_in[0] uio_out[1] 0
C210 ch2_lon ui_in[7] 0
C211 ch2_lop ch2_lon 5.7326f
C212 ui_in[3] ui_in[2] 0.03102f
C213 lop lp1 4.56646f
C214 ch1_lon vbias 2.80333f
C215 clk uo_out[5] 0.00355f
C216 ch2_lop_raw ch1_lop_raw 0.13146f
C217 ui_in[0] ui_in[3] 0
C218 uo_out[3] lon 0
C219 ch2_lon_raw uio_out[1] 0
C220 VDPWR ch2_lon 5.67299f
C221 ch2_lop ch1_lon_raw 1.80686f
C222 tail1 gm2_n 0.42892f
C223 uio_out[0] uo_out[7] 0.03102f
C224 ch2_lop_raw uio_out[7] 0
C225 ch1_lop ua[2] 2.17466f
C226 uio_in[7] ch1_lop 0
C227 ui_in[0] uio_oe[1] 0.00117f
C228 ch1_lon select_b 0.0023f
C229 ui_in[0] ln1 0.13567f
C230 ua[0] ua[2] 1.01537f
C231 gm1_p ch1_lop 1.28878f
C232 VDPWR ch1_lon_raw 3.67336f
C233 lop ch2_lop 4.86269f
C234 uio_oe[1] uio_oe[0] 0.03102f
C235 clk uio_out[5] 0.00355f
C236 ch2_lop_raw uo_out[5] 0
C237 select_b ln2 6.25622f
C238 ch1_lop lon 3.15723f
C239 ch2_lon_raw uio_oe[1] 0
C240 ua[0] gm1_p 2.00578f
C241 ui_in[0] uo_out[7] 0
C242 vbias ua[1] 0.66915f
C243 ch2_lon_raw ln1 0.00154f
C244 ch2_lon ui_in[5] 0
C245 VDPWR uio_in[3] 0.00233f
C246 ui_in[2] ui_in[1] 0.03102f
C247 ch1_lon ch2_lon 5.03226f
C248 VDPWR lop 7.76507f
C249 lop uio_oe[5] 0
C250 VDPWR uo_out[2] 0
C251 lon uio_in[2] 0
C252 clk uo_out[3] 0.00355f
C253 ui_in[0] ui_in[1] 0.03181f
C254 uo_out[1] lon 0
C255 select_b uio_out[1] 0
C256 ui_in[0] ch1_lop_raw 0.1931f
C257 ch2_lon ln2 0.14321f
C258 ua[3] vbias 1.06493f
C259 ch1_lon ch1_lon_raw 1.53161f
C260 uio_in[4] ch1_lon_raw 0
C261 uo_out[7] uo_out[6] 0.03102f
C262 ch2_lop_raw uio_out[5] 0.00365f
C263 uio_in[5] ch1_lop 0.00309f
C264 ui_in[0] uio_out[7] 0
C265 vcm vbias 0.1857f
C266 ch2_lon_raw ch1_lop_raw 5.50535f
C267 ln2 ch1_lon_raw 0.18172f
C268 ch1_lon uio_in[3] 0
C269 uio_in[4] uio_in[3] 0.03102f
C270 ch1_lon lop 0.17587f
C271 uio_oe[0] uio_out[7] 0.03102f
C272 clk uio_out[3] 0.00355f
C273 clk ch1_lop 0.00103f
C274 ch2_lop_raw uo_out[3] 0
C275 ua[1] ch2_lon 0.64126f
C276 select_b uio_oe[1] 0
C277 ch2_lon_raw uio_out[7] 0
C278 ui_in[0] uo_out[5] 0
C279 select_b ln1 1.13067f
C280 ch2_lon ui_in[3] 0
C281 gm1_p ua[2] 3.51077f
C282 clk uio_in[2] 0.00355f
C283 lop uio_oe[3] 0
C284 lop ln2 0.47474f
C285 uio_out[2] uio_out[3] 0.03102f
C286 clk uo_out[1] 0.00355f
C287 ua[0] tail1 1.58488f
C288 uio_in[7] lon 0
C289 ua[3] ch2_lon 3.09451f
C290 ch2_lon gm1_n 0.11645f
C291 VDPWR lp1 5.72913f
C292 ch2_lop_raw uio_out[3] 0
C293 uo_out[6] uo_out[5] 0.03102f
C294 vcm ch2_lon 0.31108f
C295 ch2_lop_raw ch1_lop 0.12924f
C296 ui_in[0] uio_out[5] 0
C297 select_b ch1_lop_raw 0.00372f
C298 ch1_lon uio_in[1] 0
C299 ch2_lop_raw uio_in[2] 0
C300 uio_out[7] uio_out[6] 0.03102f
C301 ch2_lop_raw uo_out[1] 0
C302 select_b uio_out[7] 0.00133f
C303 ch2_lon_raw uio_out[5] 0
C304 ui_in[0] uo_out[3] 0
C305 ch2_lon ui_in[1] 0
C306 VDPWR ch2_lop 5.65826f
C307 clk uio_in[0] 0.00355f
C308 lop uio_oe[1] 0.00236f
C309 ch2_lon ch1_lop_raw 0.09659f
C310 lop ln1 0.01204f
C311 clk uio_in[7] 0.00355f
C312 gm2_p ch2_lon 1.09359f
C313 uio_in[5] lon 0
C314 tail1 ua[2] 0.32489f
C315 VDPWR uio_oe[5] 0.00108f
C316 ch1_lop_raw ch1_lon_raw 2.5287f
C317 uo_out[5] uo_out[4] 0.03102f
C318 clk lon 0.11738f
C319 gm1_p tail1 2.84744f
C320 ua[1] ua[7] 0
C321 tail2 ua[1] 1.53328f
C322 ui_in[0] uio_out[3] 0
C323 ui_in[0] ch1_lop 0.53775f
C324 ch2_lop ui_in[5] 0.00403f
C325 ch1_lon ui_in[7] 0
C326 ch2_lop_raw uio_in[0] 0
C327 ch1_lon ch2_lop 3.5532f
C328 uio_out[6] uio_out[5] 0.03102f
C329 lop ch1_lop_raw 3.09011f
C330 gm2_n ch2_lon 1.1785f
C331 ui_in[0] uio_in[2] 0
C332 ch2_lop_raw uio_in[7] 0
C333 uo_out[2] ch1_lop_raw 0.00246f
C334 select_b uio_out[5] 0
C335 ch2_lon_raw uio_out[3] 0
C336 ui_in[0] uo_out[1] 0
C337 ch2_lon_raw ch1_lop 0.08292f
C338 ua[3] tail2 0.30069f
C339 VDPWR ui_in[5] 0
C340 tail2 gm1_n 0.72536f
C341 clk ui_in[6] 0.00355f
C342 ch2_lop ln2 0.00606f
C343 lop uio_out[7] 0
C344 VDPWR ch1_lon 3.58335f
C345 ch2_lop_raw uio_oe[6] 0
C346 VDPWR uio_in[4] 0.00185f
C347 clk uio_in[5] 0.00355f
C348 vcm tail2 1.8791f
C349 ch2_lop_raw lon 6.55561f
C350 VDPWR ln2 6.05362f
C351 vbias ch1_lop 0.14281f
C352 lp1 ln1 0.00369f
C353 uo_out[4] uo_out[3] 0.03102f
C354 ch2_lop ua[1] 0.60863f
C355 ua[0] vbias 0.7112f
C356 ch2_lop_raw ui_in[6] 0
C357 VDPWR uio_out[1] 0
C358 clk uio_out[2] 0.00355f
C359 uio_out[5] uio_out[4] 0.03102f
C360 ch1_lon uio_in[4] 0
C361 ui_in[0] uio_in[0] 0
C362 ua[1] ua[6] 0
C363 ch2_lop_raw uio_in[5] 0
C364 uio_out[0] lon 0
C365 tail2 gm2_p 2.9744f
C366 select_b uio_out[3] 0
C367 VDPWR ua[1] 0.01038f
C368 select_b ch1_lop 0.14789f
C369 ui_in[0] uio_in[7] 0
C370 clk ui_in[4] 0.00355f
C371 ua[3] ch2_lop 3.18339f
C372 ch2_lop gm1_n 0.45176f
C373 ch1_lon ln2 1.01378f
C374 ch2_lop_raw uio_oe[4] 0
C375 clk ch2_lop_raw 1.23797f
C376 ch2_lop ln1 1.22977f
C377 ch2_lop vcm 0.68824f
C378 ui_in[0] uio_oe[6] 0
C379 ui_in[0] lon 4.00239f
C380 ch2_lon ch1_lop 8.0181f
C381 VDPWR ua[3] 0.18622f
C382 ch2_lop_raw uio_out[2] 0
C383 VDPWR ln1 3.32054f
C384 uo_out[3] uo_out[2] 0.03102f
C385 tail2 gm2_n 4.90845f
C386 VDPWR vcm 1.38266f
C387 ua[0] ch2_lon 0.23251f
C388 ch1_lon ua[1] 5.92927f
C389 ch2_lon_raw lon 5.95258f
C390 vbias ua[2] 0.76939f
C391 ch1_lop ch1_lon_raw 2.53245f
C392 clk uio_out[0] 0.00355f
C393 uio_out[4] uio_out[3] 0.03102f
C394 ch2_lop ch1_lop_raw 0.35752f
C395 ui_in[0] ui_in[6] 0
C396 uo_out[6] lon 0
C397 ch2_lop gm2_p 1.15968f
C398 ui_in[0] uio_in[5] 0
C399 clk ui_in[2] 0.00355f
C400 lop ch1_lop 0.15115f
C401 ch2_lop_raw uio_oe[2] 0
C402 ch1_lon ua[3] 3.07616f
C403 VDPWR ch1_lop_raw 6.38675f
C404 ch1_lon gm1_n 1.18848f
C405 uo_out[2] ch1_lop 0
C406 ui_in[0] uio_oe[4] 0
C407 clk ui_in[0] 6.89138f
C408 ch1_lon vcm 0.31874f
C409 uio_in[3] uio_in[2] 0.03102f
C410 VDPWR uio_out[7] 0
C411 clk uio_oe[0] 0.00355f
C412 ch2_lop_raw uio_out[0] 0
C413 ln2 ln1 1.39112f
C414 uo_out[2] uo_out[1] 0.03102f
C415 ch2_lop gm2_n 3.41613f
C416 ui_in[0] uio_out[2] 0
C417 ch2_lon_raw clk 0.69476f
C418 ch2_lon uio_in[0] 0
C419 select_b lon 4.00874f
C420 ch2_lon ua[2] 9.3941f
C421 clk uo_out[6] 0.00355f
C422 ch1_lon ch1_lop_raw 0.16291f
C423 ui_in[0] ui_in[4] 0
C424 uo_out[4] lon 0
C425 ch2_lon_raw uio_out[2] 0
C426 gm1_p ch2_lon 0.0012f
C427 ch2_lop_raw ui_in[0] 2.0794f
C428 ch1_lon gm2_p 0.0707f
C429 ua[3] ua[1] 1.1534f
C430 ua[1] gm1_n 0
C431 clk rst_n 0.03473f
C432 ch2_lon lon 3.37548f
C433 vcm ua[1] 7.09929f
C434 ch2_lop_raw uio_oe[0] 0
C435 ch1_lop_raw ln2 0.02247f
C436 uo_out[0] ch1_lop 0
C437 ui_in[0] uio_oe[2] 0
C438 ch2_lon_raw ch2_lop_raw 3.57183f
C439 ua[0] tail2 0.63751f
C440 tail1 vbias 4.91437f
C441 uio_in[2] uio_in[1] 0.03102f
C442 clk uio_out[6] 0.00355f
C443 ua[3] gm1_n 4.70286f
C444 ch2_lop_raw uo_out[6] 0
C445 lon ch1_lon_raw 0.80002f
C446 uo_out[1] uo_out[0] 0.03102f
C447 clk select_b 1.14211f
C448 ch2_lon_raw uio_oe[2] 0.00357f
C449 ui_in[0] uio_out[0] 0
C450 ua[3] vcm 0.4668f
C451 ch1_lon gm2_n 0.09304f
C452 vcm gm1_n 2.12194f
C453 ch2_lon ui_in[6] 0
C454 ua[1] ua[5] 0
C455 lop uio_oe[6] 0
C456 ua[1] gm2_p 1.94742f
C457 lon uio_in[3] 0
C458 clk uo_out[4] 0.00355f
C459 lop lon 0.15715f
C460 ui_in[0] ui_in[2] 0
C461 uo_out[2] lon 0
C462 select_b uio_out[2] 0
C463 ch2_lon_raw uio_out[0] 0
R0 VDPWR XCH1LN_P/S4.t0 75.1583
R1 ch1_lon XCH1LN_P/D4.n0 1.74579
R2 ch1_lon XCH1LN_P/D4.n1 65.0005
R3 XCH1LN_P/D4.n1 XCH1LN_P/D4.t0 10.1583
R4 XCH1LN_P/D4.n1 XCH1LN_P/D4.t1 10.1583
R5 VDPWR XCH1LN_P/S3.n0 65.0005
R6 XCH1LN_P/S3.n0 XCH1LN_P/S3.t0 10.1583
R7 XCH1LN_P/S3.n0 XCH1LN_P/S3.t1 10.1583
R8 ch1_lon XCH1LN_P/D2.n0 1.74579
R9 ch1_lon XCH1LN_P/D2.n1 65.0005
R10 XCH1LN_P/D2.n1 XCH1LN_P/D2.t1 10.1583
R11 XCH1LN_P/D2.n1 XCH1LN_P/D2.t0 10.1583
R12 VDPWR XCH1LN_P/S1.n0 65.0005
R13 XCH1LN_P/S1.n0 XCH1LN_P/S1.t0 10.1583
R14 XCH1LN_P/S1.n0 XCH1LN_P/S1.t1 10.1583
R15 ch1_lon XCH1LN_P/D0.n0 1.74579
R16 ch1_lon XCH1LN_P/D0.t0 75.1583
R17 ch1_lon_raw XCH1LN_P/G.n0 9.3005
R18 ch1_lon_raw XCH1LN_P/G.n0 0.0466957
R19 ch1_lon_raw XCH1LN_P/G.n1 6.10787
R20 XCH1LN_P/G.n1 XCH1LN_P/G.n0 1.92
R21 XCH1LN_P/G.n2 ch1_lon_raw 152
R22 ch1_lon_raw XCH1LN_P/G.n3 6.10787
R23 XCH1LN_P/G.n4 ch1_lon_raw 152
R24 XCH1LN_P/G.n5 ch1_lon_raw 152
R25 XCH1LN_P/G.n6 ch1_lon_raw 152
R26 ch1_lon_raw XCH1LN_P/G.n18 152
R27 ch1_lon_raw XCH1LN_P/G.n3 6.3031
R28 ch1_lon_raw XCH1LN_P/G.n1 6.3031
R29 XCH1LN_P/G.n4 XCH1LN_P/G.n2 70.1096
R30 XCH1LN_P/G.n5 XCH1LN_P/G.n4 70.1096
R31 XCH1LN_P/G.n6 XCH1LN_P/G.n5 70.1096
R32 XCH1LN_P/G.n18 XCH1LN_P/G.n6 70.1096
R33 XCH1LN_P/G.n18 XCH1LN_P/G.t0 563.941
R34 XCH1LN_P/G.t0 XCH1LN_P/G.n7 563.941
R35 XCH1LN_P/G.n8 XCH1LN_P/G.n9 152
R36 XCH1LN_P/G.n10 XCH1LN_P/G.n11 152
R37 XCH1LN_P/G.n12 XCH1LN_P/G.n13 152
R38 XCH1LN_P/G.n12 XCH1LN_P/G.n14 70.1096
R39 XCH1LN_P/G.n12 XCH1LN_P/G.n10 70.1096
R40 XCH1LN_P/G.n10 XCH1LN_P/G.n8 70.1096
R41 XCH1LN_P/G.n8 XCH1LN_P/G.n7 70.1096
R42 XCH1LN_P/G.n15 XCH1LN_P/G.n9 6.10787
R43 XCH1LN_P/G.n16 XCH1LN_P/G.n11 9.3005
R44 XCH1LN_P/G.n17 XCH1LN_P/G.n13 6.10787
R45 XCH1LN_P/G.n14 XCH1LN_P/G.n17 158.304
R46 XCH1LN_P/G.n13 XCH1LN_P/G.n11 36.1417
R47 XCH1LN_P/G.n11 XCH1LN_P/G.n9 36.1417
R48 XCH1LN_P/G.n7 XCH1LN_P/G.n15 158.304
R49 XCH1LN_P/G.n16 XCH1LN_P/G.n17 1.92
R50 XCH1LN_P/G.n15 XCH1LN_P/G.n16 1.92
R51 XCH1LN_P/G.n14 XCH1LN_P/G.t4 563.941
R52 XCH1LN_P/G.n2 XCH1LN_P/G.t4 563.941
R53 XCH1LN_P/G.t3 XCH1LN_P/G.n12 563.941
R54 XCH1LN_P/G.n4 XCH1LN_P/G.t3 563.941
R55 XCH1LN_P/G.t2 XCH1LN_P/G.n10 563.941
R56 XCH1LN_P/G.n5 XCH1LN_P/G.t2 563.941
R57 XCH1LN_P/G.t1 XCH1LN_P/G.n8 563.941
R58 XCH1LN_P/G.n6 XCH1LN_P/G.t1 563.941
R59 XCH1LN_P/G.n3 ch1_lon_raw 1.8738
R60 XCH1LN_P/B.n1 XCH1LN_P/B.t2 23.1255
R61 VDPWR XCH1LN_P/B.n1 23.1255
R62 XCH1LN_P/B.n0 VDPWR 16.5652
R63 XCH1LN_P/B.n2 XCH1LN_P/B.n3 15.4172
R64 XCH1LN_P/B.n0 XCH1LN_P/B.n3 293.272
R65 XCH1LN_P/B.t2 XCH1LN_P/B.n4 23.1255
R66 XCH1LN_P/B.n4 XCH1LN_P/B.n5 23.1255
R67 XCH1LN_P/B.n3 XCH1LN_P/B.n5 309.836
R68 XCH1LN_P/B.n7 XCH1LN_P/B.n6 15.4172
R69 VDPWR XCH1LN_P/B.n7 309.836
R70 XCH1LN_P/B.n7 XCH1LN_P/B.n5 309.836
R71 XCH1LN_P/B.n1 XCH1LN_P/B.n6 2904.71
R72 XCH1LN_P/B.n1 XCH1LN_P/B.n2 2904.71
R73 XCH1LN_P/B.n2 XCH1LN_P/B.n4 2904.71
R74 XCH1LN_P/B.n4 XCH1LN_P/B.n6 2904.71
R75 XCH1LN_P/B.t0 XCH1LN_P/B.n2 158.181
R76 XCH1LN_P/B.t1 XCH1LN_P/B.t0 84.6016
R77 XCH1LN_P/B.t2 XCH1LN_P/B.t1 84.6016
R78 XCH1LN_P/B.t2 XCH1LN_P/B.t3 84.6016
R79 XCH1LN_P/B.t3 XCH1LN_P/B.t4 84.6016
R80 XCH1LN_P/B.t4 XCH1LN_P/B.n6 158.181
R81 XXN_P/S4.n0 ch2_lon_raw 0.141804
R82 XXN_P/S4.t0 ch2_lon_raw 166.566
R83 lon XXN_P/D4.n0 0.277674
R84 XXN_P/D4.n1 lon 146.25
R85 XXN_P/D4.t0 XXN_P/D4.n1 20.3161
R86 XXN_P/D4.n1 XXN_P/D4.t1 20.3161
R87 XXN_P/S3.n0 ch2_lon_raw 0.141804
R88 XXN_P/S3.n1 ch2_lon_raw 146.25
R89 XXN_P/S3.t1 XXN_P/S3.n1 20.3161
R90 XXN_P/S3.n1 XXN_P/S3.t0 20.3161
R91 lon XXN_P/D2.n0 0.277674
R92 XXN_P/D2.n1 lon 146.25
R93 XXN_P/D2.t1 XXN_P/D2.n1 20.3161
R94 XXN_P/D2.n1 XXN_P/D2.t0 20.3161
R95 XXN_P/S1.n0 ch2_lon_raw 0.141804
R96 XXN_P/S1.n1 ch2_lon_raw 146.25
R97 XXN_P/S1.t0 XXN_P/S1.n1 20.3161
R98 XXN_P/S1.n1 XXN_P/S1.t1 20.3161
R99 lon XXN_P/D0.n0 0.277674
R100 lon XXN_P/D0.t0 166.566
R101 select_b XXN_P/G.n0 9.3005
R102 select_b XXN_P/G.n0 0.0466957
R103 select_b XXN_P/G.n1 6.10787
R104 XXN_P/G.n1 XXN_P/G.n0 1.92
R105 XXN_P/G.n2 select_b 152
R106 select_b XXN_P/G.n3 6.10787
R107 XXN_P/G.n4 select_b 152
R108 XXN_P/G.n5 select_b 152
R109 XXN_P/G.n6 select_b 152
R110 select_b XXN_P/G.n18 152
R111 select_b XXN_P/G.n3 6.3031
R112 select_b XXN_P/G.n1 6.3031
R113 XXN_P/G.n4 XXN_P/G.n2 70.1096
R114 XXN_P/G.n5 XXN_P/G.n4 70.1096
R115 XXN_P/G.n6 XXN_P/G.n5 70.1096
R116 XXN_P/G.n18 XXN_P/G.n6 70.1096
R117 XXN_P/G.n18 XXN_P/G.t0 306.873
R118 XXN_P/G.t0 XXN_P/G.n7 306.873
R119 XXN_P/G.n8 XXN_P/G.n9 152
R120 XXN_P/G.n10 XXN_P/G.n11 152
R121 XXN_P/G.n12 XXN_P/G.n13 152
R122 XXN_P/G.n12 XXN_P/G.n14 70.1096
R123 XXN_P/G.n12 XXN_P/G.n10 70.1096
R124 XXN_P/G.n10 XXN_P/G.n8 70.1096
R125 XXN_P/G.n8 XXN_P/G.n7 70.1096
R126 XXN_P/G.n15 XXN_P/G.n9 6.10787
R127 XXN_P/G.n16 XXN_P/G.n11 9.3005
R128 XXN_P/G.n17 XXN_P/G.n13 6.10787
R129 XXN_P/G.n14 XXN_P/G.n17 158.304
R130 XXN_P/G.n13 XXN_P/G.n11 36.1417
R131 XXN_P/G.n11 XXN_P/G.n9 36.1417
R132 XXN_P/G.n7 XXN_P/G.n15 158.304
R133 XXN_P/G.n16 XXN_P/G.n17 1.92
R134 XXN_P/G.n15 XXN_P/G.n16 1.92
R135 XXN_P/G.n14 XXN_P/G.t4 306.873
R136 XXN_P/G.n2 XXN_P/G.t4 306.873
R137 XXN_P/G.t3 XXN_P/G.n12 306.873
R138 XXN_P/G.n4 XXN_P/G.t3 306.873
R139 XXN_P/G.t2 XXN_P/G.n10 306.873
R140 XXN_P/G.n5 XXN_P/G.t2 306.873
R141 XXN_P/G.t1 XXN_P/G.n8 306.873
R142 XXN_P/G.n6 XXN_P/G.t1 306.873
R143 XXN_P/G.n3 select_b 1.8738
R144 XXN_P/B.n1 XXN_P/B.t2 23.1255
R145 VDPWR XXN_P/B.n1 23.1255
R146 XXN_P/B.n0 VDPWR 16.5652
R147 XXN_P/B.n3 XXN_P/B.n2 26.4291
R148 XXN_P/B.n0 XXN_P/B.n3 233.036
R149 XXN_P/B.t2 XXN_P/B.n4 23.1255
R150 XXN_P/B.n4 XXN_P/B.n5 23.1255
R151 XXN_P/B.n5 XXN_P/B.n3 249.601
R152 XXN_P/B.n7 XXN_P/B.n6 26.4291
R153 VDPWR XXN_P/B.n7 249.601
R154 XXN_P/B.n7 XXN_P/B.n5 249.601
R155 XXN_P/B.n1 XXN_P/B.n6 2340
R156 XXN_P/B.n1 XXN_P/B.n2 2340
R157 XXN_P/B.n2 XXN_P/B.n4 2340
R158 XXN_P/B.n4 XXN_P/B.n6 2340
R159 XXN_P/B.n2 XXN_P/B.t0 229.464
R160 XXN_P/B.t1 XXN_P/B.t0 120.317
R161 XXN_P/B.t2 XXN_P/B.t1 120.317
R162 XXN_P/B.t2 XXN_P/B.t3 120.317
R163 XXN_P/B.t3 XXN_P/B.t4 120.317
R164 XXN_P/B.t4 XXN_P/B.n6 229.464
R165 VGND XLP2_N/S8.t0 48.1241
R166 lop XLP2_N/D8.n0 37.0005
R167 XLP2_N/D8.n0 XLP2_N/D8.t0 11.1241
R168 XLP2_N/D8.n0 XLP2_N/D8.t1 11.1241
R169 VGND XLP2_N/S7.n0 37.0005
R170 XLP2_N/S7.n0 XLP2_N/S7.t0 11.1241
R171 XLP2_N/S7.n0 XLP2_N/S7.t1 11.1241
R172 lop XLP2_N/D6.n0 37.0005
R173 XLP2_N/D6.n0 XLP2_N/D6.t1 11.1241
R174 XLP2_N/D6.n0 XLP2_N/D6.t0 11.1241
R175 VGND XLP2_N/S5.n0 37.0005
R176 XLP2_N/S5.n0 XLP2_N/S5.t0 11.1241
R177 XLP2_N/S5.n0 XLP2_N/S5.t1 11.1241
R178 lop XLP2_N/D4.n0 37.0005
R179 XLP2_N/D4.n0 XLP2_N/D4.t0 11.1241
R180 XLP2_N/D4.n0 XLP2_N/D4.t1 11.1241
R181 VGND XLP2_N/S3.n0 37.0005
R182 XLP2_N/S3.n0 XLP2_N/S3.t1 11.1241
R183 XLP2_N/S3.n0 XLP2_N/S3.t0 11.1241
R184 lop XLP2_N/D2.n0 37.0005
R185 XLP2_N/D2.n0 XLP2_N/D2.t0 11.1241
R186 XLP2_N/D2.n0 XLP2_N/D2.t1 11.1241
R187 VGND XLP2_N/S1.n0 37.0005
R188 XLP2_N/S1.n0 XLP2_N/S1.t1 11.1241
R189 XLP2_N/S1.n0 XLP2_N/S1.t0 11.1241
R190 lop XLP2_N/D0.t0 48.1241
R191 lp1 XLP2_N/G.n0 9.3005
R192 lp1 XLP2_N/G.n0 0.0466957
R193 lp1 XLP2_N/G.n1 9.3005
R194 XLP2_N/G.n1 XLP2_N/G.n0 0.297815
R195 lp1 XLP2_N/G.n2 9.3005
R196 XLP2_N/G.n2 XLP2_N/G.n1 0.297815
R197 lp1 XLP2_N/G.n3 6.10787
R198 XLP2_N/G.n3 XLP2_N/G.n2 1.92
R199 XLP2_N/G.n4 lp1 152
R200 lp1 XLP2_N/G.n5 6.10787
R201 lp1 XLP2_N/G.n6 9.3005
R202 lp1 XLP2_N/G.n7 9.3005
R203 XLP2_N/G.n8 lp1 152
R204 XLP2_N/G.n9 lp1 152
R205 XLP2_N/G.n10 lp1 152
R206 XLP2_N/G.n11 lp1 152
R207 XLP2_N/G.n12 lp1 152
R208 XLP2_N/G.n13 lp1 152
R209 XLP2_N/G.n14 lp1 152
R210 lp1 XLP2_N/G.n38 152
R211 lp1 XLP2_N/G.n5 6.3031
R212 lp1 XLP2_N/G.n3 6.3031
R213 XLP2_N/G.n8 XLP2_N/G.n4 70.1096
R214 XLP2_N/G.n9 XLP2_N/G.n8 70.1096
R215 XLP2_N/G.n10 XLP2_N/G.n9 70.1096
R216 XLP2_N/G.n11 XLP2_N/G.n10 70.1096
R217 XLP2_N/G.n12 XLP2_N/G.n11 70.1096
R218 XLP2_N/G.n13 XLP2_N/G.n12 70.1096
R219 XLP2_N/G.n14 XLP2_N/G.n13 70.1096
R220 XLP2_N/G.n38 XLP2_N/G.n14 70.1096
R221 XLP2_N/G.n38 XLP2_N/G.t0 321.334
R222 XLP2_N/G.t0 XLP2_N/G.n15 321.334
R223 XLP2_N/G.n16 XLP2_N/G.n17 152
R224 XLP2_N/G.n18 XLP2_N/G.n19 152
R225 XLP2_N/G.n20 XLP2_N/G.n21 152
R226 XLP2_N/G.n22 XLP2_N/G.n23 152
R227 XLP2_N/G.n25 XLP2_N/G.n24 152
R228 XLP2_N/G.n27 XLP2_N/G.n26 152
R229 XLP2_N/G.n29 XLP2_N/G.n28 152
R230 XLP2_N/G.n30 XLP2_N/G.n28 70.1096
R231 XLP2_N/G.n28 XLP2_N/G.n26 70.1096
R232 XLP2_N/G.n26 XLP2_N/G.n24 70.1096
R233 XLP2_N/G.n24 XLP2_N/G.n22 70.1096
R234 XLP2_N/G.n22 XLP2_N/G.n20 70.1096
R235 XLP2_N/G.n18 XLP2_N/G.n20 70.1096
R236 XLP2_N/G.n18 XLP2_N/G.n16 70.1096
R237 XLP2_N/G.n15 XLP2_N/G.n16 70.1096
R238 XLP2_N/G.n31 XLP2_N/G.n17 6.10787
R239 XLP2_N/G.n32 XLP2_N/G.n19 9.3005
R240 XLP2_N/G.n33 XLP2_N/G.n21 9.3005
R241 XLP2_N/G.n34 XLP2_N/G.n23 9.3005
R242 XLP2_N/G.n35 XLP2_N/G.n25 9.3005
R243 XLP2_N/G.n36 XLP2_N/G.n27 9.3005
R244 XLP2_N/G.n37 XLP2_N/G.n29 6.10787
R245 XLP2_N/G.n37 XLP2_N/G.n30 158.304
R246 XLP2_N/G.n29 XLP2_N/G.n27 36.1417
R247 XLP2_N/G.n27 XLP2_N/G.n25 36.1417
R248 XLP2_N/G.n25 XLP2_N/G.n23 36.1417
R249 XLP2_N/G.n23 XLP2_N/G.n21 36.1417
R250 XLP2_N/G.n21 XLP2_N/G.n19 36.1417
R251 XLP2_N/G.n19 XLP2_N/G.n17 36.1417
R252 XLP2_N/G.n15 XLP2_N/G.n31 158.304
R253 XLP2_N/G.n36 XLP2_N/G.n37 1.92
R254 XLP2_N/G.n35 XLP2_N/G.n36 0.297815
R255 XLP2_N/G.n34 XLP2_N/G.n35 0.297815
R256 XLP2_N/G.n33 XLP2_N/G.n34 0.297815
R257 XLP2_N/G.n32 XLP2_N/G.n33 0.297815
R258 XLP2_N/G.n31 XLP2_N/G.n32 1.92
R259 XLP2_N/G.n30 XLP2_N/G.t8 321.334
R260 XLP2_N/G.n4 XLP2_N/G.t8 321.334
R261 XLP2_N/G.n28 XLP2_N/G.t7 321.334
R262 XLP2_N/G.n8 XLP2_N/G.t7 321.334
R263 XLP2_N/G.n26 XLP2_N/G.t6 321.334
R264 XLP2_N/G.n9 XLP2_N/G.t6 321.334
R265 XLP2_N/G.n24 XLP2_N/G.t5 321.334
R266 XLP2_N/G.n10 XLP2_N/G.t5 321.334
R267 XLP2_N/G.t4 XLP2_N/G.n22 321.334
R268 XLP2_N/G.n11 XLP2_N/G.t4 321.334
R269 XLP2_N/G.n20 XLP2_N/G.t3 321.334
R270 XLP2_N/G.n12 XLP2_N/G.t3 321.334
R271 XLP2_N/G.t2 XLP2_N/G.n18 321.334
R272 XLP2_N/G.n13 XLP2_N/G.t2 321.334
R273 XLP2_N/G.n16 XLP2_N/G.t1 321.334
R274 XLP2_N/G.n14 XLP2_N/G.t1 321.334
R275 XLP2_N/G.n7 lp1 0.251619
R276 XLP2_N/G.n6 XLP2_N/G.n7 0.297815
R277 XLP2_N/G.n5 XLP2_N/G.n6 1.92
R278 XLP2_N/B.t4 XLP2_N/B.n0 41.7862
R279 XLP2_N/B.n0 XLP2_N/B.n1 41.7862
R280 XLP2_N/B.n3 XLP2_N/B.n2 73.1255
R281 XLP2_N/B.n4 XLP2_N/B.t4 41.7862
R282 VGND XLP2_N/B.n4 41.7862
R283 XLP2_N/B.n6 XLP2_N/B.n5 73.1255
R284 XLP2_N/B.n7 XLP2_N/B.n6 73.1255
R285 VGND XLP2_N/B.n5 300.515
R286 XLP2_N/B.n5 XLP2_N/B.t0 918.558
R287 XLP2_N/B.t0 XLP2_N/B.t1 544.331
R288 XLP2_N/B.t2 XLP2_N/B.t1 544.331
R289 XLP2_N/B.t3 XLP2_N/B.t2 544.331
R290 XLP2_N/B.t4 XLP2_N/B.t3 544.331
R291 XLP2_N/B.t4 XLP2_N/B.t5 544.331
R292 XLP2_N/B.t5 XLP2_N/B.t6 544.331
R293 XLP2_N/B.t6 XLP2_N/B.t7 544.331
R294 XLP2_N/B.t7 XLP2_N/B.t8 544.331
R295 XLP2_N/B.n2 XLP2_N/B.t8 991.683
R296 VGND XLP2_N/B.n7 325.272
R297 VGND XLP2_N/B.n3 325.272
R298 XLP2_N/B.n7 XLP2_N/B.n1 325.272
R299 XLP2_N/B.n1 XLP2_N/B.n3 325.272
R300 XLP2_N/B.n6 XLP2_N/B.n4 5006.12
R301 XLP2_N/B.n4 XLP2_N/B.n2 5006.12
R302 XLP2_N/B.n6 XLP2_N/B.n0 5006.12
R303 XLP2_N/B.n0 XLP2_N/B.n2 5006.12
R304 X1DN_P/S4.n0 ch1_lon_raw 0.141804
R305 X1DN_P/S4.t0 ch1_lon_raw 166.566
R306 lop X1DN_P/D4.n0 0.277674
R307 X1DN_P/D4.n1 lop 146.25
R308 X1DN_P/D4.t0 X1DN_P/D4.n1 20.3161
R309 X1DN_P/D4.n1 X1DN_P/D4.t1 20.3161
R310 X1DN_P/S3.n0 ch1_lon_raw 0.141804
R311 X1DN_P/S3.n1 ch1_lon_raw 146.25
R312 X1DN_P/S3.t1 X1DN_P/S3.n1 20.3161
R313 X1DN_P/S3.n1 X1DN_P/S3.t0 20.3161
R314 lop X1DN_P/D2.n0 0.277674
R315 X1DN_P/D2.n1 lop 146.25
R316 X1DN_P/D2.t1 X1DN_P/D2.n1 20.3161
R317 X1DN_P/D2.n1 X1DN_P/D2.t0 20.3161
R318 X1DN_P/S1.n0 ch1_lon_raw 0.141804
R319 X1DN_P/S1.n1 ch1_lon_raw 146.25
R320 X1DN_P/S1.t0 X1DN_P/S1.n1 20.3161
R321 X1DN_P/S1.n1 X1DN_P/S1.t1 20.3161
R322 lop X1DN_P/D0.n0 0.277674
R323 lop X1DN_P/D0.t0 166.566
R324 VGND X1DN_P/G.n0 9.3005
R325 VGND X1DN_P/G.n0 0.0466957
R326 VGND X1DN_P/G.n1 6.10787
R327 X1DN_P/G.n1 X1DN_P/G.n0 1.92
R328 X1DN_P/G.n2 VGND 152
R329 VGND X1DN_P/G.n3 6.10787
R330 X1DN_P/G.n4 VGND 152
R331 X1DN_P/G.n5 VGND 152
R332 X1DN_P/G.n6 VGND 152
R333 VGND X1DN_P/G.n18 152
R334 VGND X1DN_P/G.n3 6.3031
R335 VGND X1DN_P/G.n1 6.3031
R336 X1DN_P/G.n4 X1DN_P/G.n2 70.1096
R337 X1DN_P/G.n5 X1DN_P/G.n4 70.1096
R338 X1DN_P/G.n6 X1DN_P/G.n5 70.1096
R339 X1DN_P/G.n18 X1DN_P/G.n6 70.1096
R340 X1DN_P/G.n18 X1DN_P/G.t0 306.873
R341 X1DN_P/G.t0 X1DN_P/G.n7 306.873
R342 X1DN_P/G.n8 X1DN_P/G.n9 152
R343 X1DN_P/G.n10 X1DN_P/G.n11 152
R344 X1DN_P/G.n12 X1DN_P/G.n13 152
R345 X1DN_P/G.n12 X1DN_P/G.n14 70.1096
R346 X1DN_P/G.n12 X1DN_P/G.n10 70.1096
R347 X1DN_P/G.n10 X1DN_P/G.n8 70.1096
R348 X1DN_P/G.n8 X1DN_P/G.n7 70.1096
R349 X1DN_P/G.n15 X1DN_P/G.n9 6.10787
R350 X1DN_P/G.n16 X1DN_P/G.n11 9.3005
R351 X1DN_P/G.n17 X1DN_P/G.n13 6.10787
R352 X1DN_P/G.n14 X1DN_P/G.n17 158.304
R353 X1DN_P/G.n13 X1DN_P/G.n11 36.1417
R354 X1DN_P/G.n11 X1DN_P/G.n9 36.1417
R355 X1DN_P/G.n7 X1DN_P/G.n15 158.304
R356 X1DN_P/G.n16 X1DN_P/G.n17 1.92
R357 X1DN_P/G.n15 X1DN_P/G.n16 1.92
R358 X1DN_P/G.n14 X1DN_P/G.t4 306.873
R359 X1DN_P/G.n2 X1DN_P/G.t4 306.873
R360 X1DN_P/G.t3 X1DN_P/G.n12 306.873
R361 X1DN_P/G.n4 X1DN_P/G.t3 306.873
R362 X1DN_P/G.t2 X1DN_P/G.n10 306.873
R363 X1DN_P/G.n5 X1DN_P/G.t2 306.873
R364 X1DN_P/G.t1 X1DN_P/G.n8 306.873
R365 X1DN_P/G.n6 X1DN_P/G.t1 306.873
R366 X1DN_P/G.n3 VGND 1.8738
R367 X1DN_P/B.n1 X1DN_P/B.t2 23.1255
R368 VDPWR X1DN_P/B.n1 23.1255
R369 X1DN_P/B.n0 VDPWR 16.5652
R370 X1DN_P/B.n3 X1DN_P/B.n2 26.4291
R371 X1DN_P/B.n0 X1DN_P/B.n3 233.036
R372 X1DN_P/B.t2 X1DN_P/B.n4 23.1255
R373 X1DN_P/B.n4 X1DN_P/B.n5 23.1255
R374 X1DN_P/B.n5 X1DN_P/B.n3 249.601
R375 X1DN_P/B.n7 X1DN_P/B.n6 26.4291
R376 VDPWR X1DN_P/B.n7 249.601
R377 X1DN_P/B.n7 X1DN_P/B.n5 249.601
R378 X1DN_P/B.n1 X1DN_P/B.n6 2340
R379 X1DN_P/B.n1 X1DN_P/B.n2 2340
R380 X1DN_P/B.n2 X1DN_P/B.n4 2340
R381 X1DN_P/B.n4 X1DN_P/B.n6 2340
R382 X1DN_P/B.n2 X1DN_P/B.t0 229.464
R383 X1DN_P/B.t1 X1DN_P/B.t0 120.317
R384 X1DN_P/B.t2 X1DN_P/B.t1 120.317
R385 X1DN_P/B.t2 X1DN_P/B.t3 120.317
R386 X1DN_P/B.t3 X1DN_P/B.t4 120.317
R387 X1DN_P/B.t4 X1DN_P/B.n6 229.464
R388 ua[2] XRLOADP/R2.n0 0.46195
R389 XRLOADP/R2.n0 XRLOADP/R2.t0 25.3338
R390 ua[2] XRLOADP/R2.n0 8.2161
R391 XRLOADP/R1.n0 XRLOADP/R1.t0 25.3338
R392 VDPWR XRLOADP/R1.n0 0.504955
R393 VDPWR XRLOADP/R1.n0 8.2161
R394 XRLOADP/B.t0 XRLOADP/B.n0 3.35572
R395 XRLOADP/B.n1 XRLOADP/B.n2 117.001
R396 XRLOADP/B.n3 XRLOADP/B.n4 12.4473
R397 XRLOADP/B.n5 XRLOADP/B.t0 117.001
R398 VGND XRLOADP/B.n5 117.001
R399 XRLOADP/B.n6 XRLOADP/B.n7 12.4473
R400 XRLOADP/B.n7 XRLOADP/B.n8 12.4473
R401 VGND XRLOADP/B.n6 66.8967
R402 XRLOADP/B.t0 XRLOADP/B.n6 320.598
R403 XRLOADP/B.n0 XRLOADP/B.n3 320.14
R404 XRLOADP/B.n8 VGND 725.46
R405 VGND XRLOADP/B.n4 725.46
R406 XRLOADP/B.n8 XRLOADP/B.n2 725.46
R407 XRLOADP/B.n2 XRLOADP/B.n4 725.46
R408 XRLOADP/B.n7 XRLOADP/B.n5 11165.3
R409 XRLOADP/B.n5 XRLOADP/B.n3 11165.3
R410 XRLOADP/B.n7 XRLOADP/B.n1 11165.3
R411 XRLOADP/B.n0 XRLOADP/B.n1 112.468
R412 ch2_lop_raw XDP_N/S4.t0 117.251
R413 lon XDP_N/D4.n0 4.71028
R414 lon XDP_N/D4.n1 92.5005
R415 XDP_N/D4.n1 XDP_N/D4.t1 24.7505
R416 XDP_N/D4.n1 XDP_N/D4.t0 24.7505
R417 ch2_lop_raw XDP_N/S3.n0 92.5005
R418 XDP_N/S3.n0 XDP_N/S3.t0 24.7505
R419 XDP_N/S3.n0 XDP_N/S3.t1 24.7505
R420 lon XDP_N/D2.n0 4.71028
R421 lon XDP_N/D2.n1 92.5005
R422 XDP_N/D2.n1 XDP_N/D2.t0 24.7505
R423 XDP_N/D2.n1 XDP_N/D2.t1 24.7505
R424 ch2_lop_raw XDP_N/S1.n0 92.5005
R425 XDP_N/S1.n0 XDP_N/S1.t0 24.7505
R426 XDP_N/S1.n0 XDP_N/S1.t1 24.7505
R427 lon XDP_N/D0.n0 4.71028
R428 lon XDP_N/D0.t0 117.251
R429 select_b XDP_N/G.n0 9.3005
R430 select_b XDP_N/G.n0 0.0466957
R431 select_b XDP_N/G.n1 6.10787
R432 XDP_N/G.n1 XDP_N/G.n0 1.92
R433 XDP_N/G.n2 select_b 152
R434 select_b XDP_N/G.n3 6.10787
R435 XDP_N/G.n4 select_b 152
R436 XDP_N/G.n5 select_b 152
R437 XDP_N/G.n6 select_b 152
R438 select_b XDP_N/G.n18 152
R439 select_b XDP_N/G.n3 6.3031
R440 select_b XDP_N/G.n1 6.3031
R441 XDP_N/G.n4 XDP_N/G.n2 70.1096
R442 XDP_N/G.n5 XDP_N/G.n4 70.1096
R443 XDP_N/G.n6 XDP_N/G.n5 70.1096
R444 XDP_N/G.n18 XDP_N/G.n6 70.1096
R445 XDP_N/G.n18 XDP_N/G.t0 163.881
R446 XDP_N/G.t0 XDP_N/G.n7 163.881
R447 XDP_N/G.n8 XDP_N/G.n9 152
R448 XDP_N/G.n10 XDP_N/G.n11 152
R449 XDP_N/G.n12 XDP_N/G.n13 152
R450 XDP_N/G.n12 XDP_N/G.n14 70.1096
R451 XDP_N/G.n10 XDP_N/G.n12 70.1096
R452 XDP_N/G.n10 XDP_N/G.n8 70.1096
R453 XDP_N/G.n7 XDP_N/G.n8 70.1096
R454 XDP_N/G.n15 XDP_N/G.n9 6.10787
R455 XDP_N/G.n16 XDP_N/G.n11 9.3005
R456 XDP_N/G.n17 XDP_N/G.n13 6.10787
R457 XDP_N/G.n14 XDP_N/G.n17 158.304
R458 XDP_N/G.n13 XDP_N/G.n11 36.1417
R459 XDP_N/G.n11 XDP_N/G.n9 36.1417
R460 XDP_N/G.n7 XDP_N/G.n15 158.304
R461 XDP_N/G.n16 XDP_N/G.n17 1.92
R462 XDP_N/G.n15 XDP_N/G.n16 1.92
R463 XDP_N/G.n14 XDP_N/G.t4 163.881
R464 XDP_N/G.n2 XDP_N/G.t4 163.881
R465 XDP_N/G.n12 XDP_N/G.t3 163.881
R466 XDP_N/G.n4 XDP_N/G.t3 163.881
R467 XDP_N/G.t2 XDP_N/G.n10 163.881
R468 XDP_N/G.n5 XDP_N/G.t2 163.881
R469 XDP_N/G.n8 XDP_N/G.t1 163.881
R470 XDP_N/G.n6 XDP_N/G.t1 163.881
R471 XDP_N/G.n3 select_b 1.8738
R472 XDP_N/B.t2 XDP_N/B.n0 73.1255
R473 XDP_N/B.n0 XDP_N/B.n1 73.1255
R474 XDP_N/B.n3 XDP_N/B.n2 117.001
R475 XDP_N/B.n4 XDP_N/B.t2 73.1255
R476 VGND XDP_N/B.n4 73.1255
R477 XDP_N/B.n6 XDP_N/B.n5 117.001
R478 XDP_N/B.n7 XDP_N/B.n6 117.001
R479 VGND XDP_N/B.n5 402.07
R480 XDP_N/B.n5 XDP_N/B.t0 1228.97
R481 XDP_N/B.t1 XDP_N/B.t0 728.277
R482 XDP_N/B.t2 XDP_N/B.t1 728.277
R483 XDP_N/B.t2 XDP_N/B.t3 728.277
R484 XDP_N/B.t3 XDP_N/B.t4 728.277
R485 XDP_N/B.t4 XDP_N/B.n2 1345.97
R486 VGND XDP_N/B.n7 216.095
R487 VGND XDP_N/B.n3 216.095
R488 XDP_N/B.n7 XDP_N/B.n1 216.095
R489 XDP_N/B.n1 XDP_N/B.n3 216.095
R490 XDP_N/B.n6 XDP_N/B.n4 3325.82
R491 XDP_N/B.n4 XDP_N/B.n2 3325.82
R492 XDP_N/B.n6 XDP_N/B.n0 3325.82
R493 XDP_N/B.n0 XDP_N/B.n2 3325.82
R494 XLP2_P/S8.n0 VDPWR 1.86528
R495 VDPWR XLP2_P/S8.t0 67.6311
R496 lop XLP2_P/D8.n0 1.74028
R497 lop XLP2_P/D8.n1 58.5005
R498 XLP2_P/D8.n1 XLP2_P/D8.t0 9.13112
R499 XLP2_P/D8.n1 XLP2_P/D8.t1 9.13112
R500 XLP2_P/S7.n0 VDPWR 1.86528
R501 VDPWR XLP2_P/S7.n1 58.5005
R502 XLP2_P/S7.n1 XLP2_P/S7.t1 9.13112
R503 XLP2_P/S7.n1 XLP2_P/S7.t0 9.13112
R504 lop XLP2_P/D6.n0 1.74028
R505 lop XLP2_P/D6.n1 58.5005
R506 XLP2_P/D6.n1 XLP2_P/D6.t1 9.13112
R507 XLP2_P/D6.n1 XLP2_P/D6.t0 9.13112
R508 XLP2_P/S5.n0 VDPWR 1.86528
R509 VDPWR XLP2_P/S5.n1 58.5005
R510 XLP2_P/S5.n1 XLP2_P/S5.t0 9.13112
R511 XLP2_P/S5.n1 XLP2_P/S5.t1 9.13112
R512 lop XLP2_P/D4.n0 1.74028
R513 lop XLP2_P/D4.n1 58.5005
R514 XLP2_P/D4.n1 XLP2_P/D4.t1 9.13112
R515 XLP2_P/D4.n1 XLP2_P/D4.t0 9.13112
R516 XLP2_P/S3.n0 VDPWR 1.86528
R517 VDPWR XLP2_P/S3.n1 58.5005
R518 XLP2_P/S3.n1 XLP2_P/S3.t1 9.13112
R519 XLP2_P/S3.n1 XLP2_P/S3.t0 9.13112
R520 lop XLP2_P/D2.n0 1.74028
R521 lop XLP2_P/D2.n1 58.5005
R522 XLP2_P/D2.n1 XLP2_P/D2.t1 9.13112
R523 XLP2_P/D2.n1 XLP2_P/D2.t0 9.13112
R524 XLP2_P/S1.n0 VDPWR 1.86528
R525 VDPWR XLP2_P/S1.n1 58.5005
R526 XLP2_P/S1.n1 XLP2_P/S1.t0 9.13112
R527 XLP2_P/S1.n1 XLP2_P/S1.t1 9.13112
R528 lop XLP2_P/D0.n0 1.74028
R529 lop XLP2_P/D0.t0 67.6311
R530 lp1 XLP2_P/G.n0 9.3005
R531 lp1 XLP2_P/G.n0 0.0466957
R532 lp1 XLP2_P/G.n1 9.3005
R533 XLP2_P/G.n1 XLP2_P/G.n0 0.297815
R534 lp1 XLP2_P/G.n2 9.3005
R535 XLP2_P/G.n2 XLP2_P/G.n1 0.297815
R536 lp1 XLP2_P/G.n3 6.10787
R537 XLP2_P/G.n3 XLP2_P/G.n2 1.92
R538 XLP2_P/G.n4 lp1 152
R539 lp1 XLP2_P/G.n5 6.10787
R540 lp1 XLP2_P/G.n6 9.3005
R541 lp1 XLP2_P/G.n7 9.3005
R542 XLP2_P/G.n8 lp1 152
R543 XLP2_P/G.n9 lp1 152
R544 XLP2_P/G.n10 lp1 152
R545 XLP2_P/G.n11 lp1 152
R546 XLP2_P/G.n12 lp1 152
R547 XLP2_P/G.n13 lp1 152
R548 XLP2_P/G.n14 lp1 152
R549 lp1 XLP2_P/G.n38 152
R550 lp1 XLP2_P/G.n5 6.3031
R551 lp1 XLP2_P/G.n3 6.3031
R552 XLP2_P/G.n8 XLP2_P/G.n4 70.1096
R553 XLP2_P/G.n9 XLP2_P/G.n8 70.1096
R554 XLP2_P/G.n10 XLP2_P/G.n9 70.1096
R555 XLP2_P/G.n11 XLP2_P/G.n10 70.1096
R556 XLP2_P/G.n12 XLP2_P/G.n11 70.1096
R557 XLP2_P/G.n13 XLP2_P/G.n12 70.1096
R558 XLP2_P/G.n14 XLP2_P/G.n13 70.1096
R559 XLP2_P/G.n38 XLP2_P/G.n14 70.1096
R560 XLP2_P/G.n38 XLP2_P/G.t0 621.78
R561 XLP2_P/G.t0 XLP2_P/G.n15 621.78
R562 XLP2_P/G.n16 XLP2_P/G.n17 152
R563 XLP2_P/G.n18 XLP2_P/G.n19 152
R564 XLP2_P/G.n20 XLP2_P/G.n21 152
R565 XLP2_P/G.n22 XLP2_P/G.n23 152
R566 XLP2_P/G.n25 XLP2_P/G.n24 152
R567 XLP2_P/G.n27 XLP2_P/G.n26 152
R568 XLP2_P/G.n29 XLP2_P/G.n28 152
R569 XLP2_P/G.n30 XLP2_P/G.n28 70.1096
R570 XLP2_P/G.n28 XLP2_P/G.n26 70.1096
R571 XLP2_P/G.n26 XLP2_P/G.n24 70.1096
R572 XLP2_P/G.n24 XLP2_P/G.n22 70.1096
R573 XLP2_P/G.n22 XLP2_P/G.n20 70.1096
R574 XLP2_P/G.n18 XLP2_P/G.n20 70.1096
R575 XLP2_P/G.n18 XLP2_P/G.n16 70.1096
R576 XLP2_P/G.n16 XLP2_P/G.n15 70.1096
R577 XLP2_P/G.n31 XLP2_P/G.n17 6.10787
R578 XLP2_P/G.n32 XLP2_P/G.n19 9.3005
R579 XLP2_P/G.n33 XLP2_P/G.n21 9.3005
R580 XLP2_P/G.n34 XLP2_P/G.n23 9.3005
R581 XLP2_P/G.n35 XLP2_P/G.n25 9.3005
R582 XLP2_P/G.n36 XLP2_P/G.n27 9.3005
R583 XLP2_P/G.n37 XLP2_P/G.n29 6.10787
R584 XLP2_P/G.n37 XLP2_P/G.n30 158.304
R585 XLP2_P/G.n29 XLP2_P/G.n27 36.1417
R586 XLP2_P/G.n27 XLP2_P/G.n25 36.1417
R587 XLP2_P/G.n25 XLP2_P/G.n23 36.1417
R588 XLP2_P/G.n23 XLP2_P/G.n21 36.1417
R589 XLP2_P/G.n21 XLP2_P/G.n19 36.1417
R590 XLP2_P/G.n19 XLP2_P/G.n17 36.1417
R591 XLP2_P/G.n15 XLP2_P/G.n31 158.304
R592 XLP2_P/G.n36 XLP2_P/G.n37 1.92
R593 XLP2_P/G.n35 XLP2_P/G.n36 0.297815
R594 XLP2_P/G.n34 XLP2_P/G.n35 0.297815
R595 XLP2_P/G.n33 XLP2_P/G.n34 0.297815
R596 XLP2_P/G.n32 XLP2_P/G.n33 0.297815
R597 XLP2_P/G.n31 XLP2_P/G.n32 1.92
R598 XLP2_P/G.n30 XLP2_P/G.t8 621.78
R599 XLP2_P/G.n4 XLP2_P/G.t8 621.78
R600 XLP2_P/G.n28 XLP2_P/G.t7 621.78
R601 XLP2_P/G.n8 XLP2_P/G.t7 621.78
R602 XLP2_P/G.n26 XLP2_P/G.t6 621.78
R603 XLP2_P/G.n9 XLP2_P/G.t6 621.78
R604 XLP2_P/G.n24 XLP2_P/G.t5 621.78
R605 XLP2_P/G.n10 XLP2_P/G.t5 621.78
R606 XLP2_P/G.t4 XLP2_P/G.n22 621.78
R607 XLP2_P/G.n11 XLP2_P/G.t4 621.78
R608 XLP2_P/G.n20 XLP2_P/G.t3 621.78
R609 XLP2_P/G.n12 XLP2_P/G.t3 621.78
R610 XLP2_P/G.t2 XLP2_P/G.n18 621.78
R611 XLP2_P/G.n13 XLP2_P/G.t2 621.78
R612 XLP2_P/G.t1 XLP2_P/G.n16 621.78
R613 XLP2_P/G.n14 XLP2_P/G.t1 621.78
R614 XLP2_P/G.n7 lp1 0.251619
R615 XLP2_P/G.n6 XLP2_P/G.n7 0.297815
R616 XLP2_P/G.n5 XLP2_P/G.n6 1.92
R617 XLP2_P/B.n1 XLP2_P/B.t4 13.2148
R618 VDPWR XLP2_P/B.n1 13.2148
R619 XLP2_P/B.n0 VDPWR 16.5652
R620 XLP2_P/B.n3 XLP2_P/B.n2 14.2313
R621 XLP2_P/B.n0 XLP2_P/B.n3 379.106
R622 XLP2_P/B.t4 XLP2_P/B.n4 13.2148
R623 XLP2_P/B.n4 XLP2_P/B.n5 13.2148
R624 XLP2_P/B.n5 XLP2_P/B.n3 395.671
R625 XLP2_P/B.n7 XLP2_P/B.n6 14.2313
R626 VDPWR XLP2_P/B.n7 395.671
R627 XLP2_P/B.n7 XLP2_P/B.n5 395.671
R628 XLP2_P/B.n1 XLP2_P/B.n6 3709.41
R629 XLP2_P/B.n1 XLP2_P/B.n2 3709.41
R630 XLP2_P/B.n2 XLP2_P/B.n4 3709.41
R631 XLP2_P/B.n4 XLP2_P/B.n6 3709.41
R632 XLP2_P/B.n2 XLP2_P/B.t0 148.058
R633 XLP2_P/B.t1 XLP2_P/B.t0 79.3049
R634 XLP2_P/B.t2 XLP2_P/B.t1 79.3049
R635 XLP2_P/B.t3 XLP2_P/B.t2 79.3049
R636 XLP2_P/B.t4 XLP2_P/B.t3 79.3049
R637 XLP2_P/B.t4 XLP2_P/B.t5 79.3049
R638 XLP2_P/B.t5 XLP2_P/B.t6 79.3049
R639 XLP2_P/B.t6 XLP2_P/B.t7 79.3049
R640 XLP2_P/B.t7 XLP2_P/B.t8 79.3049
R641 XLP2_P/B.t8 XLP2_P/B.n6 148.058
R642 VGND XRVCMB/R2.n0 0.46195
R643 XRVCMB/R2.n0 XRVCMB/R2.t0 25.3338
R644 VGND XRVCMB/R2.n0 8.2161
R645 XRVCMB/R1.n0 XRVCMB/R1.t0 25.3338
R646 vcm XRVCMB/R1.n0 0.507818
R647 vcm XRVCMB/R1.n0 8.2161
R648 XRVCMB/B.t0 XRVCMB/B.n0 0.115861
R649 XRVCMB/B.n1 XRVCMB/B.n2 117.001
R650 XRVCMB/B.n3 XRVCMB/B.n4 2.01774
R651 XRVCMB/B.n5 XRVCMB/B.t0 117.001
R652 VGND XRVCMB/B.n5 117.001
R653 XRVCMB/B.n6 XRVCMB/B.n7 2.01774
R654 XRVCMB/B.n7 XRVCMB/B.n8 2.01774
R655 VGND XRVCMB/B.n6 11.6815
R656 XRVCMB/B.t0 XRVCMB/B.n6 55.9813
R657 XRVCMB/B.n0 XRVCMB/B.n3 57.8272
R658 XRVCMB/B.n8 VGND 3827.2
R659 VGND XRVCMB/B.n4 3827.2
R660 XRVCMB/B.n8 XRVCMB/B.n2 3827.2
R661 XRVCMB/B.n2 XRVCMB/B.n4 3827.2
R662 XRVCMB/B.n7 XRVCMB/B.n5 58903
R663 XRVCMB/B.n5 XRVCMB/B.n3 58903
R664 XRVCMB/B.n7 XRVCMB/B.n1 58903
R665 XRVCMB/B.n0 XRVCMB/B.n1 116.654
R666 XDP_P/S4.n0 ch2_lop_raw 0.141804
R667 XDP_P/S4.t0 ch2_lop_raw 166.566
R668 lon XDP_P/D4.n0 0.277674
R669 XDP_P/D4.n1 lon 146.25
R670 XDP_P/D4.t0 XDP_P/D4.n1 20.3161
R671 XDP_P/D4.n1 XDP_P/D4.t1 20.3161
R672 XDP_P/S3.n0 ch2_lop_raw 0.141804
R673 XDP_P/S3.n1 ch2_lop_raw 146.25
R674 XDP_P/S3.t1 XDP_P/S3.n1 20.3161
R675 XDP_P/S3.n1 XDP_P/S3.t0 20.3161
R676 lon XDP_P/D2.n0 0.277674
R677 XDP_P/D2.n1 lon 146.25
R678 XDP_P/D2.t1 XDP_P/D2.n1 20.3161
R679 XDP_P/D2.n1 XDP_P/D2.t0 20.3161
R680 XDP_P/S1.n0 ch2_lop_raw 0.141804
R681 XDP_P/S1.n1 ch2_lop_raw 146.25
R682 XDP_P/S1.t0 XDP_P/S1.n1 20.3161
R683 XDP_P/S1.n1 XDP_P/S1.t1 20.3161
R684 lon XDP_P/D0.n0 0.277674
R685 lon XDP_P/D0.t0 166.566
R686 ui_in[0] XDP_P/G.n0 9.3005
R687 ui_in[0] XDP_P/G.n0 0.0466957
R688 ui_in[0] XDP_P/G.n1 6.10787
R689 XDP_P/G.n1 XDP_P/G.n0 1.92
R690 XDP_P/G.n2 ui_in[0] 152
R691 ui_in[0] XDP_P/G.n3 6.10787
R692 XDP_P/G.n4 ui_in[0] 152
R693 XDP_P/G.n5 ui_in[0] 152
R694 XDP_P/G.n6 ui_in[0] 152
R695 ui_in[0] XDP_P/G.n18 152
R696 ui_in[0] XDP_P/G.n3 6.3031
R697 ui_in[0] XDP_P/G.n1 6.3031
R698 XDP_P/G.n4 XDP_P/G.n2 70.1096
R699 XDP_P/G.n5 XDP_P/G.n4 70.1096
R700 XDP_P/G.n6 XDP_P/G.n5 70.1096
R701 XDP_P/G.n18 XDP_P/G.n6 70.1096
R702 XDP_P/G.n18 XDP_P/G.t0 306.873
R703 XDP_P/G.t0 XDP_P/G.n7 306.873
R704 XDP_P/G.n8 XDP_P/G.n9 152
R705 XDP_P/G.n10 XDP_P/G.n11 152
R706 XDP_P/G.n12 XDP_P/G.n13 152
R707 XDP_P/G.n12 XDP_P/G.n14 70.1096
R708 XDP_P/G.n12 XDP_P/G.n10 70.1096
R709 XDP_P/G.n10 XDP_P/G.n8 70.1096
R710 XDP_P/G.n8 XDP_P/G.n7 70.1096
R711 XDP_P/G.n15 XDP_P/G.n9 6.10787
R712 XDP_P/G.n16 XDP_P/G.n11 9.3005
R713 XDP_P/G.n17 XDP_P/G.n13 6.10787
R714 XDP_P/G.n14 XDP_P/G.n17 158.304
R715 XDP_P/G.n13 XDP_P/G.n11 36.1417
R716 XDP_P/G.n11 XDP_P/G.n9 36.1417
R717 XDP_P/G.n7 XDP_P/G.n15 158.304
R718 XDP_P/G.n16 XDP_P/G.n17 1.92
R719 XDP_P/G.n15 XDP_P/G.n16 1.92
R720 XDP_P/G.n14 XDP_P/G.t4 306.873
R721 XDP_P/G.n2 XDP_P/G.t4 306.873
R722 XDP_P/G.t3 XDP_P/G.n12 306.873
R723 XDP_P/G.n4 XDP_P/G.t3 306.873
R724 XDP_P/G.t2 XDP_P/G.n10 306.873
R725 XDP_P/G.n5 XDP_P/G.t2 306.873
R726 XDP_P/G.t1 XDP_P/G.n8 306.873
R727 XDP_P/G.n6 XDP_P/G.t1 306.873
R728 XDP_P/G.n3 ui_in[0] 1.8738
R729 XDP_P/B.n1 XDP_P/B.t2 23.1255
R730 VDPWR XDP_P/B.n1 23.1255
R731 XDP_P/B.n0 VDPWR 16.5652
R732 XDP_P/B.n3 XDP_P/B.n2 26.4291
R733 XDP_P/B.n0 XDP_P/B.n3 233.036
R734 XDP_P/B.t2 XDP_P/B.n4 23.1255
R735 XDP_P/B.n4 XDP_P/B.n5 23.1255
R736 XDP_P/B.n5 XDP_P/B.n3 249.601
R737 XDP_P/B.n7 XDP_P/B.n6 26.4291
R738 VDPWR XDP_P/B.n7 249.601
R739 XDP_P/B.n7 XDP_P/B.n5 249.601
R740 XDP_P/B.n1 XDP_P/B.n6 2340
R741 XDP_P/B.n1 XDP_P/B.n2 2340
R742 XDP_P/B.n2 XDP_P/B.n4 2340
R743 XDP_P/B.n4 XDP_P/B.n6 2340
R744 XDP_P/B.n2 XDP_P/B.t0 229.464
R745 XDP_P/B.t1 XDP_P/B.t0 120.317
R746 XDP_P/B.t2 XDP_P/B.t1 120.317
R747 XDP_P/B.t2 XDP_P/B.t3 120.317
R748 XDP_P/B.t3 XDP_P/B.t4 120.317
R749 XDP_P/B.t4 XDP_P/B.n6 229.464
R750 ch2_lon_raw XDN_N/S4.t0 117.251
R751 lop XDN_N/D4.n0 4.71028
R752 lop XDN_N/D4.n1 92.5005
R753 XDN_N/D4.n1 XDN_N/D4.t1 24.7505
R754 XDN_N/D4.n1 XDN_N/D4.t0 24.7505
R755 ch2_lon_raw XDN_N/S3.n0 92.5005
R756 XDN_N/S3.n0 XDN_N/S3.t0 24.7505
R757 XDN_N/S3.n0 XDN_N/S3.t1 24.7505
R758 lop XDN_N/D2.n0 4.71028
R759 lop XDN_N/D2.n1 92.5005
R760 XDN_N/D2.n1 XDN_N/D2.t0 24.7505
R761 XDN_N/D2.n1 XDN_N/D2.t1 24.7505
R762 ch2_lon_raw XDN_N/S1.n0 92.5005
R763 XDN_N/S1.n0 XDN_N/S1.t0 24.7505
R764 XDN_N/S1.n0 XDN_N/S1.t1 24.7505
R765 lop XDN_N/D0.n0 4.71028
R766 lop XDN_N/D0.t0 117.251
R767 select_b XDN_N/G.n0 9.3005
R768 select_b XDN_N/G.n0 0.0466957
R769 select_b XDN_N/G.n1 6.10787
R770 XDN_N/G.n1 XDN_N/G.n0 1.92
R771 XDN_N/G.n2 select_b 152
R772 select_b XDN_N/G.n3 6.10787
R773 XDN_N/G.n4 select_b 152
R774 XDN_N/G.n5 select_b 152
R775 XDN_N/G.n6 select_b 152
R776 select_b XDN_N/G.n18 152
R777 select_b XDN_N/G.n3 6.3031
R778 select_b XDN_N/G.n1 6.3031
R779 XDN_N/G.n4 XDN_N/G.n2 70.1096
R780 XDN_N/G.n5 XDN_N/G.n4 70.1096
R781 XDN_N/G.n6 XDN_N/G.n5 70.1096
R782 XDN_N/G.n18 XDN_N/G.n6 70.1096
R783 XDN_N/G.n18 XDN_N/G.t0 163.881
R784 XDN_N/G.t0 XDN_N/G.n7 163.881
R785 XDN_N/G.n8 XDN_N/G.n9 152
R786 XDN_N/G.n10 XDN_N/G.n11 152
R787 XDN_N/G.n12 XDN_N/G.n13 152
R788 XDN_N/G.n12 XDN_N/G.n14 70.1096
R789 XDN_N/G.n10 XDN_N/G.n12 70.1096
R790 XDN_N/G.n10 XDN_N/G.n8 70.1096
R791 XDN_N/G.n7 XDN_N/G.n8 70.1096
R792 XDN_N/G.n15 XDN_N/G.n9 6.10787
R793 XDN_N/G.n16 XDN_N/G.n11 9.3005
R794 XDN_N/G.n17 XDN_N/G.n13 6.10787
R795 XDN_N/G.n14 XDN_N/G.n17 158.304
R796 XDN_N/G.n13 XDN_N/G.n11 36.1417
R797 XDN_N/G.n11 XDN_N/G.n9 36.1417
R798 XDN_N/G.n7 XDN_N/G.n15 158.304
R799 XDN_N/G.n16 XDN_N/G.n17 1.92
R800 XDN_N/G.n15 XDN_N/G.n16 1.92
R801 XDN_N/G.n14 XDN_N/G.t4 163.881
R802 XDN_N/G.n2 XDN_N/G.t4 163.881
R803 XDN_N/G.n12 XDN_N/G.t3 163.881
R804 XDN_N/G.n4 XDN_N/G.t3 163.881
R805 XDN_N/G.t2 XDN_N/G.n10 163.881
R806 XDN_N/G.n5 XDN_N/G.t2 163.881
R807 XDN_N/G.n8 XDN_N/G.t1 163.881
R808 XDN_N/G.n6 XDN_N/G.t1 163.881
R809 XDN_N/G.n3 select_b 1.8738
R810 XDN_N/B.t2 XDN_N/B.n0 73.1255
R811 XDN_N/B.n0 XDN_N/B.n1 73.1255
R812 XDN_N/B.n3 XDN_N/B.n2 117.001
R813 XDN_N/B.n4 XDN_N/B.t2 73.1255
R814 VGND XDN_N/B.n4 73.1255
R815 XDN_N/B.n6 XDN_N/B.n5 117.001
R816 XDN_N/B.n7 XDN_N/B.n6 117.001
R817 VGND XDN_N/B.n5 402.07
R818 XDN_N/B.n5 XDN_N/B.t0 1228.97
R819 XDN_N/B.t1 XDN_N/B.t0 728.277
R820 XDN_N/B.t2 XDN_N/B.t1 728.277
R821 XDN_N/B.t2 XDN_N/B.t3 728.277
R822 XDN_N/B.t3 XDN_N/B.t4 728.277
R823 XDN_N/B.t4 XDN_N/B.n2 1345.97
R824 VGND XDN_N/B.n7 216.095
R825 VGND XDN_N/B.n3 216.095
R826 XDN_N/B.n7 XDN_N/B.n1 216.095
R827 XDN_N/B.n1 XDN_N/B.n3 216.095
R828 XDN_N/B.n6 XDN_N/B.n4 3325.82
R829 XDN_N/B.n4 XDN_N/B.n2 3325.82
R830 XDN_N/B.n6 XDN_N/B.n0 3325.82
R831 XDN_N/B.n0 XDN_N/B.n2 3325.82
R832 XDN_P/S4.n0 ch2_lon_raw 0.141804
R833 XDN_P/S4.t0 ch2_lon_raw 166.566
R834 lop XDN_P/D4.n0 0.277674
R835 XDN_P/D4.n1 lop 146.25
R836 XDN_P/D4.t0 XDN_P/D4.n1 20.3161
R837 XDN_P/D4.n1 XDN_P/D4.t1 20.3161
R838 XDN_P/S3.n0 ch2_lon_raw 0.141804
R839 XDN_P/S3.n1 ch2_lon_raw 146.25
R840 XDN_P/S3.t1 XDN_P/S3.n1 20.3161
R841 XDN_P/S3.n1 XDN_P/S3.t0 20.3161
R842 lop XDN_P/D2.n0 0.277674
R843 XDN_P/D2.n1 lop 146.25
R844 XDN_P/D2.t1 XDN_P/D2.n1 20.3161
R845 XDN_P/D2.n1 XDN_P/D2.t0 20.3161
R846 XDN_P/S1.n0 ch2_lon_raw 0.141804
R847 XDN_P/S1.n1 ch2_lon_raw 146.25
R848 XDN_P/S1.t0 XDN_P/S1.n1 20.3161
R849 XDN_P/S1.n1 XDN_P/S1.t1 20.3161
R850 lop XDN_P/D0.n0 0.277674
R851 lop XDN_P/D0.t0 166.566
R852 ui_in[0] XDN_P/G.n0 9.3005
R853 ui_in[0] XDN_P/G.n0 0.0466957
R854 ui_in[0] XDN_P/G.n1 6.10787
R855 XDN_P/G.n1 XDN_P/G.n0 1.92
R856 XDN_P/G.n2 ui_in[0] 152
R857 ui_in[0] XDN_P/G.n3 6.10787
R858 XDN_P/G.n4 ui_in[0] 152
R859 XDN_P/G.n5 ui_in[0] 152
R860 XDN_P/G.n6 ui_in[0] 152
R861 ui_in[0] XDN_P/G.n18 152
R862 ui_in[0] XDN_P/G.n3 6.3031
R863 ui_in[0] XDN_P/G.n1 6.3031
R864 XDN_P/G.n4 XDN_P/G.n2 70.1096
R865 XDN_P/G.n5 XDN_P/G.n4 70.1096
R866 XDN_P/G.n6 XDN_P/G.n5 70.1096
R867 XDN_P/G.n18 XDN_P/G.n6 70.1096
R868 XDN_P/G.n18 XDN_P/G.t0 306.873
R869 XDN_P/G.t0 XDN_P/G.n7 306.873
R870 XDN_P/G.n8 XDN_P/G.n9 152
R871 XDN_P/G.n10 XDN_P/G.n11 152
R872 XDN_P/G.n12 XDN_P/G.n13 152
R873 XDN_P/G.n12 XDN_P/G.n14 70.1096
R874 XDN_P/G.n12 XDN_P/G.n10 70.1096
R875 XDN_P/G.n10 XDN_P/G.n8 70.1096
R876 XDN_P/G.n8 XDN_P/G.n7 70.1096
R877 XDN_P/G.n15 XDN_P/G.n9 6.10787
R878 XDN_P/G.n16 XDN_P/G.n11 9.3005
R879 XDN_P/G.n17 XDN_P/G.n13 6.10787
R880 XDN_P/G.n14 XDN_P/G.n17 158.304
R881 XDN_P/G.n13 XDN_P/G.n11 36.1417
R882 XDN_P/G.n11 XDN_P/G.n9 36.1417
R883 XDN_P/G.n7 XDN_P/G.n15 158.304
R884 XDN_P/G.n16 XDN_P/G.n17 1.92
R885 XDN_P/G.n15 XDN_P/G.n16 1.92
R886 XDN_P/G.n14 XDN_P/G.t4 306.873
R887 XDN_P/G.n2 XDN_P/G.t4 306.873
R888 XDN_P/G.t3 XDN_P/G.n12 306.873
R889 XDN_P/G.n4 XDN_P/G.t3 306.873
R890 XDN_P/G.t2 XDN_P/G.n10 306.873
R891 XDN_P/G.n5 XDN_P/G.t2 306.873
R892 XDN_P/G.t1 XDN_P/G.n8 306.873
R893 XDN_P/G.n6 XDN_P/G.t1 306.873
R894 XDN_P/G.n3 ui_in[0] 1.8738
R895 XDN_P/B.n1 XDN_P/B.t2 23.1255
R896 VDPWR XDN_P/B.n1 23.1255
R897 XDN_P/B.n0 VDPWR 16.5652
R898 XDN_P/B.n3 XDN_P/B.n2 26.4291
R899 XDN_P/B.n0 XDN_P/B.n3 233.036
R900 XDN_P/B.t2 XDN_P/B.n4 23.1255
R901 XDN_P/B.n4 XDN_P/B.n5 23.1255
R902 XDN_P/B.n5 XDN_P/B.n3 249.601
R903 XDN_P/B.n7 XDN_P/B.n6 26.4291
R904 VDPWR XDN_P/B.n7 249.601
R905 XDN_P/B.n7 XDN_P/B.n5 249.601
R906 XDN_P/B.n1 XDN_P/B.n6 2340
R907 XDN_P/B.n1 XDN_P/B.n2 2340
R908 XDN_P/B.n2 XDN_P/B.n4 2340
R909 XDN_P/B.n4 XDN_P/B.n6 2340
R910 XDN_P/B.n2 XDN_P/B.t0 229.464
R911 XDN_P/B.t1 XDN_P/B.t0 120.317
R912 XDN_P/B.t2 XDN_P/B.t1 120.317
R913 XDN_P/B.t2 XDN_P/B.t3 120.317
R914 XDN_P/B.t3 XDN_P/B.t4 120.317
R915 XDN_P/B.t4 XDN_P/B.n6 229.464
R916 VGND XCVCM/C2.t0 0.0891473
R917 tail1 XCH1_GM2A/S4.t0 57.1255
R918 gm1_n XCH1_GM2A/D4.n0 2.60267
R919 gm1_n XCH1_GM2A/D4.n1 46.2505
R920 XCH1_GM2A/D4.n1 XCH1_GM2A/D4.t1 10.8755
R921 XCH1_GM2A/D4.n1 XCH1_GM2A/D4.t0 10.8755
R922 tail1 XCH1_GM2A/S3.n0 46.2505
R923 XCH1_GM2A/S3.n0 XCH1_GM2A/S3.t0 10.8755
R924 XCH1_GM2A/S3.n0 XCH1_GM2A/S3.t1 10.8755
R925 gm1_n XCH1_GM2A/D2.n0 2.60267
R926 gm1_n XCH1_GM2A/D2.n1 46.2505
R927 XCH1_GM2A/D2.n1 XCH1_GM2A/D2.t1 10.8755
R928 XCH1_GM2A/D2.n1 XCH1_GM2A/D2.t0 10.8755
R929 tail1 XCH1_GM2A/S1.n0 46.2505
R930 XCH1_GM2A/S1.n0 XCH1_GM2A/S1.t0 10.8755
R931 XCH1_GM2A/S1.n0 XCH1_GM2A/S1.t1 10.8755
R932 gm1_n XCH1_GM2A/D0.n0 2.60267
R933 gm1_n XCH1_GM2A/D0.t0 57.1255
R934 vcm XCH1_GM2A/G.n0 9.3005
R935 vcm XCH1_GM2A/G.n0 0.0466957
R936 vcm XCH1_GM2A/G.n1 6.51721
R937 XCH1_GM2A/G.n1 XCH1_GM2A/G.n0 1.79883
R938 vcm XCH1_GM2A/G.n2 6.51721
R939 vcm XCH1_GM2A/G.n2 6.7822
R940 vcm XCH1_GM2A/G.n1 6.7822
R941 vcm XCH1_GM2A/G.t0 322.308
R942 XCH1_GM2A/G.t0 XCH1_GM2A/G.n8 329.089
R943 XCH1_GM2A/G.n3 XCH1_GM2A/G.n4 6.51721
R944 XCH1_GM2A/G.n6 XCH1_GM2A/G.n5 9.3005
R945 XCH1_GM2A/G.n8 XCH1_GM2A/G.n7 6.51721
R946 XCH1_GM2A/G.n4 XCH1_GM2A/G.n5 44.424
R947 XCH1_GM2A/G.n5 XCH1_GM2A/G.n7 44.424
R948 XCH1_GM2A/G.n7 XCH1_GM2A/G.t1 322.308
R949 XCH1_GM2A/G.t1 vcm 322.308
R950 XCH1_GM2A/G.n5 XCH1_GM2A/G.t2 322.308
R951 XCH1_GM2A/G.t2 vcm 322.308
R952 XCH1_GM2A/G.n4 XCH1_GM2A/G.t3 322.308
R953 XCH1_GM2A/G.t3 vcm 322.308
R954 XCH1_GM2A/G.n8 XCH1_GM2A/G.n6 1.79883
R955 XCH1_GM2A/G.n6 XCH1_GM2A/G.n3 1.79883
R956 XCH1_GM2A/G.n3 XCH1_GM2A/G.t4 329.089
R957 XCH1_GM2A/G.t4 vcm 322.308
R958 XCH1_GM2A/G.n2 vcm 1.75264
R959 XCH1_GM2A/B.t2 XCH1_GM2A/B.n0 58.5005
R960 XCH1_GM2A/B.n0 XCH1_GM2A/B.n1 58.5005
R961 XCH1_GM2A/B.n3 XCH1_GM2A/B.n2 83.5719
R962 XCH1_GM2A/B.n4 XCH1_GM2A/B.t2 58.5005
R963 VGND XCH1_GM2A/B.n4 58.5005
R964 XCH1_GM2A/B.n6 XCH1_GM2A/B.n5 83.5719
R965 XCH1_GM2A/B.n7 XCH1_GM2A/B.n6 83.5719
R966 VGND XCH1_GM2A/B.n5 315.135
R967 XCH1_GM2A/B.n5 XCH1_GM2A/B.t0 1028.65
R968 XCH1_GM2A/B.t0 XCH1_GM2A/B.t1 701.622
R969 XCH1_GM2A/B.t2 XCH1_GM2A/B.t1 701.622
R970 XCH1_GM2A/B.t2 XCH1_GM2A/B.t3 701.622
R971 XCH1_GM2A/B.t3 XCH1_GM2A/B.t4 701.622
R972 XCH1_GM2A/B.n2 XCH1_GM2A/B.t4 1112.22
R973 VGND XCH1_GM2A/B.n7 266.918
R974 VGND XCH1_GM2A/B.n3 266.918
R975 XCH1_GM2A/B.n7 XCH1_GM2A/B.n1 266.918
R976 XCH1_GM2A/B.n1 XCH1_GM2A/B.n3 266.918
R977 XCH1_GM2A/B.n6 XCH1_GM2A/B.n4 4108.03
R978 XCH1_GM2A/B.n4 XCH1_GM2A/B.n2 4108.03
R979 XCH1_GM2A/B.n6 XCH1_GM2A/B.n0 4108.03
R980 XCH1_GM2A/B.n0 XCH1_GM2A/B.n2 4108.03
R981 tail1 XCH1_GM2B/S4.t0 57.1255
R982 gm1_n XCH1_GM2B/D4.n0 2.60267
R983 gm1_n XCH1_GM2B/D4.n1 46.2505
R984 XCH1_GM2B/D4.n1 XCH1_GM2B/D4.t1 10.8755
R985 XCH1_GM2B/D4.n1 XCH1_GM2B/D4.t0 10.8755
R986 tail1 XCH1_GM2B/S3.n0 46.2505
R987 XCH1_GM2B/S3.n0 XCH1_GM2B/S3.t0 10.8755
R988 XCH1_GM2B/S3.n0 XCH1_GM2B/S3.t1 10.8755
R989 gm1_n XCH1_GM2B/D2.n0 2.60267
R990 gm1_n XCH1_GM2B/D2.n1 46.2505
R991 XCH1_GM2B/D2.n1 XCH1_GM2B/D2.t1 10.8755
R992 XCH1_GM2B/D2.n1 XCH1_GM2B/D2.t0 10.8755
R993 tail1 XCH1_GM2B/S1.n0 46.2505
R994 XCH1_GM2B/S1.n0 XCH1_GM2B/S1.t0 10.8755
R995 XCH1_GM2B/S1.n0 XCH1_GM2B/S1.t1 10.8755
R996 gm1_n XCH1_GM2B/D0.n0 2.60267
R997 gm1_n XCH1_GM2B/D0.t0 57.1255
R998 vcm XCH1_GM2B/G.n0 9.3005
R999 vcm XCH1_GM2B/G.n0 0.0466957
R1000 vcm XCH1_GM2B/G.n1 6.51721
R1001 XCH1_GM2B/G.n1 XCH1_GM2B/G.n0 1.79883
R1002 vcm XCH1_GM2B/G.n2 6.51721
R1003 vcm XCH1_GM2B/G.n2 6.7822
R1004 vcm XCH1_GM2B/G.n1 6.7822
R1005 vcm XCH1_GM2B/G.t0 322.308
R1006 XCH1_GM2B/G.t0 XCH1_GM2B/G.n8 329.089
R1007 XCH1_GM2B/G.n3 XCH1_GM2B/G.n4 6.51721
R1008 XCH1_GM2B/G.n6 XCH1_GM2B/G.n5 9.3005
R1009 XCH1_GM2B/G.n8 XCH1_GM2B/G.n7 6.51721
R1010 XCH1_GM2B/G.n4 XCH1_GM2B/G.n5 44.424
R1011 XCH1_GM2B/G.n5 XCH1_GM2B/G.n7 44.424
R1012 XCH1_GM2B/G.n7 XCH1_GM2B/G.t1 322.308
R1013 XCH1_GM2B/G.t1 vcm 322.308
R1014 XCH1_GM2B/G.n5 XCH1_GM2B/G.t2 322.308
R1015 XCH1_GM2B/G.t2 vcm 322.308
R1016 XCH1_GM2B/G.n4 XCH1_GM2B/G.t3 322.308
R1017 XCH1_GM2B/G.t3 vcm 322.308
R1018 XCH1_GM2B/G.n8 XCH1_GM2B/G.n6 1.79883
R1019 XCH1_GM2B/G.n6 XCH1_GM2B/G.n3 1.79883
R1020 XCH1_GM2B/G.n3 XCH1_GM2B/G.t4 329.089
R1021 XCH1_GM2B/G.t4 vcm 322.308
R1022 XCH1_GM2B/G.n2 vcm 1.75264
R1023 XCH1_GM2B/B.t2 XCH1_GM2B/B.n0 58.5005
R1024 XCH1_GM2B/B.n0 XCH1_GM2B/B.n1 58.5005
R1025 XCH1_GM2B/B.n3 XCH1_GM2B/B.n2 83.5719
R1026 XCH1_GM2B/B.n4 XCH1_GM2B/B.t2 58.5005
R1027 VGND XCH1_GM2B/B.n4 58.5005
R1028 XCH1_GM2B/B.n6 XCH1_GM2B/B.n5 83.5719
R1029 XCH1_GM2B/B.n7 XCH1_GM2B/B.n6 83.5719
R1030 VGND XCH1_GM2B/B.n5 315.135
R1031 XCH1_GM2B/B.n5 XCH1_GM2B/B.t0 1028.65
R1032 XCH1_GM2B/B.t0 XCH1_GM2B/B.t1 701.622
R1033 XCH1_GM2B/B.t2 XCH1_GM2B/B.t1 701.622
R1034 XCH1_GM2B/B.t2 XCH1_GM2B/B.t3 701.622
R1035 XCH1_GM2B/B.t3 XCH1_GM2B/B.t4 701.622
R1036 XCH1_GM2B/B.n2 XCH1_GM2B/B.t4 1112.22
R1037 VGND XCH1_GM2B/B.n7 266.918
R1038 VGND XCH1_GM2B/B.n3 266.918
R1039 XCH1_GM2B/B.n7 XCH1_GM2B/B.n1 266.918
R1040 XCH1_GM2B/B.n1 XCH1_GM2B/B.n3 266.918
R1041 XCH1_GM2B/B.n6 XCH1_GM2B/B.n4 4108.03
R1042 XCH1_GM2B/B.n4 XCH1_GM2B/B.n2 4108.03
R1043 XCH1_GM2B/B.n6 XCH1_GM2B/B.n0 4108.03
R1044 XCH1_GM2B/B.n0 XCH1_GM2B/B.n2 4108.03
R1045 tail1 XCH1_GM1A/S4.t0 57.1255
R1046 gm1_p XCH1_GM1A/D4.n0 2.60267
R1047 gm1_p XCH1_GM1A/D4.n1 46.2505
R1048 XCH1_GM1A/D4.n1 XCH1_GM1A/D4.t1 10.8755
R1049 XCH1_GM1A/D4.n1 XCH1_GM1A/D4.t0 10.8755
R1050 tail1 XCH1_GM1A/S3.n0 46.2505
R1051 XCH1_GM1A/S3.n0 XCH1_GM1A/S3.t0 10.8755
R1052 XCH1_GM1A/S3.n0 XCH1_GM1A/S3.t1 10.8755
R1053 gm1_p XCH1_GM1A/D2.n0 2.60267
R1054 gm1_p XCH1_GM1A/D2.n1 46.2505
R1055 XCH1_GM1A/D2.n1 XCH1_GM1A/D2.t1 10.8755
R1056 XCH1_GM1A/D2.n1 XCH1_GM1A/D2.t0 10.8755
R1057 tail1 XCH1_GM1A/S1.n0 46.2505
R1058 XCH1_GM1A/S1.n0 XCH1_GM1A/S1.t0 10.8755
R1059 XCH1_GM1A/S1.n0 XCH1_GM1A/S1.t1 10.8755
R1060 gm1_p XCH1_GM1A/D0.n0 2.60267
R1061 gm1_p XCH1_GM1A/D0.t0 57.1255
R1062 ua[0] XCH1_GM1A/G.n0 9.3005
R1063 ua[0] XCH1_GM1A/G.n0 0.0466957
R1064 ua[0] XCH1_GM1A/G.n1 6.51721
R1065 XCH1_GM1A/G.n1 XCH1_GM1A/G.n0 1.79883
R1066 ua[0] XCH1_GM1A/G.n2 6.51721
R1067 ua[0] XCH1_GM1A/G.n2 6.7822
R1068 ua[0] XCH1_GM1A/G.n1 6.7822
R1069 ua[0] XCH1_GM1A/G.t0 322.308
R1070 XCH1_GM1A/G.t0 XCH1_GM1A/G.n8 329.089
R1071 XCH1_GM1A/G.n3 XCH1_GM1A/G.n4 6.51721
R1072 XCH1_GM1A/G.n6 XCH1_GM1A/G.n5 9.3005
R1073 XCH1_GM1A/G.n8 XCH1_GM1A/G.n7 6.51721
R1074 XCH1_GM1A/G.n4 XCH1_GM1A/G.n5 44.424
R1075 XCH1_GM1A/G.n5 XCH1_GM1A/G.n7 44.424
R1076 XCH1_GM1A/G.n7 XCH1_GM1A/G.t1 322.308
R1077 XCH1_GM1A/G.t1 ua[0] 322.308
R1078 XCH1_GM1A/G.n5 XCH1_GM1A/G.t2 322.308
R1079 XCH1_GM1A/G.t2 ua[0] 322.308
R1080 XCH1_GM1A/G.n4 XCH1_GM1A/G.t3 322.308
R1081 XCH1_GM1A/G.t3 ua[0] 322.308
R1082 XCH1_GM1A/G.n8 XCH1_GM1A/G.n6 1.79883
R1083 XCH1_GM1A/G.n6 XCH1_GM1A/G.n3 1.79883
R1084 XCH1_GM1A/G.n3 XCH1_GM1A/G.t4 329.089
R1085 XCH1_GM1A/G.t4 ua[0] 322.308
R1086 XCH1_GM1A/G.n2 ua[0] 1.75264
R1087 XCH1_GM1A/B.t2 XCH1_GM1A/B.n0 58.5005
R1088 XCH1_GM1A/B.n0 XCH1_GM1A/B.n1 58.5005
R1089 XCH1_GM1A/B.n3 XCH1_GM1A/B.n2 83.5719
R1090 XCH1_GM1A/B.n4 XCH1_GM1A/B.t2 58.5005
R1091 VGND XCH1_GM1A/B.n4 58.5005
R1092 XCH1_GM1A/B.n6 XCH1_GM1A/B.n5 83.5719
R1093 XCH1_GM1A/B.n7 XCH1_GM1A/B.n6 83.5719
R1094 VGND XCH1_GM1A/B.n5 315.135
R1095 XCH1_GM1A/B.n5 XCH1_GM1A/B.t0 1028.65
R1096 XCH1_GM1A/B.t0 XCH1_GM1A/B.t1 701.622
R1097 XCH1_GM1A/B.t2 XCH1_GM1A/B.t1 701.622
R1098 XCH1_GM1A/B.t2 XCH1_GM1A/B.t3 701.622
R1099 XCH1_GM1A/B.t3 XCH1_GM1A/B.t4 701.622
R1100 XCH1_GM1A/B.n2 XCH1_GM1A/B.t4 1112.22
R1101 VGND XCH1_GM1A/B.n7 266.918
R1102 VGND XCH1_GM1A/B.n3 266.918
R1103 XCH1_GM1A/B.n7 XCH1_GM1A/B.n1 266.918
R1104 XCH1_GM1A/B.n1 XCH1_GM1A/B.n3 266.918
R1105 XCH1_GM1A/B.n6 XCH1_GM1A/B.n4 4108.03
R1106 XCH1_GM1A/B.n4 XCH1_GM1A/B.n2 4108.03
R1107 XCH1_GM1A/B.n6 XCH1_GM1A/B.n0 4108.03
R1108 XCH1_GM1A/B.n0 XCH1_GM1A/B.n2 4108.03
R1109 tail1 XCH1_GM1B/S4.t0 57.1255
R1110 gm1_p XCH1_GM1B/D4.n0 2.60267
R1111 gm1_p XCH1_GM1B/D4.n1 46.2505
R1112 XCH1_GM1B/D4.n1 XCH1_GM1B/D4.t1 10.8755
R1113 XCH1_GM1B/D4.n1 XCH1_GM1B/D4.t0 10.8755
R1114 tail1 XCH1_GM1B/S3.n0 46.2505
R1115 XCH1_GM1B/S3.n0 XCH1_GM1B/S3.t0 10.8755
R1116 XCH1_GM1B/S3.n0 XCH1_GM1B/S3.t1 10.8755
R1117 gm1_p XCH1_GM1B/D2.n0 2.60267
R1118 gm1_p XCH1_GM1B/D2.n1 46.2505
R1119 XCH1_GM1B/D2.n1 XCH1_GM1B/D2.t1 10.8755
R1120 XCH1_GM1B/D2.n1 XCH1_GM1B/D2.t0 10.8755
R1121 tail1 XCH1_GM1B/S1.n0 46.2505
R1122 XCH1_GM1B/S1.n0 XCH1_GM1B/S1.t0 10.8755
R1123 XCH1_GM1B/S1.n0 XCH1_GM1B/S1.t1 10.8755
R1124 gm1_p XCH1_GM1B/D0.n0 2.60267
R1125 gm1_p XCH1_GM1B/D0.t0 57.1255
R1126 ua[0] XCH1_GM1B/G.n0 9.3005
R1127 ua[0] XCH1_GM1B/G.n0 0.0466957
R1128 ua[0] XCH1_GM1B/G.n1 6.51721
R1129 XCH1_GM1B/G.n1 XCH1_GM1B/G.n0 1.79883
R1130 ua[0] XCH1_GM1B/G.n2 6.51721
R1131 ua[0] XCH1_GM1B/G.n2 6.7822
R1132 ua[0] XCH1_GM1B/G.n1 6.7822
R1133 ua[0] XCH1_GM1B/G.t0 322.308
R1134 XCH1_GM1B/G.t0 XCH1_GM1B/G.n8 329.089
R1135 XCH1_GM1B/G.n3 XCH1_GM1B/G.n4 6.51721
R1136 XCH1_GM1B/G.n6 XCH1_GM1B/G.n5 9.3005
R1137 XCH1_GM1B/G.n8 XCH1_GM1B/G.n7 6.51721
R1138 XCH1_GM1B/G.n4 XCH1_GM1B/G.n5 44.424
R1139 XCH1_GM1B/G.n5 XCH1_GM1B/G.n7 44.424
R1140 XCH1_GM1B/G.n7 XCH1_GM1B/G.t1 322.308
R1141 XCH1_GM1B/G.t1 ua[0] 322.308
R1142 XCH1_GM1B/G.n5 XCH1_GM1B/G.t2 322.308
R1143 XCH1_GM1B/G.t2 ua[0] 322.308
R1144 XCH1_GM1B/G.n4 XCH1_GM1B/G.t3 322.308
R1145 XCH1_GM1B/G.t3 ua[0] 322.308
R1146 XCH1_GM1B/G.n8 XCH1_GM1B/G.n6 1.79883
R1147 XCH1_GM1B/G.n6 XCH1_GM1B/G.n3 1.79883
R1148 XCH1_GM1B/G.n3 XCH1_GM1B/G.t4 329.089
R1149 XCH1_GM1B/G.t4 ua[0] 322.308
R1150 XCH1_GM1B/G.n2 ua[0] 1.75264
R1151 XCH1_GM1B/B.t2 XCH1_GM1B/B.n0 58.5005
R1152 XCH1_GM1B/B.n0 XCH1_GM1B/B.n1 58.5005
R1153 XCH1_GM1B/B.n3 XCH1_GM1B/B.n2 83.5719
R1154 XCH1_GM1B/B.n4 XCH1_GM1B/B.t2 58.5005
R1155 VGND XCH1_GM1B/B.n4 58.5005
R1156 XCH1_GM1B/B.n6 XCH1_GM1B/B.n5 83.5719
R1157 XCH1_GM1B/B.n7 XCH1_GM1B/B.n6 83.5719
R1158 VGND XCH1_GM1B/B.n5 315.135
R1159 XCH1_GM1B/B.n5 XCH1_GM1B/B.t0 1028.65
R1160 XCH1_GM1B/B.t0 XCH1_GM1B/B.t1 701.622
R1161 XCH1_GM1B/B.t2 XCH1_GM1B/B.t1 701.622
R1162 XCH1_GM1B/B.t2 XCH1_GM1B/B.t3 701.622
R1163 XCH1_GM1B/B.t3 XCH1_GM1B/B.t4 701.622
R1164 XCH1_GM1B/B.n2 XCH1_GM1B/B.t4 1112.22
R1165 VGND XCH1_GM1B/B.n7 266.918
R1166 VGND XCH1_GM1B/B.n3 266.918
R1167 XCH1_GM1B/B.n7 XCH1_GM1B/B.n1 266.918
R1168 XCH1_GM1B/B.n1 XCH1_GM1B/B.n3 266.918
R1169 XCH1_GM1B/B.n6 XCH1_GM1B/B.n4 4108.03
R1170 XCH1_GM1B/B.n4 XCH1_GM1B/B.n2 4108.03
R1171 XCH1_GM1B/B.n6 XCH1_GM1B/B.n0 4108.03
R1172 XCH1_GM1B/B.n0 XCH1_GM1B/B.n2 4108.03
R1173 VGND XLN2_N/S4.t0 117.251
R1174 ln2 XLN2_N/D4.n0 4.71028
R1175 ln2 XLN2_N/D4.n1 92.5005
R1176 XLN2_N/D4.n1 XLN2_N/D4.t1 24.7505
R1177 XLN2_N/D4.n1 XLN2_N/D4.t0 24.7505
R1178 VGND XLN2_N/S3.n0 92.5005
R1179 XLN2_N/S3.n0 XLN2_N/S3.t0 24.7505
R1180 XLN2_N/S3.n0 XLN2_N/S3.t1 24.7505
R1181 ln2 XLN2_N/D2.n0 4.71028
R1182 ln2 XLN2_N/D2.n1 92.5005
R1183 XLN2_N/D2.n1 XLN2_N/D2.t0 24.7505
R1184 XLN2_N/D2.n1 XLN2_N/D2.t1 24.7505
R1185 VGND XLN2_N/S1.n0 92.5005
R1186 XLN2_N/S1.n0 XLN2_N/S1.t0 24.7505
R1187 XLN2_N/S1.n0 XLN2_N/S1.t1 24.7505
R1188 ln2 XLN2_N/D0.n0 4.71028
R1189 ln2 XLN2_N/D0.t0 117.251
R1190 ln1 XLN2_N/G.n0 9.3005
R1191 ln1 XLN2_N/G.n0 0.0466957
R1192 ln1 XLN2_N/G.n1 6.10787
R1193 XLN2_N/G.n1 XLN2_N/G.n0 1.92
R1194 XLN2_N/G.n2 ln1 152
R1195 ln1 XLN2_N/G.n3 6.10787
R1196 XLN2_N/G.n4 ln1 152
R1197 XLN2_N/G.n5 ln1 152
R1198 XLN2_N/G.n6 ln1 152
R1199 ln1 XLN2_N/G.n18 152
R1200 ln1 XLN2_N/G.n3 6.3031
R1201 ln1 XLN2_N/G.n1 6.3031
R1202 XLN2_N/G.n4 XLN2_N/G.n2 70.1096
R1203 XLN2_N/G.n5 XLN2_N/G.n4 70.1096
R1204 XLN2_N/G.n6 XLN2_N/G.n5 70.1096
R1205 XLN2_N/G.n18 XLN2_N/G.n6 70.1096
R1206 XLN2_N/G.n18 XLN2_N/G.t0 163.881
R1207 XLN2_N/G.t0 XLN2_N/G.n7 163.881
R1208 XLN2_N/G.n8 XLN2_N/G.n9 152
R1209 XLN2_N/G.n10 XLN2_N/G.n11 152
R1210 XLN2_N/G.n12 XLN2_N/G.n13 152
R1211 XLN2_N/G.n12 XLN2_N/G.n14 70.1096
R1212 XLN2_N/G.n10 XLN2_N/G.n12 70.1096
R1213 XLN2_N/G.n10 XLN2_N/G.n8 70.1096
R1214 XLN2_N/G.n7 XLN2_N/G.n8 70.1096
R1215 XLN2_N/G.n15 XLN2_N/G.n9 6.10787
R1216 XLN2_N/G.n16 XLN2_N/G.n11 9.3005
R1217 XLN2_N/G.n17 XLN2_N/G.n13 6.10787
R1218 XLN2_N/G.n14 XLN2_N/G.n17 158.304
R1219 XLN2_N/G.n13 XLN2_N/G.n11 36.1417
R1220 XLN2_N/G.n11 XLN2_N/G.n9 36.1417
R1221 XLN2_N/G.n7 XLN2_N/G.n15 158.304
R1222 XLN2_N/G.n16 XLN2_N/G.n17 1.92
R1223 XLN2_N/G.n15 XLN2_N/G.n16 1.92
R1224 XLN2_N/G.n14 XLN2_N/G.t4 163.881
R1225 XLN2_N/G.n2 XLN2_N/G.t4 163.881
R1226 XLN2_N/G.n12 XLN2_N/G.t3 163.881
R1227 XLN2_N/G.n4 XLN2_N/G.t3 163.881
R1228 XLN2_N/G.t2 XLN2_N/G.n10 163.881
R1229 XLN2_N/G.n5 XLN2_N/G.t2 163.881
R1230 XLN2_N/G.n8 XLN2_N/G.t1 163.881
R1231 XLN2_N/G.n6 XLN2_N/G.t1 163.881
R1232 XLN2_N/G.n3 ln1 1.8738
R1233 XLN2_N/B.t2 XLN2_N/B.n0 73.1255
R1234 XLN2_N/B.n0 XLN2_N/B.n1 73.1255
R1235 XLN2_N/B.n3 XLN2_N/B.n2 117.001
R1236 XLN2_N/B.n4 XLN2_N/B.t2 73.1255
R1237 VGND XLN2_N/B.n4 73.1255
R1238 XLN2_N/B.n6 XLN2_N/B.n5 117.001
R1239 XLN2_N/B.n7 XLN2_N/B.n6 117.001
R1240 VGND XLN2_N/B.n5 402.07
R1241 XLN2_N/B.n5 XLN2_N/B.t0 1228.97
R1242 XLN2_N/B.t1 XLN2_N/B.t0 728.277
R1243 XLN2_N/B.t2 XLN2_N/B.t1 728.277
R1244 XLN2_N/B.t2 XLN2_N/B.t3 728.277
R1245 XLN2_N/B.t3 XLN2_N/B.t4 728.277
R1246 XLN2_N/B.t4 XLN2_N/B.n2 1345.97
R1247 VGND XLN2_N/B.n7 216.095
R1248 VGND XLN2_N/B.n3 216.095
R1249 XLN2_N/B.n7 XLN2_N/B.n1 216.095
R1250 XLN2_N/B.n1 XLN2_N/B.n3 216.095
R1251 XLN2_N/B.n6 XLN2_N/B.n4 3325.82
R1252 XLN2_N/B.n4 XLN2_N/B.n2 3325.82
R1253 XLN2_N/B.n6 XLN2_N/B.n0 3325.82
R1254 XLN2_N/B.n0 XLN2_N/B.n2 3325.82
R1255 vcm XRIN1/R2.n0 0.46195
R1256 XRIN1/R2.n0 XRIN1/R2.t0 25.3338
R1257 vcm XRIN1/R2.n0 8.2161
R1258 XRIN1/R1.n0 XRIN1/R1.t0 25.3338
R1259 ua[0] XRIN1/R1.n0 0.507818
R1260 ua[0] XRIN1/R1.n0 8.2161
R1261 XRIN1/B.t0 XRIN1/B.n0 0.196169
R1262 XRIN1/B.n1 XRIN1/B.n2 117.001
R1263 XRIN1/B.n3 XRIN1/B.n4 2.64756
R1264 XRIN1/B.n5 XRIN1/B.t0 117.001
R1265 VGND XRIN1/B.n5 117.001
R1266 XRIN1/B.n6 XRIN1/B.n7 2.64756
R1267 XRIN1/B.n7 XRIN1/B.n8 2.64756
R1268 VGND XRIN1/B.n6 15.2783
R1269 XRIN1/B.t0 XRIN1/B.n6 73.2185
R1270 XRIN1/B.n0 XRIN1/B.n3 75.5444
R1271 XRIN1/B.n8 VGND 2942.49
R1272 VGND XRIN1/B.n4 2942.49
R1273 XRIN1/B.n8 XRIN1/B.n2 2942.49
R1274 XRIN1/B.n2 XRIN1/B.n4 2942.49
R1275 XRIN1/B.n7 XRIN1/B.n5 45286.8
R1276 XRIN1/B.n5 XRIN1/B.n3 45286.8
R1277 XRIN1/B.n7 XRIN1/B.n1 45286.8
R1278 XRIN1/B.n0 XRIN1/B.n1 116.504
R1279 vcm XRIN2/R2.n0 0.46195
R1280 XRIN2/R2.n0 XRIN2/R2.t0 25.3338
R1281 vcm XRIN2/R2.n0 8.2161
R1282 XRIN2/R1.n0 XRIN2/R1.t0 25.3338
R1283 ua[1] XRIN2/R1.n0 0.507818
R1284 ua[1] XRIN2/R1.n0 8.2161
R1285 XRIN2/B.t0 XRIN2/B.n0 0.196169
R1286 XRIN2/B.n1 XRIN2/B.n2 117.001
R1287 XRIN2/B.n3 XRIN2/B.n4 2.64756
R1288 XRIN2/B.n5 XRIN2/B.t0 117.001
R1289 VGND XRIN2/B.n5 117.001
R1290 XRIN2/B.n6 XRIN2/B.n7 2.64756
R1291 XRIN2/B.n7 XRIN2/B.n8 2.64756
R1292 VGND XRIN2/B.n6 15.2783
R1293 XRIN2/B.t0 XRIN2/B.n6 73.2185
R1294 XRIN2/B.n0 XRIN2/B.n3 75.5444
R1295 XRIN2/B.n8 VGND 2942.49
R1296 VGND XRIN2/B.n4 2942.49
R1297 XRIN2/B.n8 XRIN2/B.n2 2942.49
R1298 XRIN2/B.n2 XRIN2/B.n4 2942.49
R1299 XRIN2/B.n7 XRIN2/B.n5 45286.8
R1300 XRIN2/B.n5 XRIN2/B.n3 45286.8
R1301 XRIN2/B.n7 XRIN2/B.n1 45286.8
R1302 XRIN2/B.n0 XRIN2/B.n1 116.504
R1303 XLN2_P/S4.n0 VDPWR 0.141804
R1304 XLN2_P/S4.t0 VDPWR 166.566
R1305 ln2 XLN2_P/D4.n0 0.277674
R1306 XLN2_P/D4.n1 ln2 146.25
R1307 XLN2_P/D4.t0 XLN2_P/D4.n1 20.3161
R1308 XLN2_P/D4.n1 XLN2_P/D4.t1 20.3161
R1309 XLN2_P/S3.n0 VDPWR 0.141804
R1310 XLN2_P/S3.n1 VDPWR 146.25
R1311 XLN2_P/S3.t1 XLN2_P/S3.n1 20.3161
R1312 XLN2_P/S3.n1 XLN2_P/S3.t0 20.3161
R1313 ln2 XLN2_P/D2.n0 0.277674
R1314 XLN2_P/D2.n1 ln2 146.25
R1315 XLN2_P/D2.t1 XLN2_P/D2.n1 20.3161
R1316 XLN2_P/D2.n1 XLN2_P/D2.t0 20.3161
R1317 XLN2_P/S1.n0 VDPWR 0.141804
R1318 XLN2_P/S1.n1 VDPWR 146.25
R1319 XLN2_P/S1.t0 XLN2_P/S1.n1 20.3161
R1320 XLN2_P/S1.n1 XLN2_P/S1.t1 20.3161
R1321 ln2 XLN2_P/D0.n0 0.277674
R1322 ln2 XLN2_P/D0.t0 166.566
R1323 ln1 XLN2_P/G.n0 9.3005
R1324 ln1 XLN2_P/G.n0 0.0466957
R1325 ln1 XLN2_P/G.n1 6.10787
R1326 XLN2_P/G.n1 XLN2_P/G.n0 1.92
R1327 XLN2_P/G.n2 ln1 152
R1328 ln1 XLN2_P/G.n3 6.10787
R1329 XLN2_P/G.n4 ln1 152
R1330 XLN2_P/G.n5 ln1 152
R1331 XLN2_P/G.n6 ln1 152
R1332 ln1 XLN2_P/G.n18 152
R1333 ln1 XLN2_P/G.n3 6.3031
R1334 ln1 XLN2_P/G.n1 6.3031
R1335 XLN2_P/G.n4 XLN2_P/G.n2 70.1096
R1336 XLN2_P/G.n5 XLN2_P/G.n4 70.1096
R1337 XLN2_P/G.n6 XLN2_P/G.n5 70.1096
R1338 XLN2_P/G.n18 XLN2_P/G.n6 70.1096
R1339 XLN2_P/G.n18 XLN2_P/G.t0 306.873
R1340 XLN2_P/G.t0 XLN2_P/G.n7 306.873
R1341 XLN2_P/G.n8 XLN2_P/G.n9 152
R1342 XLN2_P/G.n10 XLN2_P/G.n11 152
R1343 XLN2_P/G.n12 XLN2_P/G.n13 152
R1344 XLN2_P/G.n12 XLN2_P/G.n14 70.1096
R1345 XLN2_P/G.n12 XLN2_P/G.n10 70.1096
R1346 XLN2_P/G.n10 XLN2_P/G.n8 70.1096
R1347 XLN2_P/G.n8 XLN2_P/G.n7 70.1096
R1348 XLN2_P/G.n15 XLN2_P/G.n9 6.10787
R1349 XLN2_P/G.n16 XLN2_P/G.n11 9.3005
R1350 XLN2_P/G.n17 XLN2_P/G.n13 6.10787
R1351 XLN2_P/G.n14 XLN2_P/G.n17 158.304
R1352 XLN2_P/G.n13 XLN2_P/G.n11 36.1417
R1353 XLN2_P/G.n11 XLN2_P/G.n9 36.1417
R1354 XLN2_P/G.n7 XLN2_P/G.n15 158.304
R1355 XLN2_P/G.n16 XLN2_P/G.n17 1.92
R1356 XLN2_P/G.n15 XLN2_P/G.n16 1.92
R1357 XLN2_P/G.n14 XLN2_P/G.t4 306.873
R1358 XLN2_P/G.n2 XLN2_P/G.t4 306.873
R1359 XLN2_P/G.t3 XLN2_P/G.n12 306.873
R1360 XLN2_P/G.n4 XLN2_P/G.t3 306.873
R1361 XLN2_P/G.t2 XLN2_P/G.n10 306.873
R1362 XLN2_P/G.n5 XLN2_P/G.t2 306.873
R1363 XLN2_P/G.t1 XLN2_P/G.n8 306.873
R1364 XLN2_P/G.n6 XLN2_P/G.t1 306.873
R1365 XLN2_P/G.n3 ln1 1.8738
R1366 XLN2_P/B.n1 XLN2_P/B.t2 23.1255
R1367 VDPWR XLN2_P/B.n1 23.1255
R1368 XLN2_P/B.n0 VDPWR 16.5652
R1369 XLN2_P/B.n3 XLN2_P/B.n2 26.4291
R1370 XLN2_P/B.n0 XLN2_P/B.n3 233.036
R1371 XLN2_P/B.t2 XLN2_P/B.n4 23.1255
R1372 XLN2_P/B.n4 XLN2_P/B.n5 23.1255
R1373 XLN2_P/B.n5 XLN2_P/B.n3 249.601
R1374 XLN2_P/B.n7 XLN2_P/B.n6 26.4291
R1375 VDPWR XLN2_P/B.n7 249.601
R1376 XLN2_P/B.n7 XLN2_P/B.n5 249.601
R1377 XLN2_P/B.n1 XLN2_P/B.n6 2340
R1378 XLN2_P/B.n1 XLN2_P/B.n2 2340
R1379 XLN2_P/B.n2 XLN2_P/B.n4 2340
R1380 XLN2_P/B.n4 XLN2_P/B.n6 2340
R1381 XLN2_P/B.n2 XLN2_P/B.t0 229.464
R1382 XLN2_P/B.t1 XLN2_P/B.t0 120.317
R1383 XLN2_P/B.t2 XLN2_P/B.t1 120.317
R1384 XLN2_P/B.t2 XLN2_P/B.t3 120.317
R1385 XLN2_P/B.t3 XLN2_P/B.t4 120.317
R1386 XLN2_P/B.t4 XLN2_P/B.n6 229.464
R1387 gm2_n XCH2_SW4A/S4.t0 58.6255
R1388 ua[2] XCH2_SW4A/D4.n0 0.277674
R1389 XCH2_SW4A/D4.n1 ua[2] 46.2505
R1390 XCH2_SW4A/D4.t0 XCH2_SW4A/D4.n1 12.3755
R1391 XCH2_SW4A/D4.n1 XCH2_SW4A/D4.t1 12.3755
R1392 gm2_n XCH2_SW4A/S3.n0 46.2505
R1393 XCH2_SW4A/S3.n0 XCH2_SW4A/S3.t1 12.3755
R1394 XCH2_SW4A/S3.n0 XCH2_SW4A/S3.t0 12.3755
R1395 ua[2] XCH2_SW4A/D2.n0 0.277674
R1396 XCH2_SW4A/D2.n1 ua[2] 46.2505
R1397 XCH2_SW4A/D2.t0 XCH2_SW4A/D2.n1 12.3755
R1398 XCH2_SW4A/D2.n1 XCH2_SW4A/D2.t1 12.3755
R1399 gm2_n XCH2_SW4A/S1.n0 46.2505
R1400 XCH2_SW4A/S1.n0 XCH2_SW4A/S1.t0 12.3755
R1401 XCH2_SW4A/S1.n0 XCH2_SW4A/S1.t1 12.3755
R1402 ua[2] XCH2_SW4A/D0.n0 0.277674
R1403 ua[2] XCH2_SW4A/D0.t0 58.6255
R1404 ch2_lon XCH2_SW4A/G.n0 9.3005
R1405 ch2_lon XCH2_SW4A/G.n0 0.0466957
R1406 ch2_lon XCH2_SW4A/G.n1 6.10787
R1407 XCH2_SW4A/G.n1 XCH2_SW4A/G.n0 1.92
R1408 XCH2_SW4A/G.n2 ch2_lon 152
R1409 ch2_lon XCH2_SW4A/G.n3 6.10787
R1410 XCH2_SW4A/G.n4 ch2_lon 152
R1411 XCH2_SW4A/G.n5 ch2_lon 152
R1412 XCH2_SW4A/G.n6 ch2_lon 152
R1413 ch2_lon XCH2_SW4A/G.n18 152
R1414 ch2_lon XCH2_SW4A/G.n3 6.3031
R1415 ch2_lon XCH2_SW4A/G.n1 6.3031
R1416 XCH2_SW4A/G.n4 XCH2_SW4A/G.n2 70.1096
R1417 XCH2_SW4A/G.n5 XCH2_SW4A/G.n4 70.1096
R1418 XCH2_SW4A/G.n6 XCH2_SW4A/G.n5 70.1096
R1419 XCH2_SW4A/G.n18 XCH2_SW4A/G.n6 70.1096
R1420 XCH2_SW4A/G.n18 XCH2_SW4A/G.t0 292.413
R1421 XCH2_SW4A/G.t0 XCH2_SW4A/G.n7 292.413
R1422 XCH2_SW4A/G.n8 XCH2_SW4A/G.n9 152
R1423 XCH2_SW4A/G.n10 XCH2_SW4A/G.n11 152
R1424 XCH2_SW4A/G.n12 XCH2_SW4A/G.n13 152
R1425 XCH2_SW4A/G.n12 XCH2_SW4A/G.n14 70.1096
R1426 XCH2_SW4A/G.n12 XCH2_SW4A/G.n10 70.1096
R1427 XCH2_SW4A/G.n10 XCH2_SW4A/G.n8 70.1096
R1428 XCH2_SW4A/G.n8 XCH2_SW4A/G.n7 70.1096
R1429 XCH2_SW4A/G.n15 XCH2_SW4A/G.n9 6.10787
R1430 XCH2_SW4A/G.n16 XCH2_SW4A/G.n11 9.3005
R1431 XCH2_SW4A/G.n17 XCH2_SW4A/G.n13 6.10787
R1432 XCH2_SW4A/G.n14 XCH2_SW4A/G.n17 158.304
R1433 XCH2_SW4A/G.n13 XCH2_SW4A/G.n11 36.1417
R1434 XCH2_SW4A/G.n11 XCH2_SW4A/G.n9 36.1417
R1435 XCH2_SW4A/G.n7 XCH2_SW4A/G.n15 158.304
R1436 XCH2_SW4A/G.n16 XCH2_SW4A/G.n17 1.92
R1437 XCH2_SW4A/G.n15 XCH2_SW4A/G.n16 1.92
R1438 XCH2_SW4A/G.n14 XCH2_SW4A/G.t4 292.413
R1439 XCH2_SW4A/G.n2 XCH2_SW4A/G.t4 292.413
R1440 XCH2_SW4A/G.t3 XCH2_SW4A/G.n12 292.413
R1441 XCH2_SW4A/G.n4 XCH2_SW4A/G.t3 292.413
R1442 XCH2_SW4A/G.t2 XCH2_SW4A/G.n10 292.413
R1443 XCH2_SW4A/G.n5 XCH2_SW4A/G.t2 292.413
R1444 XCH2_SW4A/G.t1 XCH2_SW4A/G.n8 292.413
R1445 XCH2_SW4A/G.n6 XCH2_SW4A/G.t1 292.413
R1446 XCH2_SW4A/G.n3 ch2_lon 1.8738
R1447 XCH2_SW4A/B.t2 XCH2_SW4A/B.n0 73.1255
R1448 XCH2_SW4A/B.n0 XCH2_SW4A/B.n1 73.1255
R1449 XCH2_SW4A/B.n3 XCH2_SW4A/B.n2 83.5719
R1450 XCH2_SW4A/B.n4 XCH2_SW4A/B.t2 73.1255
R1451 VGND XCH2_SW4A/B.n4 73.1255
R1452 XCH2_SW4A/B.n6 XCH2_SW4A/B.n5 83.5719
R1453 XCH2_SW4A/B.n7 XCH2_SW4A/B.n6 83.5719
R1454 VGND XCH2_SW4A/B.n5 315.135
R1455 XCH2_SW4A/B.n5 XCH2_SW4A/B.t0 963.244
R1456 XCH2_SW4A/B.t1 XCH2_SW4A/B.t0 570.812
R1457 XCH2_SW4A/B.t2 XCH2_SW4A/B.t1 570.812
R1458 XCH2_SW4A/B.t2 XCH2_SW4A/B.t3 570.812
R1459 XCH2_SW4A/B.t3 XCH2_SW4A/B.t4 570.812
R1460 XCH2_SW4A/B.t4 XCH2_SW4A/B.n2 1046.81
R1461 VGND XCH2_SW4A/B.n7 246.213
R1462 VGND XCH2_SW4A/B.n3 246.213
R1463 XCH2_SW4A/B.n7 XCH2_SW4A/B.n1 246.213
R1464 XCH2_SW4A/B.n1 XCH2_SW4A/B.n3 246.213
R1465 XCH2_SW4A/B.n6 XCH2_SW4A/B.n4 3789.35
R1466 XCH2_SW4A/B.n4 XCH2_SW4A/B.n2 3789.35
R1467 XCH2_SW4A/B.n6 XCH2_SW4A/B.n0 3789.35
R1468 XCH2_SW4A/B.n0 XCH2_SW4A/B.n2 3789.35
R1469 VGND XSELB_N/S2.t0 117.251
R1470 select_b XSELB_N/D2.n0 4.71028
R1471 select_b XSELB_N/D2.n1 92.5005
R1472 XSELB_N/D2.n1 XSELB_N/D2.t0 24.7505
R1473 XSELB_N/D2.n1 XSELB_N/D2.t1 24.7505
R1474 VGND XSELB_N/S1.n0 92.5005
R1475 XSELB_N/S1.n0 XSELB_N/S1.t1 24.7505
R1476 XSELB_N/S1.n0 XSELB_N/S1.t0 24.7505
R1477 select_b XSELB_N/D0.n0 4.71028
R1478 select_b XSELB_N/D0.t0 117.251
R1479 ui_in[0] XSELB_N/G.n0 6.10787
R1480 ui_in[0] XSELB_N/G.n0 1.66888
R1481 XSELB_N/G.n1 ui_in[0] 152
R1482 XSELB_N/G.n2 ui_in[0] 152
R1483 ui_in[0] XSELB_N/G.n4 152
R1484 ui_in[0] XSELB_N/G.n0 6.3031
R1485 XSELB_N/G.n2 XSELB_N/G.n1 70.1096
R1486 XSELB_N/G.n4 XSELB_N/G.n2 70.1096
R1487 XSELB_N/G.n4 XSELB_N/G.t0 163.881
R1488 XSELB_N/G.t2 XSELB_N/G.n3 212.591
R1489 XSELB_N/G.t0 XSELB_N/G.n3 212.59
R1490 XSELB_N/G.n1 XSELB_N/G.t2 163.881
R1491 XSELB_N/G.n3 XSELB_N/G.t1 170.046
R1492 XSELB_N/G.n2 XSELB_N/G.t1 163.881
R1493 XSELB_N/B.t1 XSELB_N/B.n0 117.001
R1494 XSELB_N/B.n0 XSELB_N/B.n1 117.001
R1495 XSELB_N/B.n3 XSELB_N/B.n2 117.001
R1496 XSELB_N/B.n4 XSELB_N/B.t1 117.001
R1497 VGND XSELB_N/B.n4 117.001
R1498 XSELB_N/B.n6 XSELB_N/B.n5 117.001
R1499 XSELB_N/B.n7 XSELB_N/B.n6 117.001
R1500 VGND XSELB_N/B.n5 402.07
R1501 XSELB_N/B.n5 XSELB_N/B.t0 1228.97
R1502 XSELB_N/B.t1 XSELB_N/B.t0 728.277
R1503 XSELB_N/B.t1 XSELB_N/B.t2 728.277
R1504 XSELB_N/B.t2 XSELB_N/B.n2 1345.97
R1505 VGND XSELB_N/B.n7 179.953
R1506 VGND XSELB_N/B.n3 179.953
R1507 XSELB_N/B.n7 XSELB_N/B.n1 179.953
R1508 XSELB_N/B.n3 XSELB_N/B.n1 179.953
R1509 XSELB_N/B.n6 XSELB_N/B.n4 2769.59
R1510 XSELB_N/B.n4 XSELB_N/B.n2 2769.59
R1511 XSELB_N/B.n6 XSELB_N/B.n0 2769.59
R1512 XSELB_N/B.n0 XSELB_N/B.n2 2769.59
R1513 gm2_n XCH2_SW3A/S4.t0 58.6255
R1514 ua[3] XCH2_SW3A/D4.n0 0.277674
R1515 XCH2_SW3A/D4.n1 ua[3] 46.2505
R1516 XCH2_SW3A/D4.t0 XCH2_SW3A/D4.n1 12.3755
R1517 XCH2_SW3A/D4.n1 XCH2_SW3A/D4.t1 12.3755
R1518 gm2_n XCH2_SW3A/S3.n0 46.2505
R1519 XCH2_SW3A/S3.n0 XCH2_SW3A/S3.t1 12.3755
R1520 XCH2_SW3A/S3.n0 XCH2_SW3A/S3.t0 12.3755
R1521 ua[3] XCH2_SW3A/D2.n0 0.277674
R1522 XCH2_SW3A/D2.n1 ua[3] 46.2505
R1523 XCH2_SW3A/D2.t0 XCH2_SW3A/D2.n1 12.3755
R1524 XCH2_SW3A/D2.n1 XCH2_SW3A/D2.t1 12.3755
R1525 gm2_n XCH2_SW3A/S1.n0 46.2505
R1526 XCH2_SW3A/S1.n0 XCH2_SW3A/S1.t0 12.3755
R1527 XCH2_SW3A/S1.n0 XCH2_SW3A/S1.t1 12.3755
R1528 ua[3] XCH2_SW3A/D0.n0 0.277674
R1529 ua[3] XCH2_SW3A/D0.t0 58.6255
R1530 ch2_lop XCH2_SW3A/G.n0 9.3005
R1531 ch2_lop XCH2_SW3A/G.n0 0.0466957
R1532 ch2_lop XCH2_SW3A/G.n1 6.10787
R1533 XCH2_SW3A/G.n1 XCH2_SW3A/G.n0 1.92
R1534 XCH2_SW3A/G.n2 ch2_lop 152
R1535 ch2_lop XCH2_SW3A/G.n3 6.10787
R1536 XCH2_SW3A/G.n4 ch2_lop 152
R1537 XCH2_SW3A/G.n5 ch2_lop 152
R1538 XCH2_SW3A/G.n6 ch2_lop 152
R1539 ch2_lop XCH2_SW3A/G.n18 152
R1540 ch2_lop XCH2_SW3A/G.n3 6.3031
R1541 ch2_lop XCH2_SW3A/G.n1 6.3031
R1542 XCH2_SW3A/G.n4 XCH2_SW3A/G.n2 70.1096
R1543 XCH2_SW3A/G.n5 XCH2_SW3A/G.n4 70.1096
R1544 XCH2_SW3A/G.n6 XCH2_SW3A/G.n5 70.1096
R1545 XCH2_SW3A/G.n18 XCH2_SW3A/G.n6 70.1096
R1546 XCH2_SW3A/G.n18 XCH2_SW3A/G.t0 292.413
R1547 XCH2_SW3A/G.t0 XCH2_SW3A/G.n7 292.413
R1548 XCH2_SW3A/G.n8 XCH2_SW3A/G.n9 152
R1549 XCH2_SW3A/G.n10 XCH2_SW3A/G.n11 152
R1550 XCH2_SW3A/G.n12 XCH2_SW3A/G.n13 152
R1551 XCH2_SW3A/G.n12 XCH2_SW3A/G.n14 70.1096
R1552 XCH2_SW3A/G.n12 XCH2_SW3A/G.n10 70.1096
R1553 XCH2_SW3A/G.n10 XCH2_SW3A/G.n8 70.1096
R1554 XCH2_SW3A/G.n8 XCH2_SW3A/G.n7 70.1096
R1555 XCH2_SW3A/G.n15 XCH2_SW3A/G.n9 6.10787
R1556 XCH2_SW3A/G.n16 XCH2_SW3A/G.n11 9.3005
R1557 XCH2_SW3A/G.n17 XCH2_SW3A/G.n13 6.10787
R1558 XCH2_SW3A/G.n14 XCH2_SW3A/G.n17 158.304
R1559 XCH2_SW3A/G.n13 XCH2_SW3A/G.n11 36.1417
R1560 XCH2_SW3A/G.n11 XCH2_SW3A/G.n9 36.1417
R1561 XCH2_SW3A/G.n7 XCH2_SW3A/G.n15 158.304
R1562 XCH2_SW3A/G.n16 XCH2_SW3A/G.n17 1.92
R1563 XCH2_SW3A/G.n15 XCH2_SW3A/G.n16 1.92
R1564 XCH2_SW3A/G.n14 XCH2_SW3A/G.t4 292.413
R1565 XCH2_SW3A/G.n2 XCH2_SW3A/G.t4 292.413
R1566 XCH2_SW3A/G.t3 XCH2_SW3A/G.n12 292.413
R1567 XCH2_SW3A/G.n4 XCH2_SW3A/G.t3 292.413
R1568 XCH2_SW3A/G.t2 XCH2_SW3A/G.n10 292.413
R1569 XCH2_SW3A/G.n5 XCH2_SW3A/G.t2 292.413
R1570 XCH2_SW3A/G.t1 XCH2_SW3A/G.n8 292.413
R1571 XCH2_SW3A/G.n6 XCH2_SW3A/G.t1 292.413
R1572 XCH2_SW3A/G.n3 ch2_lop 1.8738
R1573 XCH2_SW3A/B.t2 XCH2_SW3A/B.n0 73.1255
R1574 XCH2_SW3A/B.n0 XCH2_SW3A/B.n1 73.1255
R1575 XCH2_SW3A/B.n3 XCH2_SW3A/B.n2 83.5719
R1576 XCH2_SW3A/B.n4 XCH2_SW3A/B.t2 73.1255
R1577 VGND XCH2_SW3A/B.n4 73.1255
R1578 XCH2_SW3A/B.n6 XCH2_SW3A/B.n5 83.5719
R1579 XCH2_SW3A/B.n7 XCH2_SW3A/B.n6 83.5719
R1580 VGND XCH2_SW3A/B.n5 315.135
R1581 XCH2_SW3A/B.n5 XCH2_SW3A/B.t0 963.244
R1582 XCH2_SW3A/B.t1 XCH2_SW3A/B.t0 570.812
R1583 XCH2_SW3A/B.t2 XCH2_SW3A/B.t1 570.812
R1584 XCH2_SW3A/B.t2 XCH2_SW3A/B.t3 570.812
R1585 XCH2_SW3A/B.t3 XCH2_SW3A/B.t4 570.812
R1586 XCH2_SW3A/B.t4 XCH2_SW3A/B.n2 1046.81
R1587 VGND XCH2_SW3A/B.n7 246.213
R1588 VGND XCH2_SW3A/B.n3 246.213
R1589 XCH2_SW3A/B.n7 XCH2_SW3A/B.n1 246.213
R1590 XCH2_SW3A/B.n1 XCH2_SW3A/B.n3 246.213
R1591 XCH2_SW3A/B.n6 XCH2_SW3A/B.n4 3789.35
R1592 XCH2_SW3A/B.n4 XCH2_SW3A/B.n2 3789.35
R1593 XCH2_SW3A/B.n6 XCH2_SW3A/B.n0 3789.35
R1594 XCH2_SW3A/B.n0 XCH2_SW3A/B.n2 3789.35
R1595 gm2_n XCH2_SW4B/S4.t0 58.6255
R1596 ua[2] XCH2_SW4B/D4.n0 0.277674
R1597 XCH2_SW4B/D4.n1 ua[2] 46.2505
R1598 XCH2_SW4B/D4.t0 XCH2_SW4B/D4.n1 12.3755
R1599 XCH2_SW4B/D4.n1 XCH2_SW4B/D4.t1 12.3755
R1600 gm2_n XCH2_SW4B/S3.n0 46.2505
R1601 XCH2_SW4B/S3.n0 XCH2_SW4B/S3.t1 12.3755
R1602 XCH2_SW4B/S3.n0 XCH2_SW4B/S3.t0 12.3755
R1603 ua[2] XCH2_SW4B/D2.n0 0.277674
R1604 XCH2_SW4B/D2.n1 ua[2] 46.2505
R1605 XCH2_SW4B/D2.t0 XCH2_SW4B/D2.n1 12.3755
R1606 XCH2_SW4B/D2.n1 XCH2_SW4B/D2.t1 12.3755
R1607 gm2_n XCH2_SW4B/S1.n0 46.2505
R1608 XCH2_SW4B/S1.n0 XCH2_SW4B/S1.t0 12.3755
R1609 XCH2_SW4B/S1.n0 XCH2_SW4B/S1.t1 12.3755
R1610 ua[2] XCH2_SW4B/D0.n0 0.277674
R1611 ua[2] XCH2_SW4B/D0.t0 58.6255
R1612 ch2_lon XCH2_SW4B/G.n0 9.3005
R1613 ch2_lon XCH2_SW4B/G.n0 0.0466957
R1614 ch2_lon XCH2_SW4B/G.n1 6.10787
R1615 XCH2_SW4B/G.n1 XCH2_SW4B/G.n0 1.92
R1616 XCH2_SW4B/G.n2 ch2_lon 152
R1617 ch2_lon XCH2_SW4B/G.n3 6.10787
R1618 XCH2_SW4B/G.n4 ch2_lon 152
R1619 XCH2_SW4B/G.n5 ch2_lon 152
R1620 XCH2_SW4B/G.n6 ch2_lon 152
R1621 ch2_lon XCH2_SW4B/G.n18 152
R1622 ch2_lon XCH2_SW4B/G.n3 6.3031
R1623 ch2_lon XCH2_SW4B/G.n1 6.3031
R1624 XCH2_SW4B/G.n4 XCH2_SW4B/G.n2 70.1096
R1625 XCH2_SW4B/G.n5 XCH2_SW4B/G.n4 70.1096
R1626 XCH2_SW4B/G.n6 XCH2_SW4B/G.n5 70.1096
R1627 XCH2_SW4B/G.n18 XCH2_SW4B/G.n6 70.1096
R1628 XCH2_SW4B/G.n18 XCH2_SW4B/G.t0 292.413
R1629 XCH2_SW4B/G.t0 XCH2_SW4B/G.n7 292.413
R1630 XCH2_SW4B/G.n8 XCH2_SW4B/G.n9 152
R1631 XCH2_SW4B/G.n10 XCH2_SW4B/G.n11 152
R1632 XCH2_SW4B/G.n12 XCH2_SW4B/G.n13 152
R1633 XCH2_SW4B/G.n12 XCH2_SW4B/G.n14 70.1096
R1634 XCH2_SW4B/G.n12 XCH2_SW4B/G.n10 70.1096
R1635 XCH2_SW4B/G.n10 XCH2_SW4B/G.n8 70.1096
R1636 XCH2_SW4B/G.n8 XCH2_SW4B/G.n7 70.1096
R1637 XCH2_SW4B/G.n15 XCH2_SW4B/G.n9 6.10787
R1638 XCH2_SW4B/G.n16 XCH2_SW4B/G.n11 9.3005
R1639 XCH2_SW4B/G.n17 XCH2_SW4B/G.n13 6.10787
R1640 XCH2_SW4B/G.n14 XCH2_SW4B/G.n17 158.304
R1641 XCH2_SW4B/G.n13 XCH2_SW4B/G.n11 36.1417
R1642 XCH2_SW4B/G.n11 XCH2_SW4B/G.n9 36.1417
R1643 XCH2_SW4B/G.n7 XCH2_SW4B/G.n15 158.304
R1644 XCH2_SW4B/G.n16 XCH2_SW4B/G.n17 1.92
R1645 XCH2_SW4B/G.n15 XCH2_SW4B/G.n16 1.92
R1646 XCH2_SW4B/G.n14 XCH2_SW4B/G.t4 292.413
R1647 XCH2_SW4B/G.n2 XCH2_SW4B/G.t4 292.413
R1648 XCH2_SW4B/G.t3 XCH2_SW4B/G.n12 292.413
R1649 XCH2_SW4B/G.n4 XCH2_SW4B/G.t3 292.413
R1650 XCH2_SW4B/G.t2 XCH2_SW4B/G.n10 292.413
R1651 XCH2_SW4B/G.n5 XCH2_SW4B/G.t2 292.413
R1652 XCH2_SW4B/G.t1 XCH2_SW4B/G.n8 292.413
R1653 XCH2_SW4B/G.n6 XCH2_SW4B/G.t1 292.413
R1654 XCH2_SW4B/G.n3 ch2_lon 1.8738
R1655 XCH2_SW4B/B.t2 XCH2_SW4B/B.n0 73.1255
R1656 XCH2_SW4B/B.n0 XCH2_SW4B/B.n1 73.1255
R1657 XCH2_SW4B/B.n3 XCH2_SW4B/B.n2 83.5719
R1658 XCH2_SW4B/B.n4 XCH2_SW4B/B.t2 73.1255
R1659 VGND XCH2_SW4B/B.n4 73.1255
R1660 XCH2_SW4B/B.n6 XCH2_SW4B/B.n5 83.5719
R1661 XCH2_SW4B/B.n7 XCH2_SW4B/B.n6 83.5719
R1662 VGND XCH2_SW4B/B.n5 315.135
R1663 XCH2_SW4B/B.n5 XCH2_SW4B/B.t0 963.244
R1664 XCH2_SW4B/B.t1 XCH2_SW4B/B.t0 570.812
R1665 XCH2_SW4B/B.t2 XCH2_SW4B/B.t1 570.812
R1666 XCH2_SW4B/B.t2 XCH2_SW4B/B.t3 570.812
R1667 XCH2_SW4B/B.t3 XCH2_SW4B/B.t4 570.812
R1668 XCH2_SW4B/B.t4 XCH2_SW4B/B.n2 1046.81
R1669 VGND XCH2_SW4B/B.n7 246.213
R1670 VGND XCH2_SW4B/B.n3 246.213
R1671 XCH2_SW4B/B.n7 XCH2_SW4B/B.n1 246.213
R1672 XCH2_SW4B/B.n1 XCH2_SW4B/B.n3 246.213
R1673 XCH2_SW4B/B.n6 XCH2_SW4B/B.n4 3789.35
R1674 XCH2_SW4B/B.n4 XCH2_SW4B/B.n2 3789.35
R1675 XCH2_SW4B/B.n6 XCH2_SW4B/B.n0 3789.35
R1676 XCH2_SW4B/B.n0 XCH2_SW4B/B.n2 3789.35
R1677 XBIASA/S8.n0 VGND 2.31159
R1678 VGND XBIASA/S8.t0 46.7758
R1679 vbias XBIASA/D8.n0 2.18659
R1680 vbias XBIASA/D8.n1 37.0005
R1681 XBIASA/D8.n1 XBIASA/D8.t0 9.77578
R1682 XBIASA/D8.n1 XBIASA/D8.t1 9.77578
R1683 XBIASA/S7.n0 VGND 2.31159
R1684 VGND XBIASA/S7.n1 37.0005
R1685 XBIASA/S7.n1 XBIASA/S7.t1 9.77578
R1686 XBIASA/S7.n1 XBIASA/S7.t0 9.77578
R1687 vbias XBIASA/D6.n0 2.18659
R1688 vbias XBIASA/D6.n1 37.0005
R1689 XBIASA/D6.n1 XBIASA/D6.t1 9.77578
R1690 XBIASA/D6.n1 XBIASA/D6.t0 9.77578
R1691 XBIASA/S5.n0 VGND 2.31159
R1692 VGND XBIASA/S5.n1 37.0005
R1693 XBIASA/S5.n1 XBIASA/S5.t1 9.77578
R1694 XBIASA/S5.n1 XBIASA/S5.t0 9.77578
R1695 vbias XBIASA/D4.n0 2.18659
R1696 vbias XBIASA/D4.n1 37.0005
R1697 XBIASA/D4.n1 XBIASA/D4.t1 9.77578
R1698 XBIASA/D4.n1 XBIASA/D4.t0 9.77578
R1699 XBIASA/S3.n0 VGND 2.31159
R1700 VGND XBIASA/S3.n1 37.0005
R1701 XBIASA/S3.n1 XBIASA/S3.t1 9.77578
R1702 XBIASA/S3.n1 XBIASA/S3.t0 9.77578
R1703 vbias XBIASA/D2.n0 2.18659
R1704 vbias XBIASA/D2.n1 37.0005
R1705 XBIASA/D2.n1 XBIASA/D2.t1 9.77578
R1706 XBIASA/D2.n1 XBIASA/D2.t0 9.77578
R1707 XBIASA/S1.n0 VGND 2.31159
R1708 VGND XBIASA/S1.n1 37.0005
R1709 XBIASA/S1.n1 XBIASA/S1.t0 9.77578
R1710 XBIASA/S1.n1 XBIASA/S1.t1 9.77578
R1711 vbias XBIASA/D0.n0 2.18659
R1712 vbias XBIASA/D0.t0 46.7758
R1713 vbias XBIASA/G.n0 9.3005
R1714 vbias XBIASA/G.n0 0.063
R1715 vbias XBIASA/G.n1 9.3005
R1716 XBIASA/G.n1 XBIASA/G.n0 0.493147
R1717 vbias XBIASA/G.n2 9.3005
R1718 XBIASA/G.n2 XBIASA/G.n1 0.493147
R1719 vbias XBIASA/G.n3 7.04123
R1720 XBIASA/G.n3 XBIASA/G.n2 1.65269
R1721 vbias XBIASA/G.n4 7.04123
R1722 vbias XBIASA/G.n5 9.3005
R1723 vbias XBIASA/G.n6 9.3005
R1724 vbias XBIASA/G.n4 7.41417
R1725 vbias XBIASA/G.n3 7.41417
R1726 vbias XBIASA/G.t0 264.307
R1727 XBIASA/G.t0 XBIASA/G.n20 271.721
R1728 XBIASA/G.n7 XBIASA/G.n8 7.04123
R1729 XBIASA/G.n10 XBIASA/G.n9 9.3005
R1730 XBIASA/G.n12 XBIASA/G.n11 9.3005
R1731 XBIASA/G.n14 XBIASA/G.n13 9.3005
R1732 XBIASA/G.n16 XBIASA/G.n15 9.3005
R1733 XBIASA/G.n18 XBIASA/G.n17 9.3005
R1734 XBIASA/G.n20 XBIASA/G.n19 7.04123
R1735 XBIASA/G.n8 XBIASA/G.n9 59.4829
R1736 XBIASA/G.n9 XBIASA/G.n11 59.4829
R1737 XBIASA/G.n11 XBIASA/G.n13 59.4829
R1738 XBIASA/G.n13 XBIASA/G.n15 59.4829
R1739 XBIASA/G.n15 XBIASA/G.n17 59.4829
R1740 XBIASA/G.n17 XBIASA/G.n19 59.4829
R1741 XBIASA/G.n19 XBIASA/G.t1 264.307
R1742 XBIASA/G.t1 vbias 264.307
R1743 XBIASA/G.n17 XBIASA/G.t2 264.307
R1744 XBIASA/G.t2 vbias 264.307
R1745 XBIASA/G.n15 XBIASA/G.t3 264.307
R1746 XBIASA/G.t3 vbias 264.307
R1747 XBIASA/G.n13 XBIASA/G.t4 264.307
R1748 XBIASA/G.t4 vbias 264.307
R1749 XBIASA/G.n11 XBIASA/G.t5 264.307
R1750 XBIASA/G.t5 vbias 264.307
R1751 XBIASA/G.n9 XBIASA/G.t6 264.307
R1752 XBIASA/G.t6 vbias 264.307
R1753 XBIASA/G.n8 XBIASA/G.t7 264.307
R1754 XBIASA/G.t7 vbias 264.307
R1755 XBIASA/G.n20 XBIASA/G.n18 1.65269
R1756 XBIASA/G.n18 XBIASA/G.n16 0.493147
R1757 XBIASA/G.n16 XBIASA/G.n14 0.493147
R1758 XBIASA/G.n14 XBIASA/G.n12 0.493147
R1759 XBIASA/G.n12 XBIASA/G.n10 0.493147
R1760 XBIASA/G.n10 XBIASA/G.n7 1.65269
R1761 XBIASA/G.n7 XBIASA/G.t8 271.721
R1762 XBIASA/G.t8 vbias 264.307
R1763 XBIASA/G.n6 vbias 0.430647
R1764 XBIASA/G.n5 XBIASA/G.n6 0.493147
R1765 XBIASA/G.n4 XBIASA/G.n5 1.65269
R1766 XBIASA/B.t4 XBIASA/B.n0 26.5914
R1767 XBIASA/B.n0 XBIASA/B.n1 26.5914
R1768 XBIASA/B.n3 XBIASA/B.n2 73.1255
R1769 XBIASA/B.n4 XBIASA/B.t4 26.5914
R1770 VGND XBIASA/B.n4 26.5914
R1771 XBIASA/B.n6 XBIASA/B.n5 73.1255
R1772 XBIASA/B.n7 XBIASA/B.n6 73.1255
R1773 VGND XBIASA/B.n5 300.515
R1774 XBIASA/B.n5 XBIASA/B.t0 1094.33
R1775 XBIASA/B.t0 XBIASA/B.t1 895.876
R1776 XBIASA/B.t1 XBIASA/B.t2 895.876
R1777 XBIASA/B.t3 XBIASA/B.t2 895.876
R1778 XBIASA/B.t4 XBIASA/B.t3 895.876
R1779 XBIASA/B.t4 XBIASA/B.t5 895.876
R1780 XBIASA/B.t5 XBIASA/B.t6 895.876
R1781 XBIASA/B.t6 XBIASA/B.t7 895.876
R1782 XBIASA/B.t8 XBIASA/B.t7 895.876
R1783 XBIASA/B.n2 XBIASA/B.t8 1167.45
R1784 VGND XBIASA/B.n7 430.307
R1785 VGND XBIASA/B.n3 430.307
R1786 XBIASA/B.n7 XBIASA/B.n1 430.307
R1787 XBIASA/B.n1 XBIASA/B.n3 430.307
R1788 XBIASA/B.n6 XBIASA/B.n4 6622.68
R1789 XBIASA/B.n4 XBIASA/B.n2 6622.68
R1790 XBIASA/B.n6 XBIASA/B.n0 6622.68
R1791 XBIASA/B.n0 XBIASA/B.n2 6622.68
R1792 VGND XCH2LP_N/S4.t0 58.6255
R1793 ch2_lop XCH2LP_N/D4.n0 0.277674
R1794 XCH2LP_N/D4.n1 ch2_lop 46.2505
R1795 XCH2LP_N/D4.t0 XCH2LP_N/D4.n1 12.3755
R1796 XCH2LP_N/D4.n1 XCH2LP_N/D4.t1 12.3755
R1797 VGND XCH2LP_N/S3.n0 46.2505
R1798 XCH2LP_N/S3.n0 XCH2LP_N/S3.t1 12.3755
R1799 XCH2LP_N/S3.n0 XCH2LP_N/S3.t0 12.3755
R1800 ch2_lop XCH2LP_N/D2.n0 0.277674
R1801 XCH2LP_N/D2.n1 ch2_lop 46.2505
R1802 XCH2LP_N/D2.t0 XCH2LP_N/D2.n1 12.3755
R1803 XCH2LP_N/D2.n1 XCH2LP_N/D2.t1 12.3755
R1804 VGND XCH2LP_N/S1.n0 46.2505
R1805 XCH2LP_N/S1.n0 XCH2LP_N/S1.t0 12.3755
R1806 XCH2LP_N/S1.n0 XCH2LP_N/S1.t1 12.3755
R1807 ch2_lop XCH2LP_N/D0.n0 0.277674
R1808 ch2_lop XCH2LP_N/D0.t0 58.6255
R1809 ch2_lop_raw XCH2LP_N/G.n0 9.3005
R1810 ch2_lop_raw XCH2LP_N/G.n0 0.0466957
R1811 ch2_lop_raw XCH2LP_N/G.n1 6.10787
R1812 XCH2LP_N/G.n1 XCH2LP_N/G.n0 1.92
R1813 XCH2LP_N/G.n2 ch2_lop_raw 152
R1814 ch2_lop_raw XCH2LP_N/G.n3 6.10787
R1815 XCH2LP_N/G.n4 ch2_lop_raw 152
R1816 XCH2LP_N/G.n5 ch2_lop_raw 152
R1817 XCH2LP_N/G.n6 ch2_lop_raw 152
R1818 ch2_lop_raw XCH2LP_N/G.n18 152
R1819 ch2_lop_raw XCH2LP_N/G.n3 6.3031
R1820 ch2_lop_raw XCH2LP_N/G.n1 6.3031
R1821 XCH2LP_N/G.n4 XCH2LP_N/G.n2 70.1096
R1822 XCH2LP_N/G.n5 XCH2LP_N/G.n4 70.1096
R1823 XCH2LP_N/G.n6 XCH2LP_N/G.n5 70.1096
R1824 XCH2LP_N/G.n18 XCH2LP_N/G.n6 70.1096
R1825 XCH2LP_N/G.n18 XCH2LP_N/G.t0 292.413
R1826 XCH2LP_N/G.t0 XCH2LP_N/G.n7 292.413
R1827 XCH2LP_N/G.n8 XCH2LP_N/G.n9 152
R1828 XCH2LP_N/G.n10 XCH2LP_N/G.n11 152
R1829 XCH2LP_N/G.n12 XCH2LP_N/G.n13 152
R1830 XCH2LP_N/G.n12 XCH2LP_N/G.n14 70.1096
R1831 XCH2LP_N/G.n12 XCH2LP_N/G.n10 70.1096
R1832 XCH2LP_N/G.n10 XCH2LP_N/G.n8 70.1096
R1833 XCH2LP_N/G.n8 XCH2LP_N/G.n7 70.1096
R1834 XCH2LP_N/G.n15 XCH2LP_N/G.n9 6.10787
R1835 XCH2LP_N/G.n16 XCH2LP_N/G.n11 9.3005
R1836 XCH2LP_N/G.n17 XCH2LP_N/G.n13 6.10787
R1837 XCH2LP_N/G.n14 XCH2LP_N/G.n17 158.304
R1838 XCH2LP_N/G.n13 XCH2LP_N/G.n11 36.1417
R1839 XCH2LP_N/G.n11 XCH2LP_N/G.n9 36.1417
R1840 XCH2LP_N/G.n7 XCH2LP_N/G.n15 158.304
R1841 XCH2LP_N/G.n16 XCH2LP_N/G.n17 1.92
R1842 XCH2LP_N/G.n15 XCH2LP_N/G.n16 1.92
R1843 XCH2LP_N/G.n14 XCH2LP_N/G.t4 292.413
R1844 XCH2LP_N/G.n2 XCH2LP_N/G.t4 292.413
R1845 XCH2LP_N/G.t3 XCH2LP_N/G.n12 292.413
R1846 XCH2LP_N/G.n4 XCH2LP_N/G.t3 292.413
R1847 XCH2LP_N/G.t2 XCH2LP_N/G.n10 292.413
R1848 XCH2LP_N/G.n5 XCH2LP_N/G.t2 292.413
R1849 XCH2LP_N/G.t1 XCH2LP_N/G.n8 292.413
R1850 XCH2LP_N/G.n6 XCH2LP_N/G.t1 292.413
R1851 XCH2LP_N/G.n3 ch2_lop_raw 1.8738
R1852 XCH2LP_N/B.t2 XCH2LP_N/B.n0 73.1255
R1853 XCH2LP_N/B.n0 XCH2LP_N/B.n1 73.1255
R1854 XCH2LP_N/B.n3 XCH2LP_N/B.n2 83.5719
R1855 XCH2LP_N/B.n4 XCH2LP_N/B.t2 73.1255
R1856 VGND XCH2LP_N/B.n4 73.1255
R1857 XCH2LP_N/B.n6 XCH2LP_N/B.n5 83.5719
R1858 XCH2LP_N/B.n7 XCH2LP_N/B.n6 83.5719
R1859 VGND XCH2LP_N/B.n5 315.135
R1860 XCH2LP_N/B.n5 XCH2LP_N/B.t0 963.244
R1861 XCH2LP_N/B.t1 XCH2LP_N/B.t0 570.812
R1862 XCH2LP_N/B.t2 XCH2LP_N/B.t1 570.812
R1863 XCH2LP_N/B.t2 XCH2LP_N/B.t3 570.812
R1864 XCH2LP_N/B.t3 XCH2LP_N/B.t4 570.812
R1865 XCH2LP_N/B.t4 XCH2LP_N/B.n2 1046.81
R1866 VGND XCH2LP_N/B.n7 246.213
R1867 VGND XCH2LP_N/B.n3 246.213
R1868 XCH2LP_N/B.n7 XCH2LP_N/B.n1 246.213
R1869 XCH2LP_N/B.n1 XCH2LP_N/B.n3 246.213
R1870 XCH2LP_N/B.n6 XCH2LP_N/B.n4 3789.35
R1871 XCH2LP_N/B.n4 XCH2LP_N/B.n2 3789.35
R1872 XCH2LP_N/B.n6 XCH2LP_N/B.n0 3789.35
R1873 XCH2LP_N/B.n0 XCH2LP_N/B.n2 3789.35
R1874 XSELB_P/S2.n0 VDPWR 3.4293
R1875 VDPWR XSELB_P/S2.t0 170.69
R1876 select_b XSELB_P/D2.n0 3.3043
R1877 select_b XSELB_P/D2.n1 146.25
R1878 XSELB_P/D2.n1 XSELB_P/D2.t1 24.4403
R1879 XSELB_P/D2.n1 XSELB_P/D2.t0 24.4403
R1880 XSELB_P/S1.n0 VDPWR 3.4293
R1881 VDPWR XSELB_P/S1.n1 146.25
R1882 XSELB_P/S1.n1 XSELB_P/S1.t1 24.4403
R1883 XSELB_P/S1.n1 XSELB_P/S1.t0 24.4403
R1884 select_b XSELB_P/D0.n0 3.3043
R1885 select_b XSELB_P/D0.t0 170.69
R1886 ui_in[0] XSELB_P/G.n0 6.10787
R1887 ui_in[0] XSELB_P/G.n0 1.66888
R1888 XSELB_P/G.n1 ui_in[0] 152
R1889 XSELB_P/G.n2 ui_in[0] 152
R1890 ui_in[0] XSELB_P/G.n4 152
R1891 ui_in[0] XSELB_P/G.n0 6.3031
R1892 XSELB_P/G.n2 XSELB_P/G.n1 70.1096
R1893 XSELB_P/G.n4 XSELB_P/G.n2 70.1096
R1894 XSELB_P/G.n4 XSELB_P/G.t0 263.493
R1895 XSELB_P/G.t2 XSELB_P/G.n3 312.204
R1896 XSELB_P/G.t0 XSELB_P/G.n3 312.204
R1897 XSELB_P/G.n1 XSELB_P/G.t2 263.493
R1898 XSELB_P/G.n3 XSELB_P/G.t1 269.659
R1899 XSELB_P/G.n2 XSELB_P/G.t1 263.493
R1900 XSELB_P/B.n1 XSELB_P/B.t1 37.0005
R1901 VDPWR XSELB_P/B.n1 37.0005
R1902 XSELB_P/B.n0 VDPWR 16.5652
R1903 XSELB_P/B.n3 XSELB_P/B.n2 30.8338
R1904 XSELB_P/B.n0 XSELB_P/B.n3 186.73
R1905 XSELB_P/B.t1 XSELB_P/B.n4 37.0005
R1906 XSELB_P/B.n4 XSELB_P/B.n5 37.0005
R1907 XSELB_P/B.n5 XSELB_P/B.n3 203.294
R1908 XSELB_P/B.n7 XSELB_P/B.n6 30.8338
R1909 VDPWR XSELB_P/B.n7 203.294
R1910 XSELB_P/B.n7 XSELB_P/B.n5 203.294
R1911 XSELB_P/B.n1 XSELB_P/B.n6 1905.88
R1912 XSELB_P/B.n1 XSELB_P/B.n2 1905.88
R1913 XSELB_P/B.n2 XSELB_P/B.n4 1905.88
R1914 XSELB_P/B.n4 XSELB_P/B.n6 1905.88
R1915 XSELB_P/B.n2 XSELB_P/B.t0 249.441
R1916 XSELB_P/B.t1 XSELB_P/B.t0 129.546
R1917 XSELB_P/B.t1 XSELB_P/B.t2 129.546
R1918 XSELB_P/B.t2 XSELB_P/B.n6 249.441
R1919 VGND XLP1_N/S2.t0 117.251
R1920 lp1 XLP1_N/D2.n0 4.71028
R1921 lp1 XLP1_N/D2.n1 92.5005
R1922 XLP1_N/D2.n1 XLP1_N/D2.t0 24.7505
R1923 XLP1_N/D2.n1 XLP1_N/D2.t1 24.7505
R1924 VGND XLP1_N/S1.n0 92.5005
R1925 XLP1_N/S1.n0 XLP1_N/S1.t1 24.7505
R1926 XLP1_N/S1.n0 XLP1_N/S1.t0 24.7505
R1927 lp1 XLP1_N/D0.n0 4.71028
R1928 lp1 XLP1_N/D0.t0 117.251
R1929 clk XLP1_N/G.n0 6.10787
R1930 clk XLP1_N/G.n0 1.66888
R1931 XLP1_N/G.n1 clk 152
R1932 XLP1_N/G.n2 clk 152
R1933 clk XLP1_N/G.n4 152
R1934 clk XLP1_N/G.n0 6.3031
R1935 XLP1_N/G.n2 XLP1_N/G.n1 70.1096
R1936 XLP1_N/G.n4 XLP1_N/G.n2 70.1096
R1937 XLP1_N/G.n4 XLP1_N/G.t0 163.881
R1938 XLP1_N/G.t2 XLP1_N/G.n3 212.591
R1939 XLP1_N/G.t0 XLP1_N/G.n3 212.59
R1940 XLP1_N/G.n1 XLP1_N/G.t2 163.881
R1941 XLP1_N/G.n3 XLP1_N/G.t1 170.046
R1942 XLP1_N/G.n2 XLP1_N/G.t1 163.881
R1943 XLP1_N/B.t1 XLP1_N/B.n0 117.001
R1944 XLP1_N/B.n0 XLP1_N/B.n1 117.001
R1945 XLP1_N/B.n3 XLP1_N/B.n2 117.001
R1946 XLP1_N/B.n4 XLP1_N/B.t1 117.001
R1947 VGND XLP1_N/B.n4 117.001
R1948 XLP1_N/B.n6 XLP1_N/B.n5 117.001
R1949 XLP1_N/B.n7 XLP1_N/B.n6 117.001
R1950 VGND XLP1_N/B.n5 402.07
R1951 XLP1_N/B.n5 XLP1_N/B.t0 1228.97
R1952 XLP1_N/B.t1 XLP1_N/B.t0 728.277
R1953 XLP1_N/B.t1 XLP1_N/B.t2 728.277
R1954 XLP1_N/B.t2 XLP1_N/B.n2 1345.97
R1955 VGND XLP1_N/B.n7 179.953
R1956 VGND XLP1_N/B.n3 179.953
R1957 XLP1_N/B.n7 XLP1_N/B.n1 179.953
R1958 XLP1_N/B.n3 XLP1_N/B.n1 179.953
R1959 XLP1_N/B.n6 XLP1_N/B.n4 2769.59
R1960 XLP1_N/B.n4 XLP1_N/B.n2 2769.59
R1961 XLP1_N/B.n6 XLP1_N/B.n0 2769.59
R1962 XLP1_N/B.n0 XLP1_N/B.n2 2769.59
R1963 VGND XCH2_TAILA/S8.t0 39.0803
R1964 tail2 XCH2_TAILA/D8.n0 1.96626
R1965 tail2 XCH2_TAILA/D8.n1 30.8338
R1966 XCH2_TAILA/D8.n1 XCH2_TAILA/D8.t1 8.24695
R1967 XCH2_TAILA/D8.n1 XCH2_TAILA/D8.t0 8.24695
R1968 VGND XCH2_TAILA/S7.n0 30.8338
R1969 XCH2_TAILA/S7.n0 XCH2_TAILA/S7.t0 8.24695
R1970 XCH2_TAILA/S7.n0 XCH2_TAILA/S7.t1 8.24695
R1971 tail2 XCH2_TAILA/D6.n0 1.96626
R1972 tail2 XCH2_TAILA/D6.n1 30.8338
R1973 XCH2_TAILA/D6.n1 XCH2_TAILA/D6.t1 8.24695
R1974 XCH2_TAILA/D6.n1 XCH2_TAILA/D6.t0 8.24695
R1975 VGND XCH2_TAILA/S5.n0 30.8338
R1976 XCH2_TAILA/S5.n0 XCH2_TAILA/S5.t0 8.24695
R1977 XCH2_TAILA/S5.n0 XCH2_TAILA/S5.t1 8.24695
R1978 tail2 XCH2_TAILA/D4.n0 1.96626
R1979 tail2 XCH2_TAILA/D4.n1 30.8338
R1980 XCH2_TAILA/D4.n1 XCH2_TAILA/D4.t1 8.24695
R1981 XCH2_TAILA/D4.n1 XCH2_TAILA/D4.t0 8.24695
R1982 VGND XCH2_TAILA/S3.n0 30.8338
R1983 XCH2_TAILA/S3.n0 XCH2_TAILA/S3.t1 8.24695
R1984 XCH2_TAILA/S3.n0 XCH2_TAILA/S3.t0 8.24695
R1985 tail2 XCH2_TAILA/D2.n0 1.96626
R1986 tail2 XCH2_TAILA/D2.n1 30.8338
R1987 XCH2_TAILA/D2.n1 XCH2_TAILA/D2.t1 8.24695
R1988 XCH2_TAILA/D2.n1 XCH2_TAILA/D2.t0 8.24695
R1989 VGND XCH2_TAILA/S1.n0 30.8338
R1990 XCH2_TAILA/S1.n0 XCH2_TAILA/S1.t0 8.24695
R1991 XCH2_TAILA/S1.n0 XCH2_TAILA/S1.t1 8.24695
R1992 tail2 XCH2_TAILA/D0.n0 1.96626
R1993 tail2 XCH2_TAILA/D0.t0 39.0803
R1994 vbias XCH2_TAILA/G.n0 9.3005
R1995 vbias XCH2_TAILA/G.n0 0.063
R1996 vbias XCH2_TAILA/G.n1 9.3005
R1997 XCH2_TAILA/G.n1 XCH2_TAILA/G.n0 0.493147
R1998 vbias XCH2_TAILA/G.n2 9.3005
R1999 XCH2_TAILA/G.n2 XCH2_TAILA/G.n1 0.493147
R2000 vbias XCH2_TAILA/G.n3 7.04123
R2001 XCH2_TAILA/G.n3 XCH2_TAILA/G.n2 1.65269
R2002 vbias XCH2_TAILA/G.n4 7.04123
R2003 vbias XCH2_TAILA/G.n5 9.3005
R2004 vbias XCH2_TAILA/G.n6 9.3005
R2005 vbias XCH2_TAILA/G.n4 7.41417
R2006 vbias XCH2_TAILA/G.n3 7.41417
R2007 vbias XCH2_TAILA/G.t0 280.212
R2008 XCH2_TAILA/G.t0 XCH2_TAILA/G.n20 287.627
R2009 XCH2_TAILA/G.n7 XCH2_TAILA/G.n8 7.04123
R2010 XCH2_TAILA/G.n10 XCH2_TAILA/G.n9 9.3005
R2011 XCH2_TAILA/G.n12 XCH2_TAILA/G.n11 9.3005
R2012 XCH2_TAILA/G.n14 XCH2_TAILA/G.n13 9.3005
R2013 XCH2_TAILA/G.n16 XCH2_TAILA/G.n15 9.3005
R2014 XCH2_TAILA/G.n18 XCH2_TAILA/G.n17 9.3005
R2015 XCH2_TAILA/G.n20 XCH2_TAILA/G.n19 7.04123
R2016 XCH2_TAILA/G.n8 XCH2_TAILA/G.n9 59.4829
R2017 XCH2_TAILA/G.n9 XCH2_TAILA/G.n11 59.4829
R2018 XCH2_TAILA/G.n11 XCH2_TAILA/G.n13 59.4829
R2019 XCH2_TAILA/G.n13 XCH2_TAILA/G.n15 59.4829
R2020 XCH2_TAILA/G.n15 XCH2_TAILA/G.n17 59.4829
R2021 XCH2_TAILA/G.n17 XCH2_TAILA/G.n19 59.4829
R2022 XCH2_TAILA/G.n19 XCH2_TAILA/G.t1 280.212
R2023 XCH2_TAILA/G.t1 vbias 280.212
R2024 XCH2_TAILA/G.n17 XCH2_TAILA/G.t2 280.212
R2025 XCH2_TAILA/G.t2 vbias 280.212
R2026 XCH2_TAILA/G.n15 XCH2_TAILA/G.t3 280.212
R2027 XCH2_TAILA/G.t3 vbias 280.212
R2028 XCH2_TAILA/G.n13 XCH2_TAILA/G.t4 280.212
R2029 XCH2_TAILA/G.t4 vbias 280.212
R2030 XCH2_TAILA/G.n11 XCH2_TAILA/G.t5 280.212
R2031 XCH2_TAILA/G.t5 vbias 280.212
R2032 XCH2_TAILA/G.n9 XCH2_TAILA/G.t6 280.212
R2033 XCH2_TAILA/G.t6 vbias 280.212
R2034 XCH2_TAILA/G.n8 XCH2_TAILA/G.t7 280.212
R2035 XCH2_TAILA/G.t7 vbias 280.212
R2036 XCH2_TAILA/G.n20 XCH2_TAILA/G.n18 1.65269
R2037 XCH2_TAILA/G.n18 XCH2_TAILA/G.n16 0.493147
R2038 XCH2_TAILA/G.n16 XCH2_TAILA/G.n14 0.493147
R2039 XCH2_TAILA/G.n14 XCH2_TAILA/G.n12 0.493147
R2040 XCH2_TAILA/G.n12 XCH2_TAILA/G.n10 0.493147
R2041 XCH2_TAILA/G.n10 XCH2_TAILA/G.n7 1.65269
R2042 XCH2_TAILA/G.n7 XCH2_TAILA/G.t8 287.627
R2043 XCH2_TAILA/G.t8 vbias 280.212
R2044 XCH2_TAILA/G.n6 vbias 0.430647
R2045 XCH2_TAILA/G.n5 XCH2_TAILA/G.n6 0.493147
R2046 XCH2_TAILA/G.n4 XCH2_TAILA/G.n5 1.65269
R2047 XCH2_TAILA/B.t4 XCH2_TAILA/B.n0 26.5914
R2048 XCH2_TAILA/B.n0 XCH2_TAILA/B.n1 26.5914
R2049 XCH2_TAILA/B.n3 XCH2_TAILA/B.n2 65.0005
R2050 XCH2_TAILA/B.n4 XCH2_TAILA/B.t4 26.5914
R2051 VGND XCH2_TAILA/B.n4 26.5914
R2052 XCH2_TAILA/B.n6 XCH2_TAILA/B.n5 65.0005
R2053 XCH2_TAILA/B.n7 XCH2_TAILA/B.n6 65.0005
R2054 VGND XCH2_TAILA/B.n5 276.961
R2055 XCH2_TAILA/B.n5 XCH2_TAILA/B.t0 1008.55
R2056 XCH2_TAILA/B.t0 XCH2_TAILA/B.t1 825.654
R2057 XCH2_TAILA/B.t1 XCH2_TAILA/B.t2 825.654
R2058 XCH2_TAILA/B.t3 XCH2_TAILA/B.t2 825.654
R2059 XCH2_TAILA/B.t4 XCH2_TAILA/B.t3 825.654
R2060 XCH2_TAILA/B.t4 XCH2_TAILA/B.t5 825.654
R2061 XCH2_TAILA/B.t5 XCH2_TAILA/B.t6 825.654
R2062 XCH2_TAILA/B.t6 XCH2_TAILA/B.t7 825.654
R2063 XCH2_TAILA/B.t8 XCH2_TAILA/B.t7 825.654
R2064 XCH2_TAILA/B.n2 XCH2_TAILA/B.t8 1073.55
R2065 VGND XCH2_TAILA/B.n7 442.729
R2066 VGND XCH2_TAILA/B.n3 442.729
R2067 XCH2_TAILA/B.n7 XCH2_TAILA/B.n1 442.729
R2068 XCH2_TAILA/B.n1 XCH2_TAILA/B.n3 442.729
R2069 XCH2_TAILA/B.n6 XCH2_TAILA/B.n4 6813.88
R2070 XCH2_TAILA/B.n4 XCH2_TAILA/B.n2 6813.88
R2071 XCH2_TAILA/B.n6 XCH2_TAILA/B.n0 6813.88
R2072 XCH2_TAILA/B.n0 XCH2_TAILA/B.n2 6813.88
R2073 gm2_n XCH2_SW3B/S4.t0 58.6255
R2074 ua[3] XCH2_SW3B/D4.n0 0.277674
R2075 XCH2_SW3B/D4.n1 ua[3] 46.2505
R2076 XCH2_SW3B/D4.t0 XCH2_SW3B/D4.n1 12.3755
R2077 XCH2_SW3B/D4.n1 XCH2_SW3B/D4.t1 12.3755
R2078 gm2_n XCH2_SW3B/S3.n0 46.2505
R2079 XCH2_SW3B/S3.n0 XCH2_SW3B/S3.t1 12.3755
R2080 XCH2_SW3B/S3.n0 XCH2_SW3B/S3.t0 12.3755
R2081 ua[3] XCH2_SW3B/D2.n0 0.277674
R2082 XCH2_SW3B/D2.n1 ua[3] 46.2505
R2083 XCH2_SW3B/D2.t0 XCH2_SW3B/D2.n1 12.3755
R2084 XCH2_SW3B/D2.n1 XCH2_SW3B/D2.t1 12.3755
R2085 gm2_n XCH2_SW3B/S1.n0 46.2505
R2086 XCH2_SW3B/S1.n0 XCH2_SW3B/S1.t0 12.3755
R2087 XCH2_SW3B/S1.n0 XCH2_SW3B/S1.t1 12.3755
R2088 ua[3] XCH2_SW3B/D0.n0 0.277674
R2089 ua[3] XCH2_SW3B/D0.t0 58.6255
R2090 ch2_lop XCH2_SW3B/G.n0 9.3005
R2091 ch2_lop XCH2_SW3B/G.n0 0.0466957
R2092 ch2_lop XCH2_SW3B/G.n1 6.10787
R2093 XCH2_SW3B/G.n1 XCH2_SW3B/G.n0 1.92
R2094 XCH2_SW3B/G.n2 ch2_lop 152
R2095 ch2_lop XCH2_SW3B/G.n3 6.10787
R2096 XCH2_SW3B/G.n4 ch2_lop 152
R2097 XCH2_SW3B/G.n5 ch2_lop 152
R2098 XCH2_SW3B/G.n6 ch2_lop 152
R2099 ch2_lop XCH2_SW3B/G.n18 152
R2100 ch2_lop XCH2_SW3B/G.n3 6.3031
R2101 ch2_lop XCH2_SW3B/G.n1 6.3031
R2102 XCH2_SW3B/G.n4 XCH2_SW3B/G.n2 70.1096
R2103 XCH2_SW3B/G.n5 XCH2_SW3B/G.n4 70.1096
R2104 XCH2_SW3B/G.n6 XCH2_SW3B/G.n5 70.1096
R2105 XCH2_SW3B/G.n18 XCH2_SW3B/G.n6 70.1096
R2106 XCH2_SW3B/G.n18 XCH2_SW3B/G.t0 292.413
R2107 XCH2_SW3B/G.t0 XCH2_SW3B/G.n7 292.413
R2108 XCH2_SW3B/G.n8 XCH2_SW3B/G.n9 152
R2109 XCH2_SW3B/G.n10 XCH2_SW3B/G.n11 152
R2110 XCH2_SW3B/G.n12 XCH2_SW3B/G.n13 152
R2111 XCH2_SW3B/G.n12 XCH2_SW3B/G.n14 70.1096
R2112 XCH2_SW3B/G.n12 XCH2_SW3B/G.n10 70.1096
R2113 XCH2_SW3B/G.n10 XCH2_SW3B/G.n8 70.1096
R2114 XCH2_SW3B/G.n8 XCH2_SW3B/G.n7 70.1096
R2115 XCH2_SW3B/G.n15 XCH2_SW3B/G.n9 6.10787
R2116 XCH2_SW3B/G.n16 XCH2_SW3B/G.n11 9.3005
R2117 XCH2_SW3B/G.n17 XCH2_SW3B/G.n13 6.10787
R2118 XCH2_SW3B/G.n14 XCH2_SW3B/G.n17 158.304
R2119 XCH2_SW3B/G.n13 XCH2_SW3B/G.n11 36.1417
R2120 XCH2_SW3B/G.n11 XCH2_SW3B/G.n9 36.1417
R2121 XCH2_SW3B/G.n7 XCH2_SW3B/G.n15 158.304
R2122 XCH2_SW3B/G.n16 XCH2_SW3B/G.n17 1.92
R2123 XCH2_SW3B/G.n15 XCH2_SW3B/G.n16 1.92
R2124 XCH2_SW3B/G.n14 XCH2_SW3B/G.t4 292.413
R2125 XCH2_SW3B/G.n2 XCH2_SW3B/G.t4 292.413
R2126 XCH2_SW3B/G.t3 XCH2_SW3B/G.n12 292.413
R2127 XCH2_SW3B/G.n4 XCH2_SW3B/G.t3 292.413
R2128 XCH2_SW3B/G.t2 XCH2_SW3B/G.n10 292.413
R2129 XCH2_SW3B/G.n5 XCH2_SW3B/G.t2 292.413
R2130 XCH2_SW3B/G.t1 XCH2_SW3B/G.n8 292.413
R2131 XCH2_SW3B/G.n6 XCH2_SW3B/G.t1 292.413
R2132 XCH2_SW3B/G.n3 ch2_lop 1.8738
R2133 XCH2_SW3B/B.t2 XCH2_SW3B/B.n0 73.1255
R2134 XCH2_SW3B/B.n0 XCH2_SW3B/B.n1 73.1255
R2135 XCH2_SW3B/B.n3 XCH2_SW3B/B.n2 83.5719
R2136 XCH2_SW3B/B.n4 XCH2_SW3B/B.t2 73.1255
R2137 VGND XCH2_SW3B/B.n4 73.1255
R2138 XCH2_SW3B/B.n6 XCH2_SW3B/B.n5 83.5719
R2139 XCH2_SW3B/B.n7 XCH2_SW3B/B.n6 83.5719
R2140 VGND XCH2_SW3B/B.n5 315.135
R2141 XCH2_SW3B/B.n5 XCH2_SW3B/B.t0 963.244
R2142 XCH2_SW3B/B.t1 XCH2_SW3B/B.t0 570.812
R2143 XCH2_SW3B/B.t2 XCH2_SW3B/B.t1 570.812
R2144 XCH2_SW3B/B.t2 XCH2_SW3B/B.t3 570.812
R2145 XCH2_SW3B/B.t3 XCH2_SW3B/B.t4 570.812
R2146 XCH2_SW3B/B.t4 XCH2_SW3B/B.n2 1046.81
R2147 VGND XCH2_SW3B/B.n7 246.213
R2148 VGND XCH2_SW3B/B.n3 246.213
R2149 XCH2_SW3B/B.n7 XCH2_SW3B/B.n1 246.213
R2150 XCH2_SW3B/B.n1 XCH2_SW3B/B.n3 246.213
R2151 XCH2_SW3B/B.n6 XCH2_SW3B/B.n4 3789.35
R2152 XCH2_SW3B/B.n4 XCH2_SW3B/B.n2 3789.35
R2153 XCH2_SW3B/B.n6 XCH2_SW3B/B.n0 3789.35
R2154 XCH2_SW3B/B.n0 XCH2_SW3B/B.n2 3789.35
R2155 gm2_p XCH2_SW2A/S4.t0 58.6255
R2156 ua[3] XCH2_SW2A/D4.n0 0.277674
R2157 XCH2_SW2A/D4.n1 ua[3] 46.2505
R2158 XCH2_SW2A/D4.t0 XCH2_SW2A/D4.n1 12.3755
R2159 XCH2_SW2A/D4.n1 XCH2_SW2A/D4.t1 12.3755
R2160 gm2_p XCH2_SW2A/S3.n0 46.2505
R2161 XCH2_SW2A/S3.n0 XCH2_SW2A/S3.t1 12.3755
R2162 XCH2_SW2A/S3.n0 XCH2_SW2A/S3.t0 12.3755
R2163 ua[3] XCH2_SW2A/D2.n0 0.277674
R2164 XCH2_SW2A/D2.n1 ua[3] 46.2505
R2165 XCH2_SW2A/D2.t0 XCH2_SW2A/D2.n1 12.3755
R2166 XCH2_SW2A/D2.n1 XCH2_SW2A/D2.t1 12.3755
R2167 gm2_p XCH2_SW2A/S1.n0 46.2505
R2168 XCH2_SW2A/S1.n0 XCH2_SW2A/S1.t0 12.3755
R2169 XCH2_SW2A/S1.n0 XCH2_SW2A/S1.t1 12.3755
R2170 ua[3] XCH2_SW2A/D0.n0 0.277674
R2171 ua[3] XCH2_SW2A/D0.t0 58.6255
R2172 ch2_lon XCH2_SW2A/G.n0 9.3005
R2173 ch2_lon XCH2_SW2A/G.n0 0.0466957
R2174 ch2_lon XCH2_SW2A/G.n1 6.10787
R2175 XCH2_SW2A/G.n1 XCH2_SW2A/G.n0 1.92
R2176 XCH2_SW2A/G.n2 ch2_lon 152
R2177 ch2_lon XCH2_SW2A/G.n3 6.10787
R2178 XCH2_SW2A/G.n4 ch2_lon 152
R2179 XCH2_SW2A/G.n5 ch2_lon 152
R2180 XCH2_SW2A/G.n6 ch2_lon 152
R2181 ch2_lon XCH2_SW2A/G.n18 152
R2182 ch2_lon XCH2_SW2A/G.n3 6.3031
R2183 ch2_lon XCH2_SW2A/G.n1 6.3031
R2184 XCH2_SW2A/G.n4 XCH2_SW2A/G.n2 70.1096
R2185 XCH2_SW2A/G.n5 XCH2_SW2A/G.n4 70.1096
R2186 XCH2_SW2A/G.n6 XCH2_SW2A/G.n5 70.1096
R2187 XCH2_SW2A/G.n18 XCH2_SW2A/G.n6 70.1096
R2188 XCH2_SW2A/G.n18 XCH2_SW2A/G.t0 292.413
R2189 XCH2_SW2A/G.t0 XCH2_SW2A/G.n7 292.413
R2190 XCH2_SW2A/G.n8 XCH2_SW2A/G.n9 152
R2191 XCH2_SW2A/G.n10 XCH2_SW2A/G.n11 152
R2192 XCH2_SW2A/G.n12 XCH2_SW2A/G.n13 152
R2193 XCH2_SW2A/G.n12 XCH2_SW2A/G.n14 70.1096
R2194 XCH2_SW2A/G.n12 XCH2_SW2A/G.n10 70.1096
R2195 XCH2_SW2A/G.n10 XCH2_SW2A/G.n8 70.1096
R2196 XCH2_SW2A/G.n8 XCH2_SW2A/G.n7 70.1096
R2197 XCH2_SW2A/G.n15 XCH2_SW2A/G.n9 6.10787
R2198 XCH2_SW2A/G.n16 XCH2_SW2A/G.n11 9.3005
R2199 XCH2_SW2A/G.n17 XCH2_SW2A/G.n13 6.10787
R2200 XCH2_SW2A/G.n14 XCH2_SW2A/G.n17 158.304
R2201 XCH2_SW2A/G.n13 XCH2_SW2A/G.n11 36.1417
R2202 XCH2_SW2A/G.n11 XCH2_SW2A/G.n9 36.1417
R2203 XCH2_SW2A/G.n7 XCH2_SW2A/G.n15 158.304
R2204 XCH2_SW2A/G.n16 XCH2_SW2A/G.n17 1.92
R2205 XCH2_SW2A/G.n15 XCH2_SW2A/G.n16 1.92
R2206 XCH2_SW2A/G.n14 XCH2_SW2A/G.t4 292.413
R2207 XCH2_SW2A/G.n2 XCH2_SW2A/G.t4 292.413
R2208 XCH2_SW2A/G.t3 XCH2_SW2A/G.n12 292.413
R2209 XCH2_SW2A/G.n4 XCH2_SW2A/G.t3 292.413
R2210 XCH2_SW2A/G.t2 XCH2_SW2A/G.n10 292.413
R2211 XCH2_SW2A/G.n5 XCH2_SW2A/G.t2 292.413
R2212 XCH2_SW2A/G.t1 XCH2_SW2A/G.n8 292.413
R2213 XCH2_SW2A/G.n6 XCH2_SW2A/G.t1 292.413
R2214 XCH2_SW2A/G.n3 ch2_lon 1.8738
R2215 XCH2_SW2A/B.t2 XCH2_SW2A/B.n0 73.1255
R2216 XCH2_SW2A/B.n0 XCH2_SW2A/B.n1 73.1255
R2217 XCH2_SW2A/B.n3 XCH2_SW2A/B.n2 83.5719
R2218 XCH2_SW2A/B.n4 XCH2_SW2A/B.t2 73.1255
R2219 VGND XCH2_SW2A/B.n4 73.1255
R2220 XCH2_SW2A/B.n6 XCH2_SW2A/B.n5 83.5719
R2221 XCH2_SW2A/B.n7 XCH2_SW2A/B.n6 83.5719
R2222 VGND XCH2_SW2A/B.n5 315.135
R2223 XCH2_SW2A/B.n5 XCH2_SW2A/B.t0 963.244
R2224 XCH2_SW2A/B.t1 XCH2_SW2A/B.t0 570.812
R2225 XCH2_SW2A/B.t2 XCH2_SW2A/B.t1 570.812
R2226 XCH2_SW2A/B.t2 XCH2_SW2A/B.t3 570.812
R2227 XCH2_SW2A/B.t3 XCH2_SW2A/B.t4 570.812
R2228 XCH2_SW2A/B.t4 XCH2_SW2A/B.n2 1046.81
R2229 VGND XCH2_SW2A/B.n7 246.213
R2230 VGND XCH2_SW2A/B.n3 246.213
R2231 XCH2_SW2A/B.n7 XCH2_SW2A/B.n1 246.213
R2232 XCH2_SW2A/B.n1 XCH2_SW2A/B.n3 246.213
R2233 XCH2_SW2A/B.n6 XCH2_SW2A/B.n4 3789.35
R2234 XCH2_SW2A/B.n4 XCH2_SW2A/B.n2 3789.35
R2235 XCH2_SW2A/B.n6 XCH2_SW2A/B.n0 3789.35
R2236 XCH2_SW2A/B.n0 XCH2_SW2A/B.n2 3789.35
R2237 XBIASB/S8.n0 VGND 2.31159
R2238 VGND XBIASB/S8.t0 46.7758
R2239 vbias XBIASB/D8.n0 2.18659
R2240 vbias XBIASB/D8.n1 37.0005
R2241 XBIASB/D8.n1 XBIASB/D8.t0 9.77578
R2242 XBIASB/D8.n1 XBIASB/D8.t1 9.77578
R2243 XBIASB/S7.n0 VGND 2.31159
R2244 VGND XBIASB/S7.n1 37.0005
R2245 XBIASB/S7.n1 XBIASB/S7.t1 9.77578
R2246 XBIASB/S7.n1 XBIASB/S7.t0 9.77578
R2247 vbias XBIASB/D6.n0 2.18659
R2248 vbias XBIASB/D6.n1 37.0005
R2249 XBIASB/D6.n1 XBIASB/D6.t1 9.77578
R2250 XBIASB/D6.n1 XBIASB/D6.t0 9.77578
R2251 XBIASB/S5.n0 VGND 2.31159
R2252 VGND XBIASB/S5.n1 37.0005
R2253 XBIASB/S5.n1 XBIASB/S5.t1 9.77578
R2254 XBIASB/S5.n1 XBIASB/S5.t0 9.77578
R2255 vbias XBIASB/D4.n0 2.18659
R2256 vbias XBIASB/D4.n1 37.0005
R2257 XBIASB/D4.n1 XBIASB/D4.t1 9.77578
R2258 XBIASB/D4.n1 XBIASB/D4.t0 9.77578
R2259 XBIASB/S3.n0 VGND 2.31159
R2260 VGND XBIASB/S3.n1 37.0005
R2261 XBIASB/S3.n1 XBIASB/S3.t1 9.77578
R2262 XBIASB/S3.n1 XBIASB/S3.t0 9.77578
R2263 vbias XBIASB/D2.n0 2.18659
R2264 vbias XBIASB/D2.n1 37.0005
R2265 XBIASB/D2.n1 XBIASB/D2.t1 9.77578
R2266 XBIASB/D2.n1 XBIASB/D2.t0 9.77578
R2267 XBIASB/S1.n0 VGND 2.31159
R2268 VGND XBIASB/S1.n1 37.0005
R2269 XBIASB/S1.n1 XBIASB/S1.t0 9.77578
R2270 XBIASB/S1.n1 XBIASB/S1.t1 9.77578
R2271 vbias XBIASB/D0.n0 2.18659
R2272 vbias XBIASB/D0.t0 46.7758
R2273 vbias XBIASB/G.n0 9.3005
R2274 vbias XBIASB/G.n0 0.063
R2275 vbias XBIASB/G.n1 9.3005
R2276 XBIASB/G.n1 XBIASB/G.n0 0.493147
R2277 vbias XBIASB/G.n2 9.3005
R2278 XBIASB/G.n2 XBIASB/G.n1 0.493147
R2279 vbias XBIASB/G.n3 7.04123
R2280 XBIASB/G.n3 XBIASB/G.n2 1.65269
R2281 vbias XBIASB/G.n4 7.04123
R2282 vbias XBIASB/G.n5 9.3005
R2283 vbias XBIASB/G.n6 9.3005
R2284 vbias XBIASB/G.n4 7.41417
R2285 vbias XBIASB/G.n3 7.41417
R2286 vbias XBIASB/G.t0 264.307
R2287 XBIASB/G.t0 XBIASB/G.n20 271.721
R2288 XBIASB/G.n7 XBIASB/G.n8 7.04123
R2289 XBIASB/G.n10 XBIASB/G.n9 9.3005
R2290 XBIASB/G.n12 XBIASB/G.n11 9.3005
R2291 XBIASB/G.n14 XBIASB/G.n13 9.3005
R2292 XBIASB/G.n16 XBIASB/G.n15 9.3005
R2293 XBIASB/G.n18 XBIASB/G.n17 9.3005
R2294 XBIASB/G.n20 XBIASB/G.n19 7.04123
R2295 XBIASB/G.n8 XBIASB/G.n9 59.4829
R2296 XBIASB/G.n9 XBIASB/G.n11 59.4829
R2297 XBIASB/G.n11 XBIASB/G.n13 59.4829
R2298 XBIASB/G.n13 XBIASB/G.n15 59.4829
R2299 XBIASB/G.n15 XBIASB/G.n17 59.4829
R2300 XBIASB/G.n17 XBIASB/G.n19 59.4829
R2301 XBIASB/G.n19 XBIASB/G.t1 264.307
R2302 XBIASB/G.t1 vbias 264.307
R2303 XBIASB/G.n17 XBIASB/G.t2 264.307
R2304 XBIASB/G.t2 vbias 264.307
R2305 XBIASB/G.n15 XBIASB/G.t3 264.307
R2306 XBIASB/G.t3 vbias 264.307
R2307 XBIASB/G.n13 XBIASB/G.t4 264.307
R2308 XBIASB/G.t4 vbias 264.307
R2309 XBIASB/G.n11 XBIASB/G.t5 264.307
R2310 XBIASB/G.t5 vbias 264.307
R2311 XBIASB/G.n9 XBIASB/G.t6 264.307
R2312 XBIASB/G.t6 vbias 264.307
R2313 XBIASB/G.n8 XBIASB/G.t7 264.307
R2314 XBIASB/G.t7 vbias 264.307
R2315 XBIASB/G.n20 XBIASB/G.n18 1.65269
R2316 XBIASB/G.n18 XBIASB/G.n16 0.493147
R2317 XBIASB/G.n16 XBIASB/G.n14 0.493147
R2318 XBIASB/G.n14 XBIASB/G.n12 0.493147
R2319 XBIASB/G.n12 XBIASB/G.n10 0.493147
R2320 XBIASB/G.n10 XBIASB/G.n7 1.65269
R2321 XBIASB/G.n7 XBIASB/G.t8 271.721
R2322 XBIASB/G.t8 vbias 264.307
R2323 XBIASB/G.n6 vbias 0.430647
R2324 XBIASB/G.n5 XBIASB/G.n6 0.493147
R2325 XBIASB/G.n4 XBIASB/G.n5 1.65269
R2326 XBIASB/B.t4 XBIASB/B.n0 26.5914
R2327 XBIASB/B.n0 XBIASB/B.n1 26.5914
R2328 XBIASB/B.n3 XBIASB/B.n2 73.1255
R2329 XBIASB/B.n4 XBIASB/B.t4 26.5914
R2330 VGND XBIASB/B.n4 26.5914
R2331 XBIASB/B.n6 XBIASB/B.n5 73.1255
R2332 XBIASB/B.n7 XBIASB/B.n6 73.1255
R2333 VGND XBIASB/B.n5 300.515
R2334 XBIASB/B.n5 XBIASB/B.t0 1094.33
R2335 XBIASB/B.t0 XBIASB/B.t1 895.876
R2336 XBIASB/B.t1 XBIASB/B.t2 895.876
R2337 XBIASB/B.t3 XBIASB/B.t2 895.876
R2338 XBIASB/B.t4 XBIASB/B.t3 895.876
R2339 XBIASB/B.t4 XBIASB/B.t5 895.876
R2340 XBIASB/B.t5 XBIASB/B.t6 895.876
R2341 XBIASB/B.t6 XBIASB/B.t7 895.876
R2342 XBIASB/B.t8 XBIASB/B.t7 895.876
R2343 XBIASB/B.n2 XBIASB/B.t8 1167.45
R2344 VGND XBIASB/B.n7 430.307
R2345 VGND XBIASB/B.n3 430.307
R2346 XBIASB/B.n7 XBIASB/B.n1 430.307
R2347 XBIASB/B.n1 XBIASB/B.n3 430.307
R2348 XBIASB/B.n6 XBIASB/B.n4 6622.68
R2349 XBIASB/B.n4 XBIASB/B.n2 6622.68
R2350 XBIASB/B.n6 XBIASB/B.n0 6622.68
R2351 XBIASB/B.n0 XBIASB/B.n2 6622.68
R2352 VGND XCH2_TAILB/S8.t0 39.0803
R2353 tail2 XCH2_TAILB/D8.n0 1.96626
R2354 tail2 XCH2_TAILB/D8.n1 30.8338
R2355 XCH2_TAILB/D8.n1 XCH2_TAILB/D8.t1 8.24695
R2356 XCH2_TAILB/D8.n1 XCH2_TAILB/D8.t0 8.24695
R2357 VGND XCH2_TAILB/S7.n0 30.8338
R2358 XCH2_TAILB/S7.n0 XCH2_TAILB/S7.t0 8.24695
R2359 XCH2_TAILB/S7.n0 XCH2_TAILB/S7.t1 8.24695
R2360 tail2 XCH2_TAILB/D6.n0 1.96626
R2361 tail2 XCH2_TAILB/D6.n1 30.8338
R2362 XCH2_TAILB/D6.n1 XCH2_TAILB/D6.t1 8.24695
R2363 XCH2_TAILB/D6.n1 XCH2_TAILB/D6.t0 8.24695
R2364 VGND XCH2_TAILB/S5.n0 30.8338
R2365 XCH2_TAILB/S5.n0 XCH2_TAILB/S5.t0 8.24695
R2366 XCH2_TAILB/S5.n0 XCH2_TAILB/S5.t1 8.24695
R2367 tail2 XCH2_TAILB/D4.n0 1.96626
R2368 tail2 XCH2_TAILB/D4.n1 30.8338
R2369 XCH2_TAILB/D4.n1 XCH2_TAILB/D4.t1 8.24695
R2370 XCH2_TAILB/D4.n1 XCH2_TAILB/D4.t0 8.24695
R2371 VGND XCH2_TAILB/S3.n0 30.8338
R2372 XCH2_TAILB/S3.n0 XCH2_TAILB/S3.t1 8.24695
R2373 XCH2_TAILB/S3.n0 XCH2_TAILB/S3.t0 8.24695
R2374 tail2 XCH2_TAILB/D2.n0 1.96626
R2375 tail2 XCH2_TAILB/D2.n1 30.8338
R2376 XCH2_TAILB/D2.n1 XCH2_TAILB/D2.t1 8.24695
R2377 XCH2_TAILB/D2.n1 XCH2_TAILB/D2.t0 8.24695
R2378 VGND XCH2_TAILB/S1.n0 30.8338
R2379 XCH2_TAILB/S1.n0 XCH2_TAILB/S1.t0 8.24695
R2380 XCH2_TAILB/S1.n0 XCH2_TAILB/S1.t1 8.24695
R2381 tail2 XCH2_TAILB/D0.n0 1.96626
R2382 tail2 XCH2_TAILB/D0.t0 39.0803
R2383 vbias XCH2_TAILB/G.n0 9.3005
R2384 vbias XCH2_TAILB/G.n0 0.063
R2385 vbias XCH2_TAILB/G.n1 9.3005
R2386 XCH2_TAILB/G.n1 XCH2_TAILB/G.n0 0.493147
R2387 vbias XCH2_TAILB/G.n2 9.3005
R2388 XCH2_TAILB/G.n2 XCH2_TAILB/G.n1 0.493147
R2389 vbias XCH2_TAILB/G.n3 7.04123
R2390 XCH2_TAILB/G.n3 XCH2_TAILB/G.n2 1.65269
R2391 vbias XCH2_TAILB/G.n4 7.04123
R2392 vbias XCH2_TAILB/G.n5 9.3005
R2393 vbias XCH2_TAILB/G.n6 9.3005
R2394 vbias XCH2_TAILB/G.n4 7.41417
R2395 vbias XCH2_TAILB/G.n3 7.41417
R2396 vbias XCH2_TAILB/G.t0 280.212
R2397 XCH2_TAILB/G.t0 XCH2_TAILB/G.n20 287.627
R2398 XCH2_TAILB/G.n7 XCH2_TAILB/G.n8 7.04123
R2399 XCH2_TAILB/G.n10 XCH2_TAILB/G.n9 9.3005
R2400 XCH2_TAILB/G.n12 XCH2_TAILB/G.n11 9.3005
R2401 XCH2_TAILB/G.n14 XCH2_TAILB/G.n13 9.3005
R2402 XCH2_TAILB/G.n16 XCH2_TAILB/G.n15 9.3005
R2403 XCH2_TAILB/G.n18 XCH2_TAILB/G.n17 9.3005
R2404 XCH2_TAILB/G.n20 XCH2_TAILB/G.n19 7.04123
R2405 XCH2_TAILB/G.n8 XCH2_TAILB/G.n9 59.4829
R2406 XCH2_TAILB/G.n9 XCH2_TAILB/G.n11 59.4829
R2407 XCH2_TAILB/G.n11 XCH2_TAILB/G.n13 59.4829
R2408 XCH2_TAILB/G.n13 XCH2_TAILB/G.n15 59.4829
R2409 XCH2_TAILB/G.n15 XCH2_TAILB/G.n17 59.4829
R2410 XCH2_TAILB/G.n17 XCH2_TAILB/G.n19 59.4829
R2411 XCH2_TAILB/G.n19 XCH2_TAILB/G.t1 280.212
R2412 XCH2_TAILB/G.t1 vbias 280.212
R2413 XCH2_TAILB/G.n17 XCH2_TAILB/G.t2 280.212
R2414 XCH2_TAILB/G.t2 vbias 280.212
R2415 XCH2_TAILB/G.n15 XCH2_TAILB/G.t3 280.212
R2416 XCH2_TAILB/G.t3 vbias 280.212
R2417 XCH2_TAILB/G.n13 XCH2_TAILB/G.t4 280.212
R2418 XCH2_TAILB/G.t4 vbias 280.212
R2419 XCH2_TAILB/G.n11 XCH2_TAILB/G.t5 280.212
R2420 XCH2_TAILB/G.t5 vbias 280.212
R2421 XCH2_TAILB/G.n9 XCH2_TAILB/G.t6 280.212
R2422 XCH2_TAILB/G.t6 vbias 280.212
R2423 XCH2_TAILB/G.n8 XCH2_TAILB/G.t7 280.212
R2424 XCH2_TAILB/G.t7 vbias 280.212
R2425 XCH2_TAILB/G.n20 XCH2_TAILB/G.n18 1.65269
R2426 XCH2_TAILB/G.n18 XCH2_TAILB/G.n16 0.493147
R2427 XCH2_TAILB/G.n16 XCH2_TAILB/G.n14 0.493147
R2428 XCH2_TAILB/G.n14 XCH2_TAILB/G.n12 0.493147
R2429 XCH2_TAILB/G.n12 XCH2_TAILB/G.n10 0.493147
R2430 XCH2_TAILB/G.n10 XCH2_TAILB/G.n7 1.65269
R2431 XCH2_TAILB/G.n7 XCH2_TAILB/G.t8 287.627
R2432 XCH2_TAILB/G.t8 vbias 280.212
R2433 XCH2_TAILB/G.n6 vbias 0.430647
R2434 XCH2_TAILB/G.n5 XCH2_TAILB/G.n6 0.493147
R2435 XCH2_TAILB/G.n4 XCH2_TAILB/G.n5 1.65269
R2436 XCH2_TAILB/B.t4 XCH2_TAILB/B.n0 26.5914
R2437 XCH2_TAILB/B.n0 XCH2_TAILB/B.n1 26.5914
R2438 XCH2_TAILB/B.n3 XCH2_TAILB/B.n2 65.0005
R2439 XCH2_TAILB/B.n4 XCH2_TAILB/B.t4 26.5914
R2440 VGND XCH2_TAILB/B.n4 26.5914
R2441 XCH2_TAILB/B.n6 XCH2_TAILB/B.n5 65.0005
R2442 XCH2_TAILB/B.n7 XCH2_TAILB/B.n6 65.0005
R2443 VGND XCH2_TAILB/B.n5 276.961
R2444 XCH2_TAILB/B.n5 XCH2_TAILB/B.t0 1008.55
R2445 XCH2_TAILB/B.t0 XCH2_TAILB/B.t1 825.654
R2446 XCH2_TAILB/B.t1 XCH2_TAILB/B.t2 825.654
R2447 XCH2_TAILB/B.t3 XCH2_TAILB/B.t2 825.654
R2448 XCH2_TAILB/B.t4 XCH2_TAILB/B.t3 825.654
R2449 XCH2_TAILB/B.t4 XCH2_TAILB/B.t5 825.654
R2450 XCH2_TAILB/B.t5 XCH2_TAILB/B.t6 825.654
R2451 XCH2_TAILB/B.t6 XCH2_TAILB/B.t7 825.654
R2452 XCH2_TAILB/B.t8 XCH2_TAILB/B.t7 825.654
R2453 XCH2_TAILB/B.n2 XCH2_TAILB/B.t8 1073.55
R2454 VGND XCH2_TAILB/B.n7 442.729
R2455 VGND XCH2_TAILB/B.n3 442.729
R2456 XCH2_TAILB/B.n7 XCH2_TAILB/B.n1 442.729
R2457 XCH2_TAILB/B.n1 XCH2_TAILB/B.n3 442.729
R2458 XCH2_TAILB/B.n6 XCH2_TAILB/B.n4 6813.88
R2459 XCH2_TAILB/B.n4 XCH2_TAILB/B.n2 6813.88
R2460 XCH2_TAILB/B.n6 XCH2_TAILB/B.n0 6813.88
R2461 XCH2_TAILB/B.n0 XCH2_TAILB/B.n2 6813.88
R2462 VGND XCH1_TAILA/S8.t0 39.0803
R2463 tail1 XCH1_TAILA/D8.n0 1.96626
R2464 tail1 XCH1_TAILA/D8.n1 30.8338
R2465 XCH1_TAILA/D8.n1 XCH1_TAILA/D8.t1 8.24695
R2466 XCH1_TAILA/D8.n1 XCH1_TAILA/D8.t0 8.24695
R2467 VGND XCH1_TAILA/S7.n0 30.8338
R2468 XCH1_TAILA/S7.n0 XCH1_TAILA/S7.t0 8.24695
R2469 XCH1_TAILA/S7.n0 XCH1_TAILA/S7.t1 8.24695
R2470 tail1 XCH1_TAILA/D6.n0 1.96626
R2471 tail1 XCH1_TAILA/D6.n1 30.8338
R2472 XCH1_TAILA/D6.n1 XCH1_TAILA/D6.t1 8.24695
R2473 XCH1_TAILA/D6.n1 XCH1_TAILA/D6.t0 8.24695
R2474 VGND XCH1_TAILA/S5.n0 30.8338
R2475 XCH1_TAILA/S5.n0 XCH1_TAILA/S5.t0 8.24695
R2476 XCH1_TAILA/S5.n0 XCH1_TAILA/S5.t1 8.24695
R2477 tail1 XCH1_TAILA/D4.n0 1.96626
R2478 tail1 XCH1_TAILA/D4.n1 30.8338
R2479 XCH1_TAILA/D4.n1 XCH1_TAILA/D4.t1 8.24695
R2480 XCH1_TAILA/D4.n1 XCH1_TAILA/D4.t0 8.24695
R2481 VGND XCH1_TAILA/S3.n0 30.8338
R2482 XCH1_TAILA/S3.n0 XCH1_TAILA/S3.t1 8.24695
R2483 XCH1_TAILA/S3.n0 XCH1_TAILA/S3.t0 8.24695
R2484 tail1 XCH1_TAILA/D2.n0 1.96626
R2485 tail1 XCH1_TAILA/D2.n1 30.8338
R2486 XCH1_TAILA/D2.n1 XCH1_TAILA/D2.t1 8.24695
R2487 XCH1_TAILA/D2.n1 XCH1_TAILA/D2.t0 8.24695
R2488 VGND XCH1_TAILA/S1.n0 30.8338
R2489 XCH1_TAILA/S1.n0 XCH1_TAILA/S1.t0 8.24695
R2490 XCH1_TAILA/S1.n0 XCH1_TAILA/S1.t1 8.24695
R2491 tail1 XCH1_TAILA/D0.n0 1.96626
R2492 tail1 XCH1_TAILA/D0.t0 39.0803
R2493 vbias XCH1_TAILA/G.n0 9.3005
R2494 vbias XCH1_TAILA/G.n0 0.063
R2495 vbias XCH1_TAILA/G.n1 9.3005
R2496 XCH1_TAILA/G.n1 XCH1_TAILA/G.n0 0.493147
R2497 vbias XCH1_TAILA/G.n2 9.3005
R2498 XCH1_TAILA/G.n2 XCH1_TAILA/G.n1 0.493147
R2499 vbias XCH1_TAILA/G.n3 7.04123
R2500 XCH1_TAILA/G.n3 XCH1_TAILA/G.n2 1.65269
R2501 vbias XCH1_TAILA/G.n4 7.04123
R2502 vbias XCH1_TAILA/G.n5 9.3005
R2503 vbias XCH1_TAILA/G.n6 9.3005
R2504 vbias XCH1_TAILA/G.n4 7.41417
R2505 vbias XCH1_TAILA/G.n3 7.41417
R2506 vbias XCH1_TAILA/G.t0 280.212
R2507 XCH1_TAILA/G.t0 XCH1_TAILA/G.n20 287.627
R2508 XCH1_TAILA/G.n7 XCH1_TAILA/G.n8 7.04123
R2509 XCH1_TAILA/G.n10 XCH1_TAILA/G.n9 9.3005
R2510 XCH1_TAILA/G.n12 XCH1_TAILA/G.n11 9.3005
R2511 XCH1_TAILA/G.n14 XCH1_TAILA/G.n13 9.3005
R2512 XCH1_TAILA/G.n16 XCH1_TAILA/G.n15 9.3005
R2513 XCH1_TAILA/G.n18 XCH1_TAILA/G.n17 9.3005
R2514 XCH1_TAILA/G.n20 XCH1_TAILA/G.n19 7.04123
R2515 XCH1_TAILA/G.n8 XCH1_TAILA/G.n9 59.4829
R2516 XCH1_TAILA/G.n9 XCH1_TAILA/G.n11 59.4829
R2517 XCH1_TAILA/G.n11 XCH1_TAILA/G.n13 59.4829
R2518 XCH1_TAILA/G.n13 XCH1_TAILA/G.n15 59.4829
R2519 XCH1_TAILA/G.n15 XCH1_TAILA/G.n17 59.4829
R2520 XCH1_TAILA/G.n17 XCH1_TAILA/G.n19 59.4829
R2521 XCH1_TAILA/G.n19 XCH1_TAILA/G.t1 280.212
R2522 XCH1_TAILA/G.t1 vbias 280.212
R2523 XCH1_TAILA/G.n17 XCH1_TAILA/G.t2 280.212
R2524 XCH1_TAILA/G.t2 vbias 280.212
R2525 XCH1_TAILA/G.n15 XCH1_TAILA/G.t3 280.212
R2526 XCH1_TAILA/G.t3 vbias 280.212
R2527 XCH1_TAILA/G.n13 XCH1_TAILA/G.t4 280.212
R2528 XCH1_TAILA/G.t4 vbias 280.212
R2529 XCH1_TAILA/G.n11 XCH1_TAILA/G.t5 280.212
R2530 XCH1_TAILA/G.t5 vbias 280.212
R2531 XCH1_TAILA/G.n9 XCH1_TAILA/G.t6 280.212
R2532 XCH1_TAILA/G.t6 vbias 280.212
R2533 XCH1_TAILA/G.n8 XCH1_TAILA/G.t7 280.212
R2534 XCH1_TAILA/G.t7 vbias 280.212
R2535 XCH1_TAILA/G.n20 XCH1_TAILA/G.n18 1.65269
R2536 XCH1_TAILA/G.n18 XCH1_TAILA/G.n16 0.493147
R2537 XCH1_TAILA/G.n16 XCH1_TAILA/G.n14 0.493147
R2538 XCH1_TAILA/G.n14 XCH1_TAILA/G.n12 0.493147
R2539 XCH1_TAILA/G.n12 XCH1_TAILA/G.n10 0.493147
R2540 XCH1_TAILA/G.n10 XCH1_TAILA/G.n7 1.65269
R2541 XCH1_TAILA/G.n7 XCH1_TAILA/G.t8 287.627
R2542 XCH1_TAILA/G.t8 vbias 280.212
R2543 XCH1_TAILA/G.n6 vbias 0.430647
R2544 XCH1_TAILA/G.n5 XCH1_TAILA/G.n6 0.493147
R2545 XCH1_TAILA/G.n4 XCH1_TAILA/G.n5 1.65269
R2546 XCH1_TAILA/B.t4 XCH1_TAILA/B.n0 26.5914
R2547 XCH1_TAILA/B.n0 XCH1_TAILA/B.n1 26.5914
R2548 XCH1_TAILA/B.n3 XCH1_TAILA/B.n2 65.0005
R2549 XCH1_TAILA/B.n4 XCH1_TAILA/B.t4 26.5914
R2550 VGND XCH1_TAILA/B.n4 26.5914
R2551 XCH1_TAILA/B.n6 XCH1_TAILA/B.n5 65.0005
R2552 XCH1_TAILA/B.n7 XCH1_TAILA/B.n6 65.0005
R2553 VGND XCH1_TAILA/B.n5 276.961
R2554 XCH1_TAILA/B.n5 XCH1_TAILA/B.t0 1008.55
R2555 XCH1_TAILA/B.t0 XCH1_TAILA/B.t1 825.654
R2556 XCH1_TAILA/B.t1 XCH1_TAILA/B.t2 825.654
R2557 XCH1_TAILA/B.t3 XCH1_TAILA/B.t2 825.654
R2558 XCH1_TAILA/B.t4 XCH1_TAILA/B.t3 825.654
R2559 XCH1_TAILA/B.t4 XCH1_TAILA/B.t5 825.654
R2560 XCH1_TAILA/B.t5 XCH1_TAILA/B.t6 825.654
R2561 XCH1_TAILA/B.t6 XCH1_TAILA/B.t7 825.654
R2562 XCH1_TAILA/B.t8 XCH1_TAILA/B.t7 825.654
R2563 XCH1_TAILA/B.n2 XCH1_TAILA/B.t8 1073.55
R2564 VGND XCH1_TAILA/B.n7 442.729
R2565 VGND XCH1_TAILA/B.n3 442.729
R2566 XCH1_TAILA/B.n7 XCH1_TAILA/B.n1 442.729
R2567 XCH1_TAILA/B.n1 XCH1_TAILA/B.n3 442.729
R2568 XCH1_TAILA/B.n6 XCH1_TAILA/B.n4 6813.88
R2569 XCH1_TAILA/B.n4 XCH1_TAILA/B.n2 6813.88
R2570 XCH1_TAILA/B.n6 XCH1_TAILA/B.n0 6813.88
R2571 XCH1_TAILA/B.n0 XCH1_TAILA/B.n2 6813.88
R2572 gm2_p XCH2_SW1A/S4.t0 58.6255
R2573 ua[2] XCH2_SW1A/D4.n0 0.277674
R2574 XCH2_SW1A/D4.n1 ua[2] 46.2505
R2575 XCH2_SW1A/D4.t0 XCH2_SW1A/D4.n1 12.3755
R2576 XCH2_SW1A/D4.n1 XCH2_SW1A/D4.t1 12.3755
R2577 gm2_p XCH2_SW1A/S3.n0 46.2505
R2578 XCH2_SW1A/S3.n0 XCH2_SW1A/S3.t1 12.3755
R2579 XCH2_SW1A/S3.n0 XCH2_SW1A/S3.t0 12.3755
R2580 ua[2] XCH2_SW1A/D2.n0 0.277674
R2581 XCH2_SW1A/D2.n1 ua[2] 46.2505
R2582 XCH2_SW1A/D2.t0 XCH2_SW1A/D2.n1 12.3755
R2583 XCH2_SW1A/D2.n1 XCH2_SW1A/D2.t1 12.3755
R2584 gm2_p XCH2_SW1A/S1.n0 46.2505
R2585 XCH2_SW1A/S1.n0 XCH2_SW1A/S1.t0 12.3755
R2586 XCH2_SW1A/S1.n0 XCH2_SW1A/S1.t1 12.3755
R2587 ua[2] XCH2_SW1A/D0.n0 0.277674
R2588 ua[2] XCH2_SW1A/D0.t0 58.6255
R2589 ch2_lop XCH2_SW1A/G.n0 9.3005
R2590 ch2_lop XCH2_SW1A/G.n0 0.0466957
R2591 ch2_lop XCH2_SW1A/G.n1 6.10787
R2592 XCH2_SW1A/G.n1 XCH2_SW1A/G.n0 1.92
R2593 XCH2_SW1A/G.n2 ch2_lop 152
R2594 ch2_lop XCH2_SW1A/G.n3 6.10787
R2595 XCH2_SW1A/G.n4 ch2_lop 152
R2596 XCH2_SW1A/G.n5 ch2_lop 152
R2597 XCH2_SW1A/G.n6 ch2_lop 152
R2598 ch2_lop XCH2_SW1A/G.n18 152
R2599 ch2_lop XCH2_SW1A/G.n3 6.3031
R2600 ch2_lop XCH2_SW1A/G.n1 6.3031
R2601 XCH2_SW1A/G.n4 XCH2_SW1A/G.n2 70.1096
R2602 XCH2_SW1A/G.n5 XCH2_SW1A/G.n4 70.1096
R2603 XCH2_SW1A/G.n6 XCH2_SW1A/G.n5 70.1096
R2604 XCH2_SW1A/G.n18 XCH2_SW1A/G.n6 70.1096
R2605 XCH2_SW1A/G.n18 XCH2_SW1A/G.t0 292.413
R2606 XCH2_SW1A/G.t0 XCH2_SW1A/G.n7 292.413
R2607 XCH2_SW1A/G.n8 XCH2_SW1A/G.n9 152
R2608 XCH2_SW1A/G.n10 XCH2_SW1A/G.n11 152
R2609 XCH2_SW1A/G.n12 XCH2_SW1A/G.n13 152
R2610 XCH2_SW1A/G.n12 XCH2_SW1A/G.n14 70.1096
R2611 XCH2_SW1A/G.n12 XCH2_SW1A/G.n10 70.1096
R2612 XCH2_SW1A/G.n10 XCH2_SW1A/G.n8 70.1096
R2613 XCH2_SW1A/G.n8 XCH2_SW1A/G.n7 70.1096
R2614 XCH2_SW1A/G.n15 XCH2_SW1A/G.n9 6.10787
R2615 XCH2_SW1A/G.n16 XCH2_SW1A/G.n11 9.3005
R2616 XCH2_SW1A/G.n17 XCH2_SW1A/G.n13 6.10787
R2617 XCH2_SW1A/G.n14 XCH2_SW1A/G.n17 158.304
R2618 XCH2_SW1A/G.n13 XCH2_SW1A/G.n11 36.1417
R2619 XCH2_SW1A/G.n11 XCH2_SW1A/G.n9 36.1417
R2620 XCH2_SW1A/G.n7 XCH2_SW1A/G.n15 158.304
R2621 XCH2_SW1A/G.n16 XCH2_SW1A/G.n17 1.92
R2622 XCH2_SW1A/G.n15 XCH2_SW1A/G.n16 1.92
R2623 XCH2_SW1A/G.n14 XCH2_SW1A/G.t4 292.413
R2624 XCH2_SW1A/G.n2 XCH2_SW1A/G.t4 292.413
R2625 XCH2_SW1A/G.t3 XCH2_SW1A/G.n12 292.413
R2626 XCH2_SW1A/G.n4 XCH2_SW1A/G.t3 292.413
R2627 XCH2_SW1A/G.t2 XCH2_SW1A/G.n10 292.413
R2628 XCH2_SW1A/G.n5 XCH2_SW1A/G.t2 292.413
R2629 XCH2_SW1A/G.t1 XCH2_SW1A/G.n8 292.413
R2630 XCH2_SW1A/G.n6 XCH2_SW1A/G.t1 292.413
R2631 XCH2_SW1A/G.n3 ch2_lop 1.8738
R2632 XCH2_SW1A/B.t2 XCH2_SW1A/B.n0 73.1255
R2633 XCH2_SW1A/B.n0 XCH2_SW1A/B.n1 73.1255
R2634 XCH2_SW1A/B.n3 XCH2_SW1A/B.n2 83.5719
R2635 XCH2_SW1A/B.n4 XCH2_SW1A/B.t2 73.1255
R2636 VGND XCH2_SW1A/B.n4 73.1255
R2637 XCH2_SW1A/B.n6 XCH2_SW1A/B.n5 83.5719
R2638 XCH2_SW1A/B.n7 XCH2_SW1A/B.n6 83.5719
R2639 VGND XCH2_SW1A/B.n5 315.135
R2640 XCH2_SW1A/B.n5 XCH2_SW1A/B.t0 963.244
R2641 XCH2_SW1A/B.t1 XCH2_SW1A/B.t0 570.812
R2642 XCH2_SW1A/B.t2 XCH2_SW1A/B.t1 570.812
R2643 XCH2_SW1A/B.t2 XCH2_SW1A/B.t3 570.812
R2644 XCH2_SW1A/B.t3 XCH2_SW1A/B.t4 570.812
R2645 XCH2_SW1A/B.t4 XCH2_SW1A/B.n2 1046.81
R2646 VGND XCH2_SW1A/B.n7 246.213
R2647 VGND XCH2_SW1A/B.n3 246.213
R2648 XCH2_SW1A/B.n7 XCH2_SW1A/B.n1 246.213
R2649 XCH2_SW1A/B.n1 XCH2_SW1A/B.n3 246.213
R2650 XCH2_SW1A/B.n6 XCH2_SW1A/B.n4 3789.35
R2651 XCH2_SW1A/B.n4 XCH2_SW1A/B.n2 3789.35
R2652 XCH2_SW1A/B.n6 XCH2_SW1A/B.n0 3789.35
R2653 XCH2_SW1A/B.n0 XCH2_SW1A/B.n2 3789.35
R2654 gm2_p XCH2_SW2B/S4.t0 58.6255
R2655 ua[3] XCH2_SW2B/D4.n0 0.277674
R2656 XCH2_SW2B/D4.n1 ua[3] 46.2505
R2657 XCH2_SW2B/D4.t0 XCH2_SW2B/D4.n1 12.3755
R2658 XCH2_SW2B/D4.n1 XCH2_SW2B/D4.t1 12.3755
R2659 gm2_p XCH2_SW2B/S3.n0 46.2505
R2660 XCH2_SW2B/S3.n0 XCH2_SW2B/S3.t1 12.3755
R2661 XCH2_SW2B/S3.n0 XCH2_SW2B/S3.t0 12.3755
R2662 ua[3] XCH2_SW2B/D2.n0 0.277674
R2663 XCH2_SW2B/D2.n1 ua[3] 46.2505
R2664 XCH2_SW2B/D2.t0 XCH2_SW2B/D2.n1 12.3755
R2665 XCH2_SW2B/D2.n1 XCH2_SW2B/D2.t1 12.3755
R2666 gm2_p XCH2_SW2B/S1.n0 46.2505
R2667 XCH2_SW2B/S1.n0 XCH2_SW2B/S1.t0 12.3755
R2668 XCH2_SW2B/S1.n0 XCH2_SW2B/S1.t1 12.3755
R2669 ua[3] XCH2_SW2B/D0.n0 0.277674
R2670 ua[3] XCH2_SW2B/D0.t0 58.6255
R2671 ch2_lon XCH2_SW2B/G.n0 9.3005
R2672 ch2_lon XCH2_SW2B/G.n0 0.0466957
R2673 ch2_lon XCH2_SW2B/G.n1 6.10787
R2674 XCH2_SW2B/G.n1 XCH2_SW2B/G.n0 1.92
R2675 XCH2_SW2B/G.n2 ch2_lon 152
R2676 ch2_lon XCH2_SW2B/G.n3 6.10787
R2677 XCH2_SW2B/G.n4 ch2_lon 152
R2678 XCH2_SW2B/G.n5 ch2_lon 152
R2679 XCH2_SW2B/G.n6 ch2_lon 152
R2680 ch2_lon XCH2_SW2B/G.n18 152
R2681 ch2_lon XCH2_SW2B/G.n3 6.3031
R2682 ch2_lon XCH2_SW2B/G.n1 6.3031
R2683 XCH2_SW2B/G.n4 XCH2_SW2B/G.n2 70.1096
R2684 XCH2_SW2B/G.n5 XCH2_SW2B/G.n4 70.1096
R2685 XCH2_SW2B/G.n6 XCH2_SW2B/G.n5 70.1096
R2686 XCH2_SW2B/G.n18 XCH2_SW2B/G.n6 70.1096
R2687 XCH2_SW2B/G.n18 XCH2_SW2B/G.t0 292.413
R2688 XCH2_SW2B/G.t0 XCH2_SW2B/G.n7 292.413
R2689 XCH2_SW2B/G.n8 XCH2_SW2B/G.n9 152
R2690 XCH2_SW2B/G.n10 XCH2_SW2B/G.n11 152
R2691 XCH2_SW2B/G.n12 XCH2_SW2B/G.n13 152
R2692 XCH2_SW2B/G.n12 XCH2_SW2B/G.n14 70.1096
R2693 XCH2_SW2B/G.n12 XCH2_SW2B/G.n10 70.1096
R2694 XCH2_SW2B/G.n10 XCH2_SW2B/G.n8 70.1096
R2695 XCH2_SW2B/G.n8 XCH2_SW2B/G.n7 70.1096
R2696 XCH2_SW2B/G.n15 XCH2_SW2B/G.n9 6.10787
R2697 XCH2_SW2B/G.n16 XCH2_SW2B/G.n11 9.3005
R2698 XCH2_SW2B/G.n17 XCH2_SW2B/G.n13 6.10787
R2699 XCH2_SW2B/G.n14 XCH2_SW2B/G.n17 158.304
R2700 XCH2_SW2B/G.n13 XCH2_SW2B/G.n11 36.1417
R2701 XCH2_SW2B/G.n11 XCH2_SW2B/G.n9 36.1417
R2702 XCH2_SW2B/G.n7 XCH2_SW2B/G.n15 158.304
R2703 XCH2_SW2B/G.n16 XCH2_SW2B/G.n17 1.92
R2704 XCH2_SW2B/G.n15 XCH2_SW2B/G.n16 1.92
R2705 XCH2_SW2B/G.n14 XCH2_SW2B/G.t4 292.413
R2706 XCH2_SW2B/G.n2 XCH2_SW2B/G.t4 292.413
R2707 XCH2_SW2B/G.t3 XCH2_SW2B/G.n12 292.413
R2708 XCH2_SW2B/G.n4 XCH2_SW2B/G.t3 292.413
R2709 XCH2_SW2B/G.t2 XCH2_SW2B/G.n10 292.413
R2710 XCH2_SW2B/G.n5 XCH2_SW2B/G.t2 292.413
R2711 XCH2_SW2B/G.t1 XCH2_SW2B/G.n8 292.413
R2712 XCH2_SW2B/G.n6 XCH2_SW2B/G.t1 292.413
R2713 XCH2_SW2B/G.n3 ch2_lon 1.8738
R2714 XCH2_SW2B/B.t2 XCH2_SW2B/B.n0 73.1255
R2715 XCH2_SW2B/B.n0 XCH2_SW2B/B.n1 73.1255
R2716 XCH2_SW2B/B.n3 XCH2_SW2B/B.n2 83.5719
R2717 XCH2_SW2B/B.n4 XCH2_SW2B/B.t2 73.1255
R2718 VGND XCH2_SW2B/B.n4 73.1255
R2719 XCH2_SW2B/B.n6 XCH2_SW2B/B.n5 83.5719
R2720 XCH2_SW2B/B.n7 XCH2_SW2B/B.n6 83.5719
R2721 VGND XCH2_SW2B/B.n5 315.135
R2722 XCH2_SW2B/B.n5 XCH2_SW2B/B.t0 963.244
R2723 XCH2_SW2B/B.t1 XCH2_SW2B/B.t0 570.812
R2724 XCH2_SW2B/B.t2 XCH2_SW2B/B.t1 570.812
R2725 XCH2_SW2B/B.t2 XCH2_SW2B/B.t3 570.812
R2726 XCH2_SW2B/B.t3 XCH2_SW2B/B.t4 570.812
R2727 XCH2_SW2B/B.t4 XCH2_SW2B/B.n2 1046.81
R2728 VGND XCH2_SW2B/B.n7 246.213
R2729 VGND XCH2_SW2B/B.n3 246.213
R2730 XCH2_SW2B/B.n7 XCH2_SW2B/B.n1 246.213
R2731 XCH2_SW2B/B.n1 XCH2_SW2B/B.n3 246.213
R2732 XCH2_SW2B/B.n6 XCH2_SW2B/B.n4 3789.35
R2733 XCH2_SW2B/B.n4 XCH2_SW2B/B.n2 3789.35
R2734 XCH2_SW2B/B.n6 XCH2_SW2B/B.n0 3789.35
R2735 XCH2_SW2B/B.n0 XCH2_SW2B/B.n2 3789.35
R2736 VDPWR XCH2LP_P/S4.t0 75.1583
R2737 ch2_lop XCH2LP_P/D4.n0 1.74579
R2738 ch2_lop XCH2LP_P/D4.n1 65.0005
R2739 XCH2LP_P/D4.n1 XCH2LP_P/D4.t0 10.1583
R2740 XCH2LP_P/D4.n1 XCH2LP_P/D4.t1 10.1583
R2741 VDPWR XCH2LP_P/S3.n0 65.0005
R2742 XCH2LP_P/S3.n0 XCH2LP_P/S3.t0 10.1583
R2743 XCH2LP_P/S3.n0 XCH2LP_P/S3.t1 10.1583
R2744 ch2_lop XCH2LP_P/D2.n0 1.74579
R2745 ch2_lop XCH2LP_P/D2.n1 65.0005
R2746 XCH2LP_P/D2.n1 XCH2LP_P/D2.t1 10.1583
R2747 XCH2LP_P/D2.n1 XCH2LP_P/D2.t0 10.1583
R2748 VDPWR XCH2LP_P/S1.n0 65.0005
R2749 XCH2LP_P/S1.n0 XCH2LP_P/S1.t0 10.1583
R2750 XCH2LP_P/S1.n0 XCH2LP_P/S1.t1 10.1583
R2751 ch2_lop XCH2LP_P/D0.n0 1.74579
R2752 ch2_lop XCH2LP_P/D0.t0 75.1583
R2753 ch2_lop_raw XCH2LP_P/G.n0 9.3005
R2754 ch2_lop_raw XCH2LP_P/G.n0 0.0466957
R2755 ch2_lop_raw XCH2LP_P/G.n1 6.10787
R2756 XCH2LP_P/G.n1 XCH2LP_P/G.n0 1.92
R2757 XCH2LP_P/G.n2 ch2_lop_raw 152
R2758 ch2_lop_raw XCH2LP_P/G.n3 6.10787
R2759 XCH2LP_P/G.n4 ch2_lop_raw 152
R2760 XCH2LP_P/G.n5 ch2_lop_raw 152
R2761 XCH2LP_P/G.n6 ch2_lop_raw 152
R2762 ch2_lop_raw XCH2LP_P/G.n18 152
R2763 ch2_lop_raw XCH2LP_P/G.n3 6.3031
R2764 ch2_lop_raw XCH2LP_P/G.n1 6.3031
R2765 XCH2LP_P/G.n4 XCH2LP_P/G.n2 70.1096
R2766 XCH2LP_P/G.n5 XCH2LP_P/G.n4 70.1096
R2767 XCH2LP_P/G.n6 XCH2LP_P/G.n5 70.1096
R2768 XCH2LP_P/G.n18 XCH2LP_P/G.n6 70.1096
R2769 XCH2LP_P/G.n18 XCH2LP_P/G.t0 563.941
R2770 XCH2LP_P/G.t0 XCH2LP_P/G.n7 563.941
R2771 XCH2LP_P/G.n8 XCH2LP_P/G.n9 152
R2772 XCH2LP_P/G.n10 XCH2LP_P/G.n11 152
R2773 XCH2LP_P/G.n12 XCH2LP_P/G.n13 152
R2774 XCH2LP_P/G.n12 XCH2LP_P/G.n14 70.1096
R2775 XCH2LP_P/G.n12 XCH2LP_P/G.n10 70.1096
R2776 XCH2LP_P/G.n10 XCH2LP_P/G.n8 70.1096
R2777 XCH2LP_P/G.n8 XCH2LP_P/G.n7 70.1096
R2778 XCH2LP_P/G.n15 XCH2LP_P/G.n9 6.10787
R2779 XCH2LP_P/G.n16 XCH2LP_P/G.n11 9.3005
R2780 XCH2LP_P/G.n17 XCH2LP_P/G.n13 6.10787
R2781 XCH2LP_P/G.n14 XCH2LP_P/G.n17 158.304
R2782 XCH2LP_P/G.n13 XCH2LP_P/G.n11 36.1417
R2783 XCH2LP_P/G.n11 XCH2LP_P/G.n9 36.1417
R2784 XCH2LP_P/G.n7 XCH2LP_P/G.n15 158.304
R2785 XCH2LP_P/G.n16 XCH2LP_P/G.n17 1.92
R2786 XCH2LP_P/G.n15 XCH2LP_P/G.n16 1.92
R2787 XCH2LP_P/G.n14 XCH2LP_P/G.t4 563.941
R2788 XCH2LP_P/G.n2 XCH2LP_P/G.t4 563.941
R2789 XCH2LP_P/G.t3 XCH2LP_P/G.n12 563.941
R2790 XCH2LP_P/G.n4 XCH2LP_P/G.t3 563.941
R2791 XCH2LP_P/G.t2 XCH2LP_P/G.n10 563.941
R2792 XCH2LP_P/G.n5 XCH2LP_P/G.t2 563.941
R2793 XCH2LP_P/G.t1 XCH2LP_P/G.n8 563.941
R2794 XCH2LP_P/G.n6 XCH2LP_P/G.t1 563.941
R2795 XCH2LP_P/G.n3 ch2_lop_raw 1.8738
R2796 XCH2LP_P/B.n1 XCH2LP_P/B.t2 23.1255
R2797 VDPWR XCH2LP_P/B.n1 23.1255
R2798 XCH2LP_P/B.n0 VDPWR 16.5652
R2799 XCH2LP_P/B.n2 XCH2LP_P/B.n3 15.4172
R2800 XCH2LP_P/B.n0 XCH2LP_P/B.n3 293.272
R2801 XCH2LP_P/B.t2 XCH2LP_P/B.n4 23.1255
R2802 XCH2LP_P/B.n4 XCH2LP_P/B.n5 23.1255
R2803 XCH2LP_P/B.n3 XCH2LP_P/B.n5 309.836
R2804 XCH2LP_P/B.n7 XCH2LP_P/B.n6 15.4172
R2805 VDPWR XCH2LP_P/B.n7 309.836
R2806 XCH2LP_P/B.n7 XCH2LP_P/B.n5 309.836
R2807 XCH2LP_P/B.n1 XCH2LP_P/B.n6 2904.71
R2808 XCH2LP_P/B.n1 XCH2LP_P/B.n2 2904.71
R2809 XCH2LP_P/B.n2 XCH2LP_P/B.n4 2904.71
R2810 XCH2LP_P/B.n4 XCH2LP_P/B.n6 2904.71
R2811 XCH2LP_P/B.t0 XCH2LP_P/B.n2 158.181
R2812 XCH2LP_P/B.t1 XCH2LP_P/B.t0 84.6016
R2813 XCH2LP_P/B.t2 XCH2LP_P/B.t1 84.6016
R2814 XCH2LP_P/B.t2 XCH2LP_P/B.t3 84.6016
R2815 XCH2LP_P/B.t3 XCH2LP_P/B.t4 84.6016
R2816 XCH2LP_P/B.t4 XCH2LP_P/B.n6 158.181
R2817 XLP1_P/S2.n0 VDPWR 3.4293
R2818 VDPWR XLP1_P/S2.t0 170.69
R2819 lp1 XLP1_P/D2.n0 3.3043
R2820 lp1 XLP1_P/D2.n1 146.25
R2821 XLP1_P/D2.n1 XLP1_P/D2.t1 24.4403
R2822 XLP1_P/D2.n1 XLP1_P/D2.t0 24.4403
R2823 XLP1_P/S1.n0 VDPWR 3.4293
R2824 VDPWR XLP1_P/S1.n1 146.25
R2825 XLP1_P/S1.n1 XLP1_P/S1.t1 24.4403
R2826 XLP1_P/S1.n1 XLP1_P/S1.t0 24.4403
R2827 lp1 XLP1_P/D0.n0 3.3043
R2828 lp1 XLP1_P/D0.t0 170.69
R2829 clk XLP1_P/G.n0 6.10787
R2830 clk XLP1_P/G.n0 1.66888
R2831 XLP1_P/G.n1 clk 152
R2832 XLP1_P/G.n2 clk 152
R2833 clk XLP1_P/G.n4 152
R2834 clk XLP1_P/G.n0 6.3031
R2835 XLP1_P/G.n2 XLP1_P/G.n1 70.1096
R2836 XLP1_P/G.n4 XLP1_P/G.n2 70.1096
R2837 XLP1_P/G.n4 XLP1_P/G.t0 263.493
R2838 XLP1_P/G.t2 XLP1_P/G.n3 312.204
R2839 XLP1_P/G.t0 XLP1_P/G.n3 312.204
R2840 XLP1_P/G.n1 XLP1_P/G.t2 263.493
R2841 XLP1_P/G.n3 XLP1_P/G.t1 269.659
R2842 XLP1_P/G.n2 XLP1_P/G.t1 263.493
R2843 XLP1_P/B.n1 XLP1_P/B.t1 37.0005
R2844 VDPWR XLP1_P/B.n1 37.0005
R2845 XLP1_P/B.n0 VDPWR 16.5652
R2846 XLP1_P/B.n3 XLP1_P/B.n2 30.8338
R2847 XLP1_P/B.n0 XLP1_P/B.n3 186.73
R2848 XLP1_P/B.t1 XLP1_P/B.n4 37.0005
R2849 XLP1_P/B.n4 XLP1_P/B.n5 37.0005
R2850 XLP1_P/B.n5 XLP1_P/B.n3 203.294
R2851 XLP1_P/B.n7 XLP1_P/B.n6 30.8338
R2852 VDPWR XLP1_P/B.n7 203.294
R2853 XLP1_P/B.n7 XLP1_P/B.n5 203.294
R2854 XLP1_P/B.n1 XLP1_P/B.n6 1905.88
R2855 XLP1_P/B.n1 XLP1_P/B.n2 1905.88
R2856 XLP1_P/B.n2 XLP1_P/B.n4 1905.88
R2857 XLP1_P/B.n4 XLP1_P/B.n6 1905.88
R2858 XLP1_P/B.n2 XLP1_P/B.t0 249.441
R2859 XLP1_P/B.t1 XLP1_P/B.t0 129.546
R2860 XLP1_P/B.t1 XLP1_P/B.t2 129.546
R2861 XLP1_P/B.t2 XLP1_P/B.n6 249.441
R2862 vcm XRVCMT/R2.n0 0.46195
R2863 XRVCMT/R2.n0 XRVCMT/R2.t0 25.3338
R2864 vcm XRVCMT/R2.n0 8.2161
R2865 XRVCMT/R1.n0 XRVCMT/R1.t0 25.3338
R2866 VDPWR XRVCMT/R1.n0 0.507818
R2867 VDPWR XRVCMT/R1.n0 8.2161
R2868 XRVCMT/B.t0 XRVCMT/B.n0 0.403262
R2869 XRVCMT/B.n1 XRVCMT/B.n2 117.001
R2870 XRVCMT/B.n3 XRVCMT/B.n4 3.87467
R2871 XRVCMT/B.n5 XRVCMT/B.t0 117.001
R2872 VGND XRVCMT/B.n5 117.001
R2873 XRVCMT/B.n6 XRVCMT/B.n7 3.87467
R2874 XRVCMT/B.n7 XRVCMT/B.n8 3.87467
R2875 VGND XRVCMT/B.n6 22.0755
R2876 XRVCMT/B.t0 XRVCMT/B.n6 105.793
R2877 XRVCMT/B.n0 XRVCMT/B.n3 108.889
R2878 XRVCMT/B.n8 VGND 2057.79
R2879 VGND XRVCMT/B.n4 2057.79
R2880 XRVCMT/B.n8 XRVCMT/B.n2 2057.79
R2881 XRVCMT/B.n2 XRVCMT/B.n4 2057.79
R2882 XRVCMT/B.n7 XRVCMT/B.n5 31670.6
R2883 XRVCMT/B.n5 XRVCMT/B.n3 31670.6
R2884 XRVCMT/B.n7 XRVCMT/B.n1 31670.6
R2885 XRVCMT/B.n0 XRVCMT/B.n1 116.169
R2886 VGND XCH1_TAILB/S8.t0 39.0803
R2887 tail1 XCH1_TAILB/D8.n0 1.96626
R2888 tail1 XCH1_TAILB/D8.n1 30.8338
R2889 XCH1_TAILB/D8.n1 XCH1_TAILB/D8.t1 8.24695
R2890 XCH1_TAILB/D8.n1 XCH1_TAILB/D8.t0 8.24695
R2891 VGND XCH1_TAILB/S7.n0 30.8338
R2892 XCH1_TAILB/S7.n0 XCH1_TAILB/S7.t0 8.24695
R2893 XCH1_TAILB/S7.n0 XCH1_TAILB/S7.t1 8.24695
R2894 tail1 XCH1_TAILB/D6.n0 1.96626
R2895 tail1 XCH1_TAILB/D6.n1 30.8338
R2896 XCH1_TAILB/D6.n1 XCH1_TAILB/D6.t1 8.24695
R2897 XCH1_TAILB/D6.n1 XCH1_TAILB/D6.t0 8.24695
R2898 VGND XCH1_TAILB/S5.n0 30.8338
R2899 XCH1_TAILB/S5.n0 XCH1_TAILB/S5.t0 8.24695
R2900 XCH1_TAILB/S5.n0 XCH1_TAILB/S5.t1 8.24695
R2901 tail1 XCH1_TAILB/D4.n0 1.96626
R2902 tail1 XCH1_TAILB/D4.n1 30.8338
R2903 XCH1_TAILB/D4.n1 XCH1_TAILB/D4.t1 8.24695
R2904 XCH1_TAILB/D4.n1 XCH1_TAILB/D4.t0 8.24695
R2905 VGND XCH1_TAILB/S3.n0 30.8338
R2906 XCH1_TAILB/S3.n0 XCH1_TAILB/S3.t1 8.24695
R2907 XCH1_TAILB/S3.n0 XCH1_TAILB/S3.t0 8.24695
R2908 tail1 XCH1_TAILB/D2.n0 1.96626
R2909 tail1 XCH1_TAILB/D2.n1 30.8338
R2910 XCH1_TAILB/D2.n1 XCH1_TAILB/D2.t1 8.24695
R2911 XCH1_TAILB/D2.n1 XCH1_TAILB/D2.t0 8.24695
R2912 VGND XCH1_TAILB/S1.n0 30.8338
R2913 XCH1_TAILB/S1.n0 XCH1_TAILB/S1.t0 8.24695
R2914 XCH1_TAILB/S1.n0 XCH1_TAILB/S1.t1 8.24695
R2915 tail1 XCH1_TAILB/D0.n0 1.96626
R2916 tail1 XCH1_TAILB/D0.t0 39.0803
R2917 vbias XCH1_TAILB/G.n0 9.3005
R2918 vbias XCH1_TAILB/G.n0 0.063
R2919 vbias XCH1_TAILB/G.n1 9.3005
R2920 XCH1_TAILB/G.n1 XCH1_TAILB/G.n0 0.493147
R2921 vbias XCH1_TAILB/G.n2 9.3005
R2922 XCH1_TAILB/G.n2 XCH1_TAILB/G.n1 0.493147
R2923 vbias XCH1_TAILB/G.n3 7.04123
R2924 XCH1_TAILB/G.n3 XCH1_TAILB/G.n2 1.65269
R2925 vbias XCH1_TAILB/G.n4 7.04123
R2926 vbias XCH1_TAILB/G.n5 9.3005
R2927 vbias XCH1_TAILB/G.n6 9.3005
R2928 vbias XCH1_TAILB/G.n4 7.41417
R2929 vbias XCH1_TAILB/G.n3 7.41417
R2930 vbias XCH1_TAILB/G.t0 280.212
R2931 XCH1_TAILB/G.t0 XCH1_TAILB/G.n20 287.627
R2932 XCH1_TAILB/G.n7 XCH1_TAILB/G.n8 7.04123
R2933 XCH1_TAILB/G.n10 XCH1_TAILB/G.n9 9.3005
R2934 XCH1_TAILB/G.n12 XCH1_TAILB/G.n11 9.3005
R2935 XCH1_TAILB/G.n14 XCH1_TAILB/G.n13 9.3005
R2936 XCH1_TAILB/G.n16 XCH1_TAILB/G.n15 9.3005
R2937 XCH1_TAILB/G.n18 XCH1_TAILB/G.n17 9.3005
R2938 XCH1_TAILB/G.n20 XCH1_TAILB/G.n19 7.04123
R2939 XCH1_TAILB/G.n8 XCH1_TAILB/G.n9 59.4829
R2940 XCH1_TAILB/G.n9 XCH1_TAILB/G.n11 59.4829
R2941 XCH1_TAILB/G.n11 XCH1_TAILB/G.n13 59.4829
R2942 XCH1_TAILB/G.n13 XCH1_TAILB/G.n15 59.4829
R2943 XCH1_TAILB/G.n15 XCH1_TAILB/G.n17 59.4829
R2944 XCH1_TAILB/G.n17 XCH1_TAILB/G.n19 59.4829
R2945 XCH1_TAILB/G.n19 XCH1_TAILB/G.t1 280.212
R2946 XCH1_TAILB/G.t1 vbias 280.212
R2947 XCH1_TAILB/G.n17 XCH1_TAILB/G.t2 280.212
R2948 XCH1_TAILB/G.t2 vbias 280.212
R2949 XCH1_TAILB/G.n15 XCH1_TAILB/G.t3 280.212
R2950 XCH1_TAILB/G.t3 vbias 280.212
R2951 XCH1_TAILB/G.n13 XCH1_TAILB/G.t4 280.212
R2952 XCH1_TAILB/G.t4 vbias 280.212
R2953 XCH1_TAILB/G.n11 XCH1_TAILB/G.t5 280.212
R2954 XCH1_TAILB/G.t5 vbias 280.212
R2955 XCH1_TAILB/G.n9 XCH1_TAILB/G.t6 280.212
R2956 XCH1_TAILB/G.t6 vbias 280.212
R2957 XCH1_TAILB/G.n8 XCH1_TAILB/G.t7 280.212
R2958 XCH1_TAILB/G.t7 vbias 280.212
R2959 XCH1_TAILB/G.n20 XCH1_TAILB/G.n18 1.65269
R2960 XCH1_TAILB/G.n18 XCH1_TAILB/G.n16 0.493147
R2961 XCH1_TAILB/G.n16 XCH1_TAILB/G.n14 0.493147
R2962 XCH1_TAILB/G.n14 XCH1_TAILB/G.n12 0.493147
R2963 XCH1_TAILB/G.n12 XCH1_TAILB/G.n10 0.493147
R2964 XCH1_TAILB/G.n10 XCH1_TAILB/G.n7 1.65269
R2965 XCH1_TAILB/G.n7 XCH1_TAILB/G.t8 287.627
R2966 XCH1_TAILB/G.t8 vbias 280.212
R2967 XCH1_TAILB/G.n6 vbias 0.430647
R2968 XCH1_TAILB/G.n5 XCH1_TAILB/G.n6 0.493147
R2969 XCH1_TAILB/G.n4 XCH1_TAILB/G.n5 1.65269
R2970 XCH1_TAILB/B.t4 XCH1_TAILB/B.n0 26.5914
R2971 XCH1_TAILB/B.n0 XCH1_TAILB/B.n1 26.5914
R2972 XCH1_TAILB/B.n3 XCH1_TAILB/B.n2 65.0005
R2973 XCH1_TAILB/B.n4 XCH1_TAILB/B.t4 26.5914
R2974 VGND XCH1_TAILB/B.n4 26.5914
R2975 XCH1_TAILB/B.n6 XCH1_TAILB/B.n5 65.0005
R2976 XCH1_TAILB/B.n7 XCH1_TAILB/B.n6 65.0005
R2977 VGND XCH1_TAILB/B.n5 276.961
R2978 XCH1_TAILB/B.n5 XCH1_TAILB/B.t0 1008.55
R2979 XCH1_TAILB/B.t0 XCH1_TAILB/B.t1 825.654
R2980 XCH1_TAILB/B.t1 XCH1_TAILB/B.t2 825.654
R2981 XCH1_TAILB/B.t3 XCH1_TAILB/B.t2 825.654
R2982 XCH1_TAILB/B.t4 XCH1_TAILB/B.t3 825.654
R2983 XCH1_TAILB/B.t4 XCH1_TAILB/B.t5 825.654
R2984 XCH1_TAILB/B.t5 XCH1_TAILB/B.t6 825.654
R2985 XCH1_TAILB/B.t6 XCH1_TAILB/B.t7 825.654
R2986 XCH1_TAILB/B.t8 XCH1_TAILB/B.t7 825.654
R2987 XCH1_TAILB/B.n2 XCH1_TAILB/B.t8 1073.55
R2988 VGND XCH1_TAILB/B.n7 442.729
R2989 VGND XCH1_TAILB/B.n3 442.729
R2990 XCH1_TAILB/B.n7 XCH1_TAILB/B.n1 442.729
R2991 XCH1_TAILB/B.n1 XCH1_TAILB/B.n3 442.729
R2992 XCH1_TAILB/B.n6 XCH1_TAILB/B.n4 6813.88
R2993 XCH1_TAILB/B.n4 XCH1_TAILB/B.n2 6813.88
R2994 XCH1_TAILB/B.n6 XCH1_TAILB/B.n0 6813.88
R2995 XCH1_TAILB/B.n0 XCH1_TAILB/B.n2 6813.88
R2996 gm2_p XCH2_SW1B/S4.t0 58.6255
R2997 ua[2] XCH2_SW1B/D4.n0 0.277674
R2998 XCH2_SW1B/D4.n1 ua[2] 46.2505
R2999 XCH2_SW1B/D4.t0 XCH2_SW1B/D4.n1 12.3755
R3000 XCH2_SW1B/D4.n1 XCH2_SW1B/D4.t1 12.3755
R3001 gm2_p XCH2_SW1B/S3.n0 46.2505
R3002 XCH2_SW1B/S3.n0 XCH2_SW1B/S3.t1 12.3755
R3003 XCH2_SW1B/S3.n0 XCH2_SW1B/S3.t0 12.3755
R3004 ua[2] XCH2_SW1B/D2.n0 0.277674
R3005 XCH2_SW1B/D2.n1 ua[2] 46.2505
R3006 XCH2_SW1B/D2.t0 XCH2_SW1B/D2.n1 12.3755
R3007 XCH2_SW1B/D2.n1 XCH2_SW1B/D2.t1 12.3755
R3008 gm2_p XCH2_SW1B/S1.n0 46.2505
R3009 XCH2_SW1B/S1.n0 XCH2_SW1B/S1.t0 12.3755
R3010 XCH2_SW1B/S1.n0 XCH2_SW1B/S1.t1 12.3755
R3011 ua[2] XCH2_SW1B/D0.n0 0.277674
R3012 ua[2] XCH2_SW1B/D0.t0 58.6255
R3013 ch2_lop XCH2_SW1B/G.n0 9.3005
R3014 ch2_lop XCH2_SW1B/G.n0 0.0466957
R3015 ch2_lop XCH2_SW1B/G.n1 6.10787
R3016 XCH2_SW1B/G.n1 XCH2_SW1B/G.n0 1.92
R3017 XCH2_SW1B/G.n2 ch2_lop 152
R3018 ch2_lop XCH2_SW1B/G.n3 6.10787
R3019 XCH2_SW1B/G.n4 ch2_lop 152
R3020 XCH2_SW1B/G.n5 ch2_lop 152
R3021 XCH2_SW1B/G.n6 ch2_lop 152
R3022 ch2_lop XCH2_SW1B/G.n18 152
R3023 ch2_lop XCH2_SW1B/G.n3 6.3031
R3024 ch2_lop XCH2_SW1B/G.n1 6.3031
R3025 XCH2_SW1B/G.n4 XCH2_SW1B/G.n2 70.1096
R3026 XCH2_SW1B/G.n5 XCH2_SW1B/G.n4 70.1096
R3027 XCH2_SW1B/G.n6 XCH2_SW1B/G.n5 70.1096
R3028 XCH2_SW1B/G.n18 XCH2_SW1B/G.n6 70.1096
R3029 XCH2_SW1B/G.n18 XCH2_SW1B/G.t0 292.413
R3030 XCH2_SW1B/G.t0 XCH2_SW1B/G.n7 292.413
R3031 XCH2_SW1B/G.n8 XCH2_SW1B/G.n9 152
R3032 XCH2_SW1B/G.n10 XCH2_SW1B/G.n11 152
R3033 XCH2_SW1B/G.n12 XCH2_SW1B/G.n13 152
R3034 XCH2_SW1B/G.n12 XCH2_SW1B/G.n14 70.1096
R3035 XCH2_SW1B/G.n12 XCH2_SW1B/G.n10 70.1096
R3036 XCH2_SW1B/G.n10 XCH2_SW1B/G.n8 70.1096
R3037 XCH2_SW1B/G.n8 XCH2_SW1B/G.n7 70.1096
R3038 XCH2_SW1B/G.n15 XCH2_SW1B/G.n9 6.10787
R3039 XCH2_SW1B/G.n16 XCH2_SW1B/G.n11 9.3005
R3040 XCH2_SW1B/G.n17 XCH2_SW1B/G.n13 6.10787
R3041 XCH2_SW1B/G.n14 XCH2_SW1B/G.n17 158.304
R3042 XCH2_SW1B/G.n13 XCH2_SW1B/G.n11 36.1417
R3043 XCH2_SW1B/G.n11 XCH2_SW1B/G.n9 36.1417
R3044 XCH2_SW1B/G.n7 XCH2_SW1B/G.n15 158.304
R3045 XCH2_SW1B/G.n16 XCH2_SW1B/G.n17 1.92
R3046 XCH2_SW1B/G.n15 XCH2_SW1B/G.n16 1.92
R3047 XCH2_SW1B/G.n14 XCH2_SW1B/G.t4 292.413
R3048 XCH2_SW1B/G.n2 XCH2_SW1B/G.t4 292.413
R3049 XCH2_SW1B/G.t3 XCH2_SW1B/G.n12 292.413
R3050 XCH2_SW1B/G.n4 XCH2_SW1B/G.t3 292.413
R3051 XCH2_SW1B/G.t2 XCH2_SW1B/G.n10 292.413
R3052 XCH2_SW1B/G.n5 XCH2_SW1B/G.t2 292.413
R3053 XCH2_SW1B/G.t1 XCH2_SW1B/G.n8 292.413
R3054 XCH2_SW1B/G.n6 XCH2_SW1B/G.t1 292.413
R3055 XCH2_SW1B/G.n3 ch2_lop 1.8738
R3056 XCH2_SW1B/B.t2 XCH2_SW1B/B.n0 73.1255
R3057 XCH2_SW1B/B.n0 XCH2_SW1B/B.n1 73.1255
R3058 XCH2_SW1B/B.n3 XCH2_SW1B/B.n2 83.5719
R3059 XCH2_SW1B/B.n4 XCH2_SW1B/B.t2 73.1255
R3060 VGND XCH2_SW1B/B.n4 73.1255
R3061 XCH2_SW1B/B.n6 XCH2_SW1B/B.n5 83.5719
R3062 XCH2_SW1B/B.n7 XCH2_SW1B/B.n6 83.5719
R3063 VGND XCH2_SW1B/B.n5 315.135
R3064 XCH2_SW1B/B.n5 XCH2_SW1B/B.t0 963.244
R3065 XCH2_SW1B/B.t1 XCH2_SW1B/B.t0 570.812
R3066 XCH2_SW1B/B.t2 XCH2_SW1B/B.t1 570.812
R3067 XCH2_SW1B/B.t2 XCH2_SW1B/B.t3 570.812
R3068 XCH2_SW1B/B.t3 XCH2_SW1B/B.t4 570.812
R3069 XCH2_SW1B/B.t4 XCH2_SW1B/B.n2 1046.81
R3070 VGND XCH2_SW1B/B.n7 246.213
R3071 VGND XCH2_SW1B/B.n3 246.213
R3072 XCH2_SW1B/B.n7 XCH2_SW1B/B.n1 246.213
R3073 XCH2_SW1B/B.n1 XCH2_SW1B/B.n3 246.213
R3074 XCH2_SW1B/B.n6 XCH2_SW1B/B.n4 3789.35
R3075 XCH2_SW1B/B.n4 XCH2_SW1B/B.n2 3789.35
R3076 XCH2_SW1B/B.n6 XCH2_SW1B/B.n0 3789.35
R3077 XCH2_SW1B/B.n0 XCH2_SW1B/B.n2 3789.35
R3078 VGND XCH2LN_N/S4.t0 58.6255
R3079 ch2_lon XCH2LN_N/D4.n0 0.277674
R3080 XCH2LN_N/D4.n1 ch2_lon 46.2505
R3081 XCH2LN_N/D4.t0 XCH2LN_N/D4.n1 12.3755
R3082 XCH2LN_N/D4.n1 XCH2LN_N/D4.t1 12.3755
R3083 VGND XCH2LN_N/S3.n0 46.2505
R3084 XCH2LN_N/S3.n0 XCH2LN_N/S3.t1 12.3755
R3085 XCH2LN_N/S3.n0 XCH2LN_N/S3.t0 12.3755
R3086 ch2_lon XCH2LN_N/D2.n0 0.277674
R3087 XCH2LN_N/D2.n1 ch2_lon 46.2505
R3088 XCH2LN_N/D2.t0 XCH2LN_N/D2.n1 12.3755
R3089 XCH2LN_N/D2.n1 XCH2LN_N/D2.t1 12.3755
R3090 VGND XCH2LN_N/S1.n0 46.2505
R3091 XCH2LN_N/S1.n0 XCH2LN_N/S1.t0 12.3755
R3092 XCH2LN_N/S1.n0 XCH2LN_N/S1.t1 12.3755
R3093 ch2_lon XCH2LN_N/D0.n0 0.277674
R3094 ch2_lon XCH2LN_N/D0.t0 58.6255
R3095 ch2_lon_raw XCH2LN_N/G.n0 9.3005
R3096 ch2_lon_raw XCH2LN_N/G.n0 0.0466957
R3097 ch2_lon_raw XCH2LN_N/G.n1 6.10787
R3098 XCH2LN_N/G.n1 XCH2LN_N/G.n0 1.92
R3099 XCH2LN_N/G.n2 ch2_lon_raw 152
R3100 ch2_lon_raw XCH2LN_N/G.n3 6.10787
R3101 XCH2LN_N/G.n4 ch2_lon_raw 152
R3102 XCH2LN_N/G.n5 ch2_lon_raw 152
R3103 XCH2LN_N/G.n6 ch2_lon_raw 152
R3104 ch2_lon_raw XCH2LN_N/G.n18 152
R3105 ch2_lon_raw XCH2LN_N/G.n3 6.3031
R3106 ch2_lon_raw XCH2LN_N/G.n1 6.3031
R3107 XCH2LN_N/G.n4 XCH2LN_N/G.n2 70.1096
R3108 XCH2LN_N/G.n5 XCH2LN_N/G.n4 70.1096
R3109 XCH2LN_N/G.n6 XCH2LN_N/G.n5 70.1096
R3110 XCH2LN_N/G.n18 XCH2LN_N/G.n6 70.1096
R3111 XCH2LN_N/G.n18 XCH2LN_N/G.t0 292.413
R3112 XCH2LN_N/G.t0 XCH2LN_N/G.n7 292.413
R3113 XCH2LN_N/G.n8 XCH2LN_N/G.n9 152
R3114 XCH2LN_N/G.n10 XCH2LN_N/G.n11 152
R3115 XCH2LN_N/G.n12 XCH2LN_N/G.n13 152
R3116 XCH2LN_N/G.n12 XCH2LN_N/G.n14 70.1096
R3117 XCH2LN_N/G.n12 XCH2LN_N/G.n10 70.1096
R3118 XCH2LN_N/G.n10 XCH2LN_N/G.n8 70.1096
R3119 XCH2LN_N/G.n8 XCH2LN_N/G.n7 70.1096
R3120 XCH2LN_N/G.n15 XCH2LN_N/G.n9 6.10787
R3121 XCH2LN_N/G.n16 XCH2LN_N/G.n11 9.3005
R3122 XCH2LN_N/G.n17 XCH2LN_N/G.n13 6.10787
R3123 XCH2LN_N/G.n14 XCH2LN_N/G.n17 158.304
R3124 XCH2LN_N/G.n13 XCH2LN_N/G.n11 36.1417
R3125 XCH2LN_N/G.n11 XCH2LN_N/G.n9 36.1417
R3126 XCH2LN_N/G.n7 XCH2LN_N/G.n15 158.304
R3127 XCH2LN_N/G.n16 XCH2LN_N/G.n17 1.92
R3128 XCH2LN_N/G.n15 XCH2LN_N/G.n16 1.92
R3129 XCH2LN_N/G.n14 XCH2LN_N/G.t4 292.413
R3130 XCH2LN_N/G.n2 XCH2LN_N/G.t4 292.413
R3131 XCH2LN_N/G.t3 XCH2LN_N/G.n12 292.413
R3132 XCH2LN_N/G.n4 XCH2LN_N/G.t3 292.413
R3133 XCH2LN_N/G.t2 XCH2LN_N/G.n10 292.413
R3134 XCH2LN_N/G.n5 XCH2LN_N/G.t2 292.413
R3135 XCH2LN_N/G.t1 XCH2LN_N/G.n8 292.413
R3136 XCH2LN_N/G.n6 XCH2LN_N/G.t1 292.413
R3137 XCH2LN_N/G.n3 ch2_lon_raw 1.8738
R3138 XCH2LN_N/B.t2 XCH2LN_N/B.n0 73.1255
R3139 XCH2LN_N/B.n0 XCH2LN_N/B.n1 73.1255
R3140 XCH2LN_N/B.n3 XCH2LN_N/B.n2 83.5719
R3141 XCH2LN_N/B.n4 XCH2LN_N/B.t2 73.1255
R3142 VGND XCH2LN_N/B.n4 73.1255
R3143 XCH2LN_N/B.n6 XCH2LN_N/B.n5 83.5719
R3144 XCH2LN_N/B.n7 XCH2LN_N/B.n6 83.5719
R3145 VGND XCH2LN_N/B.n5 315.135
R3146 XCH2LN_N/B.n5 XCH2LN_N/B.t0 963.244
R3147 XCH2LN_N/B.t1 XCH2LN_N/B.t0 570.812
R3148 XCH2LN_N/B.t2 XCH2LN_N/B.t1 570.812
R3149 XCH2LN_N/B.t2 XCH2LN_N/B.t3 570.812
R3150 XCH2LN_N/B.t3 XCH2LN_N/B.t4 570.812
R3151 XCH2LN_N/B.t4 XCH2LN_N/B.n2 1046.81
R3152 VGND XCH2LN_N/B.n7 246.213
R3153 VGND XCH2LN_N/B.n3 246.213
R3154 XCH2LN_N/B.n7 XCH2LN_N/B.n1 246.213
R3155 XCH2LN_N/B.n1 XCH2LN_N/B.n3 246.213
R3156 XCH2LN_N/B.n6 XCH2LN_N/B.n4 3789.35
R3157 XCH2LN_N/B.n4 XCH2LN_N/B.n2 3789.35
R3158 XCH2LN_N/B.n6 XCH2LN_N/B.n0 3789.35
R3159 XCH2LN_N/B.n0 XCH2LN_N/B.n2 3789.35
R3160 VDPWR XCH2LN_P/S4.t0 75.1583
R3161 ch2_lon XCH2LN_P/D4.n0 1.74579
R3162 ch2_lon XCH2LN_P/D4.n1 65.0005
R3163 XCH2LN_P/D4.n1 XCH2LN_P/D4.t0 10.1583
R3164 XCH2LN_P/D4.n1 XCH2LN_P/D4.t1 10.1583
R3165 VDPWR XCH2LN_P/S3.n0 65.0005
R3166 XCH2LN_P/S3.n0 XCH2LN_P/S3.t0 10.1583
R3167 XCH2LN_P/S3.n0 XCH2LN_P/S3.t1 10.1583
R3168 ch2_lon XCH2LN_P/D2.n0 1.74579
R3169 ch2_lon XCH2LN_P/D2.n1 65.0005
R3170 XCH2LN_P/D2.n1 XCH2LN_P/D2.t1 10.1583
R3171 XCH2LN_P/D2.n1 XCH2LN_P/D2.t0 10.1583
R3172 VDPWR XCH2LN_P/S1.n0 65.0005
R3173 XCH2LN_P/S1.n0 XCH2LN_P/S1.t0 10.1583
R3174 XCH2LN_P/S1.n0 XCH2LN_P/S1.t1 10.1583
R3175 ch2_lon XCH2LN_P/D0.n0 1.74579
R3176 ch2_lon XCH2LN_P/D0.t0 75.1583
R3177 ch2_lon_raw XCH2LN_P/G.n0 9.3005
R3178 ch2_lon_raw XCH2LN_P/G.n0 0.0466957
R3179 ch2_lon_raw XCH2LN_P/G.n1 6.10787
R3180 XCH2LN_P/G.n1 XCH2LN_P/G.n0 1.92
R3181 XCH2LN_P/G.n2 ch2_lon_raw 152
R3182 ch2_lon_raw XCH2LN_P/G.n3 6.10787
R3183 XCH2LN_P/G.n4 ch2_lon_raw 152
R3184 XCH2LN_P/G.n5 ch2_lon_raw 152
R3185 XCH2LN_P/G.n6 ch2_lon_raw 152
R3186 ch2_lon_raw XCH2LN_P/G.n18 152
R3187 ch2_lon_raw XCH2LN_P/G.n3 6.3031
R3188 ch2_lon_raw XCH2LN_P/G.n1 6.3031
R3189 XCH2LN_P/G.n4 XCH2LN_P/G.n2 70.1096
R3190 XCH2LN_P/G.n5 XCH2LN_P/G.n4 70.1096
R3191 XCH2LN_P/G.n6 XCH2LN_P/G.n5 70.1096
R3192 XCH2LN_P/G.n18 XCH2LN_P/G.n6 70.1096
R3193 XCH2LN_P/G.n18 XCH2LN_P/G.t0 563.941
R3194 XCH2LN_P/G.t0 XCH2LN_P/G.n7 563.941
R3195 XCH2LN_P/G.n8 XCH2LN_P/G.n9 152
R3196 XCH2LN_P/G.n10 XCH2LN_P/G.n11 152
R3197 XCH2LN_P/G.n12 XCH2LN_P/G.n13 152
R3198 XCH2LN_P/G.n12 XCH2LN_P/G.n14 70.1096
R3199 XCH2LN_P/G.n12 XCH2LN_P/G.n10 70.1096
R3200 XCH2LN_P/G.n10 XCH2LN_P/G.n8 70.1096
R3201 XCH2LN_P/G.n8 XCH2LN_P/G.n7 70.1096
R3202 XCH2LN_P/G.n15 XCH2LN_P/G.n9 6.10787
R3203 XCH2LN_P/G.n16 XCH2LN_P/G.n11 9.3005
R3204 XCH2LN_P/G.n17 XCH2LN_P/G.n13 6.10787
R3205 XCH2LN_P/G.n14 XCH2LN_P/G.n17 158.304
R3206 XCH2LN_P/G.n13 XCH2LN_P/G.n11 36.1417
R3207 XCH2LN_P/G.n11 XCH2LN_P/G.n9 36.1417
R3208 XCH2LN_P/G.n7 XCH2LN_P/G.n15 158.304
R3209 XCH2LN_P/G.n16 XCH2LN_P/G.n17 1.92
R3210 XCH2LN_P/G.n15 XCH2LN_P/G.n16 1.92
R3211 XCH2LN_P/G.n14 XCH2LN_P/G.t4 563.941
R3212 XCH2LN_P/G.n2 XCH2LN_P/G.t4 563.941
R3213 XCH2LN_P/G.t3 XCH2LN_P/G.n12 563.941
R3214 XCH2LN_P/G.n4 XCH2LN_P/G.t3 563.941
R3215 XCH2LN_P/G.t2 XCH2LN_P/G.n10 563.941
R3216 XCH2LN_P/G.n5 XCH2LN_P/G.t2 563.941
R3217 XCH2LN_P/G.t1 XCH2LN_P/G.n8 563.941
R3218 XCH2LN_P/G.n6 XCH2LN_P/G.t1 563.941
R3219 XCH2LN_P/G.n3 ch2_lon_raw 1.8738
R3220 XCH2LN_P/B.n1 XCH2LN_P/B.t2 23.1255
R3221 VDPWR XCH2LN_P/B.n1 23.1255
R3222 XCH2LN_P/B.n0 VDPWR 16.5652
R3223 XCH2LN_P/B.n2 XCH2LN_P/B.n3 15.4172
R3224 XCH2LN_P/B.n0 XCH2LN_P/B.n3 293.272
R3225 XCH2LN_P/B.t2 XCH2LN_P/B.n4 23.1255
R3226 XCH2LN_P/B.n4 XCH2LN_P/B.n5 23.1255
R3227 XCH2LN_P/B.n3 XCH2LN_P/B.n5 309.836
R3228 XCH2LN_P/B.n7 XCH2LN_P/B.n6 15.4172
R3229 VDPWR XCH2LN_P/B.n7 309.836
R3230 XCH2LN_P/B.n7 XCH2LN_P/B.n5 309.836
R3231 XCH2LN_P/B.n1 XCH2LN_P/B.n6 2904.71
R3232 XCH2LN_P/B.n1 XCH2LN_P/B.n2 2904.71
R3233 XCH2LN_P/B.n2 XCH2LN_P/B.n4 2904.71
R3234 XCH2LN_P/B.n4 XCH2LN_P/B.n6 2904.71
R3235 XCH2LN_P/B.t0 XCH2LN_P/B.n2 158.181
R3236 XCH2LN_P/B.t1 XCH2LN_P/B.t0 84.6016
R3237 XCH2LN_P/B.t2 XCH2LN_P/B.t1 84.6016
R3238 XCH2LN_P/B.t2 XCH2LN_P/B.t3 84.6016
R3239 XCH2LN_P/B.t3 XCH2LN_P/B.t4 84.6016
R3240 XCH2LN_P/B.t4 XCH2LN_P/B.n6 158.181
R3241 VGND XLN3_N/S8.t0 48.1241
R3242 lon XLN3_N/D8.n0 37.0005
R3243 XLN3_N/D8.n0 XLN3_N/D8.t0 11.1241
R3244 XLN3_N/D8.n0 XLN3_N/D8.t1 11.1241
R3245 VGND XLN3_N/S7.n0 37.0005
R3246 XLN3_N/S7.n0 XLN3_N/S7.t0 11.1241
R3247 XLN3_N/S7.n0 XLN3_N/S7.t1 11.1241
R3248 lon XLN3_N/D6.n0 37.0005
R3249 XLN3_N/D6.n0 XLN3_N/D6.t1 11.1241
R3250 XLN3_N/D6.n0 XLN3_N/D6.t0 11.1241
R3251 VGND XLN3_N/S5.n0 37.0005
R3252 XLN3_N/S5.n0 XLN3_N/S5.t0 11.1241
R3253 XLN3_N/S5.n0 XLN3_N/S5.t1 11.1241
R3254 lon XLN3_N/D4.n0 37.0005
R3255 XLN3_N/D4.n0 XLN3_N/D4.t0 11.1241
R3256 XLN3_N/D4.n0 XLN3_N/D4.t1 11.1241
R3257 VGND XLN3_N/S3.n0 37.0005
R3258 XLN3_N/S3.n0 XLN3_N/S3.t1 11.1241
R3259 XLN3_N/S3.n0 XLN3_N/S3.t0 11.1241
R3260 lon XLN3_N/D2.n0 37.0005
R3261 XLN3_N/D2.n0 XLN3_N/D2.t0 11.1241
R3262 XLN3_N/D2.n0 XLN3_N/D2.t1 11.1241
R3263 VGND XLN3_N/S1.n0 37.0005
R3264 XLN3_N/S1.n0 XLN3_N/S1.t1 11.1241
R3265 XLN3_N/S1.n0 XLN3_N/S1.t0 11.1241
R3266 lon XLN3_N/D0.t0 48.1241
R3267 ln2 XLN3_N/G.n0 9.3005
R3268 ln2 XLN3_N/G.n0 0.0466957
R3269 ln2 XLN3_N/G.n1 9.3005
R3270 XLN3_N/G.n1 XLN3_N/G.n0 0.297815
R3271 ln2 XLN3_N/G.n2 9.3005
R3272 XLN3_N/G.n2 XLN3_N/G.n1 0.297815
R3273 ln2 XLN3_N/G.n3 6.10787
R3274 XLN3_N/G.n3 XLN3_N/G.n2 1.92
R3275 XLN3_N/G.n4 ln2 152
R3276 ln2 XLN3_N/G.n5 6.10787
R3277 ln2 XLN3_N/G.n6 9.3005
R3278 ln2 XLN3_N/G.n7 9.3005
R3279 XLN3_N/G.n8 ln2 152
R3280 XLN3_N/G.n9 ln2 152
R3281 XLN3_N/G.n10 ln2 152
R3282 XLN3_N/G.n11 ln2 152
R3283 XLN3_N/G.n12 ln2 152
R3284 XLN3_N/G.n13 ln2 152
R3285 XLN3_N/G.n14 ln2 152
R3286 ln2 XLN3_N/G.n38 152
R3287 ln2 XLN3_N/G.n5 6.3031
R3288 ln2 XLN3_N/G.n3 6.3031
R3289 XLN3_N/G.n8 XLN3_N/G.n4 70.1096
R3290 XLN3_N/G.n9 XLN3_N/G.n8 70.1096
R3291 XLN3_N/G.n10 XLN3_N/G.n9 70.1096
R3292 XLN3_N/G.n11 XLN3_N/G.n10 70.1096
R3293 XLN3_N/G.n12 XLN3_N/G.n11 70.1096
R3294 XLN3_N/G.n13 XLN3_N/G.n12 70.1096
R3295 XLN3_N/G.n14 XLN3_N/G.n13 70.1096
R3296 XLN3_N/G.n38 XLN3_N/G.n14 70.1096
R3297 XLN3_N/G.n38 XLN3_N/G.t0 321.334
R3298 XLN3_N/G.t0 XLN3_N/G.n15 321.334
R3299 XLN3_N/G.n16 XLN3_N/G.n17 152
R3300 XLN3_N/G.n18 XLN3_N/G.n19 152
R3301 XLN3_N/G.n20 XLN3_N/G.n21 152
R3302 XLN3_N/G.n22 XLN3_N/G.n23 152
R3303 XLN3_N/G.n25 XLN3_N/G.n24 152
R3304 XLN3_N/G.n27 XLN3_N/G.n26 152
R3305 XLN3_N/G.n29 XLN3_N/G.n28 152
R3306 XLN3_N/G.n30 XLN3_N/G.n28 70.1096
R3307 XLN3_N/G.n28 XLN3_N/G.n26 70.1096
R3308 XLN3_N/G.n26 XLN3_N/G.n24 70.1096
R3309 XLN3_N/G.n24 XLN3_N/G.n22 70.1096
R3310 XLN3_N/G.n22 XLN3_N/G.n20 70.1096
R3311 XLN3_N/G.n18 XLN3_N/G.n20 70.1096
R3312 XLN3_N/G.n18 XLN3_N/G.n16 70.1096
R3313 XLN3_N/G.n15 XLN3_N/G.n16 70.1096
R3314 XLN3_N/G.n31 XLN3_N/G.n17 6.10787
R3315 XLN3_N/G.n32 XLN3_N/G.n19 9.3005
R3316 XLN3_N/G.n33 XLN3_N/G.n21 9.3005
R3317 XLN3_N/G.n34 XLN3_N/G.n23 9.3005
R3318 XLN3_N/G.n35 XLN3_N/G.n25 9.3005
R3319 XLN3_N/G.n36 XLN3_N/G.n27 9.3005
R3320 XLN3_N/G.n37 XLN3_N/G.n29 6.10787
R3321 XLN3_N/G.n37 XLN3_N/G.n30 158.304
R3322 XLN3_N/G.n29 XLN3_N/G.n27 36.1417
R3323 XLN3_N/G.n27 XLN3_N/G.n25 36.1417
R3324 XLN3_N/G.n25 XLN3_N/G.n23 36.1417
R3325 XLN3_N/G.n23 XLN3_N/G.n21 36.1417
R3326 XLN3_N/G.n21 XLN3_N/G.n19 36.1417
R3327 XLN3_N/G.n19 XLN3_N/G.n17 36.1417
R3328 XLN3_N/G.n15 XLN3_N/G.n31 158.304
R3329 XLN3_N/G.n36 XLN3_N/G.n37 1.92
R3330 XLN3_N/G.n35 XLN3_N/G.n36 0.297815
R3331 XLN3_N/G.n34 XLN3_N/G.n35 0.297815
R3332 XLN3_N/G.n33 XLN3_N/G.n34 0.297815
R3333 XLN3_N/G.n32 XLN3_N/G.n33 0.297815
R3334 XLN3_N/G.n31 XLN3_N/G.n32 1.92
R3335 XLN3_N/G.n30 XLN3_N/G.t8 321.334
R3336 XLN3_N/G.n4 XLN3_N/G.t8 321.334
R3337 XLN3_N/G.n28 XLN3_N/G.t7 321.334
R3338 XLN3_N/G.n8 XLN3_N/G.t7 321.334
R3339 XLN3_N/G.n26 XLN3_N/G.t6 321.334
R3340 XLN3_N/G.n9 XLN3_N/G.t6 321.334
R3341 XLN3_N/G.n24 XLN3_N/G.t5 321.334
R3342 XLN3_N/G.n10 XLN3_N/G.t5 321.334
R3343 XLN3_N/G.t4 XLN3_N/G.n22 321.334
R3344 XLN3_N/G.n11 XLN3_N/G.t4 321.334
R3345 XLN3_N/G.n20 XLN3_N/G.t3 321.334
R3346 XLN3_N/G.n12 XLN3_N/G.t3 321.334
R3347 XLN3_N/G.t2 XLN3_N/G.n18 321.334
R3348 XLN3_N/G.n13 XLN3_N/G.t2 321.334
R3349 XLN3_N/G.n16 XLN3_N/G.t1 321.334
R3350 XLN3_N/G.n14 XLN3_N/G.t1 321.334
R3351 XLN3_N/G.n7 ln2 0.251619
R3352 XLN3_N/G.n6 XLN3_N/G.n7 0.297815
R3353 XLN3_N/G.n5 XLN3_N/G.n6 1.92
R3354 XLN3_N/B.t4 XLN3_N/B.n0 41.7862
R3355 XLN3_N/B.n0 XLN3_N/B.n1 41.7862
R3356 XLN3_N/B.n3 XLN3_N/B.n2 73.1255
R3357 XLN3_N/B.n4 XLN3_N/B.t4 41.7862
R3358 VGND XLN3_N/B.n4 41.7862
R3359 XLN3_N/B.n6 XLN3_N/B.n5 73.1255
R3360 XLN3_N/B.n7 XLN3_N/B.n6 73.1255
R3361 VGND XLN3_N/B.n5 300.515
R3362 XLN3_N/B.n5 XLN3_N/B.t0 918.558
R3363 XLN3_N/B.t0 XLN3_N/B.t1 544.331
R3364 XLN3_N/B.t2 XLN3_N/B.t1 544.331
R3365 XLN3_N/B.t3 XLN3_N/B.t2 544.331
R3366 XLN3_N/B.t4 XLN3_N/B.t3 544.331
R3367 XLN3_N/B.t4 XLN3_N/B.t5 544.331
R3368 XLN3_N/B.t5 XLN3_N/B.t6 544.331
R3369 XLN3_N/B.t6 XLN3_N/B.t7 544.331
R3370 XLN3_N/B.t7 XLN3_N/B.t8 544.331
R3371 XLN3_N/B.n2 XLN3_N/B.t8 991.683
R3372 VGND XLN3_N/B.n7 325.272
R3373 VGND XLN3_N/B.n3 325.272
R3374 XLN3_N/B.n7 XLN3_N/B.n1 325.272
R3375 XLN3_N/B.n1 XLN3_N/B.n3 325.272
R3376 XLN3_N/B.n6 XLN3_N/B.n4 5006.12
R3377 XLN3_N/B.n4 XLN3_N/B.n2 5006.12
R3378 XLN3_N/B.n6 XLN3_N/B.n0 5006.12
R3379 XLN3_N/B.n0 XLN3_N/B.n2 5006.12
R3380 gm1_n XCH1_SW4A/S4.t0 58.6255
R3381 ua[2] XCH1_SW4A/D4.n0 0.277674
R3382 XCH1_SW4A/D4.n1 ua[2] 46.2505
R3383 XCH1_SW4A/D4.t0 XCH1_SW4A/D4.n1 12.3755
R3384 XCH1_SW4A/D4.n1 XCH1_SW4A/D4.t1 12.3755
R3385 gm1_n XCH1_SW4A/S3.n0 46.2505
R3386 XCH1_SW4A/S3.n0 XCH1_SW4A/S3.t1 12.3755
R3387 XCH1_SW4A/S3.n0 XCH1_SW4A/S3.t0 12.3755
R3388 ua[2] XCH1_SW4A/D2.n0 0.277674
R3389 XCH1_SW4A/D2.n1 ua[2] 46.2505
R3390 XCH1_SW4A/D2.t0 XCH1_SW4A/D2.n1 12.3755
R3391 XCH1_SW4A/D2.n1 XCH1_SW4A/D2.t1 12.3755
R3392 gm1_n XCH1_SW4A/S1.n0 46.2505
R3393 XCH1_SW4A/S1.n0 XCH1_SW4A/S1.t0 12.3755
R3394 XCH1_SW4A/S1.n0 XCH1_SW4A/S1.t1 12.3755
R3395 ua[2] XCH1_SW4A/D0.n0 0.277674
R3396 ua[2] XCH1_SW4A/D0.t0 58.6255
R3397 ch1_lon XCH1_SW4A/G.n0 9.3005
R3398 ch1_lon XCH1_SW4A/G.n0 0.0466957
R3399 ch1_lon XCH1_SW4A/G.n1 6.10787
R3400 XCH1_SW4A/G.n1 XCH1_SW4A/G.n0 1.92
R3401 XCH1_SW4A/G.n2 ch1_lon 152
R3402 ch1_lon XCH1_SW4A/G.n3 6.10787
R3403 XCH1_SW4A/G.n4 ch1_lon 152
R3404 XCH1_SW4A/G.n5 ch1_lon 152
R3405 XCH1_SW4A/G.n6 ch1_lon 152
R3406 ch1_lon XCH1_SW4A/G.n18 152
R3407 ch1_lon XCH1_SW4A/G.n3 6.3031
R3408 ch1_lon XCH1_SW4A/G.n1 6.3031
R3409 XCH1_SW4A/G.n4 XCH1_SW4A/G.n2 70.1096
R3410 XCH1_SW4A/G.n5 XCH1_SW4A/G.n4 70.1096
R3411 XCH1_SW4A/G.n6 XCH1_SW4A/G.n5 70.1096
R3412 XCH1_SW4A/G.n18 XCH1_SW4A/G.n6 70.1096
R3413 XCH1_SW4A/G.n18 XCH1_SW4A/G.t0 292.413
R3414 XCH1_SW4A/G.t0 XCH1_SW4A/G.n7 292.413
R3415 XCH1_SW4A/G.n8 XCH1_SW4A/G.n9 152
R3416 XCH1_SW4A/G.n10 XCH1_SW4A/G.n11 152
R3417 XCH1_SW4A/G.n12 XCH1_SW4A/G.n13 152
R3418 XCH1_SW4A/G.n12 XCH1_SW4A/G.n14 70.1096
R3419 XCH1_SW4A/G.n12 XCH1_SW4A/G.n10 70.1096
R3420 XCH1_SW4A/G.n10 XCH1_SW4A/G.n8 70.1096
R3421 XCH1_SW4A/G.n8 XCH1_SW4A/G.n7 70.1096
R3422 XCH1_SW4A/G.n15 XCH1_SW4A/G.n9 6.10787
R3423 XCH1_SW4A/G.n16 XCH1_SW4A/G.n11 9.3005
R3424 XCH1_SW4A/G.n17 XCH1_SW4A/G.n13 6.10787
R3425 XCH1_SW4A/G.n14 XCH1_SW4A/G.n17 158.304
R3426 XCH1_SW4A/G.n13 XCH1_SW4A/G.n11 36.1417
R3427 XCH1_SW4A/G.n11 XCH1_SW4A/G.n9 36.1417
R3428 XCH1_SW4A/G.n7 XCH1_SW4A/G.n15 158.304
R3429 XCH1_SW4A/G.n16 XCH1_SW4A/G.n17 1.92
R3430 XCH1_SW4A/G.n15 XCH1_SW4A/G.n16 1.92
R3431 XCH1_SW4A/G.n14 XCH1_SW4A/G.t4 292.413
R3432 XCH1_SW4A/G.n2 XCH1_SW4A/G.t4 292.413
R3433 XCH1_SW4A/G.t3 XCH1_SW4A/G.n12 292.413
R3434 XCH1_SW4A/G.n4 XCH1_SW4A/G.t3 292.413
R3435 XCH1_SW4A/G.t2 XCH1_SW4A/G.n10 292.413
R3436 XCH1_SW4A/G.n5 XCH1_SW4A/G.t2 292.413
R3437 XCH1_SW4A/G.t1 XCH1_SW4A/G.n8 292.413
R3438 XCH1_SW4A/G.n6 XCH1_SW4A/G.t1 292.413
R3439 XCH1_SW4A/G.n3 ch1_lon 1.8738
R3440 XCH1_SW4A/B.t2 XCH1_SW4A/B.n0 73.1255
R3441 XCH1_SW4A/B.n0 XCH1_SW4A/B.n1 73.1255
R3442 XCH1_SW4A/B.n3 XCH1_SW4A/B.n2 83.5719
R3443 XCH1_SW4A/B.n4 XCH1_SW4A/B.t2 73.1255
R3444 VGND XCH1_SW4A/B.n4 73.1255
R3445 XCH1_SW4A/B.n6 XCH1_SW4A/B.n5 83.5719
R3446 XCH1_SW4A/B.n7 XCH1_SW4A/B.n6 83.5719
R3447 VGND XCH1_SW4A/B.n5 315.135
R3448 XCH1_SW4A/B.n5 XCH1_SW4A/B.t0 963.244
R3449 XCH1_SW4A/B.t1 XCH1_SW4A/B.t0 570.812
R3450 XCH1_SW4A/B.t2 XCH1_SW4A/B.t1 570.812
R3451 XCH1_SW4A/B.t2 XCH1_SW4A/B.t3 570.812
R3452 XCH1_SW4A/B.t3 XCH1_SW4A/B.t4 570.812
R3453 XCH1_SW4A/B.t4 XCH1_SW4A/B.n2 1046.81
R3454 VGND XCH1_SW4A/B.n7 246.213
R3455 VGND XCH1_SW4A/B.n3 246.213
R3456 XCH1_SW4A/B.n7 XCH1_SW4A/B.n1 246.213
R3457 XCH1_SW4A/B.n1 XCH1_SW4A/B.n3 246.213
R3458 XCH1_SW4A/B.n6 XCH1_SW4A/B.n4 3789.35
R3459 XCH1_SW4A/B.n4 XCH1_SW4A/B.n2 3789.35
R3460 XCH1_SW4A/B.n6 XCH1_SW4A/B.n0 3789.35
R3461 XCH1_SW4A/B.n0 XCH1_SW4A/B.n2 3789.35
R3462 gm1_n XCH1_SW4B/S4.t0 58.6255
R3463 ua[2] XCH1_SW4B/D4.n0 0.277674
R3464 XCH1_SW4B/D4.n1 ua[2] 46.2505
R3465 XCH1_SW4B/D4.t0 XCH1_SW4B/D4.n1 12.3755
R3466 XCH1_SW4B/D4.n1 XCH1_SW4B/D4.t1 12.3755
R3467 gm1_n XCH1_SW4B/S3.n0 46.2505
R3468 XCH1_SW4B/S3.n0 XCH1_SW4B/S3.t1 12.3755
R3469 XCH1_SW4B/S3.n0 XCH1_SW4B/S3.t0 12.3755
R3470 ua[2] XCH1_SW4B/D2.n0 0.277674
R3471 XCH1_SW4B/D2.n1 ua[2] 46.2505
R3472 XCH1_SW4B/D2.t0 XCH1_SW4B/D2.n1 12.3755
R3473 XCH1_SW4B/D2.n1 XCH1_SW4B/D2.t1 12.3755
R3474 gm1_n XCH1_SW4B/S1.n0 46.2505
R3475 XCH1_SW4B/S1.n0 XCH1_SW4B/S1.t0 12.3755
R3476 XCH1_SW4B/S1.n0 XCH1_SW4B/S1.t1 12.3755
R3477 ua[2] XCH1_SW4B/D0.n0 0.277674
R3478 ua[2] XCH1_SW4B/D0.t0 58.6255
R3479 ch1_lon XCH1_SW4B/G.n0 9.3005
R3480 ch1_lon XCH1_SW4B/G.n0 0.0466957
R3481 ch1_lon XCH1_SW4B/G.n1 6.10787
R3482 XCH1_SW4B/G.n1 XCH1_SW4B/G.n0 1.92
R3483 XCH1_SW4B/G.n2 ch1_lon 152
R3484 ch1_lon XCH1_SW4B/G.n3 6.10787
R3485 XCH1_SW4B/G.n4 ch1_lon 152
R3486 XCH1_SW4B/G.n5 ch1_lon 152
R3487 XCH1_SW4B/G.n6 ch1_lon 152
R3488 ch1_lon XCH1_SW4B/G.n18 152
R3489 ch1_lon XCH1_SW4B/G.n3 6.3031
R3490 ch1_lon XCH1_SW4B/G.n1 6.3031
R3491 XCH1_SW4B/G.n4 XCH1_SW4B/G.n2 70.1096
R3492 XCH1_SW4B/G.n5 XCH1_SW4B/G.n4 70.1096
R3493 XCH1_SW4B/G.n6 XCH1_SW4B/G.n5 70.1096
R3494 XCH1_SW4B/G.n18 XCH1_SW4B/G.n6 70.1096
R3495 XCH1_SW4B/G.n18 XCH1_SW4B/G.t0 292.413
R3496 XCH1_SW4B/G.t0 XCH1_SW4B/G.n7 292.413
R3497 XCH1_SW4B/G.n8 XCH1_SW4B/G.n9 152
R3498 XCH1_SW4B/G.n10 XCH1_SW4B/G.n11 152
R3499 XCH1_SW4B/G.n12 XCH1_SW4B/G.n13 152
R3500 XCH1_SW4B/G.n12 XCH1_SW4B/G.n14 70.1096
R3501 XCH1_SW4B/G.n12 XCH1_SW4B/G.n10 70.1096
R3502 XCH1_SW4B/G.n10 XCH1_SW4B/G.n8 70.1096
R3503 XCH1_SW4B/G.n8 XCH1_SW4B/G.n7 70.1096
R3504 XCH1_SW4B/G.n15 XCH1_SW4B/G.n9 6.10787
R3505 XCH1_SW4B/G.n16 XCH1_SW4B/G.n11 9.3005
R3506 XCH1_SW4B/G.n17 XCH1_SW4B/G.n13 6.10787
R3507 XCH1_SW4B/G.n14 XCH1_SW4B/G.n17 158.304
R3508 XCH1_SW4B/G.n13 XCH1_SW4B/G.n11 36.1417
R3509 XCH1_SW4B/G.n11 XCH1_SW4B/G.n9 36.1417
R3510 XCH1_SW4B/G.n7 XCH1_SW4B/G.n15 158.304
R3511 XCH1_SW4B/G.n16 XCH1_SW4B/G.n17 1.92
R3512 XCH1_SW4B/G.n15 XCH1_SW4B/G.n16 1.92
R3513 XCH1_SW4B/G.n14 XCH1_SW4B/G.t4 292.413
R3514 XCH1_SW4B/G.n2 XCH1_SW4B/G.t4 292.413
R3515 XCH1_SW4B/G.t3 XCH1_SW4B/G.n12 292.413
R3516 XCH1_SW4B/G.n4 XCH1_SW4B/G.t3 292.413
R3517 XCH1_SW4B/G.t2 XCH1_SW4B/G.n10 292.413
R3518 XCH1_SW4B/G.n5 XCH1_SW4B/G.t2 292.413
R3519 XCH1_SW4B/G.t1 XCH1_SW4B/G.n8 292.413
R3520 XCH1_SW4B/G.n6 XCH1_SW4B/G.t1 292.413
R3521 XCH1_SW4B/G.n3 ch1_lon 1.8738
R3522 XCH1_SW4B/B.t2 XCH1_SW4B/B.n0 73.1255
R3523 XCH1_SW4B/B.n0 XCH1_SW4B/B.n1 73.1255
R3524 XCH1_SW4B/B.n3 XCH1_SW4B/B.n2 83.5719
R3525 XCH1_SW4B/B.n4 XCH1_SW4B/B.t2 73.1255
R3526 VGND XCH1_SW4B/B.n4 73.1255
R3527 XCH1_SW4B/B.n6 XCH1_SW4B/B.n5 83.5719
R3528 XCH1_SW4B/B.n7 XCH1_SW4B/B.n6 83.5719
R3529 VGND XCH1_SW4B/B.n5 315.135
R3530 XCH1_SW4B/B.n5 XCH1_SW4B/B.t0 963.244
R3531 XCH1_SW4B/B.t1 XCH1_SW4B/B.t0 570.812
R3532 XCH1_SW4B/B.t2 XCH1_SW4B/B.t1 570.812
R3533 XCH1_SW4B/B.t2 XCH1_SW4B/B.t3 570.812
R3534 XCH1_SW4B/B.t3 XCH1_SW4B/B.t4 570.812
R3535 XCH1_SW4B/B.t4 XCH1_SW4B/B.n2 1046.81
R3536 VGND XCH1_SW4B/B.n7 246.213
R3537 VGND XCH1_SW4B/B.n3 246.213
R3538 XCH1_SW4B/B.n7 XCH1_SW4B/B.n1 246.213
R3539 XCH1_SW4B/B.n1 XCH1_SW4B/B.n3 246.213
R3540 XCH1_SW4B/B.n6 XCH1_SW4B/B.n4 3789.35
R3541 XCH1_SW4B/B.n4 XCH1_SW4B/B.n2 3789.35
R3542 XCH1_SW4B/B.n6 XCH1_SW4B/B.n0 3789.35
R3543 XCH1_SW4B/B.n0 XCH1_SW4B/B.n2 3789.35
R3544 gm1_n XCH1_SW3A/S4.t0 58.6255
R3545 ua[3] XCH1_SW3A/D4.n0 0.277674
R3546 XCH1_SW3A/D4.n1 ua[3] 46.2505
R3547 XCH1_SW3A/D4.t0 XCH1_SW3A/D4.n1 12.3755
R3548 XCH1_SW3A/D4.n1 XCH1_SW3A/D4.t1 12.3755
R3549 gm1_n XCH1_SW3A/S3.n0 46.2505
R3550 XCH1_SW3A/S3.n0 XCH1_SW3A/S3.t1 12.3755
R3551 XCH1_SW3A/S3.n0 XCH1_SW3A/S3.t0 12.3755
R3552 ua[3] XCH1_SW3A/D2.n0 0.277674
R3553 XCH1_SW3A/D2.n1 ua[3] 46.2505
R3554 XCH1_SW3A/D2.t0 XCH1_SW3A/D2.n1 12.3755
R3555 XCH1_SW3A/D2.n1 XCH1_SW3A/D2.t1 12.3755
R3556 gm1_n XCH1_SW3A/S1.n0 46.2505
R3557 XCH1_SW3A/S1.n0 XCH1_SW3A/S1.t0 12.3755
R3558 XCH1_SW3A/S1.n0 XCH1_SW3A/S1.t1 12.3755
R3559 ua[3] XCH1_SW3A/D0.n0 0.277674
R3560 ua[3] XCH1_SW3A/D0.t0 58.6255
R3561 ch1_lop XCH1_SW3A/G.n0 9.3005
R3562 ch1_lop XCH1_SW3A/G.n0 0.0466957
R3563 ch1_lop XCH1_SW3A/G.n1 6.10787
R3564 XCH1_SW3A/G.n1 XCH1_SW3A/G.n0 1.92
R3565 XCH1_SW3A/G.n2 ch1_lop 152
R3566 ch1_lop XCH1_SW3A/G.n3 6.10787
R3567 XCH1_SW3A/G.n4 ch1_lop 152
R3568 XCH1_SW3A/G.n5 ch1_lop 152
R3569 XCH1_SW3A/G.n6 ch1_lop 152
R3570 ch1_lop XCH1_SW3A/G.n18 152
R3571 ch1_lop XCH1_SW3A/G.n3 6.3031
R3572 ch1_lop XCH1_SW3A/G.n1 6.3031
R3573 XCH1_SW3A/G.n4 XCH1_SW3A/G.n2 70.1096
R3574 XCH1_SW3A/G.n5 XCH1_SW3A/G.n4 70.1096
R3575 XCH1_SW3A/G.n6 XCH1_SW3A/G.n5 70.1096
R3576 XCH1_SW3A/G.n18 XCH1_SW3A/G.n6 70.1096
R3577 XCH1_SW3A/G.n18 XCH1_SW3A/G.t0 292.413
R3578 XCH1_SW3A/G.t0 XCH1_SW3A/G.n7 292.413
R3579 XCH1_SW3A/G.n8 XCH1_SW3A/G.n9 152
R3580 XCH1_SW3A/G.n10 XCH1_SW3A/G.n11 152
R3581 XCH1_SW3A/G.n12 XCH1_SW3A/G.n13 152
R3582 XCH1_SW3A/G.n12 XCH1_SW3A/G.n14 70.1096
R3583 XCH1_SW3A/G.n12 XCH1_SW3A/G.n10 70.1096
R3584 XCH1_SW3A/G.n10 XCH1_SW3A/G.n8 70.1096
R3585 XCH1_SW3A/G.n8 XCH1_SW3A/G.n7 70.1096
R3586 XCH1_SW3A/G.n15 XCH1_SW3A/G.n9 6.10787
R3587 XCH1_SW3A/G.n16 XCH1_SW3A/G.n11 9.3005
R3588 XCH1_SW3A/G.n17 XCH1_SW3A/G.n13 6.10787
R3589 XCH1_SW3A/G.n14 XCH1_SW3A/G.n17 158.304
R3590 XCH1_SW3A/G.n13 XCH1_SW3A/G.n11 36.1417
R3591 XCH1_SW3A/G.n11 XCH1_SW3A/G.n9 36.1417
R3592 XCH1_SW3A/G.n7 XCH1_SW3A/G.n15 158.304
R3593 XCH1_SW3A/G.n16 XCH1_SW3A/G.n17 1.92
R3594 XCH1_SW3A/G.n15 XCH1_SW3A/G.n16 1.92
R3595 XCH1_SW3A/G.n14 XCH1_SW3A/G.t4 292.413
R3596 XCH1_SW3A/G.n2 XCH1_SW3A/G.t4 292.413
R3597 XCH1_SW3A/G.t3 XCH1_SW3A/G.n12 292.413
R3598 XCH1_SW3A/G.n4 XCH1_SW3A/G.t3 292.413
R3599 XCH1_SW3A/G.t2 XCH1_SW3A/G.n10 292.413
R3600 XCH1_SW3A/G.n5 XCH1_SW3A/G.t2 292.413
R3601 XCH1_SW3A/G.t1 XCH1_SW3A/G.n8 292.413
R3602 XCH1_SW3A/G.n6 XCH1_SW3A/G.t1 292.413
R3603 XCH1_SW3A/G.n3 ch1_lop 1.8738
R3604 XCH1_SW3A/B.t2 XCH1_SW3A/B.n0 73.1255
R3605 XCH1_SW3A/B.n0 XCH1_SW3A/B.n1 73.1255
R3606 XCH1_SW3A/B.n3 XCH1_SW3A/B.n2 83.5719
R3607 XCH1_SW3A/B.n4 XCH1_SW3A/B.t2 73.1255
R3608 VGND XCH1_SW3A/B.n4 73.1255
R3609 XCH1_SW3A/B.n6 XCH1_SW3A/B.n5 83.5719
R3610 XCH1_SW3A/B.n7 XCH1_SW3A/B.n6 83.5719
R3611 VGND XCH1_SW3A/B.n5 315.135
R3612 XCH1_SW3A/B.n5 XCH1_SW3A/B.t0 963.244
R3613 XCH1_SW3A/B.t1 XCH1_SW3A/B.t0 570.812
R3614 XCH1_SW3A/B.t2 XCH1_SW3A/B.t1 570.812
R3615 XCH1_SW3A/B.t2 XCH1_SW3A/B.t3 570.812
R3616 XCH1_SW3A/B.t3 XCH1_SW3A/B.t4 570.812
R3617 XCH1_SW3A/B.t4 XCH1_SW3A/B.n2 1046.81
R3618 VGND XCH1_SW3A/B.n7 246.213
R3619 VGND XCH1_SW3A/B.n3 246.213
R3620 XCH1_SW3A/B.n7 XCH1_SW3A/B.n1 246.213
R3621 XCH1_SW3A/B.n1 XCH1_SW3A/B.n3 246.213
R3622 XCH1_SW3A/B.n6 XCH1_SW3A/B.n4 3789.35
R3623 XCH1_SW3A/B.n4 XCH1_SW3A/B.n2 3789.35
R3624 XCH1_SW3A/B.n6 XCH1_SW3A/B.n0 3789.35
R3625 XCH1_SW3A/B.n0 XCH1_SW3A/B.n2 3789.35
R3626 VGND XCH1LP_N/S4.t0 58.6255
R3627 ch1_lop XCH1LP_N/D4.n0 0.277674
R3628 XCH1LP_N/D4.n1 ch1_lop 46.2505
R3629 XCH1LP_N/D4.t0 XCH1LP_N/D4.n1 12.3755
R3630 XCH1LP_N/D4.n1 XCH1LP_N/D4.t1 12.3755
R3631 VGND XCH1LP_N/S3.n0 46.2505
R3632 XCH1LP_N/S3.n0 XCH1LP_N/S3.t1 12.3755
R3633 XCH1LP_N/S3.n0 XCH1LP_N/S3.t0 12.3755
R3634 ch1_lop XCH1LP_N/D2.n0 0.277674
R3635 XCH1LP_N/D2.n1 ch1_lop 46.2505
R3636 XCH1LP_N/D2.t0 XCH1LP_N/D2.n1 12.3755
R3637 XCH1LP_N/D2.n1 XCH1LP_N/D2.t1 12.3755
R3638 VGND XCH1LP_N/S1.n0 46.2505
R3639 XCH1LP_N/S1.n0 XCH1LP_N/S1.t0 12.3755
R3640 XCH1LP_N/S1.n0 XCH1LP_N/S1.t1 12.3755
R3641 ch1_lop XCH1LP_N/D0.n0 0.277674
R3642 ch1_lop XCH1LP_N/D0.t0 58.6255
R3643 ch1_lop_raw XCH1LP_N/G.n0 9.3005
R3644 ch1_lop_raw XCH1LP_N/G.n0 0.0466957
R3645 ch1_lop_raw XCH1LP_N/G.n1 6.10787
R3646 XCH1LP_N/G.n1 XCH1LP_N/G.n0 1.92
R3647 XCH1LP_N/G.n2 ch1_lop_raw 152
R3648 ch1_lop_raw XCH1LP_N/G.n3 6.10787
R3649 XCH1LP_N/G.n4 ch1_lop_raw 152
R3650 XCH1LP_N/G.n5 ch1_lop_raw 152
R3651 XCH1LP_N/G.n6 ch1_lop_raw 152
R3652 ch1_lop_raw XCH1LP_N/G.n18 152
R3653 ch1_lop_raw XCH1LP_N/G.n3 6.3031
R3654 ch1_lop_raw XCH1LP_N/G.n1 6.3031
R3655 XCH1LP_N/G.n4 XCH1LP_N/G.n2 70.1096
R3656 XCH1LP_N/G.n5 XCH1LP_N/G.n4 70.1096
R3657 XCH1LP_N/G.n6 XCH1LP_N/G.n5 70.1096
R3658 XCH1LP_N/G.n18 XCH1LP_N/G.n6 70.1096
R3659 XCH1LP_N/G.n18 XCH1LP_N/G.t0 292.413
R3660 XCH1LP_N/G.t0 XCH1LP_N/G.n7 292.413
R3661 XCH1LP_N/G.n8 XCH1LP_N/G.n9 152
R3662 XCH1LP_N/G.n10 XCH1LP_N/G.n11 152
R3663 XCH1LP_N/G.n12 XCH1LP_N/G.n13 152
R3664 XCH1LP_N/G.n12 XCH1LP_N/G.n14 70.1096
R3665 XCH1LP_N/G.n12 XCH1LP_N/G.n10 70.1096
R3666 XCH1LP_N/G.n10 XCH1LP_N/G.n8 70.1096
R3667 XCH1LP_N/G.n8 XCH1LP_N/G.n7 70.1096
R3668 XCH1LP_N/G.n15 XCH1LP_N/G.n9 6.10787
R3669 XCH1LP_N/G.n16 XCH1LP_N/G.n11 9.3005
R3670 XCH1LP_N/G.n17 XCH1LP_N/G.n13 6.10787
R3671 XCH1LP_N/G.n14 XCH1LP_N/G.n17 158.304
R3672 XCH1LP_N/G.n13 XCH1LP_N/G.n11 36.1417
R3673 XCH1LP_N/G.n11 XCH1LP_N/G.n9 36.1417
R3674 XCH1LP_N/G.n7 XCH1LP_N/G.n15 158.304
R3675 XCH1LP_N/G.n16 XCH1LP_N/G.n17 1.92
R3676 XCH1LP_N/G.n15 XCH1LP_N/G.n16 1.92
R3677 XCH1LP_N/G.n14 XCH1LP_N/G.t4 292.413
R3678 XCH1LP_N/G.n2 XCH1LP_N/G.t4 292.413
R3679 XCH1LP_N/G.t3 XCH1LP_N/G.n12 292.413
R3680 XCH1LP_N/G.n4 XCH1LP_N/G.t3 292.413
R3681 XCH1LP_N/G.t2 XCH1LP_N/G.n10 292.413
R3682 XCH1LP_N/G.n5 XCH1LP_N/G.t2 292.413
R3683 XCH1LP_N/G.t1 XCH1LP_N/G.n8 292.413
R3684 XCH1LP_N/G.n6 XCH1LP_N/G.t1 292.413
R3685 XCH1LP_N/G.n3 ch1_lop_raw 1.8738
R3686 XCH1LP_N/B.t2 XCH1LP_N/B.n0 73.1255
R3687 XCH1LP_N/B.n0 XCH1LP_N/B.n1 73.1255
R3688 XCH1LP_N/B.n3 XCH1LP_N/B.n2 83.5719
R3689 XCH1LP_N/B.n4 XCH1LP_N/B.t2 73.1255
R3690 VGND XCH1LP_N/B.n4 73.1255
R3691 XCH1LP_N/B.n6 XCH1LP_N/B.n5 83.5719
R3692 XCH1LP_N/B.n7 XCH1LP_N/B.n6 83.5719
R3693 VGND XCH1LP_N/B.n5 315.135
R3694 XCH1LP_N/B.n5 XCH1LP_N/B.t0 963.244
R3695 XCH1LP_N/B.t1 XCH1LP_N/B.t0 570.812
R3696 XCH1LP_N/B.t2 XCH1LP_N/B.t1 570.812
R3697 XCH1LP_N/B.t2 XCH1LP_N/B.t3 570.812
R3698 XCH1LP_N/B.t3 XCH1LP_N/B.t4 570.812
R3699 XCH1LP_N/B.t4 XCH1LP_N/B.n2 1046.81
R3700 VGND XCH1LP_N/B.n7 246.213
R3701 VGND XCH1LP_N/B.n3 246.213
R3702 XCH1LP_N/B.n7 XCH1LP_N/B.n1 246.213
R3703 XCH1LP_N/B.n1 XCH1LP_N/B.n3 246.213
R3704 XCH1LP_N/B.n6 XCH1LP_N/B.n4 3789.35
R3705 XCH1LP_N/B.n4 XCH1LP_N/B.n2 3789.35
R3706 XCH1LP_N/B.n6 XCH1LP_N/B.n0 3789.35
R3707 XCH1LP_N/B.n0 XCH1LP_N/B.n2 3789.35
R3708 ch2_lop_raw XXP_N/S4.t0 117.251
R3709 lop XXP_N/D4.n0 4.71028
R3710 lop XXP_N/D4.n1 92.5005
R3711 XXP_N/D4.n1 XXP_N/D4.t1 24.7505
R3712 XXP_N/D4.n1 XXP_N/D4.t0 24.7505
R3713 ch2_lop_raw XXP_N/S3.n0 92.5005
R3714 XXP_N/S3.n0 XXP_N/S3.t0 24.7505
R3715 XXP_N/S3.n0 XXP_N/S3.t1 24.7505
R3716 lop XXP_N/D2.n0 4.71028
R3717 lop XXP_N/D2.n1 92.5005
R3718 XXP_N/D2.n1 XXP_N/D2.t0 24.7505
R3719 XXP_N/D2.n1 XXP_N/D2.t1 24.7505
R3720 ch2_lop_raw XXP_N/S1.n0 92.5005
R3721 XXP_N/S1.n0 XXP_N/S1.t0 24.7505
R3722 XXP_N/S1.n0 XXP_N/S1.t1 24.7505
R3723 lop XXP_N/D0.n0 4.71028
R3724 lop XXP_N/D0.t0 117.251
R3725 ui_in[0] XXP_N/G.n0 9.3005
R3726 ui_in[0] XXP_N/G.n0 0.0466957
R3727 ui_in[0] XXP_N/G.n1 6.10787
R3728 XXP_N/G.n1 XXP_N/G.n0 1.92
R3729 XXP_N/G.n2 ui_in[0] 152
R3730 ui_in[0] XXP_N/G.n3 6.10787
R3731 XXP_N/G.n4 ui_in[0] 152
R3732 XXP_N/G.n5 ui_in[0] 152
R3733 XXP_N/G.n6 ui_in[0] 152
R3734 ui_in[0] XXP_N/G.n18 152
R3735 ui_in[0] XXP_N/G.n3 6.3031
R3736 ui_in[0] XXP_N/G.n1 6.3031
R3737 XXP_N/G.n4 XXP_N/G.n2 70.1096
R3738 XXP_N/G.n5 XXP_N/G.n4 70.1096
R3739 XXP_N/G.n6 XXP_N/G.n5 70.1096
R3740 XXP_N/G.n18 XXP_N/G.n6 70.1096
R3741 XXP_N/G.n18 XXP_N/G.t0 163.881
R3742 XXP_N/G.t0 XXP_N/G.n7 163.881
R3743 XXP_N/G.n8 XXP_N/G.n9 152
R3744 XXP_N/G.n10 XXP_N/G.n11 152
R3745 XXP_N/G.n12 XXP_N/G.n13 152
R3746 XXP_N/G.n12 XXP_N/G.n14 70.1096
R3747 XXP_N/G.n10 XXP_N/G.n12 70.1096
R3748 XXP_N/G.n10 XXP_N/G.n8 70.1096
R3749 XXP_N/G.n7 XXP_N/G.n8 70.1096
R3750 XXP_N/G.n15 XXP_N/G.n9 6.10787
R3751 XXP_N/G.n16 XXP_N/G.n11 9.3005
R3752 XXP_N/G.n17 XXP_N/G.n13 6.10787
R3753 XXP_N/G.n14 XXP_N/G.n17 158.304
R3754 XXP_N/G.n13 XXP_N/G.n11 36.1417
R3755 XXP_N/G.n11 XXP_N/G.n9 36.1417
R3756 XXP_N/G.n7 XXP_N/G.n15 158.304
R3757 XXP_N/G.n16 XXP_N/G.n17 1.92
R3758 XXP_N/G.n15 XXP_N/G.n16 1.92
R3759 XXP_N/G.n14 XXP_N/G.t4 163.881
R3760 XXP_N/G.n2 XXP_N/G.t4 163.881
R3761 XXP_N/G.n12 XXP_N/G.t3 163.881
R3762 XXP_N/G.n4 XXP_N/G.t3 163.881
R3763 XXP_N/G.t2 XXP_N/G.n10 163.881
R3764 XXP_N/G.n5 XXP_N/G.t2 163.881
R3765 XXP_N/G.n8 XXP_N/G.t1 163.881
R3766 XXP_N/G.n6 XXP_N/G.t1 163.881
R3767 XXP_N/G.n3 ui_in[0] 1.8738
R3768 XXP_N/B.t2 XXP_N/B.n0 73.1255
R3769 XXP_N/B.n0 XXP_N/B.n1 73.1255
R3770 XXP_N/B.n3 XXP_N/B.n2 117.001
R3771 XXP_N/B.n4 XXP_N/B.t2 73.1255
R3772 VGND XXP_N/B.n4 73.1255
R3773 XXP_N/B.n6 XXP_N/B.n5 117.001
R3774 XXP_N/B.n7 XXP_N/B.n6 117.001
R3775 VGND XXP_N/B.n5 402.07
R3776 XXP_N/B.n5 XXP_N/B.t0 1228.97
R3777 XXP_N/B.t1 XXP_N/B.t0 728.277
R3778 XXP_N/B.t2 XXP_N/B.t1 728.277
R3779 XXP_N/B.t2 XXP_N/B.t3 728.277
R3780 XXP_N/B.t3 XXP_N/B.t4 728.277
R3781 XXP_N/B.t4 XXP_N/B.n2 1345.97
R3782 VGND XXP_N/B.n7 216.095
R3783 VGND XXP_N/B.n3 216.095
R3784 XXP_N/B.n7 XXP_N/B.n1 216.095
R3785 XXP_N/B.n1 XXP_N/B.n3 216.095
R3786 XXP_N/B.n6 XXP_N/B.n4 3325.82
R3787 XXP_N/B.n4 XXP_N/B.n2 3325.82
R3788 XXP_N/B.n6 XXP_N/B.n0 3325.82
R3789 XXP_N/B.n0 XXP_N/B.n2 3325.82
R3790 XLN3_P/S8.n0 VDPWR 1.86528
R3791 VDPWR XLN3_P/S8.t0 67.6311
R3792 lon XLN3_P/D8.n0 1.74028
R3793 lon XLN3_P/D8.n1 58.5005
R3794 XLN3_P/D8.n1 XLN3_P/D8.t0 9.13112
R3795 XLN3_P/D8.n1 XLN3_P/D8.t1 9.13112
R3796 XLN3_P/S7.n0 VDPWR 1.86528
R3797 VDPWR XLN3_P/S7.n1 58.5005
R3798 XLN3_P/S7.n1 XLN3_P/S7.t1 9.13112
R3799 XLN3_P/S7.n1 XLN3_P/S7.t0 9.13112
R3800 lon XLN3_P/D6.n0 1.74028
R3801 lon XLN3_P/D6.n1 58.5005
R3802 XLN3_P/D6.n1 XLN3_P/D6.t1 9.13112
R3803 XLN3_P/D6.n1 XLN3_P/D6.t0 9.13112
R3804 XLN3_P/S5.n0 VDPWR 1.86528
R3805 VDPWR XLN3_P/S5.n1 58.5005
R3806 XLN3_P/S5.n1 XLN3_P/S5.t0 9.13112
R3807 XLN3_P/S5.n1 XLN3_P/S5.t1 9.13112
R3808 lon XLN3_P/D4.n0 1.74028
R3809 lon XLN3_P/D4.n1 58.5005
R3810 XLN3_P/D4.n1 XLN3_P/D4.t1 9.13112
R3811 XLN3_P/D4.n1 XLN3_P/D4.t0 9.13112
R3812 XLN3_P/S3.n0 VDPWR 1.86528
R3813 VDPWR XLN3_P/S3.n1 58.5005
R3814 XLN3_P/S3.n1 XLN3_P/S3.t1 9.13112
R3815 XLN3_P/S3.n1 XLN3_P/S3.t0 9.13112
R3816 lon XLN3_P/D2.n0 1.74028
R3817 lon XLN3_P/D2.n1 58.5005
R3818 XLN3_P/D2.n1 XLN3_P/D2.t1 9.13112
R3819 XLN3_P/D2.n1 XLN3_P/D2.t0 9.13112
R3820 XLN3_P/S1.n0 VDPWR 1.86528
R3821 VDPWR XLN3_P/S1.n1 58.5005
R3822 XLN3_P/S1.n1 XLN3_P/S1.t0 9.13112
R3823 XLN3_P/S1.n1 XLN3_P/S1.t1 9.13112
R3824 lon XLN3_P/D0.n0 1.74028
R3825 lon XLN3_P/D0.t0 67.6311
R3826 ln2 XLN3_P/G.n0 9.3005
R3827 ln2 XLN3_P/G.n0 0.0466957
R3828 ln2 XLN3_P/G.n1 9.3005
R3829 XLN3_P/G.n1 XLN3_P/G.n0 0.297815
R3830 ln2 XLN3_P/G.n2 9.3005
R3831 XLN3_P/G.n2 XLN3_P/G.n1 0.297815
R3832 ln2 XLN3_P/G.n3 6.10787
R3833 XLN3_P/G.n3 XLN3_P/G.n2 1.92
R3834 XLN3_P/G.n4 ln2 152
R3835 ln2 XLN3_P/G.n5 6.10787
R3836 ln2 XLN3_P/G.n6 9.3005
R3837 ln2 XLN3_P/G.n7 9.3005
R3838 XLN3_P/G.n8 ln2 152
R3839 XLN3_P/G.n9 ln2 152
R3840 XLN3_P/G.n10 ln2 152
R3841 XLN3_P/G.n11 ln2 152
R3842 XLN3_P/G.n12 ln2 152
R3843 XLN3_P/G.n13 ln2 152
R3844 XLN3_P/G.n14 ln2 152
R3845 ln2 XLN3_P/G.n38 152
R3846 ln2 XLN3_P/G.n5 6.3031
R3847 ln2 XLN3_P/G.n3 6.3031
R3848 XLN3_P/G.n8 XLN3_P/G.n4 70.1096
R3849 XLN3_P/G.n9 XLN3_P/G.n8 70.1096
R3850 XLN3_P/G.n10 XLN3_P/G.n9 70.1096
R3851 XLN3_P/G.n11 XLN3_P/G.n10 70.1096
R3852 XLN3_P/G.n12 XLN3_P/G.n11 70.1096
R3853 XLN3_P/G.n13 XLN3_P/G.n12 70.1096
R3854 XLN3_P/G.n14 XLN3_P/G.n13 70.1096
R3855 XLN3_P/G.n38 XLN3_P/G.n14 70.1096
R3856 XLN3_P/G.n38 XLN3_P/G.t0 621.78
R3857 XLN3_P/G.t0 XLN3_P/G.n15 621.78
R3858 XLN3_P/G.n16 XLN3_P/G.n17 152
R3859 XLN3_P/G.n18 XLN3_P/G.n19 152
R3860 XLN3_P/G.n20 XLN3_P/G.n21 152
R3861 XLN3_P/G.n22 XLN3_P/G.n23 152
R3862 XLN3_P/G.n25 XLN3_P/G.n24 152
R3863 XLN3_P/G.n27 XLN3_P/G.n26 152
R3864 XLN3_P/G.n29 XLN3_P/G.n28 152
R3865 XLN3_P/G.n30 XLN3_P/G.n28 70.1096
R3866 XLN3_P/G.n28 XLN3_P/G.n26 70.1096
R3867 XLN3_P/G.n26 XLN3_P/G.n24 70.1096
R3868 XLN3_P/G.n24 XLN3_P/G.n22 70.1096
R3869 XLN3_P/G.n22 XLN3_P/G.n20 70.1096
R3870 XLN3_P/G.n18 XLN3_P/G.n20 70.1096
R3871 XLN3_P/G.n18 XLN3_P/G.n16 70.1096
R3872 XLN3_P/G.n16 XLN3_P/G.n15 70.1096
R3873 XLN3_P/G.n31 XLN3_P/G.n17 6.10787
R3874 XLN3_P/G.n32 XLN3_P/G.n19 9.3005
R3875 XLN3_P/G.n33 XLN3_P/G.n21 9.3005
R3876 XLN3_P/G.n34 XLN3_P/G.n23 9.3005
R3877 XLN3_P/G.n35 XLN3_P/G.n25 9.3005
R3878 XLN3_P/G.n36 XLN3_P/G.n27 9.3005
R3879 XLN3_P/G.n37 XLN3_P/G.n29 6.10787
R3880 XLN3_P/G.n37 XLN3_P/G.n30 158.304
R3881 XLN3_P/G.n29 XLN3_P/G.n27 36.1417
R3882 XLN3_P/G.n27 XLN3_P/G.n25 36.1417
R3883 XLN3_P/G.n25 XLN3_P/G.n23 36.1417
R3884 XLN3_P/G.n23 XLN3_P/G.n21 36.1417
R3885 XLN3_P/G.n21 XLN3_P/G.n19 36.1417
R3886 XLN3_P/G.n19 XLN3_P/G.n17 36.1417
R3887 XLN3_P/G.n15 XLN3_P/G.n31 158.304
R3888 XLN3_P/G.n36 XLN3_P/G.n37 1.92
R3889 XLN3_P/G.n35 XLN3_P/G.n36 0.297815
R3890 XLN3_P/G.n34 XLN3_P/G.n35 0.297815
R3891 XLN3_P/G.n33 XLN3_P/G.n34 0.297815
R3892 XLN3_P/G.n32 XLN3_P/G.n33 0.297815
R3893 XLN3_P/G.n31 XLN3_P/G.n32 1.92
R3894 XLN3_P/G.n30 XLN3_P/G.t8 621.78
R3895 XLN3_P/G.n4 XLN3_P/G.t8 621.78
R3896 XLN3_P/G.n28 XLN3_P/G.t7 621.78
R3897 XLN3_P/G.n8 XLN3_P/G.t7 621.78
R3898 XLN3_P/G.n26 XLN3_P/G.t6 621.78
R3899 XLN3_P/G.n9 XLN3_P/G.t6 621.78
R3900 XLN3_P/G.n24 XLN3_P/G.t5 621.78
R3901 XLN3_P/G.n10 XLN3_P/G.t5 621.78
R3902 XLN3_P/G.t4 XLN3_P/G.n22 621.78
R3903 XLN3_P/G.n11 XLN3_P/G.t4 621.78
R3904 XLN3_P/G.n20 XLN3_P/G.t3 621.78
R3905 XLN3_P/G.n12 XLN3_P/G.t3 621.78
R3906 XLN3_P/G.t2 XLN3_P/G.n18 621.78
R3907 XLN3_P/G.n13 XLN3_P/G.t2 621.78
R3908 XLN3_P/G.t1 XLN3_P/G.n16 621.78
R3909 XLN3_P/G.n14 XLN3_P/G.t1 621.78
R3910 XLN3_P/G.n7 ln2 0.251619
R3911 XLN3_P/G.n6 XLN3_P/G.n7 0.297815
R3912 XLN3_P/G.n5 XLN3_P/G.n6 1.92
R3913 XLN3_P/B.n1 XLN3_P/B.t4 13.2148
R3914 VDPWR XLN3_P/B.n1 13.2148
R3915 XLN3_P/B.n0 VDPWR 16.5652
R3916 XLN3_P/B.n3 XLN3_P/B.n2 14.2313
R3917 XLN3_P/B.n0 XLN3_P/B.n3 379.106
R3918 XLN3_P/B.t4 XLN3_P/B.n4 13.2148
R3919 XLN3_P/B.n4 XLN3_P/B.n5 13.2148
R3920 XLN3_P/B.n5 XLN3_P/B.n3 395.671
R3921 XLN3_P/B.n7 XLN3_P/B.n6 14.2313
R3922 VDPWR XLN3_P/B.n7 395.671
R3923 XLN3_P/B.n7 XLN3_P/B.n5 395.671
R3924 XLN3_P/B.n1 XLN3_P/B.n6 3709.41
R3925 XLN3_P/B.n1 XLN3_P/B.n2 3709.41
R3926 XLN3_P/B.n2 XLN3_P/B.n4 3709.41
R3927 XLN3_P/B.n4 XLN3_P/B.n6 3709.41
R3928 XLN3_P/B.n2 XLN3_P/B.t0 148.058
R3929 XLN3_P/B.t1 XLN3_P/B.t0 79.3049
R3930 XLN3_P/B.t2 XLN3_P/B.t1 79.3049
R3931 XLN3_P/B.t3 XLN3_P/B.t2 79.3049
R3932 XLN3_P/B.t4 XLN3_P/B.t3 79.3049
R3933 XLN3_P/B.t4 XLN3_P/B.t5 79.3049
R3934 XLN3_P/B.t5 XLN3_P/B.t6 79.3049
R3935 XLN3_P/B.t6 XLN3_P/B.t7 79.3049
R3936 XLN3_P/B.t7 XLN3_P/B.t8 79.3049
R3937 XLN3_P/B.t8 XLN3_P/B.n6 148.058
R3938 vbias XRBIAS/R2.n0 0.46195
R3939 XRBIAS/R2.n0 XRBIAS/R2.t0 25.3338
R3940 vbias XRBIAS/R2.n0 8.2161
R3941 XRBIAS/R1.n0 XRBIAS/R1.t0 25.3338
R3942 VDPWR XRBIAS/R1.n0 0.507818
R3943 VDPWR XRBIAS/R1.n0 8.2161
R3944 XRBIAS/B.t0 XRBIAS/B.n0 0.435047
R3945 XRBIAS/B.n1 XRBIAS/B.n2 117.001
R3946 XRBIAS/B.n3 XRBIAS/B.n4 4.00735
R3947 XRBIAS/B.n5 XRBIAS/B.t0 117.001
R3948 VGND XRBIAS/B.n5 117.001
R3949 XRBIAS/B.n6 XRBIAS/B.n7 4.00735
R3950 XRBIAS/B.n7 XRBIAS/B.n8 4.00735
R3951 VGND XRBIAS/B.n6 22.9533
R3952 XRBIAS/B.t0 XRBIAS/B.n6 110.001
R3953 XRBIAS/B.n0 XRBIAS/B.n3 113.15
R3954 XRBIAS/B.n8 VGND 1981.74
R3955 VGND XRBIAS/B.n4 1981.74
R3956 XRBIAS/B.n8 XRBIAS/B.n2 1981.74
R3957 XRBIAS/B.n2 XRBIAS/B.n4 1981.74
R3958 XRBIAS/B.n7 XRBIAS/B.n5 30500.2
R3959 XRBIAS/B.n5 XRBIAS/B.n3 30500.2
R3960 XRBIAS/B.n7 XRBIAS/B.n1 30500.2
R3961 XRBIAS/B.n0 XRBIAS/B.n1 116.121
R3962 gm1_n XCH1_SW3B/S4.t0 58.6255
R3963 ua[3] XCH1_SW3B/D4.n0 0.277674
R3964 XCH1_SW3B/D4.n1 ua[3] 46.2505
R3965 XCH1_SW3B/D4.t0 XCH1_SW3B/D4.n1 12.3755
R3966 XCH1_SW3B/D4.n1 XCH1_SW3B/D4.t1 12.3755
R3967 gm1_n XCH1_SW3B/S3.n0 46.2505
R3968 XCH1_SW3B/S3.n0 XCH1_SW3B/S3.t1 12.3755
R3969 XCH1_SW3B/S3.n0 XCH1_SW3B/S3.t0 12.3755
R3970 ua[3] XCH1_SW3B/D2.n0 0.277674
R3971 XCH1_SW3B/D2.n1 ua[3] 46.2505
R3972 XCH1_SW3B/D2.t0 XCH1_SW3B/D2.n1 12.3755
R3973 XCH1_SW3B/D2.n1 XCH1_SW3B/D2.t1 12.3755
R3974 gm1_n XCH1_SW3B/S1.n0 46.2505
R3975 XCH1_SW3B/S1.n0 XCH1_SW3B/S1.t0 12.3755
R3976 XCH1_SW3B/S1.n0 XCH1_SW3B/S1.t1 12.3755
R3977 ua[3] XCH1_SW3B/D0.n0 0.277674
R3978 ua[3] XCH1_SW3B/D0.t0 58.6255
R3979 ch1_lop XCH1_SW3B/G.n0 9.3005
R3980 ch1_lop XCH1_SW3B/G.n0 0.0466957
R3981 ch1_lop XCH1_SW3B/G.n1 6.10787
R3982 XCH1_SW3B/G.n1 XCH1_SW3B/G.n0 1.92
R3983 XCH1_SW3B/G.n2 ch1_lop 152
R3984 ch1_lop XCH1_SW3B/G.n3 6.10787
R3985 XCH1_SW3B/G.n4 ch1_lop 152
R3986 XCH1_SW3B/G.n5 ch1_lop 152
R3987 XCH1_SW3B/G.n6 ch1_lop 152
R3988 ch1_lop XCH1_SW3B/G.n18 152
R3989 ch1_lop XCH1_SW3B/G.n3 6.3031
R3990 ch1_lop XCH1_SW3B/G.n1 6.3031
R3991 XCH1_SW3B/G.n4 XCH1_SW3B/G.n2 70.1096
R3992 XCH1_SW3B/G.n5 XCH1_SW3B/G.n4 70.1096
R3993 XCH1_SW3B/G.n6 XCH1_SW3B/G.n5 70.1096
R3994 XCH1_SW3B/G.n18 XCH1_SW3B/G.n6 70.1096
R3995 XCH1_SW3B/G.n18 XCH1_SW3B/G.t0 292.413
R3996 XCH1_SW3B/G.t0 XCH1_SW3B/G.n7 292.413
R3997 XCH1_SW3B/G.n8 XCH1_SW3B/G.n9 152
R3998 XCH1_SW3B/G.n10 XCH1_SW3B/G.n11 152
R3999 XCH1_SW3B/G.n12 XCH1_SW3B/G.n13 152
R4000 XCH1_SW3B/G.n12 XCH1_SW3B/G.n14 70.1096
R4001 XCH1_SW3B/G.n12 XCH1_SW3B/G.n10 70.1096
R4002 XCH1_SW3B/G.n10 XCH1_SW3B/G.n8 70.1096
R4003 XCH1_SW3B/G.n8 XCH1_SW3B/G.n7 70.1096
R4004 XCH1_SW3B/G.n15 XCH1_SW3B/G.n9 6.10787
R4005 XCH1_SW3B/G.n16 XCH1_SW3B/G.n11 9.3005
R4006 XCH1_SW3B/G.n17 XCH1_SW3B/G.n13 6.10787
R4007 XCH1_SW3B/G.n14 XCH1_SW3B/G.n17 158.304
R4008 XCH1_SW3B/G.n13 XCH1_SW3B/G.n11 36.1417
R4009 XCH1_SW3B/G.n11 XCH1_SW3B/G.n9 36.1417
R4010 XCH1_SW3B/G.n7 XCH1_SW3B/G.n15 158.304
R4011 XCH1_SW3B/G.n16 XCH1_SW3B/G.n17 1.92
R4012 XCH1_SW3B/G.n15 XCH1_SW3B/G.n16 1.92
R4013 XCH1_SW3B/G.n14 XCH1_SW3B/G.t4 292.413
R4014 XCH1_SW3B/G.n2 XCH1_SW3B/G.t4 292.413
R4015 XCH1_SW3B/G.t3 XCH1_SW3B/G.n12 292.413
R4016 XCH1_SW3B/G.n4 XCH1_SW3B/G.t3 292.413
R4017 XCH1_SW3B/G.t2 XCH1_SW3B/G.n10 292.413
R4018 XCH1_SW3B/G.n5 XCH1_SW3B/G.t2 292.413
R4019 XCH1_SW3B/G.t1 XCH1_SW3B/G.n8 292.413
R4020 XCH1_SW3B/G.n6 XCH1_SW3B/G.t1 292.413
R4021 XCH1_SW3B/G.n3 ch1_lop 1.8738
R4022 XCH1_SW3B/B.t2 XCH1_SW3B/B.n0 73.1255
R4023 XCH1_SW3B/B.n0 XCH1_SW3B/B.n1 73.1255
R4024 XCH1_SW3B/B.n3 XCH1_SW3B/B.n2 83.5719
R4025 XCH1_SW3B/B.n4 XCH1_SW3B/B.t2 73.1255
R4026 VGND XCH1_SW3B/B.n4 73.1255
R4027 XCH1_SW3B/B.n6 XCH1_SW3B/B.n5 83.5719
R4028 XCH1_SW3B/B.n7 XCH1_SW3B/B.n6 83.5719
R4029 VGND XCH1_SW3B/B.n5 315.135
R4030 XCH1_SW3B/B.n5 XCH1_SW3B/B.t0 963.244
R4031 XCH1_SW3B/B.t1 XCH1_SW3B/B.t0 570.812
R4032 XCH1_SW3B/B.t2 XCH1_SW3B/B.t1 570.812
R4033 XCH1_SW3B/B.t2 XCH1_SW3B/B.t3 570.812
R4034 XCH1_SW3B/B.t3 XCH1_SW3B/B.t4 570.812
R4035 XCH1_SW3B/B.t4 XCH1_SW3B/B.n2 1046.81
R4036 VGND XCH1_SW3B/B.n7 246.213
R4037 VGND XCH1_SW3B/B.n3 246.213
R4038 XCH1_SW3B/B.n7 XCH1_SW3B/B.n1 246.213
R4039 XCH1_SW3B/B.n1 XCH1_SW3B/B.n3 246.213
R4040 XCH1_SW3B/B.n6 XCH1_SW3B/B.n4 3789.35
R4041 XCH1_SW3B/B.n4 XCH1_SW3B/B.n2 3789.35
R4042 XCH1_SW3B/B.n6 XCH1_SW3B/B.n0 3789.35
R4043 XCH1_SW3B/B.n0 XCH1_SW3B/B.n2 3789.35
R4044 gm1_p XCH1_SW2A/S4.t0 58.6255
R4045 ua[3] XCH1_SW2A/D4.n0 0.277674
R4046 XCH1_SW2A/D4.n1 ua[3] 46.2505
R4047 XCH1_SW2A/D4.t0 XCH1_SW2A/D4.n1 12.3755
R4048 XCH1_SW2A/D4.n1 XCH1_SW2A/D4.t1 12.3755
R4049 gm1_p XCH1_SW2A/S3.n0 46.2505
R4050 XCH1_SW2A/S3.n0 XCH1_SW2A/S3.t1 12.3755
R4051 XCH1_SW2A/S3.n0 XCH1_SW2A/S3.t0 12.3755
R4052 ua[3] XCH1_SW2A/D2.n0 0.277674
R4053 XCH1_SW2A/D2.n1 ua[3] 46.2505
R4054 XCH1_SW2A/D2.t0 XCH1_SW2A/D2.n1 12.3755
R4055 XCH1_SW2A/D2.n1 XCH1_SW2A/D2.t1 12.3755
R4056 gm1_p XCH1_SW2A/S1.n0 46.2505
R4057 XCH1_SW2A/S1.n0 XCH1_SW2A/S1.t0 12.3755
R4058 XCH1_SW2A/S1.n0 XCH1_SW2A/S1.t1 12.3755
R4059 ua[3] XCH1_SW2A/D0.n0 0.277674
R4060 ua[3] XCH1_SW2A/D0.t0 58.6255
R4061 ch1_lon XCH1_SW2A/G.n0 9.3005
R4062 ch1_lon XCH1_SW2A/G.n0 0.0466957
R4063 ch1_lon XCH1_SW2A/G.n1 6.10787
R4064 XCH1_SW2A/G.n1 XCH1_SW2A/G.n0 1.92
R4065 XCH1_SW2A/G.n2 ch1_lon 152
R4066 ch1_lon XCH1_SW2A/G.n3 6.10787
R4067 XCH1_SW2A/G.n4 ch1_lon 152
R4068 XCH1_SW2A/G.n5 ch1_lon 152
R4069 XCH1_SW2A/G.n6 ch1_lon 152
R4070 ch1_lon XCH1_SW2A/G.n18 152
R4071 ch1_lon XCH1_SW2A/G.n3 6.3031
R4072 ch1_lon XCH1_SW2A/G.n1 6.3031
R4073 XCH1_SW2A/G.n4 XCH1_SW2A/G.n2 70.1096
R4074 XCH1_SW2A/G.n5 XCH1_SW2A/G.n4 70.1096
R4075 XCH1_SW2A/G.n6 XCH1_SW2A/G.n5 70.1096
R4076 XCH1_SW2A/G.n18 XCH1_SW2A/G.n6 70.1096
R4077 XCH1_SW2A/G.n18 XCH1_SW2A/G.t0 292.413
R4078 XCH1_SW2A/G.t0 XCH1_SW2A/G.n7 292.413
R4079 XCH1_SW2A/G.n8 XCH1_SW2A/G.n9 152
R4080 XCH1_SW2A/G.n10 XCH1_SW2A/G.n11 152
R4081 XCH1_SW2A/G.n12 XCH1_SW2A/G.n13 152
R4082 XCH1_SW2A/G.n12 XCH1_SW2A/G.n14 70.1096
R4083 XCH1_SW2A/G.n12 XCH1_SW2A/G.n10 70.1096
R4084 XCH1_SW2A/G.n10 XCH1_SW2A/G.n8 70.1096
R4085 XCH1_SW2A/G.n8 XCH1_SW2A/G.n7 70.1096
R4086 XCH1_SW2A/G.n15 XCH1_SW2A/G.n9 6.10787
R4087 XCH1_SW2A/G.n16 XCH1_SW2A/G.n11 9.3005
R4088 XCH1_SW2A/G.n17 XCH1_SW2A/G.n13 6.10787
R4089 XCH1_SW2A/G.n14 XCH1_SW2A/G.n17 158.304
R4090 XCH1_SW2A/G.n13 XCH1_SW2A/G.n11 36.1417
R4091 XCH1_SW2A/G.n11 XCH1_SW2A/G.n9 36.1417
R4092 XCH1_SW2A/G.n7 XCH1_SW2A/G.n15 158.304
R4093 XCH1_SW2A/G.n16 XCH1_SW2A/G.n17 1.92
R4094 XCH1_SW2A/G.n15 XCH1_SW2A/G.n16 1.92
R4095 XCH1_SW2A/G.n14 XCH1_SW2A/G.t4 292.413
R4096 XCH1_SW2A/G.n2 XCH1_SW2A/G.t4 292.413
R4097 XCH1_SW2A/G.t3 XCH1_SW2A/G.n12 292.413
R4098 XCH1_SW2A/G.n4 XCH1_SW2A/G.t3 292.413
R4099 XCH1_SW2A/G.t2 XCH1_SW2A/G.n10 292.413
R4100 XCH1_SW2A/G.n5 XCH1_SW2A/G.t2 292.413
R4101 XCH1_SW2A/G.t1 XCH1_SW2A/G.n8 292.413
R4102 XCH1_SW2A/G.n6 XCH1_SW2A/G.t1 292.413
R4103 XCH1_SW2A/G.n3 ch1_lon 1.8738
R4104 XCH1_SW2A/B.t2 XCH1_SW2A/B.n0 73.1255
R4105 XCH1_SW2A/B.n0 XCH1_SW2A/B.n1 73.1255
R4106 XCH1_SW2A/B.n3 XCH1_SW2A/B.n2 83.5719
R4107 XCH1_SW2A/B.n4 XCH1_SW2A/B.t2 73.1255
R4108 VGND XCH1_SW2A/B.n4 73.1255
R4109 XCH1_SW2A/B.n6 XCH1_SW2A/B.n5 83.5719
R4110 XCH1_SW2A/B.n7 XCH1_SW2A/B.n6 83.5719
R4111 VGND XCH1_SW2A/B.n5 315.135
R4112 XCH1_SW2A/B.n5 XCH1_SW2A/B.t0 963.244
R4113 XCH1_SW2A/B.t1 XCH1_SW2A/B.t0 570.812
R4114 XCH1_SW2A/B.t2 XCH1_SW2A/B.t1 570.812
R4115 XCH1_SW2A/B.t2 XCH1_SW2A/B.t3 570.812
R4116 XCH1_SW2A/B.t3 XCH1_SW2A/B.t4 570.812
R4117 XCH1_SW2A/B.t4 XCH1_SW2A/B.n2 1046.81
R4118 VGND XCH1_SW2A/B.n7 246.213
R4119 VGND XCH1_SW2A/B.n3 246.213
R4120 XCH1_SW2A/B.n7 XCH1_SW2A/B.n1 246.213
R4121 XCH1_SW2A/B.n1 XCH1_SW2A/B.n3 246.213
R4122 XCH1_SW2A/B.n6 XCH1_SW2A/B.n4 3789.35
R4123 XCH1_SW2A/B.n4 XCH1_SW2A/B.n2 3789.35
R4124 XCH1_SW2A/B.n6 XCH1_SW2A/B.n0 3789.35
R4125 XCH1_SW2A/B.n0 XCH1_SW2A/B.n2 3789.35
R4126 ch1_lop_raw X1DP_N/S4.t0 117.251
R4127 lon X1DP_N/D4.n0 4.71028
R4128 lon X1DP_N/D4.n1 92.5005
R4129 X1DP_N/D4.n1 X1DP_N/D4.t1 24.7505
R4130 X1DP_N/D4.n1 X1DP_N/D4.t0 24.7505
R4131 ch1_lop_raw X1DP_N/S3.n0 92.5005
R4132 X1DP_N/S3.n0 X1DP_N/S3.t0 24.7505
R4133 X1DP_N/S3.n0 X1DP_N/S3.t1 24.7505
R4134 lon X1DP_N/D2.n0 4.71028
R4135 lon X1DP_N/D2.n1 92.5005
R4136 X1DP_N/D2.n1 X1DP_N/D2.t0 24.7505
R4137 X1DP_N/D2.n1 X1DP_N/D2.t1 24.7505
R4138 ch1_lop_raw X1DP_N/S1.n0 92.5005
R4139 X1DP_N/S1.n0 X1DP_N/S1.t0 24.7505
R4140 X1DP_N/S1.n0 X1DP_N/S1.t1 24.7505
R4141 lon X1DP_N/D0.n0 4.71028
R4142 lon X1DP_N/D0.t0 117.251
R4143 VDPWR X1DP_N/G.n0 9.3005
R4144 VDPWR X1DP_N/G.n0 0.0466957
R4145 VDPWR X1DP_N/G.n1 6.10787
R4146 X1DP_N/G.n1 X1DP_N/G.n0 1.92
R4147 X1DP_N/G.n2 VDPWR 152
R4148 VDPWR X1DP_N/G.n3 6.10787
R4149 X1DP_N/G.n4 VDPWR 152
R4150 X1DP_N/G.n5 VDPWR 152
R4151 X1DP_N/G.n6 VDPWR 152
R4152 VDPWR X1DP_N/G.n18 152
R4153 VDPWR X1DP_N/G.n3 6.3031
R4154 VDPWR X1DP_N/G.n1 6.3031
R4155 X1DP_N/G.n4 X1DP_N/G.n2 70.1096
R4156 X1DP_N/G.n5 X1DP_N/G.n4 70.1096
R4157 X1DP_N/G.n6 X1DP_N/G.n5 70.1096
R4158 X1DP_N/G.n18 X1DP_N/G.n6 70.1096
R4159 X1DP_N/G.n18 X1DP_N/G.t0 163.881
R4160 X1DP_N/G.t0 X1DP_N/G.n7 163.881
R4161 X1DP_N/G.n8 X1DP_N/G.n9 152
R4162 X1DP_N/G.n10 X1DP_N/G.n11 152
R4163 X1DP_N/G.n12 X1DP_N/G.n13 152
R4164 X1DP_N/G.n12 X1DP_N/G.n14 70.1096
R4165 X1DP_N/G.n10 X1DP_N/G.n12 70.1096
R4166 X1DP_N/G.n10 X1DP_N/G.n8 70.1096
R4167 X1DP_N/G.n7 X1DP_N/G.n8 70.1096
R4168 X1DP_N/G.n15 X1DP_N/G.n9 6.10787
R4169 X1DP_N/G.n16 X1DP_N/G.n11 9.3005
R4170 X1DP_N/G.n17 X1DP_N/G.n13 6.10787
R4171 X1DP_N/G.n14 X1DP_N/G.n17 158.304
R4172 X1DP_N/G.n13 X1DP_N/G.n11 36.1417
R4173 X1DP_N/G.n11 X1DP_N/G.n9 36.1417
R4174 X1DP_N/G.n7 X1DP_N/G.n15 158.304
R4175 X1DP_N/G.n16 X1DP_N/G.n17 1.92
R4176 X1DP_N/G.n15 X1DP_N/G.n16 1.92
R4177 X1DP_N/G.n14 X1DP_N/G.t4 163.881
R4178 X1DP_N/G.n2 X1DP_N/G.t4 163.881
R4179 X1DP_N/G.n12 X1DP_N/G.t3 163.881
R4180 X1DP_N/G.n4 X1DP_N/G.t3 163.881
R4181 X1DP_N/G.t2 X1DP_N/G.n10 163.881
R4182 X1DP_N/G.n5 X1DP_N/G.t2 163.881
R4183 X1DP_N/G.n8 X1DP_N/G.t1 163.881
R4184 X1DP_N/G.n6 X1DP_N/G.t1 163.881
R4185 X1DP_N/G.n3 VDPWR 1.8738
R4186 X1DP_N/B.t2 X1DP_N/B.n0 73.1255
R4187 X1DP_N/B.n0 X1DP_N/B.n1 73.1255
R4188 X1DP_N/B.n3 X1DP_N/B.n2 117.001
R4189 X1DP_N/B.n4 X1DP_N/B.t2 73.1255
R4190 VGND X1DP_N/B.n4 73.1255
R4191 X1DP_N/B.n6 X1DP_N/B.n5 117.001
R4192 X1DP_N/B.n7 X1DP_N/B.n6 117.001
R4193 VGND X1DP_N/B.n5 402.07
R4194 X1DP_N/B.n5 X1DP_N/B.t0 1228.97
R4195 X1DP_N/B.t1 X1DP_N/B.t0 728.277
R4196 X1DP_N/B.t2 X1DP_N/B.t1 728.277
R4197 X1DP_N/B.t2 X1DP_N/B.t3 728.277
R4198 X1DP_N/B.t3 X1DP_N/B.t4 728.277
R4199 X1DP_N/B.t4 X1DP_N/B.n2 1345.97
R4200 VGND X1DP_N/B.n7 216.095
R4201 VGND X1DP_N/B.n3 216.095
R4202 X1DP_N/B.n7 X1DP_N/B.n1 216.095
R4203 X1DP_N/B.n1 X1DP_N/B.n3 216.095
R4204 X1DP_N/B.n6 X1DP_N/B.n4 3325.82
R4205 X1DP_N/B.n4 X1DP_N/B.n2 3325.82
R4206 X1DP_N/B.n6 X1DP_N/B.n0 3325.82
R4207 X1DP_N/B.n0 X1DP_N/B.n2 3325.82
R4208 VGND XLN1_N/S2.t0 117.251
R4209 ln1 XLN1_N/D2.n0 4.71028
R4210 ln1 XLN1_N/D2.n1 92.5005
R4211 XLN1_N/D2.n1 XLN1_N/D2.t0 24.7505
R4212 XLN1_N/D2.n1 XLN1_N/D2.t1 24.7505
R4213 VGND XLN1_N/S1.n0 92.5005
R4214 XLN1_N/S1.n0 XLN1_N/S1.t1 24.7505
R4215 XLN1_N/S1.n0 XLN1_N/S1.t0 24.7505
R4216 ln1 XLN1_N/D0.n0 4.71028
R4217 ln1 XLN1_N/D0.t0 117.251
R4218 clk XLN1_N/G.n0 6.10787
R4219 clk XLN1_N/G.n0 1.66888
R4220 XLN1_N/G.n1 clk 152
R4221 XLN1_N/G.n2 clk 152
R4222 clk XLN1_N/G.n4 152
R4223 clk XLN1_N/G.n0 6.3031
R4224 XLN1_N/G.n2 XLN1_N/G.n1 70.1096
R4225 XLN1_N/G.n4 XLN1_N/G.n2 70.1096
R4226 XLN1_N/G.n4 XLN1_N/G.t0 163.881
R4227 XLN1_N/G.t2 XLN1_N/G.n3 212.591
R4228 XLN1_N/G.t0 XLN1_N/G.n3 212.59
R4229 XLN1_N/G.n1 XLN1_N/G.t2 163.881
R4230 XLN1_N/G.n3 XLN1_N/G.t1 170.046
R4231 XLN1_N/G.n2 XLN1_N/G.t1 163.881
R4232 XLN1_N/B.t1 XLN1_N/B.n0 117.001
R4233 XLN1_N/B.n0 XLN1_N/B.n1 117.001
R4234 XLN1_N/B.n3 XLN1_N/B.n2 117.001
R4235 XLN1_N/B.n4 XLN1_N/B.t1 117.001
R4236 VGND XLN1_N/B.n4 117.001
R4237 XLN1_N/B.n6 XLN1_N/B.n5 117.001
R4238 XLN1_N/B.n7 XLN1_N/B.n6 117.001
R4239 VGND XLN1_N/B.n5 402.07
R4240 XLN1_N/B.n5 XLN1_N/B.t0 1228.97
R4241 XLN1_N/B.t1 XLN1_N/B.t0 728.277
R4242 XLN1_N/B.t1 XLN1_N/B.t2 728.277
R4243 XLN1_N/B.t2 XLN1_N/B.n2 1345.97
R4244 VGND XLN1_N/B.n7 179.953
R4245 VGND XLN1_N/B.n3 179.953
R4246 XLN1_N/B.n7 XLN1_N/B.n1 179.953
R4247 XLN1_N/B.n3 XLN1_N/B.n1 179.953
R4248 XLN1_N/B.n6 XLN1_N/B.n4 2769.59
R4249 XLN1_N/B.n4 XLN1_N/B.n2 2769.59
R4250 XLN1_N/B.n6 XLN1_N/B.n0 2769.59
R4251 XLN1_N/B.n0 XLN1_N/B.n2 2769.59
R4252 gm1_p XCH1_SW2B/S4.t0 58.6255
R4253 ua[3] XCH1_SW2B/D4.n0 0.277674
R4254 XCH1_SW2B/D4.n1 ua[3] 46.2505
R4255 XCH1_SW2B/D4.t0 XCH1_SW2B/D4.n1 12.3755
R4256 XCH1_SW2B/D4.n1 XCH1_SW2B/D4.t1 12.3755
R4257 gm1_p XCH1_SW2B/S3.n0 46.2505
R4258 XCH1_SW2B/S3.n0 XCH1_SW2B/S3.t1 12.3755
R4259 XCH1_SW2B/S3.n0 XCH1_SW2B/S3.t0 12.3755
R4260 ua[3] XCH1_SW2B/D2.n0 0.277674
R4261 XCH1_SW2B/D2.n1 ua[3] 46.2505
R4262 XCH1_SW2B/D2.t0 XCH1_SW2B/D2.n1 12.3755
R4263 XCH1_SW2B/D2.n1 XCH1_SW2B/D2.t1 12.3755
R4264 gm1_p XCH1_SW2B/S1.n0 46.2505
R4265 XCH1_SW2B/S1.n0 XCH1_SW2B/S1.t0 12.3755
R4266 XCH1_SW2B/S1.n0 XCH1_SW2B/S1.t1 12.3755
R4267 ua[3] XCH1_SW2B/D0.n0 0.277674
R4268 ua[3] XCH1_SW2B/D0.t0 58.6255
R4269 ch1_lon XCH1_SW2B/G.n0 9.3005
R4270 ch1_lon XCH1_SW2B/G.n0 0.0466957
R4271 ch1_lon XCH1_SW2B/G.n1 6.10787
R4272 XCH1_SW2B/G.n1 XCH1_SW2B/G.n0 1.92
R4273 XCH1_SW2B/G.n2 ch1_lon 152
R4274 ch1_lon XCH1_SW2B/G.n3 6.10787
R4275 XCH1_SW2B/G.n4 ch1_lon 152
R4276 XCH1_SW2B/G.n5 ch1_lon 152
R4277 XCH1_SW2B/G.n6 ch1_lon 152
R4278 ch1_lon XCH1_SW2B/G.n18 152
R4279 ch1_lon XCH1_SW2B/G.n3 6.3031
R4280 ch1_lon XCH1_SW2B/G.n1 6.3031
R4281 XCH1_SW2B/G.n4 XCH1_SW2B/G.n2 70.1096
R4282 XCH1_SW2B/G.n5 XCH1_SW2B/G.n4 70.1096
R4283 XCH1_SW2B/G.n6 XCH1_SW2B/G.n5 70.1096
R4284 XCH1_SW2B/G.n18 XCH1_SW2B/G.n6 70.1096
R4285 XCH1_SW2B/G.n18 XCH1_SW2B/G.t0 292.413
R4286 XCH1_SW2B/G.t0 XCH1_SW2B/G.n7 292.413
R4287 XCH1_SW2B/G.n8 XCH1_SW2B/G.n9 152
R4288 XCH1_SW2B/G.n10 XCH1_SW2B/G.n11 152
R4289 XCH1_SW2B/G.n12 XCH1_SW2B/G.n13 152
R4290 XCH1_SW2B/G.n12 XCH1_SW2B/G.n14 70.1096
R4291 XCH1_SW2B/G.n12 XCH1_SW2B/G.n10 70.1096
R4292 XCH1_SW2B/G.n10 XCH1_SW2B/G.n8 70.1096
R4293 XCH1_SW2B/G.n8 XCH1_SW2B/G.n7 70.1096
R4294 XCH1_SW2B/G.n15 XCH1_SW2B/G.n9 6.10787
R4295 XCH1_SW2B/G.n16 XCH1_SW2B/G.n11 9.3005
R4296 XCH1_SW2B/G.n17 XCH1_SW2B/G.n13 6.10787
R4297 XCH1_SW2B/G.n14 XCH1_SW2B/G.n17 158.304
R4298 XCH1_SW2B/G.n13 XCH1_SW2B/G.n11 36.1417
R4299 XCH1_SW2B/G.n11 XCH1_SW2B/G.n9 36.1417
R4300 XCH1_SW2B/G.n7 XCH1_SW2B/G.n15 158.304
R4301 XCH1_SW2B/G.n16 XCH1_SW2B/G.n17 1.92
R4302 XCH1_SW2B/G.n15 XCH1_SW2B/G.n16 1.92
R4303 XCH1_SW2B/G.n14 XCH1_SW2B/G.t4 292.413
R4304 XCH1_SW2B/G.n2 XCH1_SW2B/G.t4 292.413
R4305 XCH1_SW2B/G.t3 XCH1_SW2B/G.n12 292.413
R4306 XCH1_SW2B/G.n4 XCH1_SW2B/G.t3 292.413
R4307 XCH1_SW2B/G.t2 XCH1_SW2B/G.n10 292.413
R4308 XCH1_SW2B/G.n5 XCH1_SW2B/G.t2 292.413
R4309 XCH1_SW2B/G.t1 XCH1_SW2B/G.n8 292.413
R4310 XCH1_SW2B/G.n6 XCH1_SW2B/G.t1 292.413
R4311 XCH1_SW2B/G.n3 ch1_lon 1.8738
R4312 XCH1_SW2B/B.t2 XCH1_SW2B/B.n0 73.1255
R4313 XCH1_SW2B/B.n0 XCH1_SW2B/B.n1 73.1255
R4314 XCH1_SW2B/B.n3 XCH1_SW2B/B.n2 83.5719
R4315 XCH1_SW2B/B.n4 XCH1_SW2B/B.t2 73.1255
R4316 VGND XCH1_SW2B/B.n4 73.1255
R4317 XCH1_SW2B/B.n6 XCH1_SW2B/B.n5 83.5719
R4318 XCH1_SW2B/B.n7 XCH1_SW2B/B.n6 83.5719
R4319 VGND XCH1_SW2B/B.n5 315.135
R4320 XCH1_SW2B/B.n5 XCH1_SW2B/B.t0 963.244
R4321 XCH1_SW2B/B.t1 XCH1_SW2B/B.t0 570.812
R4322 XCH1_SW2B/B.t2 XCH1_SW2B/B.t1 570.812
R4323 XCH1_SW2B/B.t2 XCH1_SW2B/B.t3 570.812
R4324 XCH1_SW2B/B.t3 XCH1_SW2B/B.t4 570.812
R4325 XCH1_SW2B/B.t4 XCH1_SW2B/B.n2 1046.81
R4326 VGND XCH1_SW2B/B.n7 246.213
R4327 VGND XCH1_SW2B/B.n3 246.213
R4328 XCH1_SW2B/B.n7 XCH1_SW2B/B.n1 246.213
R4329 XCH1_SW2B/B.n1 XCH1_SW2B/B.n3 246.213
R4330 XCH1_SW2B/B.n6 XCH1_SW2B/B.n4 3789.35
R4331 XCH1_SW2B/B.n4 XCH1_SW2B/B.n2 3789.35
R4332 XCH1_SW2B/B.n6 XCH1_SW2B/B.n0 3789.35
R4333 XCH1_SW2B/B.n0 XCH1_SW2B/B.n2 3789.35
R4334 gm1_p XCH1_SW1A/S4.t0 58.6255
R4335 ua[2] XCH1_SW1A/D4.n0 0.277674
R4336 XCH1_SW1A/D4.n1 ua[2] 46.2505
R4337 XCH1_SW1A/D4.t0 XCH1_SW1A/D4.n1 12.3755
R4338 XCH1_SW1A/D4.n1 XCH1_SW1A/D4.t1 12.3755
R4339 gm1_p XCH1_SW1A/S3.n0 46.2505
R4340 XCH1_SW1A/S3.n0 XCH1_SW1A/S3.t1 12.3755
R4341 XCH1_SW1A/S3.n0 XCH1_SW1A/S3.t0 12.3755
R4342 ua[2] XCH1_SW1A/D2.n0 0.277674
R4343 XCH1_SW1A/D2.n1 ua[2] 46.2505
R4344 XCH1_SW1A/D2.t0 XCH1_SW1A/D2.n1 12.3755
R4345 XCH1_SW1A/D2.n1 XCH1_SW1A/D2.t1 12.3755
R4346 gm1_p XCH1_SW1A/S1.n0 46.2505
R4347 XCH1_SW1A/S1.n0 XCH1_SW1A/S1.t0 12.3755
R4348 XCH1_SW1A/S1.n0 XCH1_SW1A/S1.t1 12.3755
R4349 ua[2] XCH1_SW1A/D0.n0 0.277674
R4350 ua[2] XCH1_SW1A/D0.t0 58.6255
R4351 ch1_lop XCH1_SW1A/G.n0 9.3005
R4352 ch1_lop XCH1_SW1A/G.n0 0.0466957
R4353 ch1_lop XCH1_SW1A/G.n1 6.10787
R4354 XCH1_SW1A/G.n1 XCH1_SW1A/G.n0 1.92
R4355 XCH1_SW1A/G.n2 ch1_lop 152
R4356 ch1_lop XCH1_SW1A/G.n3 6.10787
R4357 XCH1_SW1A/G.n4 ch1_lop 152
R4358 XCH1_SW1A/G.n5 ch1_lop 152
R4359 XCH1_SW1A/G.n6 ch1_lop 152
R4360 ch1_lop XCH1_SW1A/G.n18 152
R4361 ch1_lop XCH1_SW1A/G.n3 6.3031
R4362 ch1_lop XCH1_SW1A/G.n1 6.3031
R4363 XCH1_SW1A/G.n4 XCH1_SW1A/G.n2 70.1096
R4364 XCH1_SW1A/G.n5 XCH1_SW1A/G.n4 70.1096
R4365 XCH1_SW1A/G.n6 XCH1_SW1A/G.n5 70.1096
R4366 XCH1_SW1A/G.n18 XCH1_SW1A/G.n6 70.1096
R4367 XCH1_SW1A/G.n18 XCH1_SW1A/G.t0 292.413
R4368 XCH1_SW1A/G.t0 XCH1_SW1A/G.n7 292.413
R4369 XCH1_SW1A/G.n8 XCH1_SW1A/G.n9 152
R4370 XCH1_SW1A/G.n10 XCH1_SW1A/G.n11 152
R4371 XCH1_SW1A/G.n12 XCH1_SW1A/G.n13 152
R4372 XCH1_SW1A/G.n12 XCH1_SW1A/G.n14 70.1096
R4373 XCH1_SW1A/G.n12 XCH1_SW1A/G.n10 70.1096
R4374 XCH1_SW1A/G.n10 XCH1_SW1A/G.n8 70.1096
R4375 XCH1_SW1A/G.n8 XCH1_SW1A/G.n7 70.1096
R4376 XCH1_SW1A/G.n15 XCH1_SW1A/G.n9 6.10787
R4377 XCH1_SW1A/G.n16 XCH1_SW1A/G.n11 9.3005
R4378 XCH1_SW1A/G.n17 XCH1_SW1A/G.n13 6.10787
R4379 XCH1_SW1A/G.n14 XCH1_SW1A/G.n17 158.304
R4380 XCH1_SW1A/G.n13 XCH1_SW1A/G.n11 36.1417
R4381 XCH1_SW1A/G.n11 XCH1_SW1A/G.n9 36.1417
R4382 XCH1_SW1A/G.n7 XCH1_SW1A/G.n15 158.304
R4383 XCH1_SW1A/G.n16 XCH1_SW1A/G.n17 1.92
R4384 XCH1_SW1A/G.n15 XCH1_SW1A/G.n16 1.92
R4385 XCH1_SW1A/G.n14 XCH1_SW1A/G.t4 292.413
R4386 XCH1_SW1A/G.n2 XCH1_SW1A/G.t4 292.413
R4387 XCH1_SW1A/G.t3 XCH1_SW1A/G.n12 292.413
R4388 XCH1_SW1A/G.n4 XCH1_SW1A/G.t3 292.413
R4389 XCH1_SW1A/G.t2 XCH1_SW1A/G.n10 292.413
R4390 XCH1_SW1A/G.n5 XCH1_SW1A/G.t2 292.413
R4391 XCH1_SW1A/G.t1 XCH1_SW1A/G.n8 292.413
R4392 XCH1_SW1A/G.n6 XCH1_SW1A/G.t1 292.413
R4393 XCH1_SW1A/G.n3 ch1_lop 1.8738
R4394 XCH1_SW1A/B.t2 XCH1_SW1A/B.n0 73.1255
R4395 XCH1_SW1A/B.n0 XCH1_SW1A/B.n1 73.1255
R4396 XCH1_SW1A/B.n3 XCH1_SW1A/B.n2 83.5719
R4397 XCH1_SW1A/B.n4 XCH1_SW1A/B.t2 73.1255
R4398 VGND XCH1_SW1A/B.n4 73.1255
R4399 XCH1_SW1A/B.n6 XCH1_SW1A/B.n5 83.5719
R4400 XCH1_SW1A/B.n7 XCH1_SW1A/B.n6 83.5719
R4401 VGND XCH1_SW1A/B.n5 315.135
R4402 XCH1_SW1A/B.n5 XCH1_SW1A/B.t0 963.244
R4403 XCH1_SW1A/B.t1 XCH1_SW1A/B.t0 570.812
R4404 XCH1_SW1A/B.t2 XCH1_SW1A/B.t1 570.812
R4405 XCH1_SW1A/B.t2 XCH1_SW1A/B.t3 570.812
R4406 XCH1_SW1A/B.t3 XCH1_SW1A/B.t4 570.812
R4407 XCH1_SW1A/B.t4 XCH1_SW1A/B.n2 1046.81
R4408 VGND XCH1_SW1A/B.n7 246.213
R4409 VGND XCH1_SW1A/B.n3 246.213
R4410 XCH1_SW1A/B.n7 XCH1_SW1A/B.n1 246.213
R4411 XCH1_SW1A/B.n1 XCH1_SW1A/B.n3 246.213
R4412 XCH1_SW1A/B.n6 XCH1_SW1A/B.n4 3789.35
R4413 XCH1_SW1A/B.n4 XCH1_SW1A/B.n2 3789.35
R4414 XCH1_SW1A/B.n6 XCH1_SW1A/B.n0 3789.35
R4415 XCH1_SW1A/B.n0 XCH1_SW1A/B.n2 3789.35
R4416 VDPWR XCH1LP_P/S4.t0 75.1583
R4417 ch1_lop XCH1LP_P/D4.n0 1.74579
R4418 ch1_lop XCH1LP_P/D4.n1 65.0005
R4419 XCH1LP_P/D4.n1 XCH1LP_P/D4.t0 10.1583
R4420 XCH1LP_P/D4.n1 XCH1LP_P/D4.t1 10.1583
R4421 VDPWR XCH1LP_P/S3.n0 65.0005
R4422 XCH1LP_P/S3.n0 XCH1LP_P/S3.t0 10.1583
R4423 XCH1LP_P/S3.n0 XCH1LP_P/S3.t1 10.1583
R4424 ch1_lop XCH1LP_P/D2.n0 1.74579
R4425 ch1_lop XCH1LP_P/D2.n1 65.0005
R4426 XCH1LP_P/D2.n1 XCH1LP_P/D2.t1 10.1583
R4427 XCH1LP_P/D2.n1 XCH1LP_P/D2.t0 10.1583
R4428 VDPWR XCH1LP_P/S1.n0 65.0005
R4429 XCH1LP_P/S1.n0 XCH1LP_P/S1.t0 10.1583
R4430 XCH1LP_P/S1.n0 XCH1LP_P/S1.t1 10.1583
R4431 ch1_lop XCH1LP_P/D0.n0 1.74579
R4432 ch1_lop XCH1LP_P/D0.t0 75.1583
R4433 ch1_lop_raw XCH1LP_P/G.n0 9.3005
R4434 ch1_lop_raw XCH1LP_P/G.n0 0.0466957
R4435 ch1_lop_raw XCH1LP_P/G.n1 6.10787
R4436 XCH1LP_P/G.n1 XCH1LP_P/G.n0 1.92
R4437 XCH1LP_P/G.n2 ch1_lop_raw 152
R4438 ch1_lop_raw XCH1LP_P/G.n3 6.10787
R4439 XCH1LP_P/G.n4 ch1_lop_raw 152
R4440 XCH1LP_P/G.n5 ch1_lop_raw 152
R4441 XCH1LP_P/G.n6 ch1_lop_raw 152
R4442 ch1_lop_raw XCH1LP_P/G.n18 152
R4443 ch1_lop_raw XCH1LP_P/G.n3 6.3031
R4444 ch1_lop_raw XCH1LP_P/G.n1 6.3031
R4445 XCH1LP_P/G.n4 XCH1LP_P/G.n2 70.1096
R4446 XCH1LP_P/G.n5 XCH1LP_P/G.n4 70.1096
R4447 XCH1LP_P/G.n6 XCH1LP_P/G.n5 70.1096
R4448 XCH1LP_P/G.n18 XCH1LP_P/G.n6 70.1096
R4449 XCH1LP_P/G.n18 XCH1LP_P/G.t0 563.941
R4450 XCH1LP_P/G.t0 XCH1LP_P/G.n7 563.941
R4451 XCH1LP_P/G.n8 XCH1LP_P/G.n9 152
R4452 XCH1LP_P/G.n10 XCH1LP_P/G.n11 152
R4453 XCH1LP_P/G.n12 XCH1LP_P/G.n13 152
R4454 XCH1LP_P/G.n12 XCH1LP_P/G.n14 70.1096
R4455 XCH1LP_P/G.n12 XCH1LP_P/G.n10 70.1096
R4456 XCH1LP_P/G.n10 XCH1LP_P/G.n8 70.1096
R4457 XCH1LP_P/G.n8 XCH1LP_P/G.n7 70.1096
R4458 XCH1LP_P/G.n15 XCH1LP_P/G.n9 6.10787
R4459 XCH1LP_P/G.n16 XCH1LP_P/G.n11 9.3005
R4460 XCH1LP_P/G.n17 XCH1LP_P/G.n13 6.10787
R4461 XCH1LP_P/G.n14 XCH1LP_P/G.n17 158.304
R4462 XCH1LP_P/G.n13 XCH1LP_P/G.n11 36.1417
R4463 XCH1LP_P/G.n11 XCH1LP_P/G.n9 36.1417
R4464 XCH1LP_P/G.n7 XCH1LP_P/G.n15 158.304
R4465 XCH1LP_P/G.n16 XCH1LP_P/G.n17 1.92
R4466 XCH1LP_P/G.n15 XCH1LP_P/G.n16 1.92
R4467 XCH1LP_P/G.n14 XCH1LP_P/G.t4 563.941
R4468 XCH1LP_P/G.n2 XCH1LP_P/G.t4 563.941
R4469 XCH1LP_P/G.t3 XCH1LP_P/G.n12 563.941
R4470 XCH1LP_P/G.n4 XCH1LP_P/G.t3 563.941
R4471 XCH1LP_P/G.t2 XCH1LP_P/G.n10 563.941
R4472 XCH1LP_P/G.n5 XCH1LP_P/G.t2 563.941
R4473 XCH1LP_P/G.t1 XCH1LP_P/G.n8 563.941
R4474 XCH1LP_P/G.n6 XCH1LP_P/G.t1 563.941
R4475 XCH1LP_P/G.n3 ch1_lop_raw 1.8738
R4476 XCH1LP_P/B.n1 XCH1LP_P/B.t2 23.1255
R4477 VDPWR XCH1LP_P/B.n1 23.1255
R4478 XCH1LP_P/B.n0 VDPWR 16.5652
R4479 XCH1LP_P/B.n2 XCH1LP_P/B.n3 15.4172
R4480 XCH1LP_P/B.n0 XCH1LP_P/B.n3 293.272
R4481 XCH1LP_P/B.t2 XCH1LP_P/B.n4 23.1255
R4482 XCH1LP_P/B.n4 XCH1LP_P/B.n5 23.1255
R4483 XCH1LP_P/B.n3 XCH1LP_P/B.n5 309.836
R4484 XCH1LP_P/B.n7 XCH1LP_P/B.n6 15.4172
R4485 VDPWR XCH1LP_P/B.n7 309.836
R4486 XCH1LP_P/B.n7 XCH1LP_P/B.n5 309.836
R4487 XCH1LP_P/B.n1 XCH1LP_P/B.n6 2904.71
R4488 XCH1LP_P/B.n1 XCH1LP_P/B.n2 2904.71
R4489 XCH1LP_P/B.n2 XCH1LP_P/B.n4 2904.71
R4490 XCH1LP_P/B.n4 XCH1LP_P/B.n6 2904.71
R4491 XCH1LP_P/B.t0 XCH1LP_P/B.n2 158.181
R4492 XCH1LP_P/B.t1 XCH1LP_P/B.t0 84.6016
R4493 XCH1LP_P/B.t2 XCH1LP_P/B.t1 84.6016
R4494 XCH1LP_P/B.t2 XCH1LP_P/B.t3 84.6016
R4495 XCH1LP_P/B.t3 XCH1LP_P/B.t4 84.6016
R4496 XCH1LP_P/B.t4 XCH1LP_P/B.n6 158.181
R4497 XXP_P/S4.n0 ch2_lop_raw 0.141804
R4498 XXP_P/S4.t0 ch2_lop_raw 166.566
R4499 lop XXP_P/D4.n0 0.277674
R4500 XXP_P/D4.n1 lop 146.25
R4501 XXP_P/D4.t0 XXP_P/D4.n1 20.3161
R4502 XXP_P/D4.n1 XXP_P/D4.t1 20.3161
R4503 XXP_P/S3.n0 ch2_lop_raw 0.141804
R4504 XXP_P/S3.n1 ch2_lop_raw 146.25
R4505 XXP_P/S3.t1 XXP_P/S3.n1 20.3161
R4506 XXP_P/S3.n1 XXP_P/S3.t0 20.3161
R4507 lop XXP_P/D2.n0 0.277674
R4508 XXP_P/D2.n1 lop 146.25
R4509 XXP_P/D2.t1 XXP_P/D2.n1 20.3161
R4510 XXP_P/D2.n1 XXP_P/D2.t0 20.3161
R4511 XXP_P/S1.n0 ch2_lop_raw 0.141804
R4512 XXP_P/S1.n1 ch2_lop_raw 146.25
R4513 XXP_P/S1.t0 XXP_P/S1.n1 20.3161
R4514 XXP_P/S1.n1 XXP_P/S1.t1 20.3161
R4515 lop XXP_P/D0.n0 0.277674
R4516 lop XXP_P/D0.t0 166.566
R4517 select_b XXP_P/G.n0 9.3005
R4518 select_b XXP_P/G.n0 0.0466957
R4519 select_b XXP_P/G.n1 6.10787
R4520 XXP_P/G.n1 XXP_P/G.n0 1.92
R4521 XXP_P/G.n2 select_b 152
R4522 select_b XXP_P/G.n3 6.10787
R4523 XXP_P/G.n4 select_b 152
R4524 XXP_P/G.n5 select_b 152
R4525 XXP_P/G.n6 select_b 152
R4526 select_b XXP_P/G.n18 152
R4527 select_b XXP_P/G.n3 6.3031
R4528 select_b XXP_P/G.n1 6.3031
R4529 XXP_P/G.n4 XXP_P/G.n2 70.1096
R4530 XXP_P/G.n5 XXP_P/G.n4 70.1096
R4531 XXP_P/G.n6 XXP_P/G.n5 70.1096
R4532 XXP_P/G.n18 XXP_P/G.n6 70.1096
R4533 XXP_P/G.n18 XXP_P/G.t0 306.873
R4534 XXP_P/G.t0 XXP_P/G.n7 306.873
R4535 XXP_P/G.n8 XXP_P/G.n9 152
R4536 XXP_P/G.n10 XXP_P/G.n11 152
R4537 XXP_P/G.n12 XXP_P/G.n13 152
R4538 XXP_P/G.n12 XXP_P/G.n14 70.1096
R4539 XXP_P/G.n12 XXP_P/G.n10 70.1096
R4540 XXP_P/G.n10 XXP_P/G.n8 70.1096
R4541 XXP_P/G.n8 XXP_P/G.n7 70.1096
R4542 XXP_P/G.n15 XXP_P/G.n9 6.10787
R4543 XXP_P/G.n16 XXP_P/G.n11 9.3005
R4544 XXP_P/G.n17 XXP_P/G.n13 6.10787
R4545 XXP_P/G.n14 XXP_P/G.n17 158.304
R4546 XXP_P/G.n13 XXP_P/G.n11 36.1417
R4547 XXP_P/G.n11 XXP_P/G.n9 36.1417
R4548 XXP_P/G.n7 XXP_P/G.n15 158.304
R4549 XXP_P/G.n16 XXP_P/G.n17 1.92
R4550 XXP_P/G.n15 XXP_P/G.n16 1.92
R4551 XXP_P/G.n14 XXP_P/G.t4 306.873
R4552 XXP_P/G.n2 XXP_P/G.t4 306.873
R4553 XXP_P/G.t3 XXP_P/G.n12 306.873
R4554 XXP_P/G.n4 XXP_P/G.t3 306.873
R4555 XXP_P/G.t2 XXP_P/G.n10 306.873
R4556 XXP_P/G.n5 XXP_P/G.t2 306.873
R4557 XXP_P/G.t1 XXP_P/G.n8 306.873
R4558 XXP_P/G.n6 XXP_P/G.t1 306.873
R4559 XXP_P/G.n3 select_b 1.8738
R4560 XXP_P/B.n1 XXP_P/B.t2 23.1255
R4561 VDPWR XXP_P/B.n1 23.1255
R4562 XXP_P/B.n0 VDPWR 16.5652
R4563 XXP_P/B.n3 XXP_P/B.n2 26.4291
R4564 XXP_P/B.n0 XXP_P/B.n3 233.036
R4565 XXP_P/B.t2 XXP_P/B.n4 23.1255
R4566 XXP_P/B.n4 XXP_P/B.n5 23.1255
R4567 XXP_P/B.n5 XXP_P/B.n3 249.601
R4568 XXP_P/B.n7 XXP_P/B.n6 26.4291
R4569 VDPWR XXP_P/B.n7 249.601
R4570 XXP_P/B.n7 XXP_P/B.n5 249.601
R4571 XXP_P/B.n1 XXP_P/B.n6 2340
R4572 XXP_P/B.n1 XXP_P/B.n2 2340
R4573 XXP_P/B.n2 XXP_P/B.n4 2340
R4574 XXP_P/B.n4 XXP_P/B.n6 2340
R4575 XXP_P/B.n2 XXP_P/B.t0 229.464
R4576 XXP_P/B.t1 XXP_P/B.t0 120.317
R4577 XXP_P/B.t2 XXP_P/B.t1 120.317
R4578 XXP_P/B.t2 XXP_P/B.t3 120.317
R4579 XXP_P/B.t3 XXP_P/B.t4 120.317
R4580 XXP_P/B.t4 XXP_P/B.n6 229.464
R4581 XLN1_P/S2.n0 VDPWR 4.83528
R4582 VDPWR XLN1_P/S2.t0 333.132
R4583 ln1 XLN1_P/D2.n0 4.71028
R4584 ln1 XLN1_P/D2.n1 292.5
R4585 XLN1_P/D2.n1 XLN1_P/D2.t0 40.6317
R4586 XLN1_P/D2.n1 XLN1_P/D2.t1 40.6317
R4587 XLN1_P/S1.n0 VDPWR 4.83528
R4588 VDPWR XLN1_P/S1.n1 292.5
R4589 XLN1_P/S1.n1 XLN1_P/S1.t0 40.6317
R4590 XLN1_P/S1.n1 XLN1_P/S1.t1 40.6317
R4591 ln1 XLN1_P/D0.n0 4.71028
R4592 ln1 XLN1_P/D0.t0 333.132
R4593 clk XLN1_P/G.n0 6.10787
R4594 clk XLN1_P/G.n0 1.66888
R4595 XLN1_P/G.n1 clk 152
R4596 XLN1_P/G.n2 clk 152
R4597 clk XLN1_P/G.n4 152
R4598 clk XLN1_P/G.n0 6.3031
R4599 XLN1_P/G.n2 XLN1_P/G.n1 70.1096
R4600 XLN1_P/G.n4 XLN1_P/G.n2 70.1096
R4601 XLN1_P/G.n4 XLN1_P/G.t0 178.34
R4602 XLN1_P/G.t2 XLN1_P/G.n3 227.052
R4603 XLN1_P/G.t0 XLN1_P/G.n3 227.05
R4604 XLN1_P/G.n1 XLN1_P/G.t2 178.34
R4605 XLN1_P/G.n3 XLN1_P/G.t1 184.506
R4606 XLN1_P/G.n2 XLN1_P/G.t1 178.34
R4607 XLN1_P/B.n1 XLN1_P/B.t1 37.0005
R4608 VDPWR XLN1_P/B.n1 37.0005
R4609 XLN1_P/B.n0 VDPWR 16.5652
R4610 XLN1_P/B.n3 XLN1_P/B.n2 37.0005
R4611 XLN1_P/B.n0 XLN1_P/B.n3 166.776
R4612 XLN1_P/B.t1 XLN1_P/B.n4 37.0005
R4613 XLN1_P/B.n4 XLN1_P/B.n5 37.0005
R4614 XLN1_P/B.n5 XLN1_P/B.n3 183.341
R4615 XLN1_P/B.n7 XLN1_P/B.n6 37.0005
R4616 VDPWR XLN1_P/B.n7 183.341
R4617 XLN1_P/B.n7 XLN1_P/B.n5 183.341
R4618 XLN1_P/B.n1 XLN1_P/B.n6 1718.82
R4619 XLN1_P/B.n1 XLN1_P/B.n2 1718.82
R4620 XLN1_P/B.n2 XLN1_P/B.n4 1718.82
R4621 XLN1_P/B.n4 XLN1_P/B.n6 1718.82
R4622 XLN1_P/B.n2 XLN1_P/B.t0 294.358
R4623 XLN1_P/B.t1 XLN1_P/B.t0 152.508
R4624 XLN1_P/B.t1 XLN1_P/B.t2 152.508
R4625 XLN1_P/B.t2 XLN1_P/B.n6 294.358
R4626 tail2 XCH2_GM2A/S4.t0 57.1255
R4627 gm2_n XCH2_GM2A/D4.n0 2.60267
R4628 gm2_n XCH2_GM2A/D4.n1 46.2505
R4629 XCH2_GM2A/D4.n1 XCH2_GM2A/D4.t1 10.8755
R4630 XCH2_GM2A/D4.n1 XCH2_GM2A/D4.t0 10.8755
R4631 tail2 XCH2_GM2A/S3.n0 46.2505
R4632 XCH2_GM2A/S3.n0 XCH2_GM2A/S3.t0 10.8755
R4633 XCH2_GM2A/S3.n0 XCH2_GM2A/S3.t1 10.8755
R4634 gm2_n XCH2_GM2A/D2.n0 2.60267
R4635 gm2_n XCH2_GM2A/D2.n1 46.2505
R4636 XCH2_GM2A/D2.n1 XCH2_GM2A/D2.t1 10.8755
R4637 XCH2_GM2A/D2.n1 XCH2_GM2A/D2.t0 10.8755
R4638 tail2 XCH2_GM2A/S1.n0 46.2505
R4639 XCH2_GM2A/S1.n0 XCH2_GM2A/S1.t0 10.8755
R4640 XCH2_GM2A/S1.n0 XCH2_GM2A/S1.t1 10.8755
R4641 gm2_n XCH2_GM2A/D0.n0 2.60267
R4642 gm2_n XCH2_GM2A/D0.t0 57.1255
R4643 vcm XCH2_GM2A/G.n0 9.3005
R4644 vcm XCH2_GM2A/G.n0 0.0466957
R4645 vcm XCH2_GM2A/G.n1 6.51721
R4646 XCH2_GM2A/G.n1 XCH2_GM2A/G.n0 1.79883
R4647 vcm XCH2_GM2A/G.n2 6.51721
R4648 vcm XCH2_GM2A/G.n2 6.7822
R4649 vcm XCH2_GM2A/G.n1 6.7822
R4650 vcm XCH2_GM2A/G.t0 322.308
R4651 XCH2_GM2A/G.t0 XCH2_GM2A/G.n8 329.089
R4652 XCH2_GM2A/G.n3 XCH2_GM2A/G.n4 6.51721
R4653 XCH2_GM2A/G.n6 XCH2_GM2A/G.n5 9.3005
R4654 XCH2_GM2A/G.n8 XCH2_GM2A/G.n7 6.51721
R4655 XCH2_GM2A/G.n4 XCH2_GM2A/G.n5 44.424
R4656 XCH2_GM2A/G.n5 XCH2_GM2A/G.n7 44.424
R4657 XCH2_GM2A/G.n7 XCH2_GM2A/G.t1 322.308
R4658 XCH2_GM2A/G.t1 vcm 322.308
R4659 XCH2_GM2A/G.n5 XCH2_GM2A/G.t2 322.308
R4660 XCH2_GM2A/G.t2 vcm 322.308
R4661 XCH2_GM2A/G.n4 XCH2_GM2A/G.t3 322.308
R4662 XCH2_GM2A/G.t3 vcm 322.308
R4663 XCH2_GM2A/G.n8 XCH2_GM2A/G.n6 1.79883
R4664 XCH2_GM2A/G.n6 XCH2_GM2A/G.n3 1.79883
R4665 XCH2_GM2A/G.n3 XCH2_GM2A/G.t4 329.089
R4666 XCH2_GM2A/G.t4 vcm 322.308
R4667 XCH2_GM2A/G.n2 vcm 1.75264
R4668 XCH2_GM2A/B.t2 XCH2_GM2A/B.n0 58.5005
R4669 XCH2_GM2A/B.n0 XCH2_GM2A/B.n1 58.5005
R4670 XCH2_GM2A/B.n3 XCH2_GM2A/B.n2 83.5719
R4671 XCH2_GM2A/B.n4 XCH2_GM2A/B.t2 58.5005
R4672 VGND XCH2_GM2A/B.n4 58.5005
R4673 XCH2_GM2A/B.n6 XCH2_GM2A/B.n5 83.5719
R4674 XCH2_GM2A/B.n7 XCH2_GM2A/B.n6 83.5719
R4675 VGND XCH2_GM2A/B.n5 315.135
R4676 XCH2_GM2A/B.n5 XCH2_GM2A/B.t0 1028.65
R4677 XCH2_GM2A/B.t0 XCH2_GM2A/B.t1 701.622
R4678 XCH2_GM2A/B.t2 XCH2_GM2A/B.t1 701.622
R4679 XCH2_GM2A/B.t2 XCH2_GM2A/B.t3 701.622
R4680 XCH2_GM2A/B.t3 XCH2_GM2A/B.t4 701.622
R4681 XCH2_GM2A/B.n2 XCH2_GM2A/B.t4 1112.22
R4682 VGND XCH2_GM2A/B.n7 266.918
R4683 VGND XCH2_GM2A/B.n3 266.918
R4684 XCH2_GM2A/B.n7 XCH2_GM2A/B.n1 266.918
R4685 XCH2_GM2A/B.n1 XCH2_GM2A/B.n3 266.918
R4686 XCH2_GM2A/B.n6 XCH2_GM2A/B.n4 4108.03
R4687 XCH2_GM2A/B.n4 XCH2_GM2A/B.n2 4108.03
R4688 XCH2_GM2A/B.n6 XCH2_GM2A/B.n0 4108.03
R4689 XCH2_GM2A/B.n0 XCH2_GM2A/B.n2 4108.03
R4690 gm1_p XCH1_SW1B/S4.t0 58.6255
R4691 ua[2] XCH1_SW1B/D4.n0 0.277674
R4692 XCH1_SW1B/D4.n1 ua[2] 46.2505
R4693 XCH1_SW1B/D4.t0 XCH1_SW1B/D4.n1 12.3755
R4694 XCH1_SW1B/D4.n1 XCH1_SW1B/D4.t1 12.3755
R4695 gm1_p XCH1_SW1B/S3.n0 46.2505
R4696 XCH1_SW1B/S3.n0 XCH1_SW1B/S3.t1 12.3755
R4697 XCH1_SW1B/S3.n0 XCH1_SW1B/S3.t0 12.3755
R4698 ua[2] XCH1_SW1B/D2.n0 0.277674
R4699 XCH1_SW1B/D2.n1 ua[2] 46.2505
R4700 XCH1_SW1B/D2.t0 XCH1_SW1B/D2.n1 12.3755
R4701 XCH1_SW1B/D2.n1 XCH1_SW1B/D2.t1 12.3755
R4702 gm1_p XCH1_SW1B/S1.n0 46.2505
R4703 XCH1_SW1B/S1.n0 XCH1_SW1B/S1.t0 12.3755
R4704 XCH1_SW1B/S1.n0 XCH1_SW1B/S1.t1 12.3755
R4705 ua[2] XCH1_SW1B/D0.n0 0.277674
R4706 ua[2] XCH1_SW1B/D0.t0 58.6255
R4707 ch1_lop XCH1_SW1B/G.n0 9.3005
R4708 ch1_lop XCH1_SW1B/G.n0 0.0466957
R4709 ch1_lop XCH1_SW1B/G.n1 6.10787
R4710 XCH1_SW1B/G.n1 XCH1_SW1B/G.n0 1.92
R4711 XCH1_SW1B/G.n2 ch1_lop 152
R4712 ch1_lop XCH1_SW1B/G.n3 6.10787
R4713 XCH1_SW1B/G.n4 ch1_lop 152
R4714 XCH1_SW1B/G.n5 ch1_lop 152
R4715 XCH1_SW1B/G.n6 ch1_lop 152
R4716 ch1_lop XCH1_SW1B/G.n18 152
R4717 ch1_lop XCH1_SW1B/G.n3 6.3031
R4718 ch1_lop XCH1_SW1B/G.n1 6.3031
R4719 XCH1_SW1B/G.n4 XCH1_SW1B/G.n2 70.1096
R4720 XCH1_SW1B/G.n5 XCH1_SW1B/G.n4 70.1096
R4721 XCH1_SW1B/G.n6 XCH1_SW1B/G.n5 70.1096
R4722 XCH1_SW1B/G.n18 XCH1_SW1B/G.n6 70.1096
R4723 XCH1_SW1B/G.n18 XCH1_SW1B/G.t0 292.413
R4724 XCH1_SW1B/G.t0 XCH1_SW1B/G.n7 292.413
R4725 XCH1_SW1B/G.n8 XCH1_SW1B/G.n9 152
R4726 XCH1_SW1B/G.n10 XCH1_SW1B/G.n11 152
R4727 XCH1_SW1B/G.n12 XCH1_SW1B/G.n13 152
R4728 XCH1_SW1B/G.n12 XCH1_SW1B/G.n14 70.1096
R4729 XCH1_SW1B/G.n12 XCH1_SW1B/G.n10 70.1096
R4730 XCH1_SW1B/G.n10 XCH1_SW1B/G.n8 70.1096
R4731 XCH1_SW1B/G.n8 XCH1_SW1B/G.n7 70.1096
R4732 XCH1_SW1B/G.n15 XCH1_SW1B/G.n9 6.10787
R4733 XCH1_SW1B/G.n16 XCH1_SW1B/G.n11 9.3005
R4734 XCH1_SW1B/G.n17 XCH1_SW1B/G.n13 6.10787
R4735 XCH1_SW1B/G.n14 XCH1_SW1B/G.n17 158.304
R4736 XCH1_SW1B/G.n13 XCH1_SW1B/G.n11 36.1417
R4737 XCH1_SW1B/G.n11 XCH1_SW1B/G.n9 36.1417
R4738 XCH1_SW1B/G.n7 XCH1_SW1B/G.n15 158.304
R4739 XCH1_SW1B/G.n16 XCH1_SW1B/G.n17 1.92
R4740 XCH1_SW1B/G.n15 XCH1_SW1B/G.n16 1.92
R4741 XCH1_SW1B/G.n14 XCH1_SW1B/G.t4 292.413
R4742 XCH1_SW1B/G.n2 XCH1_SW1B/G.t4 292.413
R4743 XCH1_SW1B/G.t3 XCH1_SW1B/G.n12 292.413
R4744 XCH1_SW1B/G.n4 XCH1_SW1B/G.t3 292.413
R4745 XCH1_SW1B/G.t2 XCH1_SW1B/G.n10 292.413
R4746 XCH1_SW1B/G.n5 XCH1_SW1B/G.t2 292.413
R4747 XCH1_SW1B/G.t1 XCH1_SW1B/G.n8 292.413
R4748 XCH1_SW1B/G.n6 XCH1_SW1B/G.t1 292.413
R4749 XCH1_SW1B/G.n3 ch1_lop 1.8738
R4750 XCH1_SW1B/B.t2 XCH1_SW1B/B.n0 73.1255
R4751 XCH1_SW1B/B.n0 XCH1_SW1B/B.n1 73.1255
R4752 XCH1_SW1B/B.n3 XCH1_SW1B/B.n2 83.5719
R4753 XCH1_SW1B/B.n4 XCH1_SW1B/B.t2 73.1255
R4754 VGND XCH1_SW1B/B.n4 73.1255
R4755 XCH1_SW1B/B.n6 XCH1_SW1B/B.n5 83.5719
R4756 XCH1_SW1B/B.n7 XCH1_SW1B/B.n6 83.5719
R4757 VGND XCH1_SW1B/B.n5 315.135
R4758 XCH1_SW1B/B.n5 XCH1_SW1B/B.t0 963.244
R4759 XCH1_SW1B/B.t1 XCH1_SW1B/B.t0 570.812
R4760 XCH1_SW1B/B.t2 XCH1_SW1B/B.t1 570.812
R4761 XCH1_SW1B/B.t2 XCH1_SW1B/B.t3 570.812
R4762 XCH1_SW1B/B.t3 XCH1_SW1B/B.t4 570.812
R4763 XCH1_SW1B/B.t4 XCH1_SW1B/B.n2 1046.81
R4764 VGND XCH1_SW1B/B.n7 246.213
R4765 VGND XCH1_SW1B/B.n3 246.213
R4766 XCH1_SW1B/B.n7 XCH1_SW1B/B.n1 246.213
R4767 XCH1_SW1B/B.n1 XCH1_SW1B/B.n3 246.213
R4768 XCH1_SW1B/B.n6 XCH1_SW1B/B.n4 3789.35
R4769 XCH1_SW1B/B.n4 XCH1_SW1B/B.n2 3789.35
R4770 XCH1_SW1B/B.n6 XCH1_SW1B/B.n0 3789.35
R4771 XCH1_SW1B/B.n0 XCH1_SW1B/B.n2 3789.35
R4772 VGND XCH1LN_N/S4.t0 58.6255
R4773 ch1_lon XCH1LN_N/D4.n0 0.277674
R4774 XCH1LN_N/D4.n1 ch1_lon 46.2505
R4775 XCH1LN_N/D4.t0 XCH1LN_N/D4.n1 12.3755
R4776 XCH1LN_N/D4.n1 XCH1LN_N/D4.t1 12.3755
R4777 VGND XCH1LN_N/S3.n0 46.2505
R4778 XCH1LN_N/S3.n0 XCH1LN_N/S3.t1 12.3755
R4779 XCH1LN_N/S3.n0 XCH1LN_N/S3.t0 12.3755
R4780 ch1_lon XCH1LN_N/D2.n0 0.277674
R4781 XCH1LN_N/D2.n1 ch1_lon 46.2505
R4782 XCH1LN_N/D2.t0 XCH1LN_N/D2.n1 12.3755
R4783 XCH1LN_N/D2.n1 XCH1LN_N/D2.t1 12.3755
R4784 VGND XCH1LN_N/S1.n0 46.2505
R4785 XCH1LN_N/S1.n0 XCH1LN_N/S1.t0 12.3755
R4786 XCH1LN_N/S1.n0 XCH1LN_N/S1.t1 12.3755
R4787 ch1_lon XCH1LN_N/D0.n0 0.277674
R4788 ch1_lon XCH1LN_N/D0.t0 58.6255
R4789 ch1_lon_raw XCH1LN_N/G.n0 9.3005
R4790 ch1_lon_raw XCH1LN_N/G.n0 0.0466957
R4791 ch1_lon_raw XCH1LN_N/G.n1 6.10787
R4792 XCH1LN_N/G.n1 XCH1LN_N/G.n0 1.92
R4793 XCH1LN_N/G.n2 ch1_lon_raw 152
R4794 ch1_lon_raw XCH1LN_N/G.n3 6.10787
R4795 XCH1LN_N/G.n4 ch1_lon_raw 152
R4796 XCH1LN_N/G.n5 ch1_lon_raw 152
R4797 XCH1LN_N/G.n6 ch1_lon_raw 152
R4798 ch1_lon_raw XCH1LN_N/G.n18 152
R4799 ch1_lon_raw XCH1LN_N/G.n3 6.3031
R4800 ch1_lon_raw XCH1LN_N/G.n1 6.3031
R4801 XCH1LN_N/G.n4 XCH1LN_N/G.n2 70.1096
R4802 XCH1LN_N/G.n5 XCH1LN_N/G.n4 70.1096
R4803 XCH1LN_N/G.n6 XCH1LN_N/G.n5 70.1096
R4804 XCH1LN_N/G.n18 XCH1LN_N/G.n6 70.1096
R4805 XCH1LN_N/G.n18 XCH1LN_N/G.t0 292.413
R4806 XCH1LN_N/G.t0 XCH1LN_N/G.n7 292.413
R4807 XCH1LN_N/G.n8 XCH1LN_N/G.n9 152
R4808 XCH1LN_N/G.n10 XCH1LN_N/G.n11 152
R4809 XCH1LN_N/G.n12 XCH1LN_N/G.n13 152
R4810 XCH1LN_N/G.n12 XCH1LN_N/G.n14 70.1096
R4811 XCH1LN_N/G.n12 XCH1LN_N/G.n10 70.1096
R4812 XCH1LN_N/G.n10 XCH1LN_N/G.n8 70.1096
R4813 XCH1LN_N/G.n8 XCH1LN_N/G.n7 70.1096
R4814 XCH1LN_N/G.n15 XCH1LN_N/G.n9 6.10787
R4815 XCH1LN_N/G.n16 XCH1LN_N/G.n11 9.3005
R4816 XCH1LN_N/G.n17 XCH1LN_N/G.n13 6.10787
R4817 XCH1LN_N/G.n14 XCH1LN_N/G.n17 158.304
R4818 XCH1LN_N/G.n13 XCH1LN_N/G.n11 36.1417
R4819 XCH1LN_N/G.n11 XCH1LN_N/G.n9 36.1417
R4820 XCH1LN_N/G.n7 XCH1LN_N/G.n15 158.304
R4821 XCH1LN_N/G.n16 XCH1LN_N/G.n17 1.92
R4822 XCH1LN_N/G.n15 XCH1LN_N/G.n16 1.92
R4823 XCH1LN_N/G.n14 XCH1LN_N/G.t4 292.413
R4824 XCH1LN_N/G.n2 XCH1LN_N/G.t4 292.413
R4825 XCH1LN_N/G.t3 XCH1LN_N/G.n12 292.413
R4826 XCH1LN_N/G.n4 XCH1LN_N/G.t3 292.413
R4827 XCH1LN_N/G.t2 XCH1LN_N/G.n10 292.413
R4828 XCH1LN_N/G.n5 XCH1LN_N/G.t2 292.413
R4829 XCH1LN_N/G.t1 XCH1LN_N/G.n8 292.413
R4830 XCH1LN_N/G.n6 XCH1LN_N/G.t1 292.413
R4831 XCH1LN_N/G.n3 ch1_lon_raw 1.8738
R4832 XCH1LN_N/B.t2 XCH1LN_N/B.n0 73.1255
R4833 XCH1LN_N/B.n0 XCH1LN_N/B.n1 73.1255
R4834 XCH1LN_N/B.n3 XCH1LN_N/B.n2 83.5719
R4835 XCH1LN_N/B.n4 XCH1LN_N/B.t2 73.1255
R4836 VGND XCH1LN_N/B.n4 73.1255
R4837 XCH1LN_N/B.n6 XCH1LN_N/B.n5 83.5719
R4838 XCH1LN_N/B.n7 XCH1LN_N/B.n6 83.5719
R4839 VGND XCH1LN_N/B.n5 315.135
R4840 XCH1LN_N/B.n5 XCH1LN_N/B.t0 963.244
R4841 XCH1LN_N/B.t1 XCH1LN_N/B.t0 570.812
R4842 XCH1LN_N/B.t2 XCH1LN_N/B.t1 570.812
R4843 XCH1LN_N/B.t2 XCH1LN_N/B.t3 570.812
R4844 XCH1LN_N/B.t3 XCH1LN_N/B.t4 570.812
R4845 XCH1LN_N/B.t4 XCH1LN_N/B.n2 1046.81
R4846 VGND XCH1LN_N/B.n7 246.213
R4847 VGND XCH1LN_N/B.n3 246.213
R4848 XCH1LN_N/B.n7 XCH1LN_N/B.n1 246.213
R4849 XCH1LN_N/B.n1 XCH1LN_N/B.n3 246.213
R4850 XCH1LN_N/B.n6 XCH1LN_N/B.n4 3789.35
R4851 XCH1LN_N/B.n4 XCH1LN_N/B.n2 3789.35
R4852 XCH1LN_N/B.n6 XCH1LN_N/B.n0 3789.35
R4853 XCH1LN_N/B.n0 XCH1LN_N/B.n2 3789.35
R4854 ch2_lon_raw XXN_N/S4.t0 117.251
R4855 lon XXN_N/D4.n0 4.71028
R4856 lon XXN_N/D4.n1 92.5005
R4857 XXN_N/D4.n1 XXN_N/D4.t1 24.7505
R4858 XXN_N/D4.n1 XXN_N/D4.t0 24.7505
R4859 ch2_lon_raw XXN_N/S3.n0 92.5005
R4860 XXN_N/S3.n0 XXN_N/S3.t0 24.7505
R4861 XXN_N/S3.n0 XXN_N/S3.t1 24.7505
R4862 lon XXN_N/D2.n0 4.71028
R4863 lon XXN_N/D2.n1 92.5005
R4864 XXN_N/D2.n1 XXN_N/D2.t0 24.7505
R4865 XXN_N/D2.n1 XXN_N/D2.t1 24.7505
R4866 ch2_lon_raw XXN_N/S1.n0 92.5005
R4867 XXN_N/S1.n0 XXN_N/S1.t0 24.7505
R4868 XXN_N/S1.n0 XXN_N/S1.t1 24.7505
R4869 lon XXN_N/D0.n0 4.71028
R4870 lon XXN_N/D0.t0 117.251
R4871 ui_in[0] XXN_N/G.n0 9.3005
R4872 ui_in[0] XXN_N/G.n0 0.0466957
R4873 ui_in[0] XXN_N/G.n1 6.10787
R4874 XXN_N/G.n1 XXN_N/G.n0 1.92
R4875 XXN_N/G.n2 ui_in[0] 152
R4876 ui_in[0] XXN_N/G.n3 6.10787
R4877 XXN_N/G.n4 ui_in[0] 152
R4878 XXN_N/G.n5 ui_in[0] 152
R4879 XXN_N/G.n6 ui_in[0] 152
R4880 ui_in[0] XXN_N/G.n18 152
R4881 ui_in[0] XXN_N/G.n3 6.3031
R4882 ui_in[0] XXN_N/G.n1 6.3031
R4883 XXN_N/G.n4 XXN_N/G.n2 70.1096
R4884 XXN_N/G.n5 XXN_N/G.n4 70.1096
R4885 XXN_N/G.n6 XXN_N/G.n5 70.1096
R4886 XXN_N/G.n18 XXN_N/G.n6 70.1096
R4887 XXN_N/G.n18 XXN_N/G.t0 163.881
R4888 XXN_N/G.t0 XXN_N/G.n7 163.881
R4889 XXN_N/G.n8 XXN_N/G.n9 152
R4890 XXN_N/G.n10 XXN_N/G.n11 152
R4891 XXN_N/G.n12 XXN_N/G.n13 152
R4892 XXN_N/G.n12 XXN_N/G.n14 70.1096
R4893 XXN_N/G.n10 XXN_N/G.n12 70.1096
R4894 XXN_N/G.n10 XXN_N/G.n8 70.1096
R4895 XXN_N/G.n7 XXN_N/G.n8 70.1096
R4896 XXN_N/G.n15 XXN_N/G.n9 6.10787
R4897 XXN_N/G.n16 XXN_N/G.n11 9.3005
R4898 XXN_N/G.n17 XXN_N/G.n13 6.10787
R4899 XXN_N/G.n14 XXN_N/G.n17 158.304
R4900 XXN_N/G.n13 XXN_N/G.n11 36.1417
R4901 XXN_N/G.n11 XXN_N/G.n9 36.1417
R4902 XXN_N/G.n7 XXN_N/G.n15 158.304
R4903 XXN_N/G.n16 XXN_N/G.n17 1.92
R4904 XXN_N/G.n15 XXN_N/G.n16 1.92
R4905 XXN_N/G.n14 XXN_N/G.t4 163.881
R4906 XXN_N/G.n2 XXN_N/G.t4 163.881
R4907 XXN_N/G.n12 XXN_N/G.t3 163.881
R4908 XXN_N/G.n4 XXN_N/G.t3 163.881
R4909 XXN_N/G.t2 XXN_N/G.n10 163.881
R4910 XXN_N/G.n5 XXN_N/G.t2 163.881
R4911 XXN_N/G.n8 XXN_N/G.t1 163.881
R4912 XXN_N/G.n6 XXN_N/G.t1 163.881
R4913 XXN_N/G.n3 ui_in[0] 1.8738
R4914 XXN_N/B.t2 XXN_N/B.n0 73.1255
R4915 XXN_N/B.n0 XXN_N/B.n1 73.1255
R4916 XXN_N/B.n3 XXN_N/B.n2 117.001
R4917 XXN_N/B.n4 XXN_N/B.t2 73.1255
R4918 VGND XXN_N/B.n4 73.1255
R4919 XXN_N/B.n6 XXN_N/B.n5 117.001
R4920 XXN_N/B.n7 XXN_N/B.n6 117.001
R4921 VGND XXN_N/B.n5 402.07
R4922 XXN_N/B.n5 XXN_N/B.t0 1228.97
R4923 XXN_N/B.t1 XXN_N/B.t0 728.277
R4924 XXN_N/B.t2 XXN_N/B.t1 728.277
R4925 XXN_N/B.t2 XXN_N/B.t3 728.277
R4926 XXN_N/B.t3 XXN_N/B.t4 728.277
R4927 XXN_N/B.t4 XXN_N/B.n2 1345.97
R4928 VGND XXN_N/B.n7 216.095
R4929 VGND XXN_N/B.n3 216.095
R4930 XXN_N/B.n7 XXN_N/B.n1 216.095
R4931 XXN_N/B.n1 XXN_N/B.n3 216.095
R4932 XXN_N/B.n6 XXN_N/B.n4 3325.82
R4933 XXN_N/B.n4 XXN_N/B.n2 3325.82
R4934 XXN_N/B.n6 XXN_N/B.n0 3325.82
R4935 XXN_N/B.n0 XXN_N/B.n2 3325.82
R4936 X1DP_P/S4.n0 ch1_lop_raw 0.141804
R4937 X1DP_P/S4.t0 ch1_lop_raw 166.566
R4938 lon X1DP_P/D4.n0 0.277674
R4939 X1DP_P/D4.n1 lon 146.25
R4940 X1DP_P/D4.t0 X1DP_P/D4.n1 20.3161
R4941 X1DP_P/D4.n1 X1DP_P/D4.t1 20.3161
R4942 X1DP_P/S3.n0 ch1_lop_raw 0.141804
R4943 X1DP_P/S3.n1 ch1_lop_raw 146.25
R4944 X1DP_P/S3.t1 X1DP_P/S3.n1 20.3161
R4945 X1DP_P/S3.n1 X1DP_P/S3.t0 20.3161
R4946 lon X1DP_P/D2.n0 0.277674
R4947 X1DP_P/D2.n1 lon 146.25
R4948 X1DP_P/D2.t1 X1DP_P/D2.n1 20.3161
R4949 X1DP_P/D2.n1 X1DP_P/D2.t0 20.3161
R4950 X1DP_P/S1.n0 ch1_lop_raw 0.141804
R4951 X1DP_P/S1.n1 ch1_lop_raw 146.25
R4952 X1DP_P/S1.t0 X1DP_P/S1.n1 20.3161
R4953 X1DP_P/S1.n1 X1DP_P/S1.t1 20.3161
R4954 lon X1DP_P/D0.n0 0.277674
R4955 lon X1DP_P/D0.t0 166.566
R4956 VGND X1DP_P/G.n0 9.3005
R4957 VGND X1DP_P/G.n0 0.0466957
R4958 VGND X1DP_P/G.n1 6.10787
R4959 X1DP_P/G.n1 X1DP_P/G.n0 1.92
R4960 X1DP_P/G.n2 VGND 152
R4961 VGND X1DP_P/G.n3 6.10787
R4962 X1DP_P/G.n4 VGND 152
R4963 X1DP_P/G.n5 VGND 152
R4964 X1DP_P/G.n6 VGND 152
R4965 VGND X1DP_P/G.n18 152
R4966 VGND X1DP_P/G.n3 6.3031
R4967 VGND X1DP_P/G.n1 6.3031
R4968 X1DP_P/G.n4 X1DP_P/G.n2 70.1096
R4969 X1DP_P/G.n5 X1DP_P/G.n4 70.1096
R4970 X1DP_P/G.n6 X1DP_P/G.n5 70.1096
R4971 X1DP_P/G.n18 X1DP_P/G.n6 70.1096
R4972 X1DP_P/G.n18 X1DP_P/G.t0 306.873
R4973 X1DP_P/G.t0 X1DP_P/G.n7 306.873
R4974 X1DP_P/G.n8 X1DP_P/G.n9 152
R4975 X1DP_P/G.n10 X1DP_P/G.n11 152
R4976 X1DP_P/G.n12 X1DP_P/G.n13 152
R4977 X1DP_P/G.n12 X1DP_P/G.n14 70.1096
R4978 X1DP_P/G.n12 X1DP_P/G.n10 70.1096
R4979 X1DP_P/G.n10 X1DP_P/G.n8 70.1096
R4980 X1DP_P/G.n8 X1DP_P/G.n7 70.1096
R4981 X1DP_P/G.n15 X1DP_P/G.n9 6.10787
R4982 X1DP_P/G.n16 X1DP_P/G.n11 9.3005
R4983 X1DP_P/G.n17 X1DP_P/G.n13 6.10787
R4984 X1DP_P/G.n14 X1DP_P/G.n17 158.304
R4985 X1DP_P/G.n13 X1DP_P/G.n11 36.1417
R4986 X1DP_P/G.n11 X1DP_P/G.n9 36.1417
R4987 X1DP_P/G.n7 X1DP_P/G.n15 158.304
R4988 X1DP_P/G.n16 X1DP_P/G.n17 1.92
R4989 X1DP_P/G.n15 X1DP_P/G.n16 1.92
R4990 X1DP_P/G.n14 X1DP_P/G.t4 306.873
R4991 X1DP_P/G.n2 X1DP_P/G.t4 306.873
R4992 X1DP_P/G.t3 X1DP_P/G.n12 306.873
R4993 X1DP_P/G.n4 X1DP_P/G.t3 306.873
R4994 X1DP_P/G.t2 X1DP_P/G.n10 306.873
R4995 X1DP_P/G.n5 X1DP_P/G.t2 306.873
R4996 X1DP_P/G.t1 X1DP_P/G.n8 306.873
R4997 X1DP_P/G.n6 X1DP_P/G.t1 306.873
R4998 X1DP_P/G.n3 VGND 1.8738
R4999 X1DP_P/B.n1 X1DP_P/B.t2 23.1255
R5000 VDPWR X1DP_P/B.n1 23.1255
R5001 X1DP_P/B.n0 VDPWR 16.5652
R5002 X1DP_P/B.n3 X1DP_P/B.n2 26.4291
R5003 X1DP_P/B.n0 X1DP_P/B.n3 233.036
R5004 X1DP_P/B.t2 X1DP_P/B.n4 23.1255
R5005 X1DP_P/B.n4 X1DP_P/B.n5 23.1255
R5006 X1DP_P/B.n5 X1DP_P/B.n3 249.601
R5007 X1DP_P/B.n7 X1DP_P/B.n6 26.4291
R5008 VDPWR X1DP_P/B.n7 249.601
R5009 X1DP_P/B.n7 X1DP_P/B.n5 249.601
R5010 X1DP_P/B.n1 X1DP_P/B.n6 2340
R5011 X1DP_P/B.n1 X1DP_P/B.n2 2340
R5012 X1DP_P/B.n2 X1DP_P/B.n4 2340
R5013 X1DP_P/B.n4 X1DP_P/B.n6 2340
R5014 X1DP_P/B.n2 X1DP_P/B.t0 229.464
R5015 X1DP_P/B.t1 X1DP_P/B.t0 120.317
R5016 X1DP_P/B.t2 X1DP_P/B.t1 120.317
R5017 X1DP_P/B.t2 X1DP_P/B.t3 120.317
R5018 X1DP_P/B.t3 X1DP_P/B.t4 120.317
R5019 X1DP_P/B.t4 X1DP_P/B.n6 229.464
R5020 tail2 XCH2_GM2B/S4.t0 57.1255
R5021 gm2_n XCH2_GM2B/D4.n0 2.60267
R5022 gm2_n XCH2_GM2B/D4.n1 46.2505
R5023 XCH2_GM2B/D4.n1 XCH2_GM2B/D4.t1 10.8755
R5024 XCH2_GM2B/D4.n1 XCH2_GM2B/D4.t0 10.8755
R5025 tail2 XCH2_GM2B/S3.n0 46.2505
R5026 XCH2_GM2B/S3.n0 XCH2_GM2B/S3.t0 10.8755
R5027 XCH2_GM2B/S3.n0 XCH2_GM2B/S3.t1 10.8755
R5028 gm2_n XCH2_GM2B/D2.n0 2.60267
R5029 gm2_n XCH2_GM2B/D2.n1 46.2505
R5030 XCH2_GM2B/D2.n1 XCH2_GM2B/D2.t1 10.8755
R5031 XCH2_GM2B/D2.n1 XCH2_GM2B/D2.t0 10.8755
R5032 tail2 XCH2_GM2B/S1.n0 46.2505
R5033 XCH2_GM2B/S1.n0 XCH2_GM2B/S1.t0 10.8755
R5034 XCH2_GM2B/S1.n0 XCH2_GM2B/S1.t1 10.8755
R5035 gm2_n XCH2_GM2B/D0.n0 2.60267
R5036 gm2_n XCH2_GM2B/D0.t0 57.1255
R5037 vcm XCH2_GM2B/G.n0 9.3005
R5038 vcm XCH2_GM2B/G.n0 0.0466957
R5039 vcm XCH2_GM2B/G.n1 6.51721
R5040 XCH2_GM2B/G.n1 XCH2_GM2B/G.n0 1.79883
R5041 vcm XCH2_GM2B/G.n2 6.51721
R5042 vcm XCH2_GM2B/G.n2 6.7822
R5043 vcm XCH2_GM2B/G.n1 6.7822
R5044 vcm XCH2_GM2B/G.t0 322.308
R5045 XCH2_GM2B/G.t0 XCH2_GM2B/G.n8 329.089
R5046 XCH2_GM2B/G.n3 XCH2_GM2B/G.n4 6.51721
R5047 XCH2_GM2B/G.n6 XCH2_GM2B/G.n5 9.3005
R5048 XCH2_GM2B/G.n8 XCH2_GM2B/G.n7 6.51721
R5049 XCH2_GM2B/G.n4 XCH2_GM2B/G.n5 44.424
R5050 XCH2_GM2B/G.n5 XCH2_GM2B/G.n7 44.424
R5051 XCH2_GM2B/G.n7 XCH2_GM2B/G.t1 322.308
R5052 XCH2_GM2B/G.t1 vcm 322.308
R5053 XCH2_GM2B/G.n5 XCH2_GM2B/G.t2 322.308
R5054 XCH2_GM2B/G.t2 vcm 322.308
R5055 XCH2_GM2B/G.n4 XCH2_GM2B/G.t3 322.308
R5056 XCH2_GM2B/G.t3 vcm 322.308
R5057 XCH2_GM2B/G.n8 XCH2_GM2B/G.n6 1.79883
R5058 XCH2_GM2B/G.n6 XCH2_GM2B/G.n3 1.79883
R5059 XCH2_GM2B/G.n3 XCH2_GM2B/G.t4 329.089
R5060 XCH2_GM2B/G.t4 vcm 322.308
R5061 XCH2_GM2B/G.n2 vcm 1.75264
R5062 XCH2_GM2B/B.t2 XCH2_GM2B/B.n0 58.5005
R5063 XCH2_GM2B/B.n0 XCH2_GM2B/B.n1 58.5005
R5064 XCH2_GM2B/B.n3 XCH2_GM2B/B.n2 83.5719
R5065 XCH2_GM2B/B.n4 XCH2_GM2B/B.t2 58.5005
R5066 VGND XCH2_GM2B/B.n4 58.5005
R5067 XCH2_GM2B/B.n6 XCH2_GM2B/B.n5 83.5719
R5068 XCH2_GM2B/B.n7 XCH2_GM2B/B.n6 83.5719
R5069 VGND XCH2_GM2B/B.n5 315.135
R5070 XCH2_GM2B/B.n5 XCH2_GM2B/B.t0 1028.65
R5071 XCH2_GM2B/B.t0 XCH2_GM2B/B.t1 701.622
R5072 XCH2_GM2B/B.t2 XCH2_GM2B/B.t1 701.622
R5073 XCH2_GM2B/B.t2 XCH2_GM2B/B.t3 701.622
R5074 XCH2_GM2B/B.t3 XCH2_GM2B/B.t4 701.622
R5075 XCH2_GM2B/B.n2 XCH2_GM2B/B.t4 1112.22
R5076 VGND XCH2_GM2B/B.n7 266.918
R5077 VGND XCH2_GM2B/B.n3 266.918
R5078 XCH2_GM2B/B.n7 XCH2_GM2B/B.n1 266.918
R5079 XCH2_GM2B/B.n1 XCH2_GM2B/B.n3 266.918
R5080 XCH2_GM2B/B.n6 XCH2_GM2B/B.n4 4108.03
R5081 XCH2_GM2B/B.n4 XCH2_GM2B/B.n2 4108.03
R5082 XCH2_GM2B/B.n6 XCH2_GM2B/B.n0 4108.03
R5083 XCH2_GM2B/B.n0 XCH2_GM2B/B.n2 4108.03
R5084 tail2 XCH2_GM1A/S4.t0 57.1255
R5085 gm2_p XCH2_GM1A/D4.n0 2.60267
R5086 gm2_p XCH2_GM1A/D4.n1 46.2505
R5087 XCH2_GM1A/D4.n1 XCH2_GM1A/D4.t1 10.8755
R5088 XCH2_GM1A/D4.n1 XCH2_GM1A/D4.t0 10.8755
R5089 tail2 XCH2_GM1A/S3.n0 46.2505
R5090 XCH2_GM1A/S3.n0 XCH2_GM1A/S3.t0 10.8755
R5091 XCH2_GM1A/S3.n0 XCH2_GM1A/S3.t1 10.8755
R5092 gm2_p XCH2_GM1A/D2.n0 2.60267
R5093 gm2_p XCH2_GM1A/D2.n1 46.2505
R5094 XCH2_GM1A/D2.n1 XCH2_GM1A/D2.t1 10.8755
R5095 XCH2_GM1A/D2.n1 XCH2_GM1A/D2.t0 10.8755
R5096 tail2 XCH2_GM1A/S1.n0 46.2505
R5097 XCH2_GM1A/S1.n0 XCH2_GM1A/S1.t0 10.8755
R5098 XCH2_GM1A/S1.n0 XCH2_GM1A/S1.t1 10.8755
R5099 gm2_p XCH2_GM1A/D0.n0 2.60267
R5100 gm2_p XCH2_GM1A/D0.t0 57.1255
R5101 ua[1] XCH2_GM1A/G.n0 9.3005
R5102 ua[1] XCH2_GM1A/G.n0 0.0466957
R5103 ua[1] XCH2_GM1A/G.n1 6.51721
R5104 XCH2_GM1A/G.n1 XCH2_GM1A/G.n0 1.79883
R5105 ua[1] XCH2_GM1A/G.n2 6.51721
R5106 ua[1] XCH2_GM1A/G.n2 6.7822
R5107 ua[1] XCH2_GM1A/G.n1 6.7822
R5108 ua[1] XCH2_GM1A/G.t0 322.308
R5109 XCH2_GM1A/G.t0 XCH2_GM1A/G.n8 329.089
R5110 XCH2_GM1A/G.n3 XCH2_GM1A/G.n4 6.51721
R5111 XCH2_GM1A/G.n6 XCH2_GM1A/G.n5 9.3005
R5112 XCH2_GM1A/G.n8 XCH2_GM1A/G.n7 6.51721
R5113 XCH2_GM1A/G.n4 XCH2_GM1A/G.n5 44.424
R5114 XCH2_GM1A/G.n5 XCH2_GM1A/G.n7 44.424
R5115 XCH2_GM1A/G.n7 XCH2_GM1A/G.t1 322.308
R5116 XCH2_GM1A/G.t1 ua[1] 322.308
R5117 XCH2_GM1A/G.n5 XCH2_GM1A/G.t2 322.308
R5118 XCH2_GM1A/G.t2 ua[1] 322.308
R5119 XCH2_GM1A/G.n4 XCH2_GM1A/G.t3 322.308
R5120 XCH2_GM1A/G.t3 ua[1] 322.308
R5121 XCH2_GM1A/G.n8 XCH2_GM1A/G.n6 1.79883
R5122 XCH2_GM1A/G.n6 XCH2_GM1A/G.n3 1.79883
R5123 XCH2_GM1A/G.n3 XCH2_GM1A/G.t4 329.089
R5124 XCH2_GM1A/G.t4 ua[1] 322.308
R5125 XCH2_GM1A/G.n2 ua[1] 1.75264
R5126 XCH2_GM1A/B.t2 XCH2_GM1A/B.n0 58.5005
R5127 XCH2_GM1A/B.n0 XCH2_GM1A/B.n1 58.5005
R5128 XCH2_GM1A/B.n3 XCH2_GM1A/B.n2 83.5719
R5129 XCH2_GM1A/B.n4 XCH2_GM1A/B.t2 58.5005
R5130 VGND XCH2_GM1A/B.n4 58.5005
R5131 XCH2_GM1A/B.n6 XCH2_GM1A/B.n5 83.5719
R5132 XCH2_GM1A/B.n7 XCH2_GM1A/B.n6 83.5719
R5133 VGND XCH2_GM1A/B.n5 315.135
R5134 XCH2_GM1A/B.n5 XCH2_GM1A/B.t0 1028.65
R5135 XCH2_GM1A/B.t0 XCH2_GM1A/B.t1 701.622
R5136 XCH2_GM1A/B.t2 XCH2_GM1A/B.t1 701.622
R5137 XCH2_GM1A/B.t2 XCH2_GM1A/B.t3 701.622
R5138 XCH2_GM1A/B.t3 XCH2_GM1A/B.t4 701.622
R5139 XCH2_GM1A/B.n2 XCH2_GM1A/B.t4 1112.22
R5140 VGND XCH2_GM1A/B.n7 266.918
R5141 VGND XCH2_GM1A/B.n3 266.918
R5142 XCH2_GM1A/B.n7 XCH2_GM1A/B.n1 266.918
R5143 XCH2_GM1A/B.n1 XCH2_GM1A/B.n3 266.918
R5144 XCH2_GM1A/B.n6 XCH2_GM1A/B.n4 4108.03
R5145 XCH2_GM1A/B.n4 XCH2_GM1A/B.n2 4108.03
R5146 XCH2_GM1A/B.n6 XCH2_GM1A/B.n0 4108.03
R5147 XCH2_GM1A/B.n0 XCH2_GM1A/B.n2 4108.03
R5148 ch1_lon_raw X1DN_N/S4.t0 117.251
R5149 lop X1DN_N/D4.n0 4.71028
R5150 lop X1DN_N/D4.n1 92.5005
R5151 X1DN_N/D4.n1 X1DN_N/D4.t1 24.7505
R5152 X1DN_N/D4.n1 X1DN_N/D4.t0 24.7505
R5153 ch1_lon_raw X1DN_N/S3.n0 92.5005
R5154 X1DN_N/S3.n0 X1DN_N/S3.t0 24.7505
R5155 X1DN_N/S3.n0 X1DN_N/S3.t1 24.7505
R5156 lop X1DN_N/D2.n0 4.71028
R5157 lop X1DN_N/D2.n1 92.5005
R5158 X1DN_N/D2.n1 X1DN_N/D2.t0 24.7505
R5159 X1DN_N/D2.n1 X1DN_N/D2.t1 24.7505
R5160 ch1_lon_raw X1DN_N/S1.n0 92.5005
R5161 X1DN_N/S1.n0 X1DN_N/S1.t0 24.7505
R5162 X1DN_N/S1.n0 X1DN_N/S1.t1 24.7505
R5163 lop X1DN_N/D0.n0 4.71028
R5164 lop X1DN_N/D0.t0 117.251
R5165 VDPWR X1DN_N/G.n0 9.3005
R5166 VDPWR X1DN_N/G.n0 0.0466957
R5167 VDPWR X1DN_N/G.n1 6.10787
R5168 X1DN_N/G.n1 X1DN_N/G.n0 1.92
R5169 X1DN_N/G.n2 VDPWR 152
R5170 VDPWR X1DN_N/G.n3 6.10787
R5171 X1DN_N/G.n4 VDPWR 152
R5172 X1DN_N/G.n5 VDPWR 152
R5173 X1DN_N/G.n6 VDPWR 152
R5174 VDPWR X1DN_N/G.n18 152
R5175 VDPWR X1DN_N/G.n3 6.3031
R5176 VDPWR X1DN_N/G.n1 6.3031
R5177 X1DN_N/G.n4 X1DN_N/G.n2 70.1096
R5178 X1DN_N/G.n5 X1DN_N/G.n4 70.1096
R5179 X1DN_N/G.n6 X1DN_N/G.n5 70.1096
R5180 X1DN_N/G.n18 X1DN_N/G.n6 70.1096
R5181 X1DN_N/G.n18 X1DN_N/G.t0 163.881
R5182 X1DN_N/G.t0 X1DN_N/G.n7 163.881
R5183 X1DN_N/G.n8 X1DN_N/G.n9 152
R5184 X1DN_N/G.n10 X1DN_N/G.n11 152
R5185 X1DN_N/G.n12 X1DN_N/G.n13 152
R5186 X1DN_N/G.n12 X1DN_N/G.n14 70.1096
R5187 X1DN_N/G.n10 X1DN_N/G.n12 70.1096
R5188 X1DN_N/G.n10 X1DN_N/G.n8 70.1096
R5189 X1DN_N/G.n7 X1DN_N/G.n8 70.1096
R5190 X1DN_N/G.n15 X1DN_N/G.n9 6.10787
R5191 X1DN_N/G.n16 X1DN_N/G.n11 9.3005
R5192 X1DN_N/G.n17 X1DN_N/G.n13 6.10787
R5193 X1DN_N/G.n14 X1DN_N/G.n17 158.304
R5194 X1DN_N/G.n13 X1DN_N/G.n11 36.1417
R5195 X1DN_N/G.n11 X1DN_N/G.n9 36.1417
R5196 X1DN_N/G.n7 X1DN_N/G.n15 158.304
R5197 X1DN_N/G.n16 X1DN_N/G.n17 1.92
R5198 X1DN_N/G.n15 X1DN_N/G.n16 1.92
R5199 X1DN_N/G.n14 X1DN_N/G.t4 163.881
R5200 X1DN_N/G.n2 X1DN_N/G.t4 163.881
R5201 X1DN_N/G.n12 X1DN_N/G.t3 163.881
R5202 X1DN_N/G.n4 X1DN_N/G.t3 163.881
R5203 X1DN_N/G.t2 X1DN_N/G.n10 163.881
R5204 X1DN_N/G.n5 X1DN_N/G.t2 163.881
R5205 X1DN_N/G.n8 X1DN_N/G.t1 163.881
R5206 X1DN_N/G.n6 X1DN_N/G.t1 163.881
R5207 X1DN_N/G.n3 VDPWR 1.8738
R5208 X1DN_N/B.t2 X1DN_N/B.n0 73.1255
R5209 X1DN_N/B.n0 X1DN_N/B.n1 73.1255
R5210 X1DN_N/B.n3 X1DN_N/B.n2 117.001
R5211 X1DN_N/B.n4 X1DN_N/B.t2 73.1255
R5212 VGND X1DN_N/B.n4 73.1255
R5213 X1DN_N/B.n6 X1DN_N/B.n5 117.001
R5214 X1DN_N/B.n7 X1DN_N/B.n6 117.001
R5215 VGND X1DN_N/B.n5 402.07
R5216 X1DN_N/B.n5 X1DN_N/B.t0 1228.97
R5217 X1DN_N/B.t1 X1DN_N/B.t0 728.277
R5218 X1DN_N/B.t2 X1DN_N/B.t1 728.277
R5219 X1DN_N/B.t2 X1DN_N/B.t3 728.277
R5220 X1DN_N/B.t3 X1DN_N/B.t4 728.277
R5221 X1DN_N/B.t4 X1DN_N/B.n2 1345.97
R5222 VGND X1DN_N/B.n7 216.095
R5223 VGND X1DN_N/B.n3 216.095
R5224 X1DN_N/B.n7 X1DN_N/B.n1 216.095
R5225 X1DN_N/B.n1 X1DN_N/B.n3 216.095
R5226 X1DN_N/B.n6 X1DN_N/B.n4 3325.82
R5227 X1DN_N/B.n4 X1DN_N/B.n2 3325.82
R5228 X1DN_N/B.n6 X1DN_N/B.n0 3325.82
R5229 X1DN_N/B.n0 X1DN_N/B.n2 3325.82
R5230 ua[3] XRLOADN/R2.n0 0.46195
R5231 XRLOADN/R2.n0 XRLOADN/R2.t0 25.3338
R5232 ua[3] XRLOADN/R2.n0 8.2161
R5233 XRLOADN/R1.n0 XRLOADN/R1.t0 25.3338
R5234 VDPWR XRLOADN/R1.n0 0.504955
R5235 VDPWR XRLOADN/R1.n0 8.2161
R5236 XRLOADN/B.t0 XRLOADN/B.n0 3.35572
R5237 XRLOADN/B.n1 XRLOADN/B.n2 117.001
R5238 XRLOADN/B.n3 XRLOADN/B.n4 12.4473
R5239 XRLOADN/B.n5 XRLOADN/B.t0 117.001
R5240 VGND XRLOADN/B.n5 117.001
R5241 XRLOADN/B.n6 XRLOADN/B.n7 12.4473
R5242 XRLOADN/B.n7 XRLOADN/B.n8 12.4473
R5243 VGND XRLOADN/B.n6 66.8967
R5244 XRLOADN/B.t0 XRLOADN/B.n6 320.598
R5245 XRLOADN/B.n0 XRLOADN/B.n3 320.14
R5246 XRLOADN/B.n8 VGND 725.46
R5247 VGND XRLOADN/B.n4 725.46
R5248 XRLOADN/B.n8 XRLOADN/B.n2 725.46
R5249 XRLOADN/B.n2 XRLOADN/B.n4 725.46
R5250 XRLOADN/B.n7 XRLOADN/B.n5 11165.3
R5251 XRLOADN/B.n5 XRLOADN/B.n3 11165.3
R5252 XRLOADN/B.n7 XRLOADN/B.n1 11165.3
R5253 XRLOADN/B.n0 XRLOADN/B.n1 112.468
R5254 tail2 XCH2_GM1B/S4.t0 57.1255
R5255 gm2_p XCH2_GM1B/D4.n0 2.60267
R5256 gm2_p XCH2_GM1B/D4.n1 46.2505
R5257 XCH2_GM1B/D4.n1 XCH2_GM1B/D4.t1 10.8755
R5258 XCH2_GM1B/D4.n1 XCH2_GM1B/D4.t0 10.8755
R5259 tail2 XCH2_GM1B/S3.n0 46.2505
R5260 XCH2_GM1B/S3.n0 XCH2_GM1B/S3.t0 10.8755
R5261 XCH2_GM1B/S3.n0 XCH2_GM1B/S3.t1 10.8755
R5262 gm2_p XCH2_GM1B/D2.n0 2.60267
R5263 gm2_p XCH2_GM1B/D2.n1 46.2505
R5264 XCH2_GM1B/D2.n1 XCH2_GM1B/D2.t1 10.8755
R5265 XCH2_GM1B/D2.n1 XCH2_GM1B/D2.t0 10.8755
R5266 tail2 XCH2_GM1B/S1.n0 46.2505
R5267 XCH2_GM1B/S1.n0 XCH2_GM1B/S1.t0 10.8755
R5268 XCH2_GM1B/S1.n0 XCH2_GM1B/S1.t1 10.8755
R5269 gm2_p XCH2_GM1B/D0.n0 2.60267
R5270 gm2_p XCH2_GM1B/D0.t0 57.1255
R5271 ua[1] XCH2_GM1B/G.n0 9.3005
R5272 ua[1] XCH2_GM1B/G.n0 0.0466957
R5273 ua[1] XCH2_GM1B/G.n1 6.51721
R5274 XCH2_GM1B/G.n1 XCH2_GM1B/G.n0 1.79883
R5275 ua[1] XCH2_GM1B/G.n2 6.51721
R5276 ua[1] XCH2_GM1B/G.n2 6.7822
R5277 ua[1] XCH2_GM1B/G.n1 6.7822
R5278 ua[1] XCH2_GM1B/G.t0 322.308
R5279 XCH2_GM1B/G.t0 XCH2_GM1B/G.n8 329.089
R5280 XCH2_GM1B/G.n3 XCH2_GM1B/G.n4 6.51721
R5281 XCH2_GM1B/G.n6 XCH2_GM1B/G.n5 9.3005
R5282 XCH2_GM1B/G.n8 XCH2_GM1B/G.n7 6.51721
R5283 XCH2_GM1B/G.n4 XCH2_GM1B/G.n5 44.424
R5284 XCH2_GM1B/G.n5 XCH2_GM1B/G.n7 44.424
R5285 XCH2_GM1B/G.n7 XCH2_GM1B/G.t1 322.308
R5286 XCH2_GM1B/G.t1 ua[1] 322.308
R5287 XCH2_GM1B/G.n5 XCH2_GM1B/G.t2 322.308
R5288 XCH2_GM1B/G.t2 ua[1] 322.308
R5289 XCH2_GM1B/G.n4 XCH2_GM1B/G.t3 322.308
R5290 XCH2_GM1B/G.t3 ua[1] 322.308
R5291 XCH2_GM1B/G.n8 XCH2_GM1B/G.n6 1.79883
R5292 XCH2_GM1B/G.n6 XCH2_GM1B/G.n3 1.79883
R5293 XCH2_GM1B/G.n3 XCH2_GM1B/G.t4 329.089
R5294 XCH2_GM1B/G.t4 ua[1] 322.308
R5295 XCH2_GM1B/G.n2 ua[1] 1.75264
R5296 XCH2_GM1B/B.t2 XCH2_GM1B/B.n0 58.5005
R5297 XCH2_GM1B/B.n0 XCH2_GM1B/B.n1 58.5005
R5298 XCH2_GM1B/B.n3 XCH2_GM1B/B.n2 83.5719
R5299 XCH2_GM1B/B.n4 XCH2_GM1B/B.t2 58.5005
R5300 VGND XCH2_GM1B/B.n4 58.5005
R5301 XCH2_GM1B/B.n6 XCH2_GM1B/B.n5 83.5719
R5302 XCH2_GM1B/B.n7 XCH2_GM1B/B.n6 83.5719
R5303 VGND XCH2_GM1B/B.n5 315.135
R5304 XCH2_GM1B/B.n5 XCH2_GM1B/B.t0 1028.65
R5305 XCH2_GM1B/B.t0 XCH2_GM1B/B.t1 701.622
R5306 XCH2_GM1B/B.t2 XCH2_GM1B/B.t1 701.622
R5307 XCH2_GM1B/B.t2 XCH2_GM1B/B.t3 701.622
R5308 XCH2_GM1B/B.t3 XCH2_GM1B/B.t4 701.622
R5309 XCH2_GM1B/B.n2 XCH2_GM1B/B.t4 1112.22
R5310 VGND XCH2_GM1B/B.n7 266.918
R5311 VGND XCH2_GM1B/B.n3 266.918
R5312 XCH2_GM1B/B.n7 XCH2_GM1B/B.n1 266.918
R5313 XCH2_GM1B/B.n1 XCH2_GM1B/B.n3 266.918
R5314 XCH2_GM1B/B.n6 XCH2_GM1B/B.n4 4108.03
R5315 XCH2_GM1B/B.n4 XCH2_GM1B/B.n2 4108.03
R5316 XCH2_GM1B/B.n6 XCH2_GM1B/B.n0 4108.03
R5317 XCH2_GM1B/B.n0 XCH2_GM1B/B.n2 4108.03
R5318 ua[0].n25 ua[0] 21.7858
R5319 ua[0].n25 ua[0].n12 1.85113
R5320 ua[0].n13 ua[0].n25 22.877
R5321 ua[0].n13 ua[0].n14 9.3005
R5322 ua[0] ua[0].n13 0.0466957
R5323 ua[0].n16 ua[0].n15 6.51721
R5324 ua[0].n13 ua[0].n16 1.79883
R5325 ua[0].n17 ua[0].n18 6.51721
R5326 ua[0].n18 ua[0].n14 44.424
R5327 ua[0].n14 ua[0].n15 44.424
R5328 ua[0].n24 ua[0].n16 658.178
R5329 ua[0].n20 ua[0].n19 6.51721
R5330 ua[0].n21 ua[0].n22 9.3005
R5331 ua[0].n23 ua[0].n24 6.51721
R5332 ua[0].n20 ua[0].n21 44.424
R5333 ua[0].n21 ua[0].n23 44.424
R5334 ua[0].n15 ua[0].n23 644.614
R5335 ua[0].n14 ua[0].n21 644.614
R5336 ua[0].n18 ua[0].n20 644.614
R5337 ua[0].n22 ua[0].n24 1.79883
R5338 ua[0].n19 ua[0].n22 1.79883
R5339 ua[0].n19 ua[0].n17 658.178
R5340 ua[0] ua[0].n17 1.75264
R5341 ua[0].n12 ua[0].n0 13.07
R5342 ua[0].n0 ua[0].n1 9.3005
R5343 ua[0] ua[0].n0 0.0466957
R5344 ua[0].n3 ua[0].n2 6.51721
R5345 ua[0].n0 ua[0].n3 1.79883
R5346 ua[0].n5 ua[0].n4 6.51721
R5347 ua[0].n1 ua[0].n5 44.424
R5348 ua[0].n1 ua[0].n2 44.424
R5349 ua[0].n11 ua[0].n3 658.178
R5350 ua[0].n6 ua[0].n7 6.51721
R5351 ua[0].n8 ua[0].n9 9.3005
R5352 ua[0].n10 ua[0].n11 6.51721
R5353 ua[0].n7 ua[0].n8 44.424
R5354 ua[0].n8 ua[0].n10 44.424
R5355 ua[0].n2 ua[0].n10 644.614
R5356 ua[0].n1 ua[0].n8 644.614
R5357 ua[0].n7 ua[0].n5 644.614
R5358 ua[0].n11 ua[0].n9 1.79883
R5359 ua[0].n9 ua[0].n6 1.79883
R5360 ua[0].n6 ua[0].n4 658.178
R5361 ua[0].n4 ua[0] 1.75264
R5362 ua[0].n12 ua[0] 36.7441
R5363 ua[1].n25 ua[1] 23.6458
R5364 ua[1].n25 ua[1].n12 1.763
R5365 ua[1].n13 ua[1].n25 21.3895
R5366 ua[1].n13 ua[1].n14 9.3005
R5367 ua[1] ua[1].n13 0.0466957
R5368 ua[1].n16 ua[1].n15 6.51721
R5369 ua[1].n13 ua[1].n16 1.79883
R5370 ua[1].n17 ua[1].n18 6.51721
R5371 ua[1].n18 ua[1].n14 44.424
R5372 ua[1].n14 ua[1].n15 44.424
R5373 ua[1].n24 ua[1].n16 658.178
R5374 ua[1].n20 ua[1].n19 6.51721
R5375 ua[1].n21 ua[1].n22 9.3005
R5376 ua[1].n23 ua[1].n24 6.51721
R5377 ua[1].n20 ua[1].n21 44.424
R5378 ua[1].n21 ua[1].n23 44.424
R5379 ua[1].n15 ua[1].n23 644.614
R5380 ua[1].n14 ua[1].n21 644.614
R5381 ua[1].n18 ua[1].n20 644.614
R5382 ua[1].n22 ua[1].n24 1.79883
R5383 ua[1].n19 ua[1].n22 1.79883
R5384 ua[1].n19 ua[1].n17 658.178
R5385 ua[1] ua[1].n17 1.75264
R5386 ua[1].n12 ua[1].n0 11.867
R5387 ua[1].n0 ua[1].n1 9.3005
R5388 ua[1] ua[1].n0 0.0466957
R5389 ua[1].n3 ua[1].n2 6.51721
R5390 ua[1].n0 ua[1].n3 1.79883
R5391 ua[1].n5 ua[1].n4 6.51721
R5392 ua[1].n1 ua[1].n5 44.424
R5393 ua[1].n1 ua[1].n2 44.424
R5394 ua[1].n11 ua[1].n3 658.178
R5395 ua[1].n6 ua[1].n7 6.51721
R5396 ua[1].n8 ua[1].n9 9.3005
R5397 ua[1].n10 ua[1].n11 6.51721
R5398 ua[1].n7 ua[1].n8 44.424
R5399 ua[1].n8 ua[1].n10 44.424
R5400 ua[1].n2 ua[1].n10 644.614
R5401 ua[1].n1 ua[1].n8 644.614
R5402 ua[1].n7 ua[1].n5 644.614
R5403 ua[1].n11 ua[1].n9 1.79883
R5404 ua[1].n9 ua[1].n6 1.79883
R5405 ua[1].n6 ua[1].n4 658.178
R5406 ua[1].n4 ua[1] 1.75264
R5407 ua[1].n12 ua[1] 37.3434
R5408 ua[2].n6 ua[2] 18.1098
R5409 ua[2].n6 ua[2].n5 3.4105
R5410 ua[2].n15 ua[2].n9 1.763
R5411 ua[2].n9 ua[2].n6 0.36005
R5412 ua[2].n17 ua[2].n16 0.1133
R5413 ua[2].n17 ua[2].n15 4.33992
R5414 ua[2] ua[2].n17 3.45112
R5415 ua[2] ua[2].n16 3.45112
R5416 ua[2] ua[2].n16 3.56393
R5417 ua[2].n11 ua[2].n10 10.228
R5418 ua[2].n13 ua[2].n11 3.0555
R5419 ua[2].n15 ua[2].n13 7.15523
R5420 ua[2].n13 ua[2].n14 7.173
R5421 ua[2] ua[2].n14 3.56393
R5422 ua[2] ua[2].n14 3.45112
R5423 ua[2] ua[2].n14 3.56393
R5424 ua[2].n11 ua[2].n12 7.173
R5425 ua[2] ua[2].n12 3.56393
R5426 ua[2] ua[2].n12 3.45112
R5427 ua[2] ua[2].n12 3.56393
R5428 ua[2] ua[2].n10 3.56393
R5429 ua[2] ua[2].n10 3.45112
R5430 ua[2] ua[2].n10 3.56393
R5431 ua[2].n8 ua[2].n7 0.1133
R5432 ua[2].n9 ua[2].n8 3.98743
R5433 ua[2] ua[2].n8 8.23387
R5434 ua[2] ua[2].n7 8.23387
R5435 ua[2] ua[2].n7 8.34667
R5436 ua[2].n5 ua[2] 18.3782
R5437 ua[2].n2 ua[2].n4 10.228
R5438 ua[2].n0 ua[2].n2 3.0555
R5439 ua[2].n5 ua[2].n0 3.73655
R5440 ua[2] ua[2].n4 8.34667
R5441 ua[2] ua[2].n4 8.23387
R5442 ua[2] ua[2].n4 8.34667
R5443 ua[2].n2 ua[2].n3 7.173
R5444 ua[2] ua[2].n3 8.34667
R5445 ua[2] ua[2].n3 8.23387
R5446 ua[2] ua[2].n3 8.34667
R5447 ua[2].n0 ua[2].n1 7.173
R5448 ua[2] ua[2].n1 8.34667
R5449 ua[2] ua[2].n1 8.23387
R5450 ua[2] ua[2].n1 8.34667
R5451 ua[3] ua[3].n19 17.3185
R5452 ua[3].n16 ua[3].n9 1.85113
R5453 ua[3].n9 ua[3].n6 0.264875
R5454 ua[3].n6 ua[3].n19 0.720188
R5455 ua[3].n18 ua[3].n17 0.1133
R5456 ua[3].n18 ua[3].n16 4.2753
R5457 ua[3] ua[3].n18 3.45112
R5458 ua[3] ua[3].n17 3.45112
R5459 ua[3] ua[3].n17 3.56393
R5460 ua[3].n12 ua[3].n11 10.2339
R5461 ua[3].n14 ua[3].n12 3.0555
R5462 ua[3].n16 ua[3].n14 7.17873
R5463 ua[3].n14 ua[3].n15 7.08487
R5464 ua[3] ua[3].n15 3.56393
R5465 ua[3] ua[3].n15 3.45112
R5466 ua[3] ua[3].n15 3.56393
R5467 ua[3].n12 ua[3].n13 7.08487
R5468 ua[3] ua[3].n13 3.56393
R5469 ua[3] ua[3].n13 3.45112
R5470 ua[3] ua[3].n13 3.56393
R5471 ua[3].n11 ua[3].n10 0.0945
R5472 ua[3] ua[3].n10 3.56393
R5473 ua[3] ua[3].n10 3.45112
R5474 ua[3] ua[3].n11 3.46992
R5475 ua[3].n8 ua[3].n7 0.1133
R5476 ua[3].n9 ua[3].n8 4.01093
R5477 ua[3] ua[3].n8 8.23387
R5478 ua[3] ua[3].n7 8.23387
R5479 ua[3] ua[3].n7 8.34667
R5480 ua[3].n2 ua[3].n1 10.2339
R5481 ua[3].n4 ua[3].n2 3.0555
R5482 ua[3].n6 ua[3].n4 7.17873
R5483 ua[3].n4 ua[3].n5 7.08487
R5484 ua[3] ua[3].n5 8.34667
R5485 ua[3] ua[3].n5 8.23387
R5486 ua[3] ua[3].n5 8.34667
R5487 ua[3].n2 ua[3].n3 7.08487
R5488 ua[3] ua[3].n3 8.34667
R5489 ua[3] ua[3].n3 8.23387
R5490 ua[3] ua[3].n3 8.34667
R5491 ua[3].n1 ua[3].n0 0.0945
R5492 ua[3] ua[3].n0 8.34667
R5493 ua[3] ua[3].n0 8.23387
R5494 ua[3] ua[3].n1 8.25267
R5495 ua[3].n19 ua[3] 22.5171
R5496 clk.n0 clk 20.3894
R5497 clk.n2 clk.n1 0.598575
R5498 clk.n1 clk.n0 0.67965
R5499 clk clk.n2 12.3894
R5500 clk clk.n2 22.8072
R5501 clk clk.n1 12.0369
R5502 clk clk.n0 23.2596
R5503 ui_in[0].n45 ui_in[0] 18.2556
R5504 ui_in[0].n91 ui_in[0].n68 0.088625
R5505 ui_in[0].n68 ui_in[0].n45 0.60445
R5506 ui_in[0].n91 ui_in[0].n92 7.5036
R5507 ui_in[0].n92 ui_in[0] 15.6479
R5508 ui_in[0] ui_in[0].n92 15.7536
R5509 ui_in[0].n91 ui_in[0].n69 19.6886
R5510 ui_in[0].n70 ui_in[0].n69 9.3005
R5511 ui_in[0] ui_in[0].n69 0.0466957
R5512 ui_in[0].n71 ui_in[0].n72 6.10787
R5513 ui_in[0].n69 ui_in[0].n72 1.92
R5514 ui_in[0].n73 ui_in[0].n72 158.304
R5515 ui_in[0].n74 ui_in[0].n75 6.10787
R5516 ui_in[0].n76 ui_in[0].n71 152
R5517 ui_in[0].n77 ui_in[0].n70 152
R5518 ui_in[0].n78 ui_in[0].n74 152
R5519 ui_in[0].n90 ui_in[0].n75 158.304
R5520 ui_in[0].n74 ui_in[0].n70 36.1417
R5521 ui_in[0].n70 ui_in[0].n71 36.1417
R5522 ui_in[0].n90 ui_in[0].n78 70.1096
R5523 ui_in[0].n78 ui_in[0].n77 70.1096
R5524 ui_in[0].n77 ui_in[0].n76 70.1096
R5525 ui_in[0].n76 ui_in[0].n73 70.1096
R5526 ui_in[0].n79 ui_in[0].n90 327.76
R5527 ui_in[0].n81 ui_in[0].n82 152
R5528 ui_in[0].n83 ui_in[0].n84 152
R5529 ui_in[0].n85 ui_in[0].n86 152
R5530 ui_in[0].n79 ui_in[0].n85 70.1096
R5531 ui_in[0].n85 ui_in[0].n83 70.1096
R5532 ui_in[0].n83 ui_in[0].n81 70.1096
R5533 ui_in[0].n81 ui_in[0].n80 70.1096
R5534 ui_in[0].n82 ui_in[0].n87 6.10787
R5535 ui_in[0].n84 ui_in[0].n88 9.3005
R5536 ui_in[0].n86 ui_in[0].n89 6.10787
R5537 ui_in[0].n79 ui_in[0].n89 158.304
R5538 ui_in[0].n86 ui_in[0].n84 36.1417
R5539 ui_in[0].n84 ui_in[0].n82 36.1417
R5540 ui_in[0].n87 ui_in[0].n80 158.304
R5541 ui_in[0].n89 ui_in[0].n88 1.92
R5542 ui_in[0].n88 ui_in[0].n87 1.92
R5543 ui_in[0].n85 ui_in[0].n78 327.76
R5544 ui_in[0].n83 ui_in[0].n77 327.76
R5545 ui_in[0].n81 ui_in[0].n76 327.76
R5546 ui_in[0].n80 ui_in[0].n73 327.76
R5547 ui_in[0].n75 ui_in[0] 1.8738
R5548 ui_in[0].n68 ui_in[0].n46 21.8918
R5549 ui_in[0].n47 ui_in[0].n46 9.3005
R5550 ui_in[0] ui_in[0].n46 0.0466957
R5551 ui_in[0].n48 ui_in[0].n49 6.10787
R5552 ui_in[0].n46 ui_in[0].n49 1.92
R5553 ui_in[0].n50 ui_in[0].n49 158.304
R5554 ui_in[0].n51 ui_in[0].n52 6.10787
R5555 ui_in[0].n53 ui_in[0].n48 152
R5556 ui_in[0].n54 ui_in[0].n47 152
R5557 ui_in[0].n55 ui_in[0].n51 152
R5558 ui_in[0].n67 ui_in[0].n52 158.304
R5559 ui_in[0].n51 ui_in[0].n47 36.1417
R5560 ui_in[0].n47 ui_in[0].n48 36.1417
R5561 ui_in[0].n67 ui_in[0].n55 70.1096
R5562 ui_in[0].n55 ui_in[0].n54 70.1096
R5563 ui_in[0].n54 ui_in[0].n53 70.1096
R5564 ui_in[0].n53 ui_in[0].n50 70.1096
R5565 ui_in[0].n56 ui_in[0].n67 327.76
R5566 ui_in[0].n58 ui_in[0].n59 152
R5567 ui_in[0].n60 ui_in[0].n61 152
R5568 ui_in[0].n62 ui_in[0].n63 152
R5569 ui_in[0].n56 ui_in[0].n62 70.1096
R5570 ui_in[0].n62 ui_in[0].n60 70.1096
R5571 ui_in[0].n60 ui_in[0].n58 70.1096
R5572 ui_in[0].n58 ui_in[0].n57 70.1096
R5573 ui_in[0].n59 ui_in[0].n64 6.10787
R5574 ui_in[0].n61 ui_in[0].n65 9.3005
R5575 ui_in[0].n63 ui_in[0].n66 6.10787
R5576 ui_in[0].n56 ui_in[0].n66 158.304
R5577 ui_in[0].n63 ui_in[0].n61 36.1417
R5578 ui_in[0].n61 ui_in[0].n59 36.1417
R5579 ui_in[0].n64 ui_in[0].n57 158.304
R5580 ui_in[0].n66 ui_in[0].n65 1.92
R5581 ui_in[0].n65 ui_in[0].n64 1.92
R5582 ui_in[0].n62 ui_in[0].n55 327.76
R5583 ui_in[0].n60 ui_in[0].n54 327.76
R5584 ui_in[0].n58 ui_in[0].n53 327.76
R5585 ui_in[0].n57 ui_in[0].n50 327.76
R5586 ui_in[0].n52 ui_in[0] 1.8738
R5587 ui_in[0].n44 ui_in[0].n45 4.77703
R5588 ui_in[0].n22 ui_in[0].n44 8.16967
R5589 ui_in[0].n23 ui_in[0].n22 9.3005
R5590 ui_in[0] ui_in[0].n22 0.0466957
R5591 ui_in[0].n24 ui_in[0].n25 6.10787
R5592 ui_in[0].n22 ui_in[0].n25 1.92
R5593 ui_in[0].n26 ui_in[0].n25 158.304
R5594 ui_in[0].n27 ui_in[0].n28 6.10787
R5595 ui_in[0].n29 ui_in[0].n24 152
R5596 ui_in[0].n30 ui_in[0].n23 152
R5597 ui_in[0].n31 ui_in[0].n27 152
R5598 ui_in[0].n43 ui_in[0].n28 158.304
R5599 ui_in[0].n27 ui_in[0].n23 36.1417
R5600 ui_in[0].n23 ui_in[0].n24 36.1417
R5601 ui_in[0].n43 ui_in[0].n31 70.1096
R5602 ui_in[0].n31 ui_in[0].n30 70.1096
R5603 ui_in[0].n30 ui_in[0].n29 70.1096
R5604 ui_in[0].n29 ui_in[0].n26 70.1096
R5605 ui_in[0].n32 ui_in[0].n43 613.747
R5606 ui_in[0].n34 ui_in[0].n35 152
R5607 ui_in[0].n36 ui_in[0].n37 152
R5608 ui_in[0].n38 ui_in[0].n39 152
R5609 ui_in[0].n32 ui_in[0].n38 70.1096
R5610 ui_in[0].n38 ui_in[0].n36 70.1096
R5611 ui_in[0].n36 ui_in[0].n34 70.1096
R5612 ui_in[0].n34 ui_in[0].n33 70.1096
R5613 ui_in[0].n35 ui_in[0].n40 6.10787
R5614 ui_in[0].n37 ui_in[0].n41 9.3005
R5615 ui_in[0].n39 ui_in[0].n42 6.10787
R5616 ui_in[0].n32 ui_in[0].n42 158.304
R5617 ui_in[0].n39 ui_in[0].n37 36.1417
R5618 ui_in[0].n37 ui_in[0].n35 36.1417
R5619 ui_in[0].n40 ui_in[0].n33 158.304
R5620 ui_in[0].n42 ui_in[0].n41 1.92
R5621 ui_in[0].n41 ui_in[0].n40 1.92
R5622 ui_in[0].n38 ui_in[0].n31 613.747
R5623 ui_in[0].n36 ui_in[0].n30 613.747
R5624 ui_in[0].n34 ui_in[0].n29 613.747
R5625 ui_in[0].n33 ui_in[0].n26 613.747
R5626 ui_in[0].n28 ui_in[0] 1.8738
R5627 ui_in[0].n0 ui_in[0].n44 10.2847
R5628 ui_in[0].n1 ui_in[0].n0 9.3005
R5629 ui_in[0] ui_in[0].n0 0.0466957
R5630 ui_in[0].n2 ui_in[0].n3 6.10787
R5631 ui_in[0].n0 ui_in[0].n3 1.92
R5632 ui_in[0].n6 ui_in[0].n5 6.10787
R5633 ui_in[0].n7 ui_in[0].n6 152
R5634 ui_in[0].n8 ui_in[0].n1 152
R5635 ui_in[0].n9 ui_in[0].n2 152
R5636 ui_in[0].n21 ui_in[0].n3 158.304
R5637 ui_in[0].n4 ui_in[0].n5 158.304
R5638 ui_in[0].n6 ui_in[0].n1 36.1417
R5639 ui_in[0].n1 ui_in[0].n2 36.1417
R5640 ui_in[0].n4 ui_in[0].n7 70.1096
R5641 ui_in[0].n7 ui_in[0].n8 70.1096
R5642 ui_in[0].n8 ui_in[0].n9 70.1096
R5643 ui_in[0].n9 ui_in[0].n21 70.1096
R5644 ui_in[0].n10 ui_in[0].n21 613.747
R5645 ui_in[0].n11 ui_in[0].n12 152
R5646 ui_in[0].n13 ui_in[0].n14 152
R5647 ui_in[0].n15 ui_in[0].n16 152
R5648 ui_in[0].n17 ui_in[0].n15 70.1096
R5649 ui_in[0].n15 ui_in[0].n13 70.1096
R5650 ui_in[0].n13 ui_in[0].n11 70.1096
R5651 ui_in[0].n11 ui_in[0].n10 70.1096
R5652 ui_in[0].n12 ui_in[0].n18 6.10787
R5653 ui_in[0].n14 ui_in[0].n19 9.3005
R5654 ui_in[0].n16 ui_in[0].n20 6.10787
R5655 ui_in[0].n17 ui_in[0].n20 158.304
R5656 ui_in[0].n16 ui_in[0].n14 36.1417
R5657 ui_in[0].n14 ui_in[0].n12 36.1417
R5658 ui_in[0].n18 ui_in[0].n10 158.304
R5659 ui_in[0].n20 ui_in[0].n19 1.92
R5660 ui_in[0].n19 ui_in[0].n18 1.92
R5661 ui_in[0].n17 ui_in[0].n4 613.747
R5662 ui_in[0].n15 ui_in[0].n7 613.747
R5663 ui_in[0].n13 ui_in[0].n8 613.747
R5664 ui_in[0].n11 ui_in[0].n9 613.747
R5665 ui_in[0].n5 ui_in[0] 1.8738
R5666 VGND VGND.n657 22.1625
R5667 VGND.n8 VGND.n7 3.4105
R5668 VGND.n72 VGND.n71 3.4105
R5669 VGND.n86 VGND.n85 3.4105
R5670 VGND.n88 VGND.n87 3.4105
R5671 VGND.n96 VGND.n95 3.4105
R5672 VGND.n98 VGND.n97 3.4105
R5673 VGND.n99 VGND.n98 1.33412
R5674 VGND.n98 VGND.n96 0.0950875
R5675 VGND.n96 VGND.n88 2.02091
R5676 VGND.n88 VGND.n86 0.0950875
R5677 VGND.n86 VGND.n78 2.49091
R5678 VGND.n78 VGND.n77 0.52925
R5679 VGND.n77 VGND.n76 1.58675
R5680 VGND.n76 VGND.n75 0.206125
R5681 VGND.n75 VGND.n74 1.76594
R5682 VGND.n74 VGND.n73 1.49569
R5683 VGND.n73 VGND.n657 2.54437
R5684 VGND.n657 VGND.n72 7.15038
R5685 VGND.n72 VGND.n70 0.0950875
R5686 VGND.n70 VGND.n54 1.29241
R5687 VGND.n54 VGND.n8 0.964
R5688 VGND.n8 VGND.n6 3.50509
R5689 VGND.n100 VGND.n99 5.0226
R5690 VGND.n101 VGND.n100 1.1755
R5691 VGND.n102 VGND.n101 1.1755
R5692 VGND.n103 VGND.n102 18.4871
R5693 VGND.n105 VGND.n104 117.001
R5694 VGND.n103 VGND.n105 117.001
R5695 VGND VGND.n103 0.145955
R5696 VGND.n111 VGND.n106 2.64756
R5697 VGND.n106 VGND.n107 2.64756
R5698 VGND.n103 VGND.n107 2932.33
R5699 VGND.n108 VGND.n109 117.001
R5700 VGND.n109 VGND.n110 117.001
R5701 VGND.n110 VGND.n107 2942.49
R5702 VGND.n111 VGND.n655 2.64756
R5703 VGND.n655 VGND.n656 2.64756
R5704 VGND.n656 VGND.n110 2942.49
R5705 VGND.n656 VGND 2932.18
R5706 VGND.n655 VGND.n105 45286.8
R5707 VGND.n105 VGND.n106 45286.8
R5708 VGND.n655 VGND.n109 45286.8
R5709 VGND.n109 VGND.n106 45286.8
R5710 VGND.n112 VGND.n113 41.7862
R5711 VGND.n113 VGND.n114 41.7862
R5712 VGND.n115 VGND.n116 73.1255
R5713 VGND.n116 VGND.n117 73.1255
R5714 VGND.n118 VGND.n119 41.7862
R5715 VGND.n174 VGND.n119 41.7862
R5716 VGND.n115 VGND.n120 73.1255
R5717 VGND.n120 VGND.n121 73.1255
R5718 VGND.n122 VGND.n123 117.001
R5719 VGND.n123 VGND.n124 117.001
R5720 VGND.n125 VGND.n126 117.001
R5721 VGND.n126 VGND.n127 117.001
R5722 VGND.n118 VGND.n128 117.001
R5723 VGND.n173 VGND.n128 117.001
R5724 VGND.n125 VGND.n129 117.001
R5725 VGND.n129 VGND.n130 117.001
R5726 VGND.n112 VGND.n131 41.7862
R5727 VGND.n131 VGND.n132 41.7862
R5728 VGND.n115 VGND.n133 73.1255
R5729 VGND.n133 VGND.n134 73.1255
R5730 VGND.n135 VGND.n118 41.7862
R5731 VGND.n180 VGND.n135 41.7862
R5732 VGND.n115 VGND.n136 73.1255
R5733 VGND.n136 VGND.n137 73.1255
R5734 VGND.n122 VGND.n138 117.001
R5735 VGND.n138 VGND.n139 117.001
R5736 VGND.n125 VGND.n140 117.001
R5737 VGND.n140 VGND.n141 117.001
R5738 VGND.n118 VGND.n142 117.001
R5739 VGND.n176 VGND.n142 117.001
R5740 VGND.n125 VGND.n143 117.001
R5741 VGND.n143 VGND.n144 117.001
R5742 VGND.n122 VGND.n145 73.1255
R5743 VGND.n145 VGND.n146 73.1255
R5744 VGND.n125 VGND.n147 117.001
R5745 VGND.n147 VGND.n148 117.001
R5746 VGND.n118 VGND.n149 73.1255
R5747 VGND.n178 VGND.n149 73.1255
R5748 VGND.n125 VGND.n150 117.001
R5749 VGND.n150 VGND.n151 117.001
R5750 VGND.n122 VGND.n152 117.001
R5751 VGND.n152 VGND.n153 117.001
R5752 VGND.n125 VGND.n154 117.001
R5753 VGND.n154 VGND.n155 117.001
R5754 VGND.n118 VGND.n156 117.001
R5755 VGND.n182 VGND.n156 117.001
R5756 VGND.n125 VGND.n157 117.001
R5757 VGND.n157 VGND.n158 117.001
R5758 VGND.n122 VGND.n159 73.1255
R5759 VGND.n159 VGND.n160 73.1255
R5760 VGND.n125 VGND.n161 117.001
R5761 VGND.n161 VGND.n162 117.001
R5762 VGND.n118 VGND.n163 73.1255
R5763 VGND.n184 VGND.n163 73.1255
R5764 VGND.n125 VGND.n164 117.001
R5765 VGND.n164 VGND.n165 117.001
R5766 VGND.n122 VGND.n166 73.1255
R5767 VGND.n166 VGND.n167 73.1255
R5768 VGND.n125 VGND.n168 117.001
R5769 VGND.n168 VGND.n169 117.001
R5770 VGND.n118 VGND.n170 73.1255
R5771 VGND.n171 VGND.n170 73.1255
R5772 VGND.n125 VGND.n172 117.001
R5773 VGND.n172 VGND.n186 117.001
R5774 VGND.n187 VGND.n188 117.001
R5775 VGND.n188 VGND.n189 117.001
R5776 VGND.n190 VGND.n191 4.00735
R5777 VGND.n191 VGND.n192 4.00735
R5778 VGND.n194 VGND.n193 117.001
R5779 VGND.n195 VGND.n194 117.001
R5780 VGND.n190 VGND.n196 4.00735
R5781 VGND.n196 VGND.n197 4.00735
R5782 VGND.n198 VGND.n199 117.001
R5783 VGND.n199 VGND.n200 117.001
R5784 VGND.n201 VGND.n202 2.01774
R5785 VGND.n202 VGND.n203 2.01774
R5786 VGND.n104 VGND.n204 117.001
R5787 VGND.n205 VGND.n204 117.001
R5788 VGND.n201 VGND.n206 2.01774
R5789 VGND.n206 VGND.n207 2.01774
R5790 VGND.n208 VGND.n209 26.5914
R5791 VGND.n209 VGND.n210 26.5914
R5792 VGND.n211 VGND.n212 73.1255
R5793 VGND.n212 VGND.n213 73.1255
R5794 VGND.n214 VGND.n215 26.5914
R5795 VGND.n226 VGND.n215 26.5914
R5796 VGND.n211 VGND.n216 73.1255
R5797 VGND.n216 VGND.n217 73.1255
R5798 VGND.n208 VGND.n218 26.5914
R5799 VGND.n218 VGND.n219 26.5914
R5800 VGND.n211 VGND.n220 73.1255
R5801 VGND.n220 VGND.n221 73.1255
R5802 VGND.n222 VGND.n214 26.5914
R5803 VGND.n223 VGND.n222 26.5914
R5804 VGND.n211 VGND.n224 73.1255
R5805 VGND.n224 VGND.n243 73.1255
R5806 VGND.n244 VGND.n245 117.001
R5807 VGND.n245 VGND.n246 117.001
R5808 VGND.n247 VGND.n248 12.4473
R5809 VGND.n248 VGND.n249 12.4473
R5810 VGND.n251 VGND.n250 117.001
R5811 VGND.n262 VGND.n251 117.001
R5812 VGND.n247 VGND.n252 12.4473
R5813 VGND.n252 VGND.n253 12.4473
R5814 VGND.n244 VGND.n254 117.001
R5815 VGND.n254 VGND.n255 117.001
R5816 VGND.n247 VGND.n256 12.4473
R5817 VGND.n256 VGND.n257 12.4473
R5818 VGND.n250 VGND.n258 117.001
R5819 VGND.n259 VGND.n258 117.001
R5820 VGND.n247 VGND.n260 12.4473
R5821 VGND.n260 VGND.n263 12.4473
R5822 VGND.n108 VGND.n264 117.001
R5823 VGND.n264 VGND.n265 117.001
R5824 VGND.n111 VGND.n266 2.64756
R5825 VGND.n266 VGND.n267 2.64756
R5826 VGND.n104 VGND.n268 117.001
R5827 VGND.n269 VGND.n268 117.001
R5828 VGND.n111 VGND.n270 2.64756
R5829 VGND.n270 VGND.n271 2.64756
R5830 VGND.n272 VGND.n273 73.1255
R5831 VGND.n273 VGND.n274 73.1255
R5832 VGND.n275 VGND.n276 83.5719
R5833 VGND.n276 VGND.n277 83.5719
R5834 VGND.n278 VGND.n279 73.1255
R5835 VGND.n331 VGND.n279 73.1255
R5836 VGND.n275 VGND.n280 83.5719
R5837 VGND.n280 VGND.n281 83.5719
R5838 VGND.n272 VGND.n282 73.1255
R5839 VGND.n282 VGND.n283 73.1255
R5840 VGND.n275 VGND.n284 83.5719
R5841 VGND.n284 VGND.n285 83.5719
R5842 VGND.n278 VGND.n286 73.1255
R5843 VGND.n332 VGND.n286 73.1255
R5844 VGND.n275 VGND.n287 83.5719
R5845 VGND.n287 VGND.n288 83.5719
R5846 VGND.n272 VGND.n289 73.1255
R5847 VGND.n289 VGND.n290 73.1255
R5848 VGND.n275 VGND.n291 83.5719
R5849 VGND.n291 VGND.n292 83.5719
R5850 VGND.n278 VGND.n293 73.1255
R5851 VGND.n334 VGND.n293 73.1255
R5852 VGND.n275 VGND.n294 83.5719
R5853 VGND.n294 VGND.n295 83.5719
R5854 VGND.n272 VGND.n296 73.1255
R5855 VGND.n296 VGND.n297 73.1255
R5856 VGND.n275 VGND.n298 83.5719
R5857 VGND.n298 VGND.n299 83.5719
R5858 VGND.n278 VGND.n300 73.1255
R5859 VGND.n336 VGND.n300 73.1255
R5860 VGND.n275 VGND.n301 83.5719
R5861 VGND.n301 VGND.n302 83.5719
R5862 VGND.n272 VGND.n303 73.1255
R5863 VGND.n303 VGND.n304 73.1255
R5864 VGND.n275 VGND.n305 83.5719
R5865 VGND.n305 VGND.n306 83.5719
R5866 VGND.n278 VGND.n307 73.1255
R5867 VGND.n338 VGND.n307 73.1255
R5868 VGND.n275 VGND.n308 83.5719
R5869 VGND.n308 VGND.n309 83.5719
R5870 VGND.n272 VGND.n310 73.1255
R5871 VGND.n310 VGND.n311 73.1255
R5872 VGND.n275 VGND.n312 83.5719
R5873 VGND.n312 VGND.n313 83.5719
R5874 VGND.n278 VGND.n314 73.1255
R5875 VGND.n340 VGND.n314 73.1255
R5876 VGND.n275 VGND.n315 83.5719
R5877 VGND.n315 VGND.n316 83.5719
R5878 VGND.n272 VGND.n317 73.1255
R5879 VGND.n317 VGND.n318 73.1255
R5880 VGND.n275 VGND.n319 83.5719
R5881 VGND.n319 VGND.n320 83.5719
R5882 VGND.n278 VGND.n321 73.1255
R5883 VGND.n342 VGND.n321 73.1255
R5884 VGND.n275 VGND.n322 83.5719
R5885 VGND.n322 VGND.n323 83.5719
R5886 VGND.n272 VGND.n324 73.1255
R5887 VGND.n324 VGND.n325 73.1255
R5888 VGND.n275 VGND.n326 83.5719
R5889 VGND.n326 VGND.n327 83.5719
R5890 VGND.n328 VGND.n278 73.1255
R5891 VGND.n329 VGND.n328 73.1255
R5892 VGND.n275 VGND.n330 83.5719
R5893 VGND.n330 VGND.n345 83.5719
R5894 VGND.n346 VGND.n347 73.1255
R5895 VGND.n347 VGND.n348 73.1255
R5896 VGND.n349 VGND.n350 83.5719
R5897 VGND.n350 VGND.n351 83.5719
R5898 VGND.n352 VGND.n353 73.1255
R5899 VGND.n405 VGND.n353 73.1255
R5900 VGND.n349 VGND.n354 83.5719
R5901 VGND.n354 VGND.n355 83.5719
R5902 VGND.n346 VGND.n356 73.1255
R5903 VGND.n356 VGND.n357 73.1255
R5904 VGND.n349 VGND.n358 83.5719
R5905 VGND.n358 VGND.n359 83.5719
R5906 VGND.n352 VGND.n360 73.1255
R5907 VGND.n406 VGND.n360 73.1255
R5908 VGND.n349 VGND.n361 83.5719
R5909 VGND.n361 VGND.n362 83.5719
R5910 VGND.n346 VGND.n363 73.1255
R5911 VGND.n363 VGND.n364 73.1255
R5912 VGND.n349 VGND.n365 83.5719
R5913 VGND.n365 VGND.n366 83.5719
R5914 VGND.n352 VGND.n367 73.1255
R5915 VGND.n408 VGND.n367 73.1255
R5916 VGND.n349 VGND.n368 83.5719
R5917 VGND.n368 VGND.n369 83.5719
R5918 VGND.n346 VGND.n370 73.1255
R5919 VGND.n370 VGND.n371 73.1255
R5920 VGND.n349 VGND.n372 83.5719
R5921 VGND.n372 VGND.n373 83.5719
R5922 VGND.n352 VGND.n374 73.1255
R5923 VGND.n410 VGND.n374 73.1255
R5924 VGND.n349 VGND.n375 83.5719
R5925 VGND.n375 VGND.n376 83.5719
R5926 VGND.n346 VGND.n377 73.1255
R5927 VGND.n377 VGND.n378 73.1255
R5928 VGND.n349 VGND.n379 83.5719
R5929 VGND.n379 VGND.n380 83.5719
R5930 VGND.n352 VGND.n381 73.1255
R5931 VGND.n412 VGND.n381 73.1255
R5932 VGND.n349 VGND.n382 83.5719
R5933 VGND.n382 VGND.n383 83.5719
R5934 VGND.n346 VGND.n384 73.1255
R5935 VGND.n384 VGND.n385 73.1255
R5936 VGND.n349 VGND.n386 83.5719
R5937 VGND.n386 VGND.n387 83.5719
R5938 VGND.n352 VGND.n388 73.1255
R5939 VGND.n414 VGND.n388 73.1255
R5940 VGND.n349 VGND.n389 83.5719
R5941 VGND.n389 VGND.n390 83.5719
R5942 VGND.n346 VGND.n391 73.1255
R5943 VGND.n391 VGND.n392 73.1255
R5944 VGND.n349 VGND.n393 83.5719
R5945 VGND.n393 VGND.n394 83.5719
R5946 VGND.n352 VGND.n395 73.1255
R5947 VGND.n416 VGND.n395 73.1255
R5948 VGND.n349 VGND.n396 83.5719
R5949 VGND.n396 VGND.n397 83.5719
R5950 VGND.n346 VGND.n398 73.1255
R5951 VGND.n398 VGND.n399 73.1255
R5952 VGND.n349 VGND.n400 83.5719
R5953 VGND.n400 VGND.n401 83.5719
R5954 VGND.n402 VGND.n352 73.1255
R5955 VGND.n403 VGND.n402 73.1255
R5956 VGND.n349 VGND.n404 83.5719
R5957 VGND.n404 VGND.n419 83.5719
R5958 VGND.n420 VGND.n421 26.5914
R5959 VGND.n421 VGND.n422 26.5914
R5960 VGND.n423 VGND.n424 65.0005
R5961 VGND.n424 VGND.n425 65.0005
R5962 VGND.n426 VGND.n427 26.5914
R5963 VGND.n474 VGND.n427 26.5914
R5964 VGND.n423 VGND.n428 65.0005
R5965 VGND.n428 VGND.n429 65.0005
R5966 VGND.n430 VGND.n431 58.5005
R5967 VGND.n431 VGND.n432 58.5005
R5968 VGND.n433 VGND.n434 83.5719
R5969 VGND.n434 VGND.n435 83.5719
R5970 VGND.n426 VGND.n436 58.5005
R5971 VGND.n467 VGND.n436 58.5005
R5972 VGND.n433 VGND.n437 83.5719
R5973 VGND.n437 VGND.n438 83.5719
R5974 VGND.n430 VGND.n439 58.5005
R5975 VGND.n439 VGND.n440 58.5005
R5976 VGND.n433 VGND.n441 83.5719
R5977 VGND.n441 VGND.n442 83.5719
R5978 VGND.n426 VGND.n443 58.5005
R5979 VGND.n468 VGND.n443 58.5005
R5980 VGND.n433 VGND.n444 83.5719
R5981 VGND.n444 VGND.n445 83.5719
R5982 VGND.n430 VGND.n446 58.5005
R5983 VGND.n446 VGND.n447 58.5005
R5984 VGND.n433 VGND.n448 83.5719
R5985 VGND.n448 VGND.n449 83.5719
R5986 VGND.n426 VGND.n450 58.5005
R5987 VGND.n470 VGND.n450 58.5005
R5988 VGND.n433 VGND.n451 83.5719
R5989 VGND.n451 VGND.n452 83.5719
R5990 VGND.n430 VGND.n453 58.5005
R5991 VGND.n453 VGND.n454 58.5005
R5992 VGND.n433 VGND.n455 83.5719
R5993 VGND.n455 VGND.n456 83.5719
R5994 VGND.n426 VGND.n457 58.5005
R5995 VGND.n472 VGND.n457 58.5005
R5996 VGND.n433 VGND.n458 83.5719
R5997 VGND.n458 VGND.n459 83.5719
R5998 VGND.n420 VGND.n460 26.5914
R5999 VGND.n460 VGND.n461 26.5914
R6000 VGND.n423 VGND.n462 65.0005
R6001 VGND.n462 VGND.n463 65.0005
R6002 VGND.n464 VGND.n426 26.5914
R6003 VGND.n465 VGND.n464 26.5914
R6004 VGND.n423 VGND.n466 65.0005
R6005 VGND.n466 VGND.n476 65.0005
R6006 VGND.n477 VGND.n478 26.5914
R6007 VGND.n478 VGND.n479 26.5914
R6008 VGND.n480 VGND.n481 65.0005
R6009 VGND.n481 VGND.n482 65.0005
R6010 VGND.n483 VGND.n484 26.5914
R6011 VGND.n531 VGND.n484 26.5914
R6012 VGND.n480 VGND.n485 65.0005
R6013 VGND.n485 VGND.n486 65.0005
R6014 VGND.n487 VGND.n488 58.5005
R6015 VGND.n488 VGND.n489 58.5005
R6016 VGND.n490 VGND.n491 83.5719
R6017 VGND.n491 VGND.n492 83.5719
R6018 VGND.n483 VGND.n493 58.5005
R6019 VGND.n524 VGND.n493 58.5005
R6020 VGND.n490 VGND.n494 83.5719
R6021 VGND.n494 VGND.n495 83.5719
R6022 VGND.n487 VGND.n496 58.5005
R6023 VGND.n496 VGND.n497 58.5005
R6024 VGND.n490 VGND.n498 83.5719
R6025 VGND.n498 VGND.n499 83.5719
R6026 VGND.n483 VGND.n500 58.5005
R6027 VGND.n525 VGND.n500 58.5005
R6028 VGND.n490 VGND.n501 83.5719
R6029 VGND.n501 VGND.n502 83.5719
R6030 VGND.n487 VGND.n503 58.5005
R6031 VGND.n503 VGND.n504 58.5005
R6032 VGND.n490 VGND.n505 83.5719
R6033 VGND.n505 VGND.n506 83.5719
R6034 VGND.n483 VGND.n507 58.5005
R6035 VGND.n527 VGND.n507 58.5005
R6036 VGND.n490 VGND.n508 83.5719
R6037 VGND.n508 VGND.n509 83.5719
R6038 VGND.n487 VGND.n510 58.5005
R6039 VGND.n510 VGND.n511 58.5005
R6040 VGND.n490 VGND.n512 83.5719
R6041 VGND.n512 VGND.n513 83.5719
R6042 VGND.n483 VGND.n514 58.5005
R6043 VGND.n529 VGND.n514 58.5005
R6044 VGND.n490 VGND.n515 83.5719
R6045 VGND.n515 VGND.n516 83.5719
R6046 VGND.n477 VGND.n517 26.5914
R6047 VGND.n517 VGND.n518 26.5914
R6048 VGND.n480 VGND.n519 65.0005
R6049 VGND.n519 VGND.n520 65.0005
R6050 VGND.n521 VGND.n483 26.5914
R6051 VGND.n522 VGND.n521 26.5914
R6052 VGND.n480 VGND.n523 65.0005
R6053 VGND.n523 VGND.n533 65.0005
R6054 VGND.n534 VGND.n535 117.001
R6055 VGND.n535 VGND.n536 117.001
R6056 VGND.n537 VGND.n538 3.87467
R6057 VGND.n538 VGND.n539 3.87467
R6058 VGND.n104 VGND.n540 117.001
R6059 VGND.n541 VGND.n540 117.001
R6060 VGND.n537 VGND.n542 3.87467
R6061 VGND.n542 VGND.n543 3.87467
R6062 VGND VGND.n104 7.34284
R6063 VGND.n104 VGND 352.849
R6064 VGND VGND.n483 7.34284
R6065 VGND.n483 VGND.n490 43.916
R6066 VGND.n490 VGND.n480 7.06577
R6067 VGND.n480 VGND.n487 36.8507
R6068 VGND.n487 VGND.n477 14.131
R6069 VGND.n477 VGND.n537 262.247
R6070 VGND.n537 VGND 127.175
R6071 VGND VGND.n426 7.34284
R6072 VGND.n426 VGND.n433 43.916
R6073 VGND.n433 VGND.n423 7.06577
R6074 VGND.n423 VGND.n430 36.8507
R6075 VGND.n430 VGND.n420 14.131
R6076 VGND.n420 VGND.n111 89.0783
R6077 VGND.n111 VGND.n201 325.557
R6078 VGND.n201 VGND.n534 73.2854
R6079 VGND.n534 VGND 12.3301
R6080 VGND VGND.n352 7.34284
R6081 VGND.n352 VGND.n349 43.916
R6082 VGND.n349 VGND.n346 43.916
R6083 VGND.n346 VGND 71.0688
R6084 VGND VGND.n193 7.34284
R6085 VGND.n193 VGND 325.142
R6086 VGND VGND.n278 7.34284
R6087 VGND.n278 VGND.n275 43.916
R6088 VGND.n275 VGND.n272 43.916
R6089 VGND.n272 VGND.n108 44.8857
R6090 VGND.n108 VGND 53.8905
R6091 VGND VGND.n250 7.34284
R6092 VGND.n250 VGND.n190 169.982
R6093 VGND.n190 VGND.n247 64.1421
R6094 VGND.n247 VGND 70.6532
R6095 VGND VGND.n214 7.34284
R6096 VGND.n214 VGND.n211 46.4096
R6097 VGND.n211 VGND.n244 6.23456
R6098 VGND.n244 VGND.n208 40.1756
R6099 VGND.n208 VGND.n198 81.4589
R6100 VGND.n198 VGND.n187 276.515
R6101 VGND.n187 VGND 2035.49
R6102 VGND VGND.n118 7.34284
R6103 VGND.n118 VGND.n125 32.8332
R6104 VGND.n125 VGND.n115 13.5769
R6105 VGND.n115 VGND.n122 19.2568
R6106 VGND.n122 VGND.n112 27.1533
R6107 VGND.n112 VGND.n654 121.496
R6108 VGND.n552 VGND.n544 956.563
R6109 VGND.n654 VGND.n545 1289.59
R6110 VGND.n654 VGND.n546 883.547
R6111 VGND.n654 VGND.n547 1040.16
R6112 VGND.n654 VGND.n548 1127.63
R6113 VGND.n654 VGND.n549 1095.42
R6114 VGND.n654 VGND.n550 1197.13
R6115 VGND.n654 VGND.n551 1040.16
R6116 VGND.n654 VGND.n552 115.835
R6117 VGND.n553 VGND.n554 73.1255
R6118 VGND.n554 VGND.n555 73.1255
R6119 VGND.n557 VGND.n556 83.5719
R6120 VGND.n558 VGND.n557 83.5719
R6121 VGND.n559 VGND.n553 73.1255
R6122 VGND.n647 VGND.n559 73.1255
R6123 VGND.n561 VGND.n560 83.5719
R6124 VGND.n562 VGND.n561 83.5719
R6125 VGND.n563 VGND.n564 73.1255
R6126 VGND.n564 VGND.n565 73.1255
R6127 VGND.n567 VGND.n566 83.5719
R6128 VGND.n568 VGND.n567 83.5719
R6129 VGND.n569 VGND.n563 73.1255
R6130 VGND.n649 VGND.n569 73.1255
R6131 VGND.n571 VGND.n570 83.5719
R6132 VGND.n572 VGND.n571 83.5719
R6133 VGND VGND.n560 71.9314
R6134 VGND.n560 VGND.n553 480.445
R6135 VGND.n553 VGND.n556 480.445
R6136 VGND.n556 VGND.n544 1962.49
R6137 VGND.n544 VGND 1890.56
R6138 VGND VGND.n570 71.9314
R6139 VGND.n570 VGND.n563 480.445
R6140 VGND.n563 VGND.n566 480.445
R6141 VGND.n573 VGND.n574 73.1255
R6142 VGND.n574 VGND.n575 73.1255
R6143 VGND.n577 VGND.n576 83.5719
R6144 VGND.n578 VGND.n577 83.5719
R6145 VGND.n579 VGND.n573 73.1255
R6146 VGND.n645 VGND.n579 73.1255
R6147 VGND.n581 VGND.n580 83.5719
R6148 VGND.n582 VGND.n581 83.5719
R6149 VGND.n583 VGND.n545 1603.28
R6150 VGND.n545 VGND 1603.28
R6151 VGND VGND.n580 70.7529
R6152 VGND.n580 VGND.n573 472.574
R6153 VGND.n573 VGND.n576 472.574
R6154 VGND.n576 VGND.n551 1802.18
R6155 VGND.n551 VGND.n653 128.155
R6156 VGND.n653 VGND 1859.59
R6157 VGND.n653 VGND.n544 9977.56
R6158 VGND.n566 VGND.n552 2996.04
R6159 VGND.n545 VGND.n652 2635.61
R6160 VGND.n545 VGND.n653 9556.21
R6161 VGND.n585 VGND.n584 73.1255
R6162 VGND.n586 VGND.n585 73.1255
R6163 VGND.n587 VGND.n588 83.5719
R6164 VGND.n589 VGND.n588 83.5719
R6165 VGND.n591 VGND.n590 73.1255
R6166 VGND.n592 VGND.n591 73.1255
R6167 VGND.n593 VGND.n587 83.5719
R6168 VGND.n651 VGND.n593 83.5719
R6169 VGND VGND.n590 194.659
R6170 VGND.n590 VGND.n583 448.08
R6171 VGND.n583 VGND.n587 716.194
R6172 VGND.n587 VGND.n584 1164.27
R6173 VGND.n584 VGND.n652 14834.5
R6174 VGND.n592 VGND.n651 236.048
R6175 VGND.n592 VGND.n589 236.048
R6176 VGND.n651 VGND.n586 246.213
R6177 VGND.n589 VGND.n586 246.213
R6178 VGND.n650 VGND.n592 17.3121
R6179 VGND.n595 VGND.n594 2.1155
R6180 VGND.n644 VGND.n595 2.1155
R6181 VGND.n650 VGND.n644 2.1155
R6182 VGND.n646 VGND.n650 2.1155
R6183 VGND.n7 VGND.n646 0.521025
R6184 VGND.n7 VGND.n648 1.59498
R6185 VGND.n648 VGND.n649 19.4271
R6186 VGND.n649 VGND.n568 236.048
R6187 VGND.n565 VGND.n568 246.213
R6188 VGND.n572 VGND.n565 246.213
R6189 VGND.n649 VGND.n572 236.048
R6190 VGND.n648 VGND.n647 17.3121
R6191 VGND.n647 VGND.n558 236.048
R6192 VGND.n555 VGND.n558 246.213
R6193 VGND.n562 VGND.n555 246.213
R6194 VGND.n647 VGND.n562 236.048
R6195 VGND.n646 VGND.n645 17.3121
R6196 VGND.n645 VGND.n578 236.048
R6197 VGND.n575 VGND.n578 246.213
R6198 VGND.n582 VGND.n575 246.213
R6199 VGND.n645 VGND.n582 236.048
R6200 VGND.n644 VGND.n596 17.3121
R6201 VGND.n598 VGND.n597 73.1255
R6202 VGND.n596 VGND.n598 73.1255
R6203 VGND.n600 VGND.n599 117.001
R6204 VGND.n601 VGND.n600 117.001
R6205 VGND.n596 VGND.n601 205.929
R6206 VGND.n597 VGND.n602 73.1255
R6207 VGND.n602 VGND.n603 73.1255
R6208 VGND.n603 VGND.n601 216.095
R6209 VGND.n642 VGND.n641 117.001
R6210 VGND.n643 VGND.n642 117.001
R6211 VGND.n643 VGND.n603 216.095
R6212 VGND.n596 VGND.n643 205.929
R6213 VGND.n642 VGND.n598 3325.82
R6214 VGND.n598 VGND.n600 3325.82
R6215 VGND.n642 VGND.n602 3325.82
R6216 VGND.n602 VGND.n600 3325.82
R6217 VGND VGND.n641 71.9314
R6218 VGND.n641 VGND.n597 480.445
R6219 VGND.n597 VGND.n599 480.445
R6220 VGND.n599 VGND.n550 1962.49
R6221 VGND.n550 VGND.n583 1890.56
R6222 VGND.n604 VGND.n605 73.1255
R6223 VGND.n605 VGND.n606 73.1255
R6224 VGND.n608 VGND.n607 117.001
R6225 VGND.n609 VGND.n608 117.001
R6226 VGND.n610 VGND.n604 73.1255
R6227 VGND.n611 VGND.n610 73.1255
R6228 VGND.n613 VGND.n612 117.001
R6229 VGND.n614 VGND.n613 117.001
R6230 VGND.n615 VGND.n549 1553.32
R6231 VGND.n549 VGND 1553.32
R6232 VGND VGND.n612 68.5484
R6233 VGND.n612 VGND.n604 457.849
R6234 VGND.n604 VGND.n607 457.849
R6235 VGND.n607 VGND.n546 1746.03
R6236 VGND.n546 VGND.n640 124.162
R6237 VGND.n640 VGND 1801.65
R6238 VGND.n640 VGND.n550 8986.09
R6239 VGND.n550 VGND.n652 13096.6
R6240 VGND.n549 VGND.n639 2635.61
R6241 VGND.n549 VGND.n640 8564.74
R6242 VGND.n629 VGND.n628 73.1255
R6243 VGND.n630 VGND.n629 73.1255
R6244 VGND.n632 VGND.n631 117.001
R6245 VGND.n633 VGND.n632 117.001
R6246 VGND.n635 VGND.n634 73.1255
R6247 VGND.n636 VGND.n635 73.1255
R6248 VGND.n631 VGND.n637 117.001
R6249 VGND.n638 VGND.n637 117.001
R6250 VGND VGND.n634 194.659
R6251 VGND.n634 VGND.n615 448.08
R6252 VGND.n615 VGND.n631 422.372
R6253 VGND.n631 VGND.n628 870.452
R6254 VGND.n628 VGND.n639 15422.2
R6255 VGND.n636 VGND.n638 205.929
R6256 VGND.n636 VGND.n633 205.929
R6257 VGND.n638 VGND.n630 216.095
R6258 VGND.n633 VGND.n630 216.095
R6259 VGND.n594 VGND.n636 17.3121
R6260 VGND.n637 VGND.n635 3325.82
R6261 VGND.n635 VGND.n632 3325.82
R6262 VGND.n637 VGND.n629 3325.82
R6263 VGND.n629 VGND.n632 3325.82
R6264 VGND.n627 VGND.n639 10271.8
R6265 VGND.n616 VGND.n617 73.1255
R6266 VGND.n617 VGND.n618 73.1255
R6267 VGND.n620 VGND.n619 117.001
R6268 VGND.n621 VGND.n620 117.001
R6269 VGND.n622 VGND.n616 73.1255
R6270 VGND.n623 VGND.n622 73.1255
R6271 VGND.n625 VGND.n624 117.001
R6272 VGND.n626 VGND.n625 117.001
R6273 VGND.n548 VGND 1834.22
R6274 VGND VGND.n624 70.7529
R6275 VGND.n624 VGND.n616 472.574
R6276 VGND.n616 VGND.n619 472.574
R6277 VGND.n619 VGND.n547 1802.18
R6278 VGND.n547 VGND.n627 128.155
R6279 VGND.n627 VGND.n615 1859.59
R6280 VGND.n623 VGND.n626 205.929
R6281 VGND.n623 VGND.n621 205.929
R6282 VGND.n626 VGND.n618 216.095
R6283 VGND.n618 VGND.n621 216.095
R6284 VGND.n594 VGND.n623 19.4271
R6285 VGND.n625 VGND.n622 3325.82
R6286 VGND.n622 VGND.n620 3325.82
R6287 VGND.n625 VGND.n617 3325.82
R6288 VGND.n617 VGND.n620 3325.82
R6289 VGND.n548 VGND.n627 8141.14
R6290 VGND.n611 VGND.n614 205.929
R6291 VGND.n611 VGND.n609 205.929
R6292 VGND.n614 VGND.n606 216.095
R6293 VGND.n606 VGND.n609 216.095
R6294 VGND.n595 VGND.n611 17.3121
R6295 VGND.n613 VGND.n610 3325.82
R6296 VGND.n610 VGND.n608 3325.82
R6297 VGND.n613 VGND.n605 3325.82
R6298 VGND.n605 VGND.n608 3325.82
R6299 VGND.n593 VGND.n591 3789.35
R6300 VGND.n591 VGND.n588 3789.35
R6301 VGND.n593 VGND.n585 3789.35
R6302 VGND.n585 VGND.n588 3789.35
R6303 VGND.n581 VGND.n579 3789.35
R6304 VGND.n579 VGND.n577 3789.35
R6305 VGND.n581 VGND.n574 3789.35
R6306 VGND.n574 VGND.n577 3789.35
R6307 VGND.n571 VGND.n569 3789.35
R6308 VGND.n569 VGND.n567 3789.35
R6309 VGND.n571 VGND.n564 3789.35
R6310 VGND.n564 VGND.n567 3789.35
R6311 VGND.n561 VGND.n559 3789.35
R6312 VGND.n559 VGND.n557 3789.35
R6313 VGND.n561 VGND.n554 3789.35
R6314 VGND.n554 VGND.n557 3789.35
R6315 VGND.n543 VGND 2047.48
R6316 VGND VGND.n541 0.145955
R6317 VGND.n541 VGND.n539 2047.62
R6318 VGND.n543 VGND.n536 2057.79
R6319 VGND.n536 VGND.n539 2057.79
R6320 VGND.n101 VGND.n541 17.3121
R6321 VGND.n542 VGND.n540 31670.6
R6322 VGND.n540 VGND.n538 31670.6
R6323 VGND.n542 VGND.n535 31670.6
R6324 VGND.n535 VGND.n538 31670.6
R6325 VGND.n533 VGND 432.42
R6326 VGND VGND.n522 0.145955
R6327 VGND.n522 VGND.n520 432.565
R6328 VGND.n533 VGND.n518 442.729
R6329 VGND.n518 VGND.n520 442.729
R6330 VGND.n97 VGND.n522 17.8907
R6331 VGND.n528 VGND.n526 2.3505
R6332 VGND.n530 VGND.n528 2.3505
R6333 VGND.n532 VGND.n530 2.5949
R6334 VGND.n97 VGND.n532 1.53681
R6335 VGND.n532 VGND.n531 17.3121
R6336 VGND VGND.n531 0.145955
R6337 VGND.n531 VGND.n482 432.565
R6338 VGND.n479 VGND.n482 442.729
R6339 VGND.n486 VGND.n479 442.729
R6340 VGND.n486 VGND 432.42
R6341 VGND.n530 VGND.n529 17.3121
R6342 VGND VGND.n529 0.145955
R6343 VGND.n529 VGND.n513 256.753
R6344 VGND.n511 VGND.n513 266.918
R6345 VGND.n516 VGND.n511 266.918
R6346 VGND.n516 VGND 256.608
R6347 VGND.n528 VGND.n527 17.3121
R6348 VGND VGND.n527 0.145955
R6349 VGND.n527 VGND.n506 256.753
R6350 VGND.n504 VGND.n506 266.918
R6351 VGND.n509 VGND.n504 266.918
R6352 VGND.n509 VGND 256.608
R6353 VGND.n526 VGND.n525 17.3121
R6354 VGND VGND.n525 0.145955
R6355 VGND.n525 VGND.n499 256.753
R6356 VGND.n497 VGND.n499 266.918
R6357 VGND.n502 VGND.n497 266.918
R6358 VGND.n502 VGND 256.608
R6359 VGND.n526 VGND.n524 19.6621
R6360 VGND VGND.n524 0.145955
R6361 VGND.n524 VGND.n492 256.753
R6362 VGND.n489 VGND.n492 266.918
R6363 VGND.n495 VGND.n489 266.918
R6364 VGND.n495 VGND 256.608
R6365 VGND.n523 VGND.n521 6813.88
R6366 VGND.n521 VGND.n519 6813.88
R6367 VGND.n523 VGND.n517 6813.88
R6368 VGND.n517 VGND.n519 6813.88
R6369 VGND.n515 VGND.n514 4108.03
R6370 VGND.n514 VGND.n512 4108.03
R6371 VGND.n515 VGND.n510 4108.03
R6372 VGND.n510 VGND.n512 4108.03
R6373 VGND.n508 VGND.n507 4108.03
R6374 VGND.n507 VGND.n505 4108.03
R6375 VGND.n508 VGND.n503 4108.03
R6376 VGND.n503 VGND.n505 4108.03
R6377 VGND.n501 VGND.n500 4108.03
R6378 VGND.n500 VGND.n498 4108.03
R6379 VGND.n501 VGND.n496 4108.03
R6380 VGND.n496 VGND.n498 4108.03
R6381 VGND.n494 VGND.n493 4108.03
R6382 VGND.n493 VGND.n491 4108.03
R6383 VGND.n494 VGND.n488 4108.03
R6384 VGND.n488 VGND.n491 4108.03
R6385 VGND.n485 VGND.n484 6813.88
R6386 VGND.n484 VGND.n481 6813.88
R6387 VGND.n485 VGND.n478 6813.88
R6388 VGND.n478 VGND.n481 6813.88
R6389 VGND.n476 VGND 432.42
R6390 VGND VGND.n465 0.145955
R6391 VGND.n465 VGND.n463 432.565
R6392 VGND.n476 VGND.n461 442.729
R6393 VGND.n461 VGND.n463 442.729
R6394 VGND.n87 VGND.n465 17.8907
R6395 VGND.n471 VGND.n469 2.3505
R6396 VGND.n473 VGND.n471 2.3505
R6397 VGND.n475 VGND.n473 2.5949
R6398 VGND.n87 VGND.n475 1.53681
R6399 VGND.n475 VGND.n474 17.3121
R6400 VGND VGND.n474 0.145955
R6401 VGND.n474 VGND.n425 432.565
R6402 VGND.n422 VGND.n425 442.729
R6403 VGND.n429 VGND.n422 442.729
R6404 VGND.n429 VGND 432.42
R6405 VGND.n473 VGND.n472 17.3121
R6406 VGND VGND.n472 0.145955
R6407 VGND.n472 VGND.n456 256.753
R6408 VGND.n454 VGND.n456 266.918
R6409 VGND.n459 VGND.n454 266.918
R6410 VGND.n459 VGND 256.608
R6411 VGND.n471 VGND.n470 17.3121
R6412 VGND VGND.n470 0.145955
R6413 VGND.n470 VGND.n449 256.753
R6414 VGND.n447 VGND.n449 266.918
R6415 VGND.n452 VGND.n447 266.918
R6416 VGND.n452 VGND 256.608
R6417 VGND.n469 VGND.n468 17.3121
R6418 VGND VGND.n468 0.145955
R6419 VGND.n468 VGND.n442 256.753
R6420 VGND.n440 VGND.n442 266.918
R6421 VGND.n445 VGND.n440 266.918
R6422 VGND.n445 VGND 256.608
R6423 VGND.n469 VGND.n467 19.6621
R6424 VGND VGND.n467 0.145955
R6425 VGND.n467 VGND.n435 256.753
R6426 VGND.n432 VGND.n435 266.918
R6427 VGND.n438 VGND.n432 266.918
R6428 VGND.n438 VGND 256.608
R6429 VGND.n466 VGND.n464 6813.88
R6430 VGND.n464 VGND.n462 6813.88
R6431 VGND.n466 VGND.n460 6813.88
R6432 VGND.n460 VGND.n462 6813.88
R6433 VGND.n458 VGND.n457 4108.03
R6434 VGND.n457 VGND.n455 4108.03
R6435 VGND.n458 VGND.n453 4108.03
R6436 VGND.n453 VGND.n455 4108.03
R6437 VGND.n451 VGND.n450 4108.03
R6438 VGND.n450 VGND.n448 4108.03
R6439 VGND.n451 VGND.n446 4108.03
R6440 VGND.n446 VGND.n448 4108.03
R6441 VGND.n444 VGND.n443 4108.03
R6442 VGND.n443 VGND.n441 4108.03
R6443 VGND.n444 VGND.n439 4108.03
R6444 VGND.n439 VGND.n441 4108.03
R6445 VGND.n437 VGND.n436 4108.03
R6446 VGND.n436 VGND.n434 4108.03
R6447 VGND.n437 VGND.n431 4108.03
R6448 VGND.n431 VGND.n434 4108.03
R6449 VGND.n428 VGND.n427 6813.88
R6450 VGND.n427 VGND.n424 6813.88
R6451 VGND.n428 VGND.n421 6813.88
R6452 VGND.n421 VGND.n424 6813.88
R6453 VGND.n419 VGND 235.903
R6454 VGND VGND.n403 0.145955
R6455 VGND.n403 VGND.n401 236.048
R6456 VGND.n419 VGND.n399 246.213
R6457 VGND.n399 VGND.n401 246.213
R6458 VGND.n418 VGND.n403 17.3121
R6459 VGND.n409 VGND.n407 1.528
R6460 VGND.n411 VGND.n409 1.528
R6461 VGND.n413 VGND.n411 1.528
R6462 VGND.n415 VGND.n413 1.528
R6463 VGND.n417 VGND.n415 1.528
R6464 VGND.n418 VGND.n417 1.528
R6465 VGND.n78 VGND.n418 4.16602
R6466 VGND.n417 VGND.n416 17.3121
R6467 VGND VGND.n416 0.145955
R6468 VGND.n416 VGND.n394 236.048
R6469 VGND.n392 VGND.n394 246.213
R6470 VGND.n397 VGND.n392 246.213
R6471 VGND.n397 VGND 235.903
R6472 VGND.n415 VGND.n414 17.3121
R6473 VGND VGND.n414 0.145955
R6474 VGND.n414 VGND.n387 236.048
R6475 VGND.n385 VGND.n387 246.213
R6476 VGND.n390 VGND.n385 246.213
R6477 VGND.n390 VGND 235.903
R6478 VGND.n413 VGND.n412 17.3121
R6479 VGND VGND.n412 0.145955
R6480 VGND.n412 VGND.n380 236.048
R6481 VGND.n378 VGND.n380 246.213
R6482 VGND.n383 VGND.n378 246.213
R6483 VGND.n383 VGND 235.903
R6484 VGND.n411 VGND.n410 17.3121
R6485 VGND VGND.n410 0.145955
R6486 VGND.n410 VGND.n373 236.048
R6487 VGND.n371 VGND.n373 246.213
R6488 VGND.n376 VGND.n371 246.213
R6489 VGND.n376 VGND 235.903
R6490 VGND.n409 VGND.n408 17.3121
R6491 VGND VGND.n408 0.145955
R6492 VGND.n408 VGND.n366 236.048
R6493 VGND.n364 VGND.n366 246.213
R6494 VGND.n369 VGND.n364 246.213
R6495 VGND.n369 VGND 235.903
R6496 VGND.n407 VGND.n406 17.3121
R6497 VGND VGND.n406 0.145955
R6498 VGND.n406 VGND.n359 236.048
R6499 VGND.n357 VGND.n359 246.213
R6500 VGND.n362 VGND.n357 246.213
R6501 VGND.n362 VGND 235.903
R6502 VGND.n407 VGND.n405 18.8396
R6503 VGND VGND.n405 0.145955
R6504 VGND.n405 VGND.n351 236.048
R6505 VGND.n348 VGND.n351 246.213
R6506 VGND.n355 VGND.n348 246.213
R6507 VGND.n355 VGND 235.903
R6508 VGND.n404 VGND.n402 3789.35
R6509 VGND.n402 VGND.n400 3789.35
R6510 VGND.n404 VGND.n398 3789.35
R6511 VGND.n398 VGND.n400 3789.35
R6512 VGND.n396 VGND.n395 3789.35
R6513 VGND.n395 VGND.n393 3789.35
R6514 VGND.n396 VGND.n391 3789.35
R6515 VGND.n391 VGND.n393 3789.35
R6516 VGND.n389 VGND.n388 3789.35
R6517 VGND.n388 VGND.n386 3789.35
R6518 VGND.n389 VGND.n384 3789.35
R6519 VGND.n384 VGND.n386 3789.35
R6520 VGND.n382 VGND.n381 3789.35
R6521 VGND.n381 VGND.n379 3789.35
R6522 VGND.n382 VGND.n377 3789.35
R6523 VGND.n377 VGND.n379 3789.35
R6524 VGND.n375 VGND.n374 3789.35
R6525 VGND.n374 VGND.n372 3789.35
R6526 VGND.n375 VGND.n370 3789.35
R6527 VGND.n370 VGND.n372 3789.35
R6528 VGND.n368 VGND.n367 3789.35
R6529 VGND.n367 VGND.n365 3789.35
R6530 VGND.n368 VGND.n363 3789.35
R6531 VGND.n363 VGND.n365 3789.35
R6532 VGND.n361 VGND.n360 3789.35
R6533 VGND.n360 VGND.n358 3789.35
R6534 VGND.n361 VGND.n356 3789.35
R6535 VGND.n356 VGND.n358 3789.35
R6536 VGND.n354 VGND.n353 3789.35
R6537 VGND.n353 VGND.n350 3789.35
R6538 VGND.n354 VGND.n347 3789.35
R6539 VGND.n347 VGND.n350 3789.35
R6540 VGND.n345 VGND 235.903
R6541 VGND VGND.n329 0.145955
R6542 VGND.n329 VGND.n327 236.048
R6543 VGND.n345 VGND.n325 246.213
R6544 VGND.n325 VGND.n327 246.213
R6545 VGND.n344 VGND.n329 17.3121
R6546 VGND.n335 VGND.n333 1.528
R6547 VGND.n337 VGND.n335 1.528
R6548 VGND.n339 VGND.n337 1.528
R6549 VGND.n341 VGND.n339 1.528
R6550 VGND.n343 VGND.n341 1.528
R6551 VGND.n344 VGND.n343 1.528
R6552 VGND.n76 VGND.n344 4.16602
R6553 VGND.n343 VGND.n342 17.3121
R6554 VGND VGND.n342 0.145955
R6555 VGND.n342 VGND.n320 236.048
R6556 VGND.n318 VGND.n320 246.213
R6557 VGND.n323 VGND.n318 246.213
R6558 VGND.n323 VGND 235.903
R6559 VGND.n341 VGND.n340 17.3121
R6560 VGND VGND.n340 0.145955
R6561 VGND.n340 VGND.n313 236.048
R6562 VGND.n311 VGND.n313 246.213
R6563 VGND.n316 VGND.n311 246.213
R6564 VGND.n316 VGND 235.903
R6565 VGND.n339 VGND.n338 17.3121
R6566 VGND VGND.n338 0.145955
R6567 VGND.n338 VGND.n306 236.048
R6568 VGND.n304 VGND.n306 246.213
R6569 VGND.n309 VGND.n304 246.213
R6570 VGND.n309 VGND 235.903
R6571 VGND.n337 VGND.n336 17.3121
R6572 VGND VGND.n336 0.145955
R6573 VGND.n336 VGND.n299 236.048
R6574 VGND.n297 VGND.n299 246.213
R6575 VGND.n302 VGND.n297 246.213
R6576 VGND.n302 VGND 235.903
R6577 VGND.n335 VGND.n334 17.3121
R6578 VGND VGND.n334 0.145955
R6579 VGND.n334 VGND.n292 236.048
R6580 VGND.n290 VGND.n292 246.213
R6581 VGND.n295 VGND.n290 246.213
R6582 VGND.n295 VGND 235.903
R6583 VGND.n333 VGND.n332 17.3121
R6584 VGND VGND.n332 0.145955
R6585 VGND.n332 VGND.n285 236.048
R6586 VGND.n283 VGND.n285 246.213
R6587 VGND.n288 VGND.n283 246.213
R6588 VGND.n288 VGND 235.903
R6589 VGND.n333 VGND.n331 18.8396
R6590 VGND VGND.n331 0.145955
R6591 VGND.n331 VGND.n277 236.048
R6592 VGND.n274 VGND.n277 246.213
R6593 VGND.n281 VGND.n274 246.213
R6594 VGND.n281 VGND 235.903
R6595 VGND.n330 VGND.n328 3789.35
R6596 VGND.n328 VGND.n326 3789.35
R6597 VGND.n330 VGND.n324 3789.35
R6598 VGND.n324 VGND.n326 3789.35
R6599 VGND.n322 VGND.n321 3789.35
R6600 VGND.n321 VGND.n319 3789.35
R6601 VGND.n322 VGND.n317 3789.35
R6602 VGND.n317 VGND.n319 3789.35
R6603 VGND.n315 VGND.n314 3789.35
R6604 VGND.n314 VGND.n312 3789.35
R6605 VGND.n315 VGND.n310 3789.35
R6606 VGND.n310 VGND.n312 3789.35
R6607 VGND.n308 VGND.n307 3789.35
R6608 VGND.n307 VGND.n305 3789.35
R6609 VGND.n308 VGND.n303 3789.35
R6610 VGND.n303 VGND.n305 3789.35
R6611 VGND.n301 VGND.n300 3789.35
R6612 VGND.n300 VGND.n298 3789.35
R6613 VGND.n301 VGND.n296 3789.35
R6614 VGND.n296 VGND.n298 3789.35
R6615 VGND.n294 VGND.n293 3789.35
R6616 VGND.n293 VGND.n291 3789.35
R6617 VGND.n294 VGND.n289 3789.35
R6618 VGND.n289 VGND.n291 3789.35
R6619 VGND.n287 VGND.n286 3789.35
R6620 VGND.n286 VGND.n284 3789.35
R6621 VGND.n287 VGND.n282 3789.35
R6622 VGND.n282 VGND.n284 3789.35
R6623 VGND.n280 VGND.n279 3789.35
R6624 VGND.n279 VGND.n276 3789.35
R6625 VGND.n280 VGND.n273 3789.35
R6626 VGND.n273 VGND.n276 3789.35
R6627 VGND.n271 VGND 2925.93
R6628 VGND VGND.n269 0.145955
R6629 VGND.n269 VGND.n267 2932.33
R6630 VGND.n271 VGND.n265 2942.49
R6631 VGND.n265 VGND.n267 2942.49
R6632 VGND.n100 VGND.n269 17.3121
R6633 VGND.n270 VGND.n268 45286.8
R6634 VGND.n268 VGND.n266 45286.8
R6635 VGND.n270 VGND.n264 45286.8
R6636 VGND.n264 VGND.n266 45286.8
R6637 VGND.n263 VGND 715.149
R6638 VGND VGND.n259 0.145955
R6639 VGND.n259 VGND.n257 715.294
R6640 VGND.n263 VGND.n255 725.46
R6641 VGND.n255 VGND.n257 725.46
R6642 VGND.n261 VGND.n259 25.8887
R6643 VGND.n75 VGND.n261 5.25172
R6644 VGND.n261 VGND.n262 24.9369
R6645 VGND VGND.n262 0.145955
R6646 VGND.n262 VGND.n249 715.294
R6647 VGND.n246 VGND.n249 725.46
R6648 VGND.n253 VGND.n246 725.46
R6649 VGND.n253 VGND 715.149
R6650 VGND.n260 VGND.n258 11165.3
R6651 VGND.n258 VGND.n256 11165.3
R6652 VGND.n260 VGND.n254 11165.3
R6653 VGND.n254 VGND.n256 11165.3
R6654 VGND.n252 VGND.n251 11165.3
R6655 VGND.n251 VGND.n248 11165.3
R6656 VGND.n252 VGND.n245 11165.3
R6657 VGND.n245 VGND.n248 11165.3
R6658 VGND.n243 VGND 419.997
R6659 VGND VGND.n223 0.145955
R6660 VGND.n223 VGND.n221 420.142
R6661 VGND.n243 VGND.n219 430.307
R6662 VGND.n219 VGND.n221 430.307
R6663 VGND.n242 VGND.n223 24.9369
R6664 VGND.n227 VGND.n225 1.85932
R6665 VGND.n242 VGND.n227 0.124973
R6666 VGND.n74 VGND.n242 11.4134
R6667 VGND.n225 VGND.n235 11.1667
R6668 VGND.n235 VGND.n241 0.602062
R6669 VGND.n241 VGND.n240 0.586438
R6670 VGND.n241 VGND 0.0708125
R6671 VGND.n240 VGND 0.141125
R6672 VGND VGND.n239 0.03175
R6673 VGND.n240 VGND 0.234875
R6674 VGND VGND.n239 0.03175
R6675 VGND VGND.n239 6.81482
R6676 VGND.n236 VGND.n238 0.586438
R6677 VGND.n235 VGND.n236 0.602062
R6678 VGND.n238 VGND 0.141125
R6679 VGND VGND.n237 0.03175
R6680 VGND.n238 VGND 0.234875
R6681 VGND VGND.n237 0.03175
R6682 VGND VGND.n237 6.81482
R6683 VGND.n236 VGND 0.0708125
R6684 VGND.n235 VGND 0.0551875
R6685 VGND.n227 VGND.n228 10.9355
R6686 VGND.n228 VGND.n234 0.602062
R6687 VGND.n234 VGND.n233 0.586438
R6688 VGND.n234 VGND 0.0708125
R6689 VGND.n233 VGND 0.141125
R6690 VGND VGND.n232 0.03175
R6691 VGND.n233 VGND 0.234875
R6692 VGND VGND.n232 0.03175
R6693 VGND VGND.n232 6.81482
R6694 VGND.n229 VGND.n231 0.586438
R6695 VGND.n228 VGND.n229 0.602062
R6696 VGND.n231 VGND 0.141125
R6697 VGND VGND.n230 0.03175
R6698 VGND.n231 VGND 0.234875
R6699 VGND VGND.n230 0.03175
R6700 VGND VGND.n230 6.81482
R6701 VGND.n229 VGND 0.0708125
R6702 VGND.n228 VGND 0.0551875
R6703 VGND.n225 VGND.n226 25.0309
R6704 VGND VGND.n226 0.145955
R6705 VGND.n226 VGND.n213 420.142
R6706 VGND.n210 VGND.n213 430.307
R6707 VGND.n217 VGND.n210 430.307
R6708 VGND.n217 VGND 419.997
R6709 VGND.n224 VGND.n222 6622.68
R6710 VGND.n222 VGND.n220 6622.68
R6711 VGND.n224 VGND.n218 6622.68
R6712 VGND.n218 VGND.n220 6622.68
R6713 VGND.n216 VGND.n215 6622.68
R6714 VGND.n215 VGND.n212 6622.68
R6715 VGND.n216 VGND.n209 6622.68
R6716 VGND.n209 VGND.n212 6622.68
R6717 VGND.n207 VGND 3816.89
R6718 VGND VGND.n205 0.145955
R6719 VGND.n205 VGND.n203 3817.04
R6720 VGND.n207 VGND.n200 3827.2
R6721 VGND.n200 VGND.n203 3827.2
R6722 VGND.n102 VGND.n205 17.3121
R6723 VGND.n206 VGND.n204 58903
R6724 VGND.n204 VGND.n202 58903
R6725 VGND.n206 VGND.n199 58903
R6726 VGND.n199 VGND.n202 58903
R6727 VGND.n197 VGND 1971.43
R6728 VGND VGND.n195 0.145955
R6729 VGND.n195 VGND.n192 1971.58
R6730 VGND.n197 VGND.n189 1981.74
R6731 VGND.n189 VGND.n192 1981.74
R6732 VGND.n77 VGND.n195 33.249
R6733 VGND.n196 VGND.n194 30500.2
R6734 VGND.n194 VGND.n191 30500.2
R6735 VGND.n196 VGND.n188 30500.2
R6736 VGND.n188 VGND.n191 30500.2
R6737 VGND.n186 VGND 205.785
R6738 VGND VGND.n171 0.145955
R6739 VGND.n171 VGND.n169 205.929
R6740 VGND.n186 VGND.n167 216.095
R6741 VGND.n167 VGND.n169 216.095
R6742 VGND.n185 VGND.n171 19.4271
R6743 VGND.n177 VGND.n175 1.9463
R6744 VGND.n179 VGND.n177 2.1719
R6745 VGND.n181 VGND.n179 2.2283
R6746 VGND.n183 VGND.n181 1.9463
R6747 VGND.n71 VGND.n183 0.577425
R6748 VGND.n71 VGND.n185 1.59498
R6749 VGND.n185 VGND.n184 17.3121
R6750 VGND VGND.n184 0.145955
R6751 VGND.n184 VGND.n162 205.929
R6752 VGND.n160 VGND.n162 216.095
R6753 VGND.n165 VGND.n160 216.095
R6754 VGND.n165 VGND 205.785
R6755 VGND.n183 VGND.n182 17.3121
R6756 VGND VGND.n182 0.145955
R6757 VGND.n182 VGND.n155 169.788
R6758 VGND.n155 VGND.n153 179.953
R6759 VGND.n158 VGND.n153 179.953
R6760 VGND.n158 VGND 169.643
R6761 VGND.n181 VGND.n180 17.3121
R6762 VGND VGND.n180 0.145955
R6763 VGND.n180 VGND.n134 315.106
R6764 VGND.n132 VGND.n134 325.272
R6765 VGND.n137 VGND.n132 325.272
R6766 VGND.n137 VGND 314.961
R6767 VGND.n179 VGND.n178 17.3121
R6768 VGND VGND.n178 0.145955
R6769 VGND.n178 VGND.n148 205.929
R6770 VGND.n146 VGND.n148 216.095
R6771 VGND.n151 VGND.n146 216.095
R6772 VGND.n151 VGND 205.785
R6773 VGND.n177 VGND.n176 17.3121
R6774 VGND VGND.n176 0.145955
R6775 VGND.n176 VGND.n141 169.788
R6776 VGND.n141 VGND.n139 179.953
R6777 VGND.n144 VGND.n139 179.953
R6778 VGND.n144 VGND 169.643
R6779 VGND.n175 VGND.n174 17.3121
R6780 VGND VGND.n174 0.145955
R6781 VGND.n174 VGND.n117 315.106
R6782 VGND.n114 VGND.n117 325.272
R6783 VGND.n121 VGND.n114 325.272
R6784 VGND.n121 VGND 314.961
R6785 VGND.n175 VGND.n173 19.5963
R6786 VGND VGND.n173 0.145955
R6787 VGND.n173 VGND.n127 169.788
R6788 VGND.n127 VGND.n124 179.953
R6789 VGND.n130 VGND.n124 179.953
R6790 VGND.n130 VGND 169.643
R6791 VGND.n172 VGND.n170 3325.82
R6792 VGND.n170 VGND.n168 3325.82
R6793 VGND.n172 VGND.n166 3325.82
R6794 VGND.n166 VGND.n168 3325.82
R6795 VGND.n164 VGND.n163 3325.82
R6796 VGND.n163 VGND.n161 3325.82
R6797 VGND.n164 VGND.n159 3325.82
R6798 VGND.n159 VGND.n161 3325.82
R6799 VGND.n157 VGND.n156 2769.59
R6800 VGND.n156 VGND.n154 2769.59
R6801 VGND.n157 VGND.n152 2769.59
R6802 VGND.n152 VGND.n154 2769.59
R6803 VGND.n150 VGND.n149 3325.82
R6804 VGND.n149 VGND.n147 3325.82
R6805 VGND.n150 VGND.n145 3325.82
R6806 VGND.n145 VGND.n147 3325.82
R6807 VGND.n143 VGND.n142 2769.59
R6808 VGND.n142 VGND.n140 2769.59
R6809 VGND.n143 VGND.n138 2769.59
R6810 VGND.n138 VGND.n140 2769.59
R6811 VGND.n136 VGND.n135 5006.12
R6812 VGND.n135 VGND.n133 5006.12
R6813 VGND.n136 VGND.n131 5006.12
R6814 VGND.n131 VGND.n133 5006.12
R6815 VGND.n129 VGND.n128 2769.59
R6816 VGND.n128 VGND.n126 2769.59
R6817 VGND.n129 VGND.n123 2769.59
R6818 VGND.n123 VGND.n126 2769.59
R6819 VGND.n120 VGND.n119 5006.12
R6820 VGND.n119 VGND.n116 5006.12
R6821 VGND.n120 VGND.n113 5006.12
R6822 VGND.n113 VGND.n116 5006.12
R6823 VGND.n99 VGND 22.617
R6824 VGND.n95 VGND.n89 4.9004
R6825 VGND.n95 VGND.n92 4.0356
R6826 VGND.n92 VGND.n94 0.602062
R6827 VGND.n94 VGND 4.67238
R6828 VGND.n94 VGND 5.30116
R6829 VGND.n92 VGND.n93 0.602062
R6830 VGND.n93 VGND 5.30116
R6831 VGND.n93 VGND 4.67238
R6832 VGND.n92 VGND 4.65675
R6833 VGND.n89 VGND.n91 0.602062
R6834 VGND.n91 VGND 4.67238
R6835 VGND.n91 VGND 5.30116
R6836 VGND.n89 VGND.n90 0.602062
R6837 VGND.n90 VGND 5.30116
R6838 VGND.n90 VGND 4.67238
R6839 VGND.n89 VGND 4.65675
R6840 VGND.n85 VGND.n79 4.9004
R6841 VGND.n85 VGND.n82 4.0356
R6842 VGND.n82 VGND.n84 0.602062
R6843 VGND.n84 VGND 4.67238
R6844 VGND.n84 VGND 5.30116
R6845 VGND.n82 VGND.n83 0.602062
R6846 VGND.n83 VGND 5.30116
R6847 VGND.n83 VGND 4.67238
R6848 VGND.n82 VGND 4.65675
R6849 VGND.n79 VGND.n81 0.602062
R6850 VGND.n81 VGND 4.67238
R6851 VGND.n81 VGND 5.30116
R6852 VGND.n79 VGND.n80 0.602062
R6853 VGND.n80 VGND 5.30116
R6854 VGND.n80 VGND 4.67238
R6855 VGND.n79 VGND 4.65675
R6856 VGND VGND.n73 9.41307
R6857 VGND.n59 VGND.n56 3.4105
R6858 VGND.n61 VGND.n60 3.4105
R6859 VGND.n63 VGND.n62 3.4105
R6860 VGND.n67 VGND.n64 3.4105
R6861 VGND.n69 VGND.n68 3.4105
R6862 VGND.n59 VGND.n55 5.6383
R6863 VGND.n61 VGND.n59 2.0027
R6864 VGND.n63 VGND.n61 2.1155
R6865 VGND.n67 VGND.n63 2.2283
R6866 VGND.n69 VGND.n67 2.0027
R6867 VGND.n70 VGND.n69 3.90282
R6868 VGND.n68 VGND 5.06549
R6869 VGND VGND.n68 4.67889
R6870 VGND.n64 VGND.n66 0.359875
R6871 VGND.n66 VGND 4.67238
R6872 VGND.n66 VGND 5.05898
R6873 VGND.n64 VGND.n65 0.359875
R6874 VGND.n65 VGND 5.05898
R6875 VGND.n65 VGND 4.67238
R6876 VGND.n64 VGND 4.65675
R6877 VGND.n62 VGND 5.06549
R6878 VGND.n62 VGND 5.06549
R6879 VGND VGND.n62 4.67889
R6880 VGND.n60 VGND 5.06549
R6881 VGND VGND.n60 4.67889
R6882 VGND.n56 VGND.n58 0.359875
R6883 VGND.n58 VGND 4.67238
R6884 VGND.n58 VGND 5.05898
R6885 VGND.n56 VGND.n57 0.359875
R6886 VGND.n57 VGND 5.05898
R6887 VGND.n57 VGND 4.67238
R6888 VGND.n56 VGND 4.65675
R6889 VGND.n55 VGND 5.06549
R6890 VGND VGND.n55 4.67889
R6891 VGND.n54 VGND.n31 5.00498
R6892 VGND.n31 VGND.n32 10.2847
R6893 VGND.n32 VGND.n33 9.3005
R6894 VGND VGND.n32 0.0466957
R6895 VGND.n35 VGND.n34 6.10787
R6896 VGND.n32 VGND.n35 1.92
R6897 VGND.n35 VGND.n36 158.304
R6898 VGND.n37 VGND.n38 6.10787
R6899 VGND.n34 VGND.n39 152
R6900 VGND.n33 VGND.n40 152
R6901 VGND.n37 VGND.n41 152
R6902 VGND.n38 VGND.n53 158.304
R6903 VGND.n33 VGND.n37 36.1417
R6904 VGND.n33 VGND.n34 36.1417
R6905 VGND.n53 VGND.n41 70.1096
R6906 VGND.n41 VGND.n40 70.1096
R6907 VGND.n40 VGND.n39 70.1096
R6908 VGND.n39 VGND.n36 70.1096
R6909 VGND.n53 VGND.n42 613.747
R6910 VGND.n44 VGND.n45 152
R6911 VGND.n46 VGND.n47 152
R6912 VGND.n48 VGND.n49 152
R6913 VGND.n42 VGND.n48 70.1096
R6914 VGND.n48 VGND.n46 70.1096
R6915 VGND.n46 VGND.n44 70.1096
R6916 VGND.n44 VGND.n43 70.1096
R6917 VGND.n45 VGND.n50 6.10787
R6918 VGND.n47 VGND.n51 9.3005
R6919 VGND.n52 VGND.n49 6.10787
R6920 VGND.n42 VGND.n52 158.304
R6921 VGND.n49 VGND.n47 36.1417
R6922 VGND.n47 VGND.n45 36.1417
R6923 VGND.n50 VGND.n43 158.304
R6924 VGND.n51 VGND.n52 1.92
R6925 VGND.n50 VGND.n51 1.92
R6926 VGND.n41 VGND.n48 613.747
R6927 VGND.n40 VGND.n46 613.747
R6928 VGND.n39 VGND.n44 613.747
R6929 VGND.n36 VGND.n43 613.747
R6930 VGND.n38 VGND 1.8738
R6931 VGND.n31 VGND.n9 8.16967
R6932 VGND.n9 VGND.n10 9.3005
R6933 VGND VGND.n9 0.0466957
R6934 VGND.n12 VGND.n11 6.10787
R6935 VGND.n9 VGND.n12 1.92
R6936 VGND.n12 VGND.n13 158.304
R6937 VGND.n14 VGND.n15 6.10787
R6938 VGND.n11 VGND.n16 152
R6939 VGND.n10 VGND.n17 152
R6940 VGND.n14 VGND.n18 152
R6941 VGND.n15 VGND.n30 158.304
R6942 VGND.n10 VGND.n14 36.1417
R6943 VGND.n10 VGND.n11 36.1417
R6944 VGND.n30 VGND.n18 70.1096
R6945 VGND.n18 VGND.n17 70.1096
R6946 VGND.n17 VGND.n16 70.1096
R6947 VGND.n16 VGND.n13 70.1096
R6948 VGND.n30 VGND.n19 613.747
R6949 VGND.n21 VGND.n22 152
R6950 VGND.n23 VGND.n24 152
R6951 VGND.n25 VGND.n26 152
R6952 VGND.n19 VGND.n25 70.1096
R6953 VGND.n25 VGND.n23 70.1096
R6954 VGND.n23 VGND.n21 70.1096
R6955 VGND.n21 VGND.n20 70.1096
R6956 VGND.n22 VGND.n27 6.10787
R6957 VGND.n24 VGND.n28 9.3005
R6958 VGND.n29 VGND.n26 6.10787
R6959 VGND.n19 VGND.n29 158.304
R6960 VGND.n26 VGND.n24 36.1417
R6961 VGND.n24 VGND.n22 36.1417
R6962 VGND.n27 VGND.n20 158.304
R6963 VGND.n28 VGND.n29 1.92
R6964 VGND.n27 VGND.n28 1.92
R6965 VGND.n18 VGND.n25 613.747
R6966 VGND.n17 VGND.n23 613.747
R6967 VGND.n16 VGND.n21 613.747
R6968 VGND.n13 VGND.n20 613.747
R6969 VGND.n15 VGND 1.8738
R6970 VGND.n2 VGND.n1 3.4105
R6971 VGND.n4 VGND.n3 3.4105
R6972 VGND.n2 VGND.n0 5.5255
R6973 VGND.n6 VGND.n2 0.492825
R6974 VGND.n6 VGND.n4 1.62318
R6975 VGND.n4 VGND.n5 5.5255
R6976 VGND.n5 VGND 5.04335
R6977 VGND.n5 VGND 5.04335
R6978 VGND.n5 VGND 4.65675
R6979 VGND.n3 VGND 5.04335
R6980 VGND.n3 VGND 5.04335
R6981 VGND.n3 VGND 4.65675
R6982 VGND.n1 VGND 5.04335
R6983 VGND.n1 VGND 5.04335
R6984 VGND.n1 VGND 4.65675
R6985 VGND.n0 VGND 5.04335
R6986 VGND.n0 VGND 5.04335
R6987 VGND.n0 VGND 4.65675
R6988 VDPWR VDPWR.n257 24.5395
R6989 VDPWR.n94 VDPWR.n93 3.4105
R6990 VDPWR.n207 VDPWR.n206 3.4105
R6991 VDPWR.n253 VDPWR.n252 3.4105
R6992 VDPWR.n256 VDPWR.n255 3.4105
R6993 VDPWR.n256 VDPWR.n254 1.68898
R6994 VDPWR.n254 VDPWR.n257 1.29535
R6995 VDPWR.n257 VDPWR.n253 7.70967
R6996 VDPWR.n253 VDPWR.n207 0.60445
R6997 VDPWR.n207 VDPWR.n104 0.182625
R6998 VDPWR.n104 VDPWR.n94 2.1625
R6999 VDPWR.n94 VDPWR.n6 3.51038
R7000 VDPWR VDPWR.n256 17.025
R7001 VDPWR VDPWR.n255 8.9989
R7002 VDPWR VDPWR.n255 8.5007
R7003 VDPWR VDPWR.n254 14.9558
R7004 VDPWR.n252 VDPWR.n230 9.81115
R7005 VDPWR.n230 VDPWR.n231 9.3005
R7006 VDPWR VDPWR.n230 0.0466957
R7007 VDPWR.n233 VDPWR.n232 6.10787
R7008 VDPWR.n230 VDPWR.n233 1.92
R7009 VDPWR.n233 VDPWR.n234 158.304
R7010 VDPWR.n235 VDPWR.n236 6.10787
R7011 VDPWR.n232 VDPWR.n237 152
R7012 VDPWR.n231 VDPWR.n238 152
R7013 VDPWR.n235 VDPWR.n239 152
R7014 VDPWR.n236 VDPWR.n251 158.304
R7015 VDPWR.n231 VDPWR.n235 36.1417
R7016 VDPWR.n231 VDPWR.n232 36.1417
R7017 VDPWR.n251 VDPWR.n239 70.1096
R7018 VDPWR.n239 VDPWR.n238 70.1096
R7019 VDPWR.n238 VDPWR.n237 70.1096
R7020 VDPWR.n237 VDPWR.n234 70.1096
R7021 VDPWR.n251 VDPWR.n240 327.76
R7022 VDPWR.n242 VDPWR.n243 152
R7023 VDPWR.n244 VDPWR.n245 152
R7024 VDPWR.n246 VDPWR.n247 152
R7025 VDPWR.n240 VDPWR.n246 70.1096
R7026 VDPWR.n246 VDPWR.n244 70.1096
R7027 VDPWR.n244 VDPWR.n242 70.1096
R7028 VDPWR.n242 VDPWR.n241 70.1096
R7029 VDPWR.n243 VDPWR.n248 6.10787
R7030 VDPWR.n245 VDPWR.n249 9.3005
R7031 VDPWR.n250 VDPWR.n247 6.10787
R7032 VDPWR.n240 VDPWR.n250 158.304
R7033 VDPWR.n247 VDPWR.n245 36.1417
R7034 VDPWR.n245 VDPWR.n243 36.1417
R7035 VDPWR.n248 VDPWR.n241 158.304
R7036 VDPWR.n249 VDPWR.n250 1.92
R7037 VDPWR.n248 VDPWR.n249 1.92
R7038 VDPWR.n239 VDPWR.n246 327.76
R7039 VDPWR.n238 VDPWR.n244 327.76
R7040 VDPWR.n237 VDPWR.n242 327.76
R7041 VDPWR.n234 VDPWR.n241 327.76
R7042 VDPWR.n236 VDPWR 1.8738
R7043 VDPWR.n252 VDPWR.n208 8.6432
R7044 VDPWR.n208 VDPWR.n209 9.3005
R7045 VDPWR VDPWR.n208 0.0466957
R7046 VDPWR.n211 VDPWR.n210 6.10787
R7047 VDPWR.n208 VDPWR.n211 1.92
R7048 VDPWR.n211 VDPWR.n212 158.304
R7049 VDPWR.n213 VDPWR.n214 6.10787
R7050 VDPWR.n210 VDPWR.n215 152
R7051 VDPWR.n209 VDPWR.n216 152
R7052 VDPWR.n213 VDPWR.n217 152
R7053 VDPWR.n214 VDPWR.n229 158.304
R7054 VDPWR.n209 VDPWR.n213 36.1417
R7055 VDPWR.n209 VDPWR.n210 36.1417
R7056 VDPWR.n229 VDPWR.n217 70.1096
R7057 VDPWR.n217 VDPWR.n216 70.1096
R7058 VDPWR.n216 VDPWR.n215 70.1096
R7059 VDPWR.n215 VDPWR.n212 70.1096
R7060 VDPWR.n229 VDPWR.n218 327.76
R7061 VDPWR.n220 VDPWR.n221 152
R7062 VDPWR.n222 VDPWR.n223 152
R7063 VDPWR.n224 VDPWR.n225 152
R7064 VDPWR.n218 VDPWR.n224 70.1096
R7065 VDPWR.n224 VDPWR.n222 70.1096
R7066 VDPWR.n222 VDPWR.n220 70.1096
R7067 VDPWR.n220 VDPWR.n219 70.1096
R7068 VDPWR.n221 VDPWR.n226 6.10787
R7069 VDPWR.n223 VDPWR.n227 9.3005
R7070 VDPWR.n228 VDPWR.n225 6.10787
R7071 VDPWR.n218 VDPWR.n228 158.304
R7072 VDPWR.n225 VDPWR.n223 36.1417
R7073 VDPWR.n223 VDPWR.n221 36.1417
R7074 VDPWR.n226 VDPWR.n219 158.304
R7075 VDPWR.n227 VDPWR.n228 1.92
R7076 VDPWR.n226 VDPWR.n227 1.92
R7077 VDPWR.n217 VDPWR.n224 327.76
R7078 VDPWR.n216 VDPWR.n222 327.76
R7079 VDPWR.n215 VDPWR.n220 327.76
R7080 VDPWR.n212 VDPWR.n219 327.76
R7081 VDPWR.n214 VDPWR 1.8738
R7082 VDPWR.n115 VDPWR.n171 1.53458
R7083 VDPWR.n174 VDPWR.n115 0.24866
R7084 VDPWR.n126 VDPWR.n174 1.30898
R7085 VDPWR.n137 VDPWR.n126 1.73762
R7086 VDPWR.n148 VDPWR.n137 1.78274
R7087 VDPWR.n180 VDPWR.n148 0.24866
R7088 VDPWR.n159 VDPWR.n180 1.30898
R7089 VDPWR.n170 VDPWR.n159 1.73762
R7090 VDPWR.n206 VDPWR.n170 0.37932
R7091 VDPWR.n206 VDPWR.n196 18.9463
R7092 VDPWR.n196 VDPWR.n198 23.1255
R7093 VDPWR VDPWR.n196 6.4005
R7094 VDPWR.n200 VDPWR.n199 26.4291
R7095 VDPWR VDPWR.n200 233.036
R7096 VDPWR.n197 VDPWR.n201 7.67543
R7097 VDPWR.n202 VDPWR.n203 23.1255
R7098 VDPWR.n203 VDPWR.n200 249.601
R7099 VDPWR.n205 VDPWR.n204 26.4291
R7100 VDPWR.n205 VDPWR.n203 249.601
R7101 VDPWR.n196 VDPWR.n205 239.435
R7102 VDPWR.n198 VDPWR.n204 2340
R7103 VDPWR.n198 VDPWR.n197 19.1003
R7104 VDPWR.n199 VDPWR.n202 2340
R7105 VDPWR.n201 VDPWR.n202 19.1003
R7106 VDPWR.n199 VDPWR.n197 388.26
R7107 VDPWR.n201 VDPWR.n204 388.26
R7108 VDPWR.n171 VDPWR.n186 17.6714
R7109 VDPWR.n186 VDPWR.n188 37.0005
R7110 VDPWR VDPWR.n186 6.4005
R7111 VDPWR.n191 VDPWR.n189 24.1801
R7112 VDPWR.n189 VDPWR.n190 30.8338
R7113 VDPWR VDPWR.n190 186.73
R7114 VDPWR.n193 VDPWR.n192 37.0005
R7115 VDPWR.n190 VDPWR.n193 203.294
R7116 VDPWR.n194 VDPWR.n187 24.1801
R7117 VDPWR.n195 VDPWR.n194 30.8338
R7118 VDPWR.n195 VDPWR.n193 203.294
R7119 VDPWR.n186 VDPWR.n195 193.13
R7120 VDPWR.n188 VDPWR.n187 387.132
R7121 VDPWR.n188 VDPWR.n189 1905.88
R7122 VDPWR.n191 VDPWR.n192 387.132
R7123 VDPWR.n192 VDPWR.n194 1905.88
R7124 VDPWR.n187 VDPWR.n191 12.5275
R7125 VDPWR.n180 VDPWR.n181 10.6006
R7126 VDPWR.n181 VDPWR.n185 0.359875
R7127 VDPWR.n185 VDPWR.n184 0.34425
R7128 VDPWR.n185 VDPWR 0.0708125
R7129 VDPWR.n184 VDPWR 0.141125
R7130 VDPWR.n184 VDPWR 0.234875
R7131 VDPWR.n182 VDPWR.n183 0.34425
R7132 VDPWR.n181 VDPWR.n182 0.359875
R7133 VDPWR.n183 VDPWR 0.141125
R7134 VDPWR.n183 VDPWR 0.234875
R7135 VDPWR.n182 VDPWR 0.0708125
R7136 VDPWR.n181 VDPWR 0.0551875
R7137 VDPWR.n174 VDPWR.n175 10.6006
R7138 VDPWR.n175 VDPWR.n179 0.359875
R7139 VDPWR.n179 VDPWR.n178 0.34425
R7140 VDPWR.n179 VDPWR 0.0708125
R7141 VDPWR.n178 VDPWR 0.141125
R7142 VDPWR.n178 VDPWR 0.234875
R7143 VDPWR.n176 VDPWR.n177 0.34425
R7144 VDPWR.n175 VDPWR.n176 0.359875
R7145 VDPWR.n177 VDPWR 0.141125
R7146 VDPWR.n177 VDPWR 0.234875
R7147 VDPWR.n176 VDPWR 0.0708125
R7148 VDPWR.n175 VDPWR 0.0551875
R7149 VDPWR.n171 VDPWR.n172 10.6006
R7150 VDPWR.n172 VDPWR.n173 0.328625
R7151 VDPWR.n173 VDPWR 0.234875
R7152 VDPWR VDPWR.n173 0.203625
R7153 VDPWR.n172 VDPWR 0.0551875
R7154 VDPWR.n170 VDPWR.n160 17.3121
R7155 VDPWR.n160 VDPWR.n162 23.1255
R7156 VDPWR VDPWR.n160 6.4005
R7157 VDPWR.n164 VDPWR.n163 26.4291
R7158 VDPWR VDPWR.n164 233.036
R7159 VDPWR.n161 VDPWR.n165 7.67543
R7160 VDPWR.n166 VDPWR.n167 23.1255
R7161 VDPWR.n167 VDPWR.n164 249.601
R7162 VDPWR.n169 VDPWR.n168 26.4291
R7163 VDPWR.n169 VDPWR.n167 249.601
R7164 VDPWR.n160 VDPWR.n169 239.435
R7165 VDPWR.n162 VDPWR.n168 2340
R7166 VDPWR.n162 VDPWR.n161 19.1003
R7167 VDPWR.n163 VDPWR.n166 2340
R7168 VDPWR.n165 VDPWR.n166 19.1003
R7169 VDPWR.n163 VDPWR.n161 388.26
R7170 VDPWR.n165 VDPWR.n168 388.26
R7171 VDPWR.n159 VDPWR.n149 17.3121
R7172 VDPWR.n149 VDPWR.n151 37.0005
R7173 VDPWR VDPWR.n149 6.4005
R7174 VDPWR.n154 VDPWR.n152 24.1801
R7175 VDPWR.n152 VDPWR.n153 30.8338
R7176 VDPWR VDPWR.n153 186.73
R7177 VDPWR.n156 VDPWR.n155 37.0005
R7178 VDPWR.n153 VDPWR.n156 203.294
R7179 VDPWR.n157 VDPWR.n150 24.1801
R7180 VDPWR.n158 VDPWR.n157 30.8338
R7181 VDPWR.n158 VDPWR.n156 203.294
R7182 VDPWR.n149 VDPWR.n158 193.13
R7183 VDPWR.n151 VDPWR.n150 387.132
R7184 VDPWR.n151 VDPWR.n152 1905.88
R7185 VDPWR.n154 VDPWR.n155 387.132
R7186 VDPWR.n155 VDPWR.n157 1905.88
R7187 VDPWR.n150 VDPWR.n154 12.5275
R7188 VDPWR.n148 VDPWR.n138 17.3121
R7189 VDPWR.n138 VDPWR.n140 13.2148
R7190 VDPWR VDPWR.n138 6.4005
R7191 VDPWR.n141 VDPWR.n142 14.2313
R7192 VDPWR VDPWR.n142 379.106
R7193 VDPWR.n139 VDPWR.n143 2.93771
R7194 VDPWR.n144 VDPWR.n145 13.2148
R7195 VDPWR.n145 VDPWR.n142 395.671
R7196 VDPWR.n147 VDPWR.n146 14.2313
R7197 VDPWR.n147 VDPWR.n145 395.671
R7198 VDPWR.n138 VDPWR.n147 385.507
R7199 VDPWR.n140 VDPWR.n146 3709.41
R7200 VDPWR.n140 VDPWR.n139 11.7055
R7201 VDPWR.n141 VDPWR.n144 3709.41
R7202 VDPWR.n143 VDPWR.n144 11.7055
R7203 VDPWR.n139 VDPWR.n141 412.115
R7204 VDPWR.n143 VDPWR.n146 412.115
R7205 VDPWR.n137 VDPWR.n127 17.3121
R7206 VDPWR.n127 VDPWR.n129 23.1255
R7207 VDPWR VDPWR.n127 6.4005
R7208 VDPWR.n131 VDPWR.n130 26.4291
R7209 VDPWR VDPWR.n131 233.036
R7210 VDPWR.n128 VDPWR.n132 7.67543
R7211 VDPWR.n133 VDPWR.n134 23.1255
R7212 VDPWR.n134 VDPWR.n131 249.601
R7213 VDPWR.n136 VDPWR.n135 26.4291
R7214 VDPWR.n136 VDPWR.n134 249.601
R7215 VDPWR.n127 VDPWR.n136 239.435
R7216 VDPWR.n129 VDPWR.n135 2340
R7217 VDPWR.n129 VDPWR.n128 19.1003
R7218 VDPWR.n130 VDPWR.n133 2340
R7219 VDPWR.n132 VDPWR.n133 19.1003
R7220 VDPWR.n130 VDPWR.n128 388.26
R7221 VDPWR.n132 VDPWR.n135 388.26
R7222 VDPWR.n126 VDPWR.n116 17.3121
R7223 VDPWR.n116 VDPWR.n118 37.0005
R7224 VDPWR VDPWR.n116 6.4005
R7225 VDPWR.n120 VDPWR.n119 37.0005
R7226 VDPWR VDPWR.n120 166.776
R7227 VDPWR.n117 VDPWR.n121 15.0141
R7228 VDPWR.n122 VDPWR.n123 37.0005
R7229 VDPWR.n123 VDPWR.n120 183.341
R7230 VDPWR.n125 VDPWR.n124 37.0005
R7231 VDPWR.n125 VDPWR.n123 183.341
R7232 VDPWR.n116 VDPWR.n125 173.177
R7233 VDPWR.n118 VDPWR.n124 1718.82
R7234 VDPWR.n118 VDPWR.n117 28.8732
R7235 VDPWR.n119 VDPWR.n122 1718.82
R7236 VDPWR.n121 VDPWR.n122 28.8732
R7237 VDPWR.n119 VDPWR.n117 348.704
R7238 VDPWR.n121 VDPWR.n124 348.704
R7239 VDPWR.n115 VDPWR.n105 17.3121
R7240 VDPWR.n105 VDPWR.n107 13.2148
R7241 VDPWR VDPWR.n105 6.4005
R7242 VDPWR.n108 VDPWR.n109 14.2313
R7243 VDPWR VDPWR.n109 379.106
R7244 VDPWR.n106 VDPWR.n110 2.93771
R7245 VDPWR.n111 VDPWR.n112 13.2148
R7246 VDPWR.n112 VDPWR.n109 395.671
R7247 VDPWR.n114 VDPWR.n113 14.2313
R7248 VDPWR.n114 VDPWR.n112 395.671
R7249 VDPWR.n105 VDPWR.n114 385.507
R7250 VDPWR.n107 VDPWR.n113 3709.41
R7251 VDPWR.n107 VDPWR.n106 11.7055
R7252 VDPWR.n108 VDPWR.n111 3709.41
R7253 VDPWR.n110 VDPWR.n111 11.7055
R7254 VDPWR.n106 VDPWR.n108 412.115
R7255 VDPWR.n110 VDPWR.n113 412.115
R7256 VDPWR.n97 VDPWR.n95 12.7156
R7257 VDPWR.n101 VDPWR.n97 4.2305
R7258 VDPWR.n104 VDPWR.n101 5.68883
R7259 VDPWR.n101 VDPWR.n102 10.6006
R7260 VDPWR.n102 VDPWR.n103 0.328625
R7261 VDPWR.n103 VDPWR 0.141125
R7262 VDPWR.n103 VDPWR 0.234875
R7263 VDPWR.n102 VDPWR 0.0551875
R7264 VDPWR.n97 VDPWR.n98 10.6006
R7265 VDPWR.n98 VDPWR.n100 0.328625
R7266 VDPWR.n100 VDPWR 0.141125
R7267 VDPWR.n100 VDPWR 0.234875
R7268 VDPWR.n98 VDPWR.n99 0.328625
R7269 VDPWR.n99 VDPWR 0.141125
R7270 VDPWR.n99 VDPWR 0.234875
R7271 VDPWR.n98 VDPWR 0.0551875
R7272 VDPWR.n95 VDPWR.n96 0.328625
R7273 VDPWR.n96 VDPWR 0.141125
R7274 VDPWR.n96 VDPWR 0.234875
R7275 VDPWR.n95 VDPWR 0.0551875
R7276 VDPWR.n38 VDPWR.n27 2.1155
R7277 VDPWR.n49 VDPWR.n38 2.1155
R7278 VDPWR.n60 VDPWR.n49 2.1155
R7279 VDPWR.n71 VDPWR.n60 2.1155
R7280 VDPWR.n82 VDPWR.n71 2.1155
R7281 VDPWR.n93 VDPWR.n82 0.474025
R7282 VDPWR.n93 VDPWR.n83 18.9535
R7283 VDPWR.n83 VDPWR.n85 23.1255
R7284 VDPWR VDPWR.n83 6.4005
R7285 VDPWR.n88 VDPWR.n86 12.7575
R7286 VDPWR.n86 VDPWR.n87 15.4172
R7287 VDPWR VDPWR.n87 293.272
R7288 VDPWR.n90 VDPWR.n89 23.1255
R7289 VDPWR.n87 VDPWR.n90 309.836
R7290 VDPWR.n91 VDPWR.n84 12.7575
R7291 VDPWR.n92 VDPWR.n91 15.4172
R7292 VDPWR.n92 VDPWR.n90 309.836
R7293 VDPWR.n83 VDPWR.n92 299.671
R7294 VDPWR.n85 VDPWR.n84 488.462
R7295 VDPWR.n85 VDPWR.n86 2904.71
R7296 VDPWR.n88 VDPWR.n89 488.462
R7297 VDPWR.n89 VDPWR.n91 2904.71
R7298 VDPWR.n84 VDPWR.n88 5.1865
R7299 VDPWR.n82 VDPWR.n72 17.3121
R7300 VDPWR.n72 VDPWR.n74 23.1255
R7301 VDPWR VDPWR.n72 6.4005
R7302 VDPWR.n77 VDPWR.n75 12.7575
R7303 VDPWR.n75 VDPWR.n76 15.4172
R7304 VDPWR VDPWR.n76 293.272
R7305 VDPWR.n79 VDPWR.n78 23.1255
R7306 VDPWR.n76 VDPWR.n79 309.836
R7307 VDPWR.n80 VDPWR.n73 12.7575
R7308 VDPWR.n81 VDPWR.n80 15.4172
R7309 VDPWR.n81 VDPWR.n79 309.836
R7310 VDPWR.n72 VDPWR.n81 299.671
R7311 VDPWR.n74 VDPWR.n73 488.462
R7312 VDPWR.n74 VDPWR.n75 2904.71
R7313 VDPWR.n77 VDPWR.n78 488.462
R7314 VDPWR.n78 VDPWR.n80 2904.71
R7315 VDPWR.n73 VDPWR.n77 5.1865
R7316 VDPWR.n71 VDPWR.n61 17.3121
R7317 VDPWR.n61 VDPWR.n63 23.1255
R7318 VDPWR VDPWR.n61 6.4005
R7319 VDPWR.n66 VDPWR.n64 12.7575
R7320 VDPWR.n64 VDPWR.n65 15.4172
R7321 VDPWR VDPWR.n65 293.272
R7322 VDPWR.n68 VDPWR.n67 23.1255
R7323 VDPWR.n65 VDPWR.n68 309.836
R7324 VDPWR.n69 VDPWR.n62 12.7575
R7325 VDPWR.n70 VDPWR.n69 15.4172
R7326 VDPWR.n70 VDPWR.n68 309.836
R7327 VDPWR.n61 VDPWR.n70 299.671
R7328 VDPWR.n63 VDPWR.n62 488.462
R7329 VDPWR.n63 VDPWR.n64 2904.71
R7330 VDPWR.n66 VDPWR.n67 488.462
R7331 VDPWR.n67 VDPWR.n69 2904.71
R7332 VDPWR.n62 VDPWR.n66 5.1865
R7333 VDPWR.n60 VDPWR.n50 17.3121
R7334 VDPWR.n50 VDPWR.n52 23.1255
R7335 VDPWR VDPWR.n50 6.4005
R7336 VDPWR.n55 VDPWR.n53 12.7575
R7337 VDPWR.n53 VDPWR.n54 15.4172
R7338 VDPWR VDPWR.n54 293.272
R7339 VDPWR.n57 VDPWR.n56 23.1255
R7340 VDPWR.n54 VDPWR.n57 309.836
R7341 VDPWR.n58 VDPWR.n51 12.7575
R7342 VDPWR.n59 VDPWR.n58 15.4172
R7343 VDPWR.n59 VDPWR.n57 309.836
R7344 VDPWR.n50 VDPWR.n59 299.671
R7345 VDPWR.n52 VDPWR.n51 488.462
R7346 VDPWR.n52 VDPWR.n53 2904.71
R7347 VDPWR.n55 VDPWR.n56 488.462
R7348 VDPWR.n56 VDPWR.n58 2904.71
R7349 VDPWR.n51 VDPWR.n55 5.1865
R7350 VDPWR.n49 VDPWR.n39 17.3121
R7351 VDPWR.n39 VDPWR.n41 23.1255
R7352 VDPWR VDPWR.n39 6.4005
R7353 VDPWR.n43 VDPWR.n42 26.4291
R7354 VDPWR VDPWR.n43 233.036
R7355 VDPWR.n40 VDPWR.n44 7.67543
R7356 VDPWR.n45 VDPWR.n46 23.1255
R7357 VDPWR.n46 VDPWR.n43 249.601
R7358 VDPWR.n48 VDPWR.n47 26.4291
R7359 VDPWR.n48 VDPWR.n46 249.601
R7360 VDPWR.n39 VDPWR.n48 239.435
R7361 VDPWR.n41 VDPWR.n47 2340
R7362 VDPWR.n41 VDPWR.n40 19.1003
R7363 VDPWR.n42 VDPWR.n45 2340
R7364 VDPWR.n44 VDPWR.n45 19.1003
R7365 VDPWR.n42 VDPWR.n40 388.26
R7366 VDPWR.n44 VDPWR.n47 388.26
R7367 VDPWR.n38 VDPWR.n28 17.3121
R7368 VDPWR.n28 VDPWR.n30 23.1255
R7369 VDPWR VDPWR.n28 6.4005
R7370 VDPWR.n32 VDPWR.n31 26.4291
R7371 VDPWR VDPWR.n32 233.036
R7372 VDPWR.n29 VDPWR.n33 7.67543
R7373 VDPWR.n34 VDPWR.n35 23.1255
R7374 VDPWR.n35 VDPWR.n32 249.601
R7375 VDPWR.n37 VDPWR.n36 26.4291
R7376 VDPWR.n37 VDPWR.n35 249.601
R7377 VDPWR.n28 VDPWR.n37 239.435
R7378 VDPWR.n30 VDPWR.n36 2340
R7379 VDPWR.n30 VDPWR.n29 19.1003
R7380 VDPWR.n31 VDPWR.n34 2340
R7381 VDPWR.n33 VDPWR.n34 19.1003
R7382 VDPWR.n31 VDPWR.n29 388.26
R7383 VDPWR.n33 VDPWR.n36 388.26
R7384 VDPWR.n27 VDPWR.n17 17.3121
R7385 VDPWR.n17 VDPWR.n19 23.1255
R7386 VDPWR VDPWR.n17 6.4005
R7387 VDPWR.n21 VDPWR.n20 26.4291
R7388 VDPWR VDPWR.n21 233.036
R7389 VDPWR.n18 VDPWR.n22 7.67543
R7390 VDPWR.n23 VDPWR.n24 23.1255
R7391 VDPWR.n24 VDPWR.n21 249.601
R7392 VDPWR.n26 VDPWR.n25 26.4291
R7393 VDPWR.n26 VDPWR.n24 249.601
R7394 VDPWR.n17 VDPWR.n26 239.435
R7395 VDPWR.n19 VDPWR.n25 2340
R7396 VDPWR.n19 VDPWR.n18 19.1003
R7397 VDPWR.n20 VDPWR.n23 2340
R7398 VDPWR.n22 VDPWR.n23 19.1003
R7399 VDPWR.n20 VDPWR.n18 388.26
R7400 VDPWR.n22 VDPWR.n25 388.26
R7401 VDPWR.n27 VDPWR.n7 19.4271
R7402 VDPWR.n7 VDPWR.n9 23.1255
R7403 VDPWR VDPWR.n7 6.4005
R7404 VDPWR.n11 VDPWR.n10 26.4291
R7405 VDPWR VDPWR.n11 233.036
R7406 VDPWR.n8 VDPWR.n12 7.67543
R7407 VDPWR.n13 VDPWR.n14 23.1255
R7408 VDPWR.n14 VDPWR.n11 249.601
R7409 VDPWR.n16 VDPWR.n15 26.4291
R7410 VDPWR.n16 VDPWR.n14 249.601
R7411 VDPWR.n7 VDPWR.n16 239.435
R7412 VDPWR.n9 VDPWR.n15 2340
R7413 VDPWR.n9 VDPWR.n8 19.1003
R7414 VDPWR.n10 VDPWR.n13 2340
R7415 VDPWR.n12 VDPWR.n13 19.1003
R7416 VDPWR.n10 VDPWR.n8 388.26
R7417 VDPWR.n12 VDPWR.n15 388.26
R7418 VDPWR.n2 VDPWR.n1 3.4105
R7419 VDPWR.n4 VDPWR.n3 3.4105
R7420 VDPWR.n2 VDPWR.n0 5.5255
R7421 VDPWR.n4 VDPWR.n2 2.1155
R7422 VDPWR.n6 VDPWR.n4 0.445825
R7423 VDPWR.n6 VDPWR.n5 5.08017
R7424 VDPWR.n5 VDPWR 5.04335
R7425 VDPWR.n5 VDPWR 5.04335
R7426 VDPWR.n5 VDPWR 4.65675
R7427 VDPWR.n3 VDPWR 5.04335
R7428 VDPWR.n3 VDPWR 5.04335
R7429 VDPWR.n3 VDPWR 4.65675
R7430 VDPWR.n1 VDPWR 5.04335
R7431 VDPWR.n1 VDPWR 5.04335
R7432 VDPWR.n1 VDPWR 4.65675
R7433 VDPWR.n0 VDPWR 5.04335
R7434 VDPWR.n0 VDPWR 5.04335
R7435 VDPWR.n0 VDPWR 4.65675
R7436 tail1.n0 tail1 5.12829
R7437 tail1.n0 tail1 5.12929
R7438 tail1.n0 tail1.n23 18.4827
R7439 tail1.n11 tail1 3.4105
R7440 tail1.n23 tail1.n21 0.438775
R7441 tail1.n21 tail1 1.32472
R7442 tail1.n22 tail1.n23 6.96267
R7443 tail1.n22 tail1 5.12929
R7444 tail1.n22 tail1 5.12929
R7445 tail1.n22 tail1 4.65675
R7446 tail1.n21 tail1.n20 15.3982
R7447 tail1.n13 tail1.n14 3.4105
R7448 tail1.n15 tail1.n16 3.4105
R7449 tail1.n17 tail1.n18 3.4105
R7450 tail1.n12 tail1.n14 3.59615
R7451 tail1.n14 tail1.n16 0.18615
R7452 tail1.n16 tail1.n20 0.0945
R7453 tail1.n20 tail1.n18 0.09215
R7454 tail1.n18 tail1.n19 3.59615
R7455 tail1 tail1.n19 0.041125
R7456 tail1 tail1.n19 6.51246
R7457 tail1 tail1.n17 0.041125
R7458 tail1 tail1.n17 6.51246
R7459 tail1 tail1.n15 0.041125
R7460 tail1 tail1.n15 6.51246
R7461 tail1 tail1.n13 0.041125
R7462 tail1 tail1.n13 6.51246
R7463 tail1 tail1.n12 0.041125
R7464 tail1 tail1.n12 6.51246
R7465 tail1.n9 tail1.n11 12.8989
R7466 tail1.n11 tail1.n10 13.3548
R7467 tail1.n10 tail1 5.12929
R7468 tail1.n10 tail1 5.12929
R7469 tail1.n10 tail1 4.65675
R7470 tail1.n9 tail1 5.12929
R7471 tail1.n9 tail1 5.12929
R7472 tail1.n9 tail1 4.65675
R7473 tail1 tail1.n1 18.3862
R7474 tail1.n3 tail1.n4 3.4105
R7475 tail1.n5 tail1.n1 3.4105
R7476 tail1.n6 tail1.n7 3.4105
R7477 tail1.n2 tail1.n4 3.59615
R7478 tail1.n4 tail1.n1 0.18615
R7479 tail1.n1 tail1.n7 0.18615
R7480 tail1.n7 tail1.n8 3.59615
R7481 tail1 tail1.n8 0.041125
R7482 tail1 tail1.n8 6.51246
R7483 tail1 tail1.n6 0.041125
R7484 tail1 tail1.n6 6.51246
R7485 tail1 tail1.n5 0.041125
R7486 tail1 tail1.n5 6.51246
R7487 tail1 tail1.n3 0.041125
R7488 tail1 tail1.n3 6.51246
R7489 tail1 tail1.n2 0.041125
R7490 tail1 tail1.n2 6.51246
R7491 tail1.n0 tail1 4.65675
R7492 tail2.n0 tail2 5.12829
R7493 tail2.n0 tail2 5.12929
R7494 tail2.n0 tail2.n23 17.2313
R7495 tail2.n23 tail2.n21 1.22955
R7496 tail2.n21 tail2 0.88645
R7497 tail2 tail2.n11 3.49745
R7498 tail2.n23 tail2.n22 8.45845
R7499 tail2.n22 tail2 5.12929
R7500 tail2.n22 tail2 5.12929
R7501 tail2.n22 tail2 4.65675
R7502 tail2.n21 tail2.n13 17.4638
R7503 tail2.n15 tail2.n16 3.4105
R7504 tail2.n17 tail2.n13 3.4105
R7505 tail2.n18 tail2.n19 3.4105
R7506 tail2.n14 tail2.n16 3.59615
R7507 tail2.n16 tail2.n13 0.18615
R7508 tail2.n13 tail2.n19 0.18615
R7509 tail2.n19 tail2.n20 3.59615
R7510 tail2 tail2.n20 0.041125
R7511 tail2 tail2.n20 6.51246
R7512 tail2 tail2.n18 0.041125
R7513 tail2 tail2.n18 6.51246
R7514 tail2 tail2.n17 0.041125
R7515 tail2 tail2.n17 6.51246
R7516 tail2 tail2.n15 0.041125
R7517 tail2 tail2.n15 6.51246
R7518 tail2 tail2.n14 0.041125
R7519 tail2 tail2.n14 6.51246
R7520 tail2.n12 tail2 7.53255
R7521 tail2.n12 tail2 5.12929
R7522 tail2.n12 tail2 5.12929
R7523 tail2.n12 tail2 4.65675
R7524 tail2.n11 tail2.n10 11.2403
R7525 tail2.n3 tail2.n4 3.4105
R7526 tail2.n5 tail2.n6 3.4105
R7527 tail2.n7 tail2.n8 3.4105
R7528 tail2.n2 tail2.n4 3.59615
R7529 tail2.n4 tail2.n6 0.18615
R7530 tail2.n6 tail2.n10 0.0945
R7531 tail2.n10 tail2.n8 0.09215
R7532 tail2.n8 tail2.n9 3.59615
R7533 tail2 tail2.n9 0.041125
R7534 tail2 tail2.n9 6.51246
R7535 tail2 tail2.n7 0.041125
R7536 tail2 tail2.n7 6.51246
R7537 tail2 tail2.n5 0.041125
R7538 tail2 tail2.n5 6.51246
R7539 tail2 tail2.n3 0.041125
R7540 tail2 tail2.n3 6.51246
R7541 tail2 tail2.n2 0.041125
R7542 tail2 tail2.n2 6.51246
R7543 tail2.n1 tail2.n11 15.7289
R7544 tail2.n1 tail2 5.12929
R7545 tail2.n1 tail2 5.12929
R7546 tail2.n1 tail2 4.65675
R7547 tail2.n0 tail2 4.65675
R7548 gm1_n.n0 gm1_n.n1 4.55128
R7549 gm1_n gm1_n.n0 2.59809
R7550 gm1_n gm1_n.n1 0.041125
R7551 gm1_n.n2 gm1_n.n3 3.4105
R7552 gm1_n.n4 gm1_n.n5 3.4105
R7553 gm1_n.n1 gm1_n.n3 3.54915
R7554 gm1_n.n3 gm1_n.n5 0.13915
R7555 gm1_n.n5 gm1_n.n16 6.0566
R7556 gm1_n.n16 gm1_n 2.11902
R7557 gm1_n.n16 gm1_n.n12 12.4395
R7558 gm1_n.n14 gm1_n.n12 3.4105
R7559 gm1_n.n13 gm1_n.n12 3.54915
R7560 gm1_n.n12 gm1_n.n15 3.54915
R7561 gm1_n gm1_n.n15 0.041125
R7562 gm1_n gm1_n.n15 7.14887
R7563 gm1_n gm1_n.n14 0.041125
R7564 gm1_n gm1_n.n14 7.14887
R7565 gm1_n gm1_n.n13 0.041125
R7566 gm1_n gm1_n.n13 7.14887
R7567 gm1_n.n9 gm1_n.n10 3.4105
R7568 gm1_n gm1_n.n10 4.21068
R7569 gm1_n.n10 gm1_n.n11 4.938
R7570 gm1_n.n11 gm1_n 5.04335
R7571 gm1_n.n11 gm1_n 5.04335
R7572 gm1_n.n11 gm1_n 4.65675
R7573 gm1_n.n9 gm1_n 5.04335
R7574 gm1_n.n9 gm1_n 5.04335
R7575 gm1_n.n9 gm1_n 4.65675
R7576 gm1_n gm1_n.n6 9.8448
R7577 gm1_n.n6 gm1_n.n8 12.0341
R7578 gm1_n.n8 gm1_n 5.04335
R7579 gm1_n.n8 gm1_n 5.04335
R7580 gm1_n.n8 gm1_n 4.65675
R7581 gm1_n.n7 gm1_n.n6 10.6946
R7582 gm1_n.n7 gm1_n 5.04335
R7583 gm1_n.n7 gm1_n 5.04335
R7584 gm1_n.n7 gm1_n 4.65675
R7585 gm1_n gm1_n.n4 0.041125
R7586 gm1_n gm1_n.n4 7.14887
R7587 gm1_n gm1_n.n2 0.041125
R7588 gm1_n gm1_n.n2 7.14887
R7589 gm2_n.n0 gm2_n.n1 4.55128
R7590 gm2_n gm2_n.n0 2.59809
R7591 gm2_n gm2_n.n1 0.041125
R7592 gm2_n.n2 gm2_n.n3 3.4105
R7593 gm2_n.n1 gm2_n.n3 3.54915
R7594 gm2_n.n3 gm2_n.n16 3.54915
R7595 gm2_n gm2_n.n16 0.041125
R7596 gm2_n gm2_n.n16 7.14887
R7597 gm2_n.n15 gm2_n.n3 14.3724
R7598 gm2_n.n15 gm2_n 2.47152
R7599 gm2_n.n11 gm2_n.n12 3.4105
R7600 gm2_n.n13 gm2_n.n14 3.4105
R7601 gm2_n.n10 gm2_n.n12 3.54915
R7602 gm2_n.n12 gm2_n.n14 0.13915
R7603 gm2_n.n14 gm2_n.n15 3.77123
R7604 gm2_n gm2_n.n13 0.041125
R7605 gm2_n gm2_n.n13 7.14887
R7606 gm2_n gm2_n.n11 0.041125
R7607 gm2_n gm2_n.n11 7.14887
R7608 gm2_n gm2_n.n10 0.041125
R7609 gm2_n gm2_n.n10 7.14887
R7610 gm2_n gm2_n.n7 7.54767
R7611 gm2_n.n7 gm2_n.n9 12.0341
R7612 gm2_n.n9 gm2_n 5.04335
R7613 gm2_n.n9 gm2_n 5.04335
R7614 gm2_n.n9 gm2_n 4.65675
R7615 gm2_n.n8 gm2_n.n7 10.6946
R7616 gm2_n.n8 gm2_n 5.04335
R7617 gm2_n.n8 gm2_n 5.04335
R7618 gm2_n.n8 gm2_n 4.65675
R7619 gm2_n.n4 gm2_n.n5 3.4105
R7620 gm2_n gm2_n.n5 6.14355
R7621 gm2_n.n5 gm2_n.n6 4.938
R7622 gm2_n.n6 gm2_n 5.04335
R7623 gm2_n.n6 gm2_n 5.04335
R7624 gm2_n.n6 gm2_n 4.65675
R7625 gm2_n.n4 gm2_n 5.04335
R7626 gm2_n.n4 gm2_n 5.04335
R7627 gm2_n.n4 gm2_n 4.65675
R7628 gm2_n gm2_n.n2 0.041125
R7629 gm2_n gm2_n.n2 7.14887
R7630 gm1_p.n0 gm1_p.n1 4.55128
R7631 gm1_p gm1_p.n0 2.59809
R7632 gm1_p gm1_p.n1 0.041125
R7633 gm1_p.n2 gm1_p.n3 3.4105
R7634 gm1_p.n4 gm1_p.n5 3.4105
R7635 gm1_p.n1 gm1_p.n3 3.54915
R7636 gm1_p.n3 gm1_p.n5 0.13915
R7637 gm1_p.n5 gm1_p.n16 6.5266
R7638 gm1_p.n11 gm1_p 3.4105
R7639 gm1_p.n16 gm1_p 2.11902
R7640 gm1_p.n16 gm1_p.n12 11.9695
R7641 gm1_p.n14 gm1_p.n12 3.4105
R7642 gm1_p.n13 gm1_p.n12 3.54915
R7643 gm1_p.n12 gm1_p.n15 3.54915
R7644 gm1_p gm1_p.n15 0.041125
R7645 gm1_p gm1_p.n15 7.14887
R7646 gm1_p gm1_p.n14 0.041125
R7647 gm1_p gm1_p.n14 7.14887
R7648 gm1_p gm1_p.n13 0.041125
R7649 gm1_p gm1_p.n13 7.14887
R7650 gm1_p.n9 gm1_p.n11 4.49033
R7651 gm1_p.n11 gm1_p.n10 3.85818
R7652 gm1_p.n10 gm1_p 5.04335
R7653 gm1_p.n10 gm1_p 5.04335
R7654 gm1_p.n10 gm1_p 4.65675
R7655 gm1_p.n9 gm1_p 5.04335
R7656 gm1_p.n9 gm1_p 5.04335
R7657 gm1_p.n9 gm1_p 4.65675
R7658 gm1_p gm1_p.n6 7.8708
R7659 gm1_p.n6 gm1_p.n8 12.1281
R7660 gm1_p.n8 gm1_p 5.04335
R7661 gm1_p.n8 gm1_p 5.04335
R7662 gm1_p.n8 gm1_p 4.65675
R7663 gm1_p.n7 gm1_p.n6 10.6006
R7664 gm1_p.n7 gm1_p 5.04335
R7665 gm1_p.n7 gm1_p 5.04335
R7666 gm1_p.n7 gm1_p 4.65675
R7667 gm1_p gm1_p.n4 0.041125
R7668 gm1_p gm1_p.n4 7.14887
R7669 gm1_p gm1_p.n2 0.041125
R7670 gm1_p gm1_p.n2 7.14887
R7671 gm2_p.n0 gm2_p.n1 4.55128
R7672 gm2_p gm2_p.n0 2.59809
R7673 gm2_p gm2_p.n1 0.041125
R7674 gm2_p.n2 gm2_p.n3 3.4105
R7675 gm2_p.n1 gm2_p.n3 3.54915
R7676 gm2_p.n3 gm2_p.n16 3.54915
R7677 gm2_p gm2_p.n16 0.041125
R7678 gm2_p gm2_p.n16 7.14887
R7679 gm2_p.n15 gm2_p.n3 13.7261
R7680 gm2_p.n15 gm2_p 2.11902
R7681 gm2_p gm2_p.n6 5.78987
R7682 gm2_p.n11 gm2_p.n12 3.4105
R7683 gm2_p.n13 gm2_p.n14 3.4105
R7684 gm2_p.n10 gm2_p.n12 3.54915
R7685 gm2_p.n12 gm2_p.n14 0.13915
R7686 gm2_p.n14 gm2_p.n15 4.24123
R7687 gm2_p gm2_p.n13 0.041125
R7688 gm2_p gm2_p.n13 7.14887
R7689 gm2_p gm2_p.n11 0.041125
R7690 gm2_p gm2_p.n11 7.14887
R7691 gm2_p gm2_p.n10 0.041125
R7692 gm2_p gm2_p.n10 7.14887
R7693 gm2_p gm2_p.n7 5.57367
R7694 gm2_p.n7 gm2_p.n9 12.3044
R7695 gm2_p.n9 gm2_p 5.04335
R7696 gm2_p.n9 gm2_p 5.04335
R7697 gm2_p.n9 gm2_p 4.65675
R7698 gm2_p.n8 gm2_p.n7 10.7769
R7699 gm2_p.n8 gm2_p 5.04335
R7700 gm2_p.n8 gm2_p 5.04335
R7701 gm2_p.n8 gm2_p 4.65675
R7702 gm2_p.n4 gm2_p.n6 4.58433
R7703 gm2_p.n6 gm2_p.n5 3.76417
R7704 gm2_p.n5 gm2_p 5.04335
R7705 gm2_p.n5 gm2_p 5.04335
R7706 gm2_p.n5 gm2_p 4.65675
R7707 gm2_p.n4 gm2_p 5.04335
R7708 gm2_p.n4 gm2_p 5.04335
R7709 gm2_p.n4 gm2_p 4.65675
R7710 gm2_p gm2_p.n2 0.041125
R7711 gm2_p gm2_p.n2 7.14887
R7712 vbias vbias.n127 9.3005
R7713 vbias vbias.n127 0.063
R7714 vbias vbias.n128 9.3005
R7715 vbias.n128 vbias.n127 0.493147
R7716 vbias vbias.n129 9.3005
R7717 vbias.n129 vbias.n128 0.493147
R7718 vbias vbias.n130 7.04123
R7719 vbias.n130 vbias.n129 1.65269
R7720 vbias vbias.n131 7.04123
R7721 vbias vbias.n132 9.3005
R7722 vbias vbias.n133 9.3005
R7723 vbias vbias.n131 7.41417
R7724 vbias vbias.n130 7.41417
R7725 vbias vbias.n147 567.838
R7726 vbias.n134 vbias.n135 7.04123
R7727 vbias.n137 vbias.n136 9.3005
R7728 vbias.n139 vbias.n138 9.3005
R7729 vbias.n141 vbias.n140 9.3005
R7730 vbias.n143 vbias.n142 9.3005
R7731 vbias.n145 vbias.n144 9.3005
R7732 vbias.n147 vbias.n146 7.04123
R7733 vbias.n135 vbias.n136 59.4829
R7734 vbias.n136 vbias.n138 59.4829
R7735 vbias.n138 vbias.n140 59.4829
R7736 vbias.n140 vbias.n142 59.4829
R7737 vbias.n142 vbias.n144 59.4829
R7738 vbias.n144 vbias.n146 59.4829
R7739 vbias.n146 vbias 560.424
R7740 vbias.n144 vbias 560.424
R7741 vbias.n142 vbias 560.424
R7742 vbias.n140 vbias 560.424
R7743 vbias.n138 vbias 560.424
R7744 vbias.n136 vbias 560.424
R7745 vbias.n135 vbias 560.424
R7746 vbias.n147 vbias.n145 1.65269
R7747 vbias.n145 vbias.n143 0.493147
R7748 vbias.n143 vbias.n141 0.493147
R7749 vbias.n141 vbias.n139 0.493147
R7750 vbias.n139 vbias.n137 0.493147
R7751 vbias.n137 vbias.n134 1.65269
R7752 vbias.n134 vbias 567.838
R7753 vbias.n133 vbias 0.430647
R7754 vbias.n132 vbias.n133 0.493147
R7755 vbias.n131 vbias.n132 1.65269
R7756 vbias.n127 vbias.n21 10.2847
R7757 vbias.n21 vbias.n126 6.07481
R7758 vbias.n126 vbias 2.97677
R7759 vbias.n126 vbias.n125 3.95981
R7760 vbias.n125 vbias.n104 8.16967
R7761 vbias vbias.n104 9.3005
R7762 vbias vbias.n104 0.063
R7763 vbias vbias.n105 9.3005
R7764 vbias.n104 vbias.n105 0.493147
R7765 vbias vbias.n106 9.3005
R7766 vbias.n105 vbias.n106 0.493147
R7767 vbias vbias.n107 7.04123
R7768 vbias.n106 vbias.n107 1.65269
R7769 vbias vbias.n108 7.04123
R7770 vbias vbias.n109 9.3005
R7771 vbias vbias.n110 9.3005
R7772 vbias vbias.n108 7.41417
R7773 vbias.n107 vbias 7.41417
R7774 vbias.n124 vbias 567.838
R7775 vbias.n112 vbias.n111 7.04123
R7776 vbias.n113 vbias.n114 9.3005
R7777 vbias.n115 vbias.n116 9.3005
R7778 vbias.n117 vbias.n118 9.3005
R7779 vbias.n119 vbias.n120 9.3005
R7780 vbias.n121 vbias.n122 9.3005
R7781 vbias.n123 vbias.n124 7.04123
R7782 vbias.n112 vbias.n113 59.4829
R7783 vbias.n113 vbias.n115 59.4829
R7784 vbias.n115 vbias.n117 59.4829
R7785 vbias.n117 vbias.n119 59.4829
R7786 vbias.n119 vbias.n121 59.4829
R7787 vbias.n121 vbias.n123 59.4829
R7788 vbias.n123 vbias 560.424
R7789 vbias.n121 vbias 560.424
R7790 vbias.n119 vbias 560.424
R7791 vbias.n117 vbias 560.424
R7792 vbias.n115 vbias 560.424
R7793 vbias.n113 vbias 560.424
R7794 vbias.n112 vbias 560.424
R7795 vbias.n122 vbias.n124 1.65269
R7796 vbias.n120 vbias.n122 0.493147
R7797 vbias.n118 vbias.n120 0.493147
R7798 vbias.n116 vbias.n118 0.493147
R7799 vbias.n114 vbias.n116 0.493147
R7800 vbias.n111 vbias.n114 1.65269
R7801 vbias.n111 vbias 567.838
R7802 vbias.n110 vbias 0.430647
R7803 vbias.n109 vbias.n110 0.493147
R7804 vbias.n108 vbias.n109 1.65269
R7805 vbias.n125 vbias.n83 10.2847
R7806 vbias vbias.n83 9.3005
R7807 vbias vbias.n83 0.063
R7808 vbias vbias.n84 9.3005
R7809 vbias.n83 vbias.n84 0.493147
R7810 vbias vbias.n85 9.3005
R7811 vbias.n84 vbias.n85 0.493147
R7812 vbias vbias.n86 7.04123
R7813 vbias.n85 vbias.n86 1.65269
R7814 vbias vbias.n87 7.04123
R7815 vbias vbias.n88 9.3005
R7816 vbias vbias.n89 9.3005
R7817 vbias vbias.n87 7.41417
R7818 vbias.n86 vbias 7.41417
R7819 vbias.n103 vbias 567.838
R7820 vbias.n91 vbias.n90 7.04123
R7821 vbias.n92 vbias.n93 9.3005
R7822 vbias.n94 vbias.n95 9.3005
R7823 vbias.n96 vbias.n97 9.3005
R7824 vbias.n98 vbias.n99 9.3005
R7825 vbias.n100 vbias.n101 9.3005
R7826 vbias.n102 vbias.n103 7.04123
R7827 vbias.n91 vbias.n92 59.4829
R7828 vbias.n92 vbias.n94 59.4829
R7829 vbias.n94 vbias.n96 59.4829
R7830 vbias.n96 vbias.n98 59.4829
R7831 vbias.n98 vbias.n100 59.4829
R7832 vbias.n100 vbias.n102 59.4829
R7833 vbias.n102 vbias 560.424
R7834 vbias.n100 vbias 560.424
R7835 vbias.n98 vbias 560.424
R7836 vbias.n96 vbias 560.424
R7837 vbias.n94 vbias 560.424
R7838 vbias.n92 vbias 560.424
R7839 vbias.n91 vbias 560.424
R7840 vbias.n101 vbias.n103 1.65269
R7841 vbias.n99 vbias.n101 0.493147
R7842 vbias.n97 vbias.n99 0.493147
R7843 vbias.n95 vbias.n97 0.493147
R7844 vbias.n93 vbias.n95 0.493147
R7845 vbias.n90 vbias.n93 1.65269
R7846 vbias.n90 vbias 567.838
R7847 vbias.n89 vbias 0.430647
R7848 vbias.n88 vbias.n89 0.493147
R7849 vbias.n87 vbias.n88 1.65269
R7850 vbias.n22 vbias.n31 1.23598
R7851 vbias.n31 vbias.n53 0.0797098
R7852 vbias.n53 vbias 12.3199
R7853 vbias.n62 vbias.n22 16.537
R7854 vbias vbias.n62 9.3005
R7855 vbias vbias.n62 0.063
R7856 vbias vbias.n63 9.3005
R7857 vbias.n62 vbias.n63 0.493147
R7858 vbias vbias.n64 9.3005
R7859 vbias.n63 vbias.n64 0.493147
R7860 vbias vbias.n65 7.04123
R7861 vbias.n64 vbias.n65 1.65269
R7862 vbias vbias.n66 7.04123
R7863 vbias vbias.n67 9.3005
R7864 vbias vbias.n68 9.3005
R7865 vbias vbias.n66 7.41417
R7866 vbias.n65 vbias 7.41417
R7867 vbias.n82 vbias 536.027
R7868 vbias.n70 vbias.n69 7.04123
R7869 vbias.n71 vbias.n72 9.3005
R7870 vbias.n73 vbias.n74 9.3005
R7871 vbias.n75 vbias.n76 9.3005
R7872 vbias.n77 vbias.n78 9.3005
R7873 vbias.n79 vbias.n80 9.3005
R7874 vbias.n81 vbias.n82 7.04123
R7875 vbias.n70 vbias.n71 59.4829
R7876 vbias.n71 vbias.n73 59.4829
R7877 vbias.n73 vbias.n75 59.4829
R7878 vbias.n75 vbias.n77 59.4829
R7879 vbias.n77 vbias.n79 59.4829
R7880 vbias.n79 vbias.n81 59.4829
R7881 vbias.n81 vbias 528.612
R7882 vbias.n79 vbias 528.612
R7883 vbias.n77 vbias 528.612
R7884 vbias.n75 vbias 528.612
R7885 vbias.n73 vbias 528.612
R7886 vbias.n71 vbias 528.612
R7887 vbias.n70 vbias 528.612
R7888 vbias.n80 vbias.n82 1.65269
R7889 vbias.n78 vbias.n80 0.493147
R7890 vbias.n76 vbias.n78 0.493147
R7891 vbias.n74 vbias.n76 0.493147
R7892 vbias.n72 vbias.n74 0.493147
R7893 vbias.n69 vbias.n72 1.65269
R7894 vbias.n69 vbias 536.027
R7895 vbias.n68 vbias 0.430647
R7896 vbias.n67 vbias.n68 0.493147
R7897 vbias.n66 vbias.n67 1.65269
R7898 vbias.n53 vbias.n54 7.878
R7899 vbias.n56 vbias.n57 3.4105
R7900 vbias.n58 vbias.n54 3.4105
R7901 vbias.n59 vbias.n60 3.4105
R7902 vbias.n55 vbias.n57 3.59615
R7903 vbias.n57 vbias.n54 0.18615
R7904 vbias.n54 vbias.n60 0.18615
R7905 vbias.n60 vbias.n61 3.59615
R7906 vbias vbias.n61 0.041125
R7907 vbias vbias.n61 6.73278
R7908 vbias vbias.n59 0.041125
R7909 vbias vbias.n59 6.73278
R7910 vbias vbias.n58 0.041125
R7911 vbias vbias.n58 6.73278
R7912 vbias vbias.n56 0.041125
R7913 vbias vbias.n56 6.73278
R7914 vbias vbias.n55 0.041125
R7915 vbias vbias.n55 6.73278
R7916 vbias.n32 vbias.n31 16.4114
R7917 vbias vbias.n32 9.3005
R7918 vbias vbias.n32 0.063
R7919 vbias vbias.n33 9.3005
R7920 vbias.n32 vbias.n33 0.493147
R7921 vbias vbias.n34 9.3005
R7922 vbias.n33 vbias.n34 0.493147
R7923 vbias vbias.n35 7.04123
R7924 vbias.n34 vbias.n35 1.65269
R7925 vbias vbias.n36 7.04123
R7926 vbias vbias.n37 9.3005
R7927 vbias vbias.n38 9.3005
R7928 vbias vbias.n36 7.41417
R7929 vbias.n35 vbias 7.41417
R7930 vbias.n52 vbias 536.027
R7931 vbias.n40 vbias.n39 7.04123
R7932 vbias.n41 vbias.n42 9.3005
R7933 vbias.n43 vbias.n44 9.3005
R7934 vbias.n45 vbias.n46 9.3005
R7935 vbias.n47 vbias.n48 9.3005
R7936 vbias.n49 vbias.n50 9.3005
R7937 vbias.n51 vbias.n52 7.04123
R7938 vbias.n40 vbias.n41 59.4829
R7939 vbias.n41 vbias.n43 59.4829
R7940 vbias.n43 vbias.n45 59.4829
R7941 vbias.n45 vbias.n47 59.4829
R7942 vbias.n47 vbias.n49 59.4829
R7943 vbias.n49 vbias.n51 59.4829
R7944 vbias.n51 vbias 528.612
R7945 vbias.n49 vbias 528.612
R7946 vbias.n47 vbias 528.612
R7947 vbias.n45 vbias 528.612
R7948 vbias.n43 vbias 528.612
R7949 vbias.n41 vbias 528.612
R7950 vbias.n40 vbias 528.612
R7951 vbias.n50 vbias.n52 1.65269
R7952 vbias.n48 vbias.n50 0.493147
R7953 vbias.n46 vbias.n48 0.493147
R7954 vbias.n44 vbias.n46 0.493147
R7955 vbias.n42 vbias.n44 0.493147
R7956 vbias.n39 vbias.n42 1.65269
R7957 vbias.n39 vbias 536.027
R7958 vbias.n38 vbias 0.430647
R7959 vbias.n37 vbias.n38 0.493147
R7960 vbias.n36 vbias.n37 1.65269
R7961 vbias.n22 vbias.n23 7.878
R7962 vbias.n25 vbias.n26 3.4105
R7963 vbias.n27 vbias.n23 3.4105
R7964 vbias.n28 vbias.n29 3.4105
R7965 vbias.n24 vbias.n26 3.59615
R7966 vbias.n26 vbias.n23 0.18615
R7967 vbias.n23 vbias.n29 0.18615
R7968 vbias.n29 vbias.n30 3.59615
R7969 vbias vbias.n30 0.041125
R7970 vbias vbias.n30 6.73278
R7971 vbias vbias.n28 0.041125
R7972 vbias vbias.n28 6.73278
R7973 vbias vbias.n27 0.041125
R7974 vbias vbias.n27 6.73278
R7975 vbias vbias.n25 0.041125
R7976 vbias vbias.n25 6.73278
R7977 vbias vbias.n24 0.041125
R7978 vbias vbias.n24 6.73278
R7979 vbias.n21 vbias.n0 8.16967
R7980 vbias vbias.n0 9.3005
R7981 vbias vbias.n0 0.063
R7982 vbias vbias.n1 9.3005
R7983 vbias.n0 vbias.n1 0.493147
R7984 vbias vbias.n2 9.3005
R7985 vbias.n1 vbias.n2 0.493147
R7986 vbias vbias.n3 7.04123
R7987 vbias.n2 vbias.n3 1.65269
R7988 vbias vbias.n4 7.04123
R7989 vbias vbias.n5 9.3005
R7990 vbias vbias.n6 9.3005
R7991 vbias vbias.n4 7.41417
R7992 vbias.n3 vbias 7.41417
R7993 vbias.n20 vbias 567.838
R7994 vbias.n8 vbias.n7 7.04123
R7995 vbias.n9 vbias.n10 9.3005
R7996 vbias.n11 vbias.n12 9.3005
R7997 vbias.n13 vbias.n14 9.3005
R7998 vbias.n15 vbias.n16 9.3005
R7999 vbias.n17 vbias.n18 9.3005
R8000 vbias.n19 vbias.n20 7.04123
R8001 vbias.n8 vbias.n9 59.4829
R8002 vbias.n9 vbias.n11 59.4829
R8003 vbias.n11 vbias.n13 59.4829
R8004 vbias.n13 vbias.n15 59.4829
R8005 vbias.n15 vbias.n17 59.4829
R8006 vbias.n17 vbias.n19 59.4829
R8007 vbias.n19 vbias 560.424
R8008 vbias.n17 vbias 560.424
R8009 vbias.n15 vbias 560.424
R8010 vbias.n13 vbias 560.424
R8011 vbias.n11 vbias 560.424
R8012 vbias.n9 vbias 560.424
R8013 vbias.n8 vbias 560.424
R8014 vbias.n18 vbias.n20 1.65269
R8015 vbias.n16 vbias.n18 0.493147
R8016 vbias.n14 vbias.n16 0.493147
R8017 vbias.n12 vbias.n14 0.493147
R8018 vbias.n10 vbias.n12 0.493147
R8019 vbias.n7 vbias.n10 1.65269
R8020 vbias.n7 vbias 567.838
R8021 vbias.n6 vbias 0.430647
R8022 vbias.n5 vbias.n6 0.493147
R8023 vbias.n4 vbias.n5 1.65269
R8024 vcm.n41 vcm 7.96665
R8025 vcm.n40 vcm.n41 12.901
R8026 vcm vcm.n40 1.68193
R8027 vcm vcm.n20 2.20362
R8028 vcm.n20 vcm.n10 0.353
R8029 vcm.n10 vcm.n0 7.2902
R8030 vcm.n40 vcm 31.2121
R8031 vcm vcm.n30 4.82579
R8032 vcm.n30 vcm.n31 10.5197
R8033 vcm vcm.n31 9.3005
R8034 vcm vcm.n31 0.0466957
R8035 vcm vcm.n32 6.51721
R8036 vcm.n31 vcm.n32 1.79883
R8037 vcm vcm.n33 6.51721
R8038 vcm vcm.n33 6.7822
R8039 vcm.n32 vcm 6.7822
R8040 vcm.n39 vcm 651.395
R8041 vcm.n35 vcm.n34 6.51721
R8042 vcm.n36 vcm.n37 9.3005
R8043 vcm.n38 vcm.n39 6.51721
R8044 vcm.n35 vcm.n36 44.424
R8045 vcm.n36 vcm.n38 44.424
R8046 vcm.n38 vcm 644.614
R8047 vcm.n36 vcm 644.614
R8048 vcm.n35 vcm 644.614
R8049 vcm.n37 vcm.n39 1.79883
R8050 vcm.n34 vcm.n37 1.79883
R8051 vcm.n34 vcm 651.395
R8052 vcm.n33 vcm 1.75264
R8053 vcm.n30 vcm.n21 8.16967
R8054 vcm vcm.n21 9.3005
R8055 vcm vcm.n21 0.0466957
R8056 vcm vcm.n22 6.51721
R8057 vcm.n21 vcm.n22 1.79883
R8058 vcm vcm.n23 6.51721
R8059 vcm vcm.n23 6.7822
R8060 vcm.n22 vcm 6.7822
R8061 vcm.n29 vcm 651.395
R8062 vcm.n25 vcm.n24 6.51721
R8063 vcm.n26 vcm.n27 9.3005
R8064 vcm.n28 vcm.n29 6.51721
R8065 vcm.n25 vcm.n26 44.424
R8066 vcm.n26 vcm.n28 44.424
R8067 vcm.n28 vcm 644.614
R8068 vcm.n26 vcm 644.614
R8069 vcm.n25 vcm 644.614
R8070 vcm.n27 vcm.n29 1.79883
R8071 vcm.n24 vcm.n27 1.79883
R8072 vcm.n24 vcm 651.395
R8073 vcm.n23 vcm 1.75264
R8074 vcm.n20 vcm.n11 19.9031
R8075 vcm vcm.n11 9.3005
R8076 vcm vcm.n11 0.0466957
R8077 vcm vcm.n12 6.51721
R8078 vcm.n11 vcm.n12 1.79883
R8079 vcm vcm.n13 6.51721
R8080 vcm vcm.n13 6.7822
R8081 vcm.n12 vcm 6.7822
R8082 vcm.n19 vcm 651.395
R8083 vcm.n15 vcm.n14 6.51721
R8084 vcm.n16 vcm.n17 9.3005
R8085 vcm.n18 vcm.n19 6.51721
R8086 vcm.n15 vcm.n16 44.424
R8087 vcm.n16 vcm.n18 44.424
R8088 vcm.n18 vcm 644.614
R8089 vcm.n16 vcm 644.614
R8090 vcm.n15 vcm 644.614
R8091 vcm.n17 vcm.n19 1.79883
R8092 vcm.n14 vcm.n17 1.79883
R8093 vcm.n14 vcm 651.395
R8094 vcm.n13 vcm 1.75264
R8095 vcm.n10 vcm.n1 22.6056
R8096 vcm vcm.n1 9.3005
R8097 vcm vcm.n1 0.0466957
R8098 vcm vcm.n2 6.51721
R8099 vcm.n1 vcm.n2 1.79883
R8100 vcm vcm.n3 6.51721
R8101 vcm vcm.n3 6.7822
R8102 vcm.n2 vcm 6.7822
R8103 vcm.n9 vcm 651.395
R8104 vcm.n5 vcm.n4 6.51721
R8105 vcm.n6 vcm.n7 9.3005
R8106 vcm.n8 vcm.n9 6.51721
R8107 vcm.n5 vcm.n6 44.424
R8108 vcm.n6 vcm.n8 44.424
R8109 vcm.n8 vcm 644.614
R8110 vcm.n6 vcm 644.614
R8111 vcm.n5 vcm 644.614
R8112 vcm.n7 vcm.n9 1.79883
R8113 vcm.n4 vcm.n7 1.79883
R8114 vcm.n4 vcm 651.395
R8115 vcm.n3 vcm 1.75264
R8116 vcm.n0 vcm 9.33442
R8117 vcm.n0 vcm 33.185
R8118 vcm.n41 vcm 9.14165
R8119 ln1.n0 ln1.n1 4.55128
R8120 ln1 ln1.n0 4.7057
R8121 ln1 ln1.n1 0.041125
R8122 ln1.n2 ln1.n3 3.4105
R8123 ln1.n1 ln1.n3 3.5233
R8124 ln1.n3 ln1.n46 4.61546
R8125 ln1.n46 ln1 1.04507
R8126 ln1 ln1.n26 3.42342
R8127 ln1.n27 ln1.n46 12.6571
R8128 ln1 ln1.n27 9.3005
R8129 ln1 ln1.n27 0.0466957
R8130 ln1 ln1.n28 6.10787
R8131 ln1.n27 ln1.n28 1.92
R8132 ln1.n29 ln1 152
R8133 ln1 ln1.n30 6.10787
R8134 ln1.n31 ln1 152
R8135 ln1.n32 ln1 152
R8136 ln1.n33 ln1 152
R8137 ln1.n45 ln1 152
R8138 ln1 ln1.n30 6.3031
R8139 ln1.n28 ln1 6.3031
R8140 ln1.n45 ln1.n33 70.1096
R8141 ln1.n33 ln1.n32 70.1096
R8142 ln1.n32 ln1.n31 70.1096
R8143 ln1.n31 ln1.n29 70.1096
R8144 ln1.n34 ln1.n45 327.76
R8145 ln1.n36 ln1.n37 152
R8146 ln1.n38 ln1.n39 152
R8147 ln1.n40 ln1.n41 152
R8148 ln1.n34 ln1.n40 70.1096
R8149 ln1.n40 ln1.n38 70.1096
R8150 ln1.n38 ln1.n36 70.1096
R8151 ln1.n36 ln1.n35 70.1096
R8152 ln1.n37 ln1.n42 6.10787
R8153 ln1.n39 ln1.n43 9.3005
R8154 ln1.n41 ln1.n44 6.10787
R8155 ln1.n34 ln1.n44 158.304
R8156 ln1.n41 ln1.n39 36.1417
R8157 ln1.n39 ln1.n37 36.1417
R8158 ln1.n42 ln1.n35 158.304
R8159 ln1.n44 ln1.n43 1.92
R8160 ln1.n43 ln1.n42 1.92
R8161 ln1.n40 ln1.n33 327.76
R8162 ln1.n38 ln1.n32 327.76
R8163 ln1.n36 ln1.n31 327.76
R8164 ln1.n35 ln1.n29 327.76
R8165 ln1.n30 ln1 1.8738
R8166 ln1.n7 ln1.n26 9.23422
R8167 ln1 ln1.n7 9.3005
R8168 ln1 ln1.n7 0.0466957
R8169 ln1 ln1.n8 6.10787
R8170 ln1.n7 ln1.n8 1.92
R8171 ln1.n9 ln1 152
R8172 ln1 ln1.n10 6.10787
R8173 ln1.n11 ln1 152
R8174 ln1.n12 ln1 152
R8175 ln1.n13 ln1 152
R8176 ln1.n25 ln1 152
R8177 ln1 ln1.n10 6.3031
R8178 ln1.n8 ln1 6.3031
R8179 ln1.n9 ln1.n11 70.1096
R8180 ln1.n11 ln1.n12 70.1096
R8181 ln1.n12 ln1.n13 70.1096
R8182 ln1.n13 ln1.n25 70.1096
R8183 ln1.n14 ln1.n25 613.747
R8184 ln1.n15 ln1.n16 152
R8185 ln1.n17 ln1.n18 152
R8186 ln1.n19 ln1.n20 152
R8187 ln1.n21 ln1.n19 70.1096
R8188 ln1.n19 ln1.n17 70.1096
R8189 ln1.n17 ln1.n15 70.1096
R8190 ln1.n15 ln1.n14 70.1096
R8191 ln1.n16 ln1.n22 6.10787
R8192 ln1.n18 ln1.n23 9.3005
R8193 ln1.n20 ln1.n24 6.10787
R8194 ln1.n21 ln1.n24 158.304
R8195 ln1.n20 ln1.n18 36.1417
R8196 ln1.n18 ln1.n16 36.1417
R8197 ln1.n22 ln1.n14 158.304
R8198 ln1.n24 ln1.n23 1.92
R8199 ln1.n23 ln1.n22 1.92
R8200 ln1.n21 ln1.n9 613.747
R8201 ln1.n19 ln1.n11 613.747
R8202 ln1.n17 ln1.n12 613.747
R8203 ln1.n15 ln1.n13 613.747
R8204 ln1.n10 ln1 1.8738
R8205 ln1.n4 ln1.n26 8.13767
R8206 ln1.n6 ln1.n4 3.4105
R8207 ln1.n5 ln1.n4 3.5233
R8208 ln1 ln1.n6 0.041125
R8209 ln1 ln1.n6 9.25648
R8210 ln1 ln1.n5 0.041125
R8211 ln1 ln1.n5 9.25648
R8212 ln1 ln1.n2 0.041125
R8213 ln1 ln1.n2 9.25648
R8214 ln2.n0 ln2.n1 4.55128
R8215 ln2 ln2.n0 4.7057
R8216 ln2 ln2.n1 0.041125
R8217 ln2.n2 ln2.n3 3.4105
R8218 ln2.n1 ln2.n3 3.5233
R8219 ln2.n3 ln2.n88 3.5233
R8220 ln2 ln2.n88 0.041125
R8221 ln2 ln2.n88 9.25648
R8222 ln2.n3 ln2.n43 9.30793
R8223 ln2.n43 ln2 7.39906
R8224 ln2.n83 ln2 5.76927
R8225 ln2.n84 ln2.n83 9.41727
R8226 ln2.n86 ln2.n84 3.4105
R8227 ln2.n85 ln2.n84 3.5233
R8228 ln2.n84 ln2.n87 3.5233
R8229 ln2 ln2.n87 0.041125
R8230 ln2 ln2.n87 7.14887
R8231 ln2 ln2.n86 0.041125
R8232 ln2 ln2.n86 7.14887
R8233 ln2 ln2.n85 0.041125
R8234 ln2 ln2.n85 7.14887
R8235 ln2.n44 ln2.n83 8.16967
R8236 ln2 ln2.n44 9.3005
R8237 ln2 ln2.n44 0.0466957
R8238 ln2 ln2.n45 9.3005
R8239 ln2.n44 ln2.n45 0.297815
R8240 ln2 ln2.n46 9.3005
R8241 ln2.n45 ln2.n46 0.297815
R8242 ln2 ln2.n47 6.10787
R8243 ln2.n46 ln2.n47 1.92
R8244 ln2.n48 ln2 152
R8245 ln2 ln2.n49 6.10787
R8246 ln2 ln2.n50 9.3005
R8247 ln2 ln2.n51 9.3005
R8248 ln2.n52 ln2 152
R8249 ln2.n53 ln2 152
R8250 ln2.n54 ln2 152
R8251 ln2.n55 ln2 152
R8252 ln2.n56 ln2 152
R8253 ln2.n57 ln2 152
R8254 ln2.n58 ln2 152
R8255 ln2.n82 ln2 152
R8256 ln2 ln2.n49 6.3031
R8257 ln2.n47 ln2 6.3031
R8258 ln2.n48 ln2.n52 70.1096
R8259 ln2.n52 ln2.n53 70.1096
R8260 ln2.n53 ln2.n54 70.1096
R8261 ln2.n54 ln2.n55 70.1096
R8262 ln2.n55 ln2.n56 70.1096
R8263 ln2.n56 ln2.n57 70.1096
R8264 ln2.n57 ln2.n58 70.1096
R8265 ln2.n58 ln2.n82 70.1096
R8266 ln2.n59 ln2.n82 1243.56
R8267 ln2.n60 ln2.n61 152
R8268 ln2.n62 ln2.n63 152
R8269 ln2.n64 ln2.n65 152
R8270 ln2.n66 ln2.n67 152
R8271 ln2.n68 ln2.n69 152
R8272 ln2.n70 ln2.n71 152
R8273 ln2.n72 ln2.n73 152
R8274 ln2.n74 ln2.n72 70.1096
R8275 ln2.n72 ln2.n70 70.1096
R8276 ln2.n70 ln2.n68 70.1096
R8277 ln2.n68 ln2.n66 70.1096
R8278 ln2.n66 ln2.n64 70.1096
R8279 ln2.n64 ln2.n62 70.1096
R8280 ln2.n62 ln2.n60 70.1096
R8281 ln2.n60 ln2.n59 70.1096
R8282 ln2.n61 ln2.n75 6.10787
R8283 ln2.n63 ln2.n76 9.3005
R8284 ln2.n65 ln2.n77 9.3005
R8285 ln2.n67 ln2.n78 9.3005
R8286 ln2.n69 ln2.n79 9.3005
R8287 ln2.n71 ln2.n80 9.3005
R8288 ln2.n73 ln2.n81 6.10787
R8289 ln2.n74 ln2.n81 158.304
R8290 ln2.n73 ln2.n71 36.1417
R8291 ln2.n71 ln2.n69 36.1417
R8292 ln2.n69 ln2.n67 36.1417
R8293 ln2.n67 ln2.n65 36.1417
R8294 ln2.n65 ln2.n63 36.1417
R8295 ln2.n63 ln2.n61 36.1417
R8296 ln2.n75 ln2.n59 158.304
R8297 ln2.n81 ln2.n80 1.92
R8298 ln2.n80 ln2.n79 0.297815
R8299 ln2.n79 ln2.n78 0.297815
R8300 ln2.n78 ln2.n77 0.297815
R8301 ln2.n77 ln2.n76 0.297815
R8302 ln2.n76 ln2.n75 1.92
R8303 ln2.n74 ln2.n48 1243.56
R8304 ln2.n72 ln2.n52 1243.56
R8305 ln2.n70 ln2.n53 1243.56
R8306 ln2.n68 ln2.n54 1243.56
R8307 ln2.n66 ln2.n55 1243.56
R8308 ln2.n64 ln2.n56 1243.56
R8309 ln2.n62 ln2.n57 1243.56
R8310 ln2.n60 ln2.n58 1243.56
R8311 ln2.n51 ln2 0.251619
R8312 ln2.n50 ln2.n51 0.297815
R8313 ln2.n49 ln2.n50 1.92
R8314 ln2.n4 ln2.n43 8.16967
R8315 ln2 ln2.n4 9.3005
R8316 ln2 ln2.n4 0.0466957
R8317 ln2 ln2.n5 9.3005
R8318 ln2.n4 ln2.n5 0.297815
R8319 ln2 ln2.n6 9.3005
R8320 ln2.n5 ln2.n6 0.297815
R8321 ln2 ln2.n7 6.10787
R8322 ln2.n6 ln2.n7 1.92
R8323 ln2.n8 ln2 152
R8324 ln2 ln2.n9 9.3005
R8325 ln2 ln2.n10 9.3005
R8326 ln2 ln2.n11 6.10787
R8327 ln2.n12 ln2 152
R8328 ln2.n13 ln2 152
R8329 ln2.n14 ln2 152
R8330 ln2.n15 ln2 152
R8331 ln2.n16 ln2 152
R8332 ln2.n17 ln2 152
R8333 ln2.n18 ln2 152
R8334 ln2.n42 ln2 152
R8335 ln2 ln2.n11 6.3031
R8336 ln2.n7 ln2 6.3031
R8337 ln2.n42 ln2.n18 70.1096
R8338 ln2.n18 ln2.n17 70.1096
R8339 ln2.n17 ln2.n16 70.1096
R8340 ln2.n16 ln2.n15 70.1096
R8341 ln2.n15 ln2.n14 70.1096
R8342 ln2.n14 ln2.n13 70.1096
R8343 ln2.n13 ln2.n12 70.1096
R8344 ln2.n12 ln2.n8 70.1096
R8345 ln2.n19 ln2.n42 642.668
R8346 ln2.n21 ln2.n22 152
R8347 ln2.n23 ln2.n24 152
R8348 ln2.n25 ln2.n26 152
R8349 ln2.n27 ln2.n28 152
R8350 ln2.n29 ln2.n30 152
R8351 ln2.n31 ln2.n32 152
R8352 ln2.n33 ln2.n34 152
R8353 ln2.n19 ln2.n33 70.1096
R8354 ln2.n33 ln2.n31 70.1096
R8355 ln2.n31 ln2.n29 70.1096
R8356 ln2.n29 ln2.n27 70.1096
R8357 ln2.n27 ln2.n25 70.1096
R8358 ln2.n25 ln2.n23 70.1096
R8359 ln2.n23 ln2.n21 70.1096
R8360 ln2.n21 ln2.n20 70.1096
R8361 ln2.n22 ln2.n35 6.10787
R8362 ln2.n24 ln2.n36 9.3005
R8363 ln2.n26 ln2.n37 9.3005
R8364 ln2.n28 ln2.n38 9.3005
R8365 ln2.n30 ln2.n39 9.3005
R8366 ln2.n32 ln2.n40 9.3005
R8367 ln2.n34 ln2.n41 6.10787
R8368 ln2.n19 ln2.n41 158.304
R8369 ln2.n34 ln2.n32 36.1417
R8370 ln2.n32 ln2.n30 36.1417
R8371 ln2.n30 ln2.n28 36.1417
R8372 ln2.n28 ln2.n26 36.1417
R8373 ln2.n26 ln2.n24 36.1417
R8374 ln2.n24 ln2.n22 36.1417
R8375 ln2.n35 ln2.n20 158.304
R8376 ln2.n41 ln2.n40 1.92
R8377 ln2.n40 ln2.n39 0.297815
R8378 ln2.n39 ln2.n38 0.297815
R8379 ln2.n38 ln2.n37 0.297815
R8380 ln2.n37 ln2.n36 0.297815
R8381 ln2.n36 ln2.n35 1.92
R8382 ln2.n33 ln2.n18 642.668
R8383 ln2.n31 ln2.n17 642.668
R8384 ln2.n29 ln2.n16 642.668
R8385 ln2.n27 ln2.n15 642.668
R8386 ln2.n25 ln2.n14 642.668
R8387 ln2.n23 ln2.n13 642.668
R8388 ln2.n21 ln2.n12 642.668
R8389 ln2.n20 ln2.n8 642.668
R8390 ln2.n11 ln2.n10 1.92
R8391 ln2.n10 ln2.n9 0.297815
R8392 ln2.n9 ln2 0.251619
R8393 ln2 ln2.n2 0.041125
R8394 ln2 ln2.n2 9.25648
R8395 lp1.n0 lp1.n1 4.55128
R8396 lp1 lp1.n0 4.7057
R8397 lp1 lp1.n1 0.041125
R8398 lp1.n2 lp1.n3 3.4105
R8399 lp1.n1 lp1.n3 3.5233
R8400 lp1.n3 lp1.n85 6.79861
R8401 lp1.n85 lp1 0.753675
R8402 lp1.n46 lp1.n85 12.4574
R8403 lp1 lp1.n46 9.3005
R8404 lp1 lp1.n46 0.0466957
R8405 lp1 lp1.n47 9.3005
R8406 lp1.n46 lp1.n47 0.297815
R8407 lp1 lp1.n48 9.3005
R8408 lp1.n47 lp1.n48 0.297815
R8409 lp1 lp1.n49 6.10787
R8410 lp1.n48 lp1.n49 1.92
R8411 lp1.n50 lp1 152
R8412 lp1 lp1.n51 9.3005
R8413 lp1 lp1.n52 9.3005
R8414 lp1 lp1.n53 6.10787
R8415 lp1.n54 lp1 152
R8416 lp1.n55 lp1 152
R8417 lp1.n56 lp1 152
R8418 lp1.n57 lp1 152
R8419 lp1.n58 lp1 152
R8420 lp1.n59 lp1 152
R8421 lp1.n60 lp1 152
R8422 lp1.n84 lp1 152
R8423 lp1 lp1.n53 6.3031
R8424 lp1.n49 lp1 6.3031
R8425 lp1.n84 lp1.n60 70.1096
R8426 lp1.n60 lp1.n59 70.1096
R8427 lp1.n59 lp1.n58 70.1096
R8428 lp1.n58 lp1.n57 70.1096
R8429 lp1.n57 lp1.n56 70.1096
R8430 lp1.n56 lp1.n55 70.1096
R8431 lp1.n55 lp1.n54 70.1096
R8432 lp1.n54 lp1.n50 70.1096
R8433 lp1.n61 lp1.n84 642.668
R8434 lp1.n63 lp1.n64 152
R8435 lp1.n65 lp1.n66 152
R8436 lp1.n67 lp1.n68 152
R8437 lp1.n69 lp1.n70 152
R8438 lp1.n71 lp1.n72 152
R8439 lp1.n73 lp1.n74 152
R8440 lp1.n75 lp1.n76 152
R8441 lp1.n61 lp1.n75 70.1096
R8442 lp1.n75 lp1.n73 70.1096
R8443 lp1.n73 lp1.n71 70.1096
R8444 lp1.n71 lp1.n69 70.1096
R8445 lp1.n69 lp1.n67 70.1096
R8446 lp1.n67 lp1.n65 70.1096
R8447 lp1.n65 lp1.n63 70.1096
R8448 lp1.n63 lp1.n62 70.1096
R8449 lp1.n64 lp1.n77 6.10787
R8450 lp1.n66 lp1.n78 9.3005
R8451 lp1.n68 lp1.n79 9.3005
R8452 lp1.n70 lp1.n80 9.3005
R8453 lp1.n72 lp1.n81 9.3005
R8454 lp1.n74 lp1.n82 9.3005
R8455 lp1.n76 lp1.n83 6.10787
R8456 lp1.n61 lp1.n83 158.304
R8457 lp1.n76 lp1.n74 36.1417
R8458 lp1.n74 lp1.n72 36.1417
R8459 lp1.n72 lp1.n70 36.1417
R8460 lp1.n70 lp1.n68 36.1417
R8461 lp1.n68 lp1.n66 36.1417
R8462 lp1.n66 lp1.n64 36.1417
R8463 lp1.n77 lp1.n62 158.304
R8464 lp1.n83 lp1.n82 1.92
R8465 lp1.n82 lp1.n81 0.297815
R8466 lp1.n81 lp1.n80 0.297815
R8467 lp1.n80 lp1.n79 0.297815
R8468 lp1.n79 lp1.n78 0.297815
R8469 lp1.n78 lp1.n77 1.92
R8470 lp1.n75 lp1.n60 642.668
R8471 lp1.n73 lp1.n59 642.668
R8472 lp1.n71 lp1.n58 642.668
R8473 lp1.n69 lp1.n57 642.668
R8474 lp1.n67 lp1.n56 642.668
R8475 lp1.n65 lp1.n55 642.668
R8476 lp1.n63 lp1.n54 642.668
R8477 lp1.n62 lp1.n50 642.668
R8478 lp1.n53 lp1.n52 1.92
R8479 lp1.n52 lp1.n51 0.297815
R8480 lp1.n51 lp1 0.251619
R8481 lp1.n44 lp1.n45 3.4105
R8482 lp1.n43 lp1.n45 3.5233
R8483 lp1.n45 lp1 6.54423
R8484 lp1 lp1.n44 0.041125
R8485 lp1 lp1.n44 7.8505
R8486 lp1 lp1.n43 0.041125
R8487 lp1 lp1.n43 7.8505
R8488 lp1.n4 lp1 12.8639
R8489 lp1 lp1.n4 9.3005
R8490 lp1 lp1.n4 0.0466957
R8491 lp1 lp1.n5 9.3005
R8492 lp1.n4 lp1.n5 0.297815
R8493 lp1 lp1.n6 9.3005
R8494 lp1.n5 lp1.n6 0.297815
R8495 lp1 lp1.n7 6.10787
R8496 lp1.n6 lp1.n7 1.92
R8497 lp1.n8 lp1 152
R8498 lp1 lp1.n9 6.10787
R8499 lp1 lp1.n10 9.3005
R8500 lp1 lp1.n11 9.3005
R8501 lp1.n12 lp1 152
R8502 lp1.n13 lp1 152
R8503 lp1.n14 lp1 152
R8504 lp1.n15 lp1 152
R8505 lp1.n16 lp1 152
R8506 lp1.n17 lp1 152
R8507 lp1.n18 lp1 152
R8508 lp1.n42 lp1 152
R8509 lp1 lp1.n9 6.3031
R8510 lp1.n7 lp1 6.3031
R8511 lp1.n8 lp1.n12 70.1096
R8512 lp1.n12 lp1.n13 70.1096
R8513 lp1.n13 lp1.n14 70.1096
R8514 lp1.n14 lp1.n15 70.1096
R8515 lp1.n15 lp1.n16 70.1096
R8516 lp1.n16 lp1.n17 70.1096
R8517 lp1.n17 lp1.n18 70.1096
R8518 lp1.n18 lp1.n42 70.1096
R8519 lp1.n19 lp1.n42 1243.56
R8520 lp1.n20 lp1.n21 152
R8521 lp1.n22 lp1.n23 152
R8522 lp1.n24 lp1.n25 152
R8523 lp1.n26 lp1.n27 152
R8524 lp1.n28 lp1.n29 152
R8525 lp1.n30 lp1.n31 152
R8526 lp1.n32 lp1.n33 152
R8527 lp1.n34 lp1.n32 70.1096
R8528 lp1.n32 lp1.n30 70.1096
R8529 lp1.n30 lp1.n28 70.1096
R8530 lp1.n28 lp1.n26 70.1096
R8531 lp1.n26 lp1.n24 70.1096
R8532 lp1.n24 lp1.n22 70.1096
R8533 lp1.n22 lp1.n20 70.1096
R8534 lp1.n20 lp1.n19 70.1096
R8535 lp1.n21 lp1.n35 6.10787
R8536 lp1.n23 lp1.n36 9.3005
R8537 lp1.n25 lp1.n37 9.3005
R8538 lp1.n27 lp1.n38 9.3005
R8539 lp1.n29 lp1.n39 9.3005
R8540 lp1.n31 lp1.n40 9.3005
R8541 lp1.n33 lp1.n41 6.10787
R8542 lp1.n34 lp1.n41 158.304
R8543 lp1.n33 lp1.n31 36.1417
R8544 lp1.n31 lp1.n29 36.1417
R8545 lp1.n29 lp1.n27 36.1417
R8546 lp1.n27 lp1.n25 36.1417
R8547 lp1.n25 lp1.n23 36.1417
R8548 lp1.n23 lp1.n21 36.1417
R8549 lp1.n35 lp1.n19 158.304
R8550 lp1.n41 lp1.n40 1.92
R8551 lp1.n40 lp1.n39 0.297815
R8552 lp1.n39 lp1.n38 0.297815
R8553 lp1.n38 lp1.n37 0.297815
R8554 lp1.n37 lp1.n36 0.297815
R8555 lp1.n36 lp1.n35 1.92
R8556 lp1.n34 lp1.n8 1243.56
R8557 lp1.n32 lp1.n12 1243.56
R8558 lp1.n30 lp1.n13 1243.56
R8559 lp1.n28 lp1.n14 1243.56
R8560 lp1.n26 lp1.n15 1243.56
R8561 lp1.n24 lp1.n16 1243.56
R8562 lp1.n22 lp1.n17 1243.56
R8563 lp1.n20 lp1.n18 1243.56
R8564 lp1.n11 lp1 0.251619
R8565 lp1.n10 lp1.n11 0.297815
R8566 lp1.n9 lp1.n10 1.92
R8567 lp1 lp1.n2 0.041125
R8568 lp1 lp1.n2 9.25648
R8569 lop lop.n0 8.39558
R8570 lop.n1 lop.n0 0.1133
R8571 lop.n2 lop.n1 0.1133
R8572 lop.n3 lop.n2 0.1133
R8573 lop.n39 lop.n3 4.56083
R8574 lop lop.n19 3.4105
R8575 lop.n34 lop.n39 1.15494
R8576 lop.n24 lop.n34 0.387075
R8577 lop lop.n24 0.694338
R8578 lop lop.n8 4.44979
R8579 lop.n39 lop.n35 22.2519
R8580 lop.n35 lop.n37 3.4105
R8581 lop.n35 lop.n36 3.5233
R8582 lop.n35 lop.n38 3.5233
R8583 lop lop.n38 0.041125
R8584 lop lop.n38 9.25648
R8585 lop lop.n37 0.041125
R8586 lop lop.n37 9.25648
R8587 lop lop.n36 0.041125
R8588 lop lop.n36 9.25648
R8589 lop.n27 lop.n26 3.4105
R8590 lop.n29 lop.n28 3.4105
R8591 lop.n31 lop.n30 3.4105
R8592 lop.n33 lop.n32 3.4105
R8593 lop.n27 lop.n25 3.5233
R8594 lop.n29 lop.n27 0.1133
R8595 lop.n31 lop.n29 0.1133
R8596 lop.n33 lop.n31 0.1133
R8597 lop.n34 lop.n33 4.56083
R8598 lop lop.n32 0.041125
R8599 lop lop.n32 6.28648
R8600 lop lop.n30 0.041125
R8601 lop lop.n30 6.28648
R8602 lop lop.n28 0.041125
R8603 lop lop.n28 6.28648
R8604 lop lop.n26 0.041125
R8605 lop lop.n26 6.28648
R8606 lop lop.n25 0.041125
R8607 lop lop.n25 6.28648
R8608 lop.n24 lop.n20 22.0487
R8609 lop.n20 lop.n22 3.4105
R8610 lop.n20 lop.n21 3.5233
R8611 lop.n20 lop.n23 3.5233
R8612 lop lop.n23 0.041125
R8613 lop lop.n23 7.14887
R8614 lop lop.n22 0.041125
R8615 lop lop.n22 7.14887
R8616 lop lop.n21 0.041125
R8617 lop lop.n21 7.14887
R8618 lop.n11 lop.n10 3.4105
R8619 lop.n13 lop.n12 3.4105
R8620 lop.n15 lop.n14 3.4105
R8621 lop.n17 lop.n16 3.4105
R8622 lop.n11 lop.n9 3.5233
R8623 lop.n13 lop.n11 0.1133
R8624 lop.n19 lop.n13 1.37643
R8625 lop.n19 lop.n15 0.513975
R8626 lop.n15 lop.n17 0.1133
R8627 lop.n17 lop.n18 3.5233
R8628 lop lop.n18 0.041125
R8629 lop lop.n18 9.25648
R8630 lop lop.n16 0.041125
R8631 lop lop.n16 9.25648
R8632 lop lop.n14 0.041125
R8633 lop lop.n14 9.25648
R8634 lop lop.n12 0.041125
R8635 lop lop.n12 9.25648
R8636 lop lop.n10 0.041125
R8637 lop lop.n10 9.25648
R8638 lop lop.n9 0.041125
R8639 lop lop.n9 9.25648
R8640 lop.n5 lop.n4 0.1133
R8641 lop.n8 lop.n5 1.37643
R8642 lop.n8 lop.n6 0.513975
R8643 lop.n6 lop.n7 0.1133
R8644 lop lop.n7 8.34667
R8645 lop lop.n7 8.23387
R8646 lop lop.n6 8.23387
R8647 lop lop.n5 8.23387
R8648 lop lop.n4 8.23387
R8649 lop lop.n4 8.34667
R8650 lop lop.n3 8.28278
R8651 lop lop.n2 8.28278
R8652 lop lop.n1 8.28278
R8653 lop lop.n0 8.28278
R8654 lon lon.n0 8.39558
R8655 lon.n1 lon.n0 0.1133
R8656 lon.n38 lon.n1 0.1133
R8657 lon lon.n38 8.39558
R8658 lon lon.n38 8.28278
R8659 lon.n1 lon.n37 13.3219
R8660 lon.n37 lon.n31 0.572138
R8661 lon.n31 lon.n25 0.2308
R8662 lon.n25 lon 1.08091
R8663 lon lon.n10 0.3436
R8664 lon.n33 lon.n32 3.4105
R8665 lon.n35 lon.n34 3.4105
R8666 lon.n37 lon.n33 5.14363
R8667 lon.n33 lon.n35 0.1133
R8668 lon.n35 lon.n36 3.5233
R8669 lon lon.n36 0.041125
R8670 lon lon.n36 9.25648
R8671 lon lon.n34 0.041125
R8672 lon lon.n34 9.25648
R8673 lon lon.n32 0.041125
R8674 lon lon.n32 9.25648
R8675 lon.n27 lon.n26 3.4105
R8676 lon.n29 lon.n28 3.4105
R8677 lon.n31 lon.n27 4.67598
R8678 lon.n27 lon.n29 0.1133
R8679 lon.n29 lon.n30 3.5233
R8680 lon lon.n30 0.041125
R8681 lon lon.n30 7.14887
R8682 lon lon.n28 0.041125
R8683 lon lon.n28 7.14887
R8684 lon lon.n26 0.041125
R8685 lon lon.n26 7.14887
R8686 lon.n18 lon.n17 3.4105
R8687 lon.n20 lon.n19 3.4105
R8688 lon.n22 lon.n21 3.4105
R8689 lon.n24 lon.n23 3.4105
R8690 lon.n18 lon.n16 3.5233
R8691 lon.n20 lon.n18 0.1133
R8692 lon.n22 lon.n20 0.1133
R8693 lon.n24 lon.n22 0.1133
R8694 lon.n25 lon.n24 5.92383
R8695 lon lon.n23 0.041125
R8696 lon lon.n23 6.28648
R8697 lon lon.n21 0.041125
R8698 lon lon.n21 6.28648
R8699 lon lon.n19 0.041125
R8700 lon lon.n19 6.28648
R8701 lon lon.n17 0.041125
R8702 lon lon.n17 6.28648
R8703 lon lon.n16 0.041125
R8704 lon lon.n16 6.28648
R8705 lon.n12 lon.n13 3.4105
R8706 lon.n14 lon.n15 3.4105
R8707 lon.n11 lon.n13 3.5233
R8708 lon.n13 lon.n15 0.1133
R8709 lon.n15 lon 8.26442
R8710 lon lon.n14 0.041125
R8711 lon lon.n14 9.25648
R8712 lon lon.n12 0.041125
R8713 lon lon.n12 9.25648
R8714 lon lon.n11 0.041125
R8715 lon lon.n11 9.25648
R8716 lon.n9 lon.n10 14.9731
R8717 lon.n5 lon.n9 3.7536
R8718 lon.n9 lon.n4 4.10669
R8719 lon.n7 lon.n5 3.4105
R8720 lon.n6 lon.n5 3.5233
R8721 lon.n5 lon.n8 3.5233
R8722 lon lon.n8 0.041125
R8723 lon lon.n8 9.25648
R8724 lon lon.n7 0.041125
R8725 lon lon.n7 9.25648
R8726 lon lon.n6 0.041125
R8727 lon lon.n6 9.25648
R8728 lon lon.n4 8.34667
R8729 lon lon.n4 8.23387
R8730 lon lon.n4 8.34667
R8731 lon.n2 lon.n3 0.1133
R8732 lon.n3 lon.n10 8.96061
R8733 lon lon.n3 8.23387
R8734 lon lon.n2 8.23387
R8735 lon lon.n2 8.34667
R8736 lon lon.n1 8.28278
R8737 lon lon.n0 8.28278
R8738 select_b.n0 select_b.n1 4.55128
R8739 select_b select_b.n0 4.7057
R8740 select_b select_b.n1 0.041125
R8741 select_b.n2 select_b.n3 3.4105
R8742 select_b.n1 select_b.n3 3.5233
R8743 select_b.n85 select_b.n3 18.9261
R8744 select_b.n85 select_b 0.953425
R8745 select_b.n85 select_b.n82 17.9185
R8746 select_b.n84 select_b.n82 3.4105
R8747 select_b.n83 select_b.n82 3.5233
R8748 select_b select_b.n84 0.041125
R8749 select_b select_b.n84 7.8505
R8750 select_b select_b.n83 0.041125
R8751 select_b select_b.n83 7.8505
R8752 select_b.n81 select_b 4.68302
R8753 select_b.n62 select_b.n81 8.16967
R8754 select_b select_b.n62 9.3005
R8755 select_b select_b.n62 0.0466957
R8756 select_b select_b.n63 6.10787
R8757 select_b.n62 select_b.n63 1.92
R8758 select_b.n64 select_b 152
R8759 select_b select_b.n65 6.10787
R8760 select_b.n66 select_b 152
R8761 select_b.n67 select_b 152
R8762 select_b.n68 select_b 152
R8763 select_b.n80 select_b 152
R8764 select_b select_b.n65 6.3031
R8765 select_b.n63 select_b 6.3031
R8766 select_b.n80 select_b.n68 70.1096
R8767 select_b.n68 select_b.n67 70.1096
R8768 select_b.n67 select_b.n66 70.1096
R8769 select_b.n66 select_b.n64 70.1096
R8770 select_b.n69 select_b.n80 327.76
R8771 select_b.n71 select_b.n72 152
R8772 select_b.n73 select_b.n74 152
R8773 select_b.n75 select_b.n76 152
R8774 select_b.n69 select_b.n75 70.1096
R8775 select_b.n75 select_b.n73 70.1096
R8776 select_b.n73 select_b.n71 70.1096
R8777 select_b.n71 select_b.n70 70.1096
R8778 select_b.n72 select_b.n77 6.10787
R8779 select_b.n74 select_b.n78 9.3005
R8780 select_b.n76 select_b.n79 6.10787
R8781 select_b.n69 select_b.n79 158.304
R8782 select_b.n76 select_b.n74 36.1417
R8783 select_b.n74 select_b.n72 36.1417
R8784 select_b.n77 select_b.n70 158.304
R8785 select_b.n79 select_b.n78 1.92
R8786 select_b.n78 select_b.n77 1.92
R8787 select_b.n75 select_b.n68 327.76
R8788 select_b.n73 select_b.n67 327.76
R8789 select_b.n71 select_b.n66 327.76
R8790 select_b.n70 select_b.n64 327.76
R8791 select_b.n65 select_b 1.8738
R8792 select_b.n43 select_b.n81 10.2847
R8793 select_b select_b.n43 9.3005
R8794 select_b select_b.n43 0.0466957
R8795 select_b select_b.n44 6.10787
R8796 select_b.n43 select_b.n44 1.92
R8797 select_b.n45 select_b 152
R8798 select_b select_b.n46 6.10787
R8799 select_b.n47 select_b 152
R8800 select_b.n48 select_b 152
R8801 select_b.n49 select_b 152
R8802 select_b.n61 select_b 152
R8803 select_b select_b.n46 6.3031
R8804 select_b.n44 select_b 6.3031
R8805 select_b.n61 select_b.n49 70.1096
R8806 select_b.n49 select_b.n48 70.1096
R8807 select_b.n48 select_b.n47 70.1096
R8808 select_b.n47 select_b.n45 70.1096
R8809 select_b.n50 select_b.n61 327.76
R8810 select_b.n52 select_b.n53 152
R8811 select_b.n54 select_b.n55 152
R8812 select_b.n56 select_b.n57 152
R8813 select_b.n50 select_b.n56 70.1096
R8814 select_b.n56 select_b.n54 70.1096
R8815 select_b.n54 select_b.n52 70.1096
R8816 select_b.n52 select_b.n51 70.1096
R8817 select_b.n53 select_b.n58 6.10787
R8818 select_b.n55 select_b.n59 9.3005
R8819 select_b.n57 select_b.n60 6.10787
R8820 select_b.n50 select_b.n60 158.304
R8821 select_b.n57 select_b.n55 36.1417
R8822 select_b.n55 select_b.n53 36.1417
R8823 select_b.n58 select_b.n51 158.304
R8824 select_b.n60 select_b.n59 1.92
R8825 select_b.n59 select_b.n58 1.92
R8826 select_b.n56 select_b.n49 327.76
R8827 select_b.n54 select_b.n48 327.76
R8828 select_b.n52 select_b.n47 327.76
R8829 select_b.n51 select_b.n45 327.76
R8830 select_b.n46 select_b 1.8738
R8831 select_b select_b.n4 5.0978
R8832 select_b.n4 select_b.n24 17.6569
R8833 select_b select_b.n24 9.3005
R8834 select_b select_b.n24 0.0466957
R8835 select_b select_b.n25 6.10787
R8836 select_b.n24 select_b.n25 1.92
R8837 select_b.n26 select_b 152
R8838 select_b select_b.n27 6.10787
R8839 select_b.n28 select_b 152
R8840 select_b.n29 select_b 152
R8841 select_b.n30 select_b 152
R8842 select_b.n42 select_b 152
R8843 select_b select_b.n27 6.3031
R8844 select_b.n25 select_b 6.3031
R8845 select_b.n42 select_b.n30 70.1096
R8846 select_b.n30 select_b.n29 70.1096
R8847 select_b.n29 select_b.n28 70.1096
R8848 select_b.n28 select_b.n26 70.1096
R8849 select_b.n31 select_b.n42 613.747
R8850 select_b.n33 select_b.n34 152
R8851 select_b.n35 select_b.n36 152
R8852 select_b.n37 select_b.n38 152
R8853 select_b.n31 select_b.n37 70.1096
R8854 select_b.n37 select_b.n35 70.1096
R8855 select_b.n35 select_b.n33 70.1096
R8856 select_b.n33 select_b.n32 70.1096
R8857 select_b.n34 select_b.n39 6.10787
R8858 select_b.n36 select_b.n40 9.3005
R8859 select_b.n38 select_b.n41 6.10787
R8860 select_b.n31 select_b.n41 158.304
R8861 select_b.n38 select_b.n36 36.1417
R8862 select_b.n36 select_b.n34 36.1417
R8863 select_b.n39 select_b.n32 158.304
R8864 select_b.n41 select_b.n40 1.92
R8865 select_b.n40 select_b.n39 1.92
R8866 select_b.n37 select_b.n30 613.747
R8867 select_b.n35 select_b.n29 613.747
R8868 select_b.n33 select_b.n28 613.747
R8869 select_b.n32 select_b.n26 613.747
R8870 select_b.n27 select_b 1.8738
R8871 select_b.n5 select_b.n4 15.5419
R8872 select_b select_b.n5 9.3005
R8873 select_b select_b.n5 0.0466957
R8874 select_b select_b.n6 6.10787
R8875 select_b.n5 select_b.n6 1.92
R8876 select_b.n7 select_b 152
R8877 select_b select_b.n8 6.10787
R8878 select_b.n9 select_b 152
R8879 select_b.n10 select_b 152
R8880 select_b.n11 select_b 152
R8881 select_b.n23 select_b 152
R8882 select_b select_b.n8 6.3031
R8883 select_b.n6 select_b 6.3031
R8884 select_b.n7 select_b.n9 70.1096
R8885 select_b.n9 select_b.n10 70.1096
R8886 select_b.n10 select_b.n11 70.1096
R8887 select_b.n11 select_b.n23 70.1096
R8888 select_b.n12 select_b.n23 613.747
R8889 select_b.n13 select_b.n14 152
R8890 select_b.n15 select_b.n16 152
R8891 select_b.n17 select_b.n18 152
R8892 select_b.n19 select_b.n17 70.1096
R8893 select_b.n17 select_b.n15 70.1096
R8894 select_b.n15 select_b.n13 70.1096
R8895 select_b.n13 select_b.n12 70.1096
R8896 select_b.n14 select_b.n20 6.10787
R8897 select_b.n16 select_b.n21 9.3005
R8898 select_b.n18 select_b.n22 6.10787
R8899 select_b.n19 select_b.n22 158.304
R8900 select_b.n18 select_b.n16 36.1417
R8901 select_b.n16 select_b.n14 36.1417
R8902 select_b.n20 select_b.n12 158.304
R8903 select_b.n22 select_b.n21 1.92
R8904 select_b.n21 select_b.n20 1.92
R8905 select_b.n19 select_b.n7 613.747
R8906 select_b.n17 select_b.n9 613.747
R8907 select_b.n15 select_b.n10 613.747
R8908 select_b.n13 select_b.n11 613.747
R8909 select_b.n8 select_b 1.8738
R8910 select_b select_b.n2 0.041125
R8911 select_b select_b.n2 9.25648
R8912 ch2_lon ch2_lon.n68 9.3005
R8913 ch2_lon ch2_lon.n68 0.0466957
R8914 ch2_lon ch2_lon.n69 6.10787
R8915 ch2_lon.n69 ch2_lon.n68 1.92
R8916 ch2_lon ch2_lon.n70 152
R8917 ch2_lon ch2_lon.n71 6.10787
R8918 ch2_lon.n72 ch2_lon 152
R8919 ch2_lon.n73 ch2_lon 152
R8920 ch2_lon.n74 ch2_lon 152
R8921 ch2_lon.n86 ch2_lon 152
R8922 ch2_lon ch2_lon.n71 6.3031
R8923 ch2_lon ch2_lon.n69 6.3031
R8924 ch2_lon.n74 ch2_lon.n86 70.1096
R8925 ch2_lon.n73 ch2_lon.n74 70.1096
R8926 ch2_lon.n72 ch2_lon.n73 70.1096
R8927 ch2_lon.n70 ch2_lon.n72 70.1096
R8928 ch2_lon.n75 ch2_lon.n86 584.827
R8929 ch2_lon.n77 ch2_lon.n78 152
R8930 ch2_lon.n79 ch2_lon.n80 152
R8931 ch2_lon.n81 ch2_lon.n82 152
R8932 ch2_lon.n81 ch2_lon.n75 70.1096
R8933 ch2_lon.n79 ch2_lon.n81 70.1096
R8934 ch2_lon.n79 ch2_lon.n77 70.1096
R8935 ch2_lon.n77 ch2_lon.n76 70.1096
R8936 ch2_lon.n83 ch2_lon.n78 6.10787
R8937 ch2_lon.n84 ch2_lon.n80 9.3005
R8938 ch2_lon.n85 ch2_lon.n82 6.10787
R8939 ch2_lon.n75 ch2_lon.n85 158.304
R8940 ch2_lon.n82 ch2_lon.n80 36.1417
R8941 ch2_lon.n80 ch2_lon.n78 36.1417
R8942 ch2_lon.n76 ch2_lon.n83 158.304
R8943 ch2_lon.n84 ch2_lon.n85 1.92
R8944 ch2_lon.n83 ch2_lon.n84 1.92
R8945 ch2_lon.n81 ch2_lon.n74 584.827
R8946 ch2_lon.n73 ch2_lon.n79 584.827
R8947 ch2_lon.n72 ch2_lon.n77 584.827
R8948 ch2_lon.n70 ch2_lon.n76 584.827
R8949 ch2_lon.n71 ch2_lon 1.8738
R8950 ch2_lon.n68 ch2_lon.n67 27.7914
R8951 ch2_lon.n67 ch2_lon 1.93925
R8952 ch2_lon ch2_lon.n8 15.4594
R8953 ch2_lon.n67 ch2_lon.n48 12.9579
R8954 ch2_lon ch2_lon.n48 9.3005
R8955 ch2_lon ch2_lon.n48 0.0466957
R8956 ch2_lon ch2_lon.n49 6.10787
R8957 ch2_lon.n48 ch2_lon.n49 1.92
R8958 ch2_lon.n50 ch2_lon 152
R8959 ch2_lon ch2_lon.n51 6.10787
R8960 ch2_lon.n52 ch2_lon 152
R8961 ch2_lon.n53 ch2_lon 152
R8962 ch2_lon.n54 ch2_lon 152
R8963 ch2_lon.n66 ch2_lon 152
R8964 ch2_lon ch2_lon.n51 6.3031
R8965 ch2_lon.n49 ch2_lon 6.3031
R8966 ch2_lon.n66 ch2_lon.n54 70.1096
R8967 ch2_lon.n54 ch2_lon.n53 70.1096
R8968 ch2_lon.n53 ch2_lon.n52 70.1096
R8969 ch2_lon.n52 ch2_lon.n50 70.1096
R8970 ch2_lon.n55 ch2_lon.n66 584.827
R8971 ch2_lon.n57 ch2_lon.n58 152
R8972 ch2_lon.n59 ch2_lon.n60 152
R8973 ch2_lon.n61 ch2_lon.n62 152
R8974 ch2_lon.n55 ch2_lon.n61 70.1096
R8975 ch2_lon.n61 ch2_lon.n59 70.1096
R8976 ch2_lon.n59 ch2_lon.n57 70.1096
R8977 ch2_lon.n57 ch2_lon.n56 70.1096
R8978 ch2_lon.n58 ch2_lon.n63 6.10787
R8979 ch2_lon.n60 ch2_lon.n64 9.3005
R8980 ch2_lon.n62 ch2_lon.n65 6.10787
R8981 ch2_lon.n55 ch2_lon.n65 158.304
R8982 ch2_lon.n62 ch2_lon.n60 36.1417
R8983 ch2_lon.n60 ch2_lon.n58 36.1417
R8984 ch2_lon.n63 ch2_lon.n56 158.304
R8985 ch2_lon.n65 ch2_lon.n64 1.92
R8986 ch2_lon.n64 ch2_lon.n63 1.92
R8987 ch2_lon.n61 ch2_lon.n54 584.827
R8988 ch2_lon.n59 ch2_lon.n53 584.827
R8989 ch2_lon.n57 ch2_lon.n52 584.827
R8990 ch2_lon.n56 ch2_lon.n50 584.827
R8991 ch2_lon.n51 ch2_lon 1.8738
R8992 ch2_lon.n9 ch2_lon.n28 23.3557
R8993 ch2_lon.n28 ch2_lon 7.50302
R8994 ch2_lon.n29 ch2_lon.n28 15.5302
R8995 ch2_lon ch2_lon.n29 9.3005
R8996 ch2_lon ch2_lon.n29 0.0466957
R8997 ch2_lon ch2_lon.n30 6.10787
R8998 ch2_lon.n29 ch2_lon.n30 1.92
R8999 ch2_lon.n31 ch2_lon 152
R9000 ch2_lon ch2_lon.n32 6.10787
R9001 ch2_lon.n33 ch2_lon 152
R9002 ch2_lon.n34 ch2_lon 152
R9003 ch2_lon.n35 ch2_lon 152
R9004 ch2_lon.n47 ch2_lon 152
R9005 ch2_lon ch2_lon.n32 6.3031
R9006 ch2_lon.n30 ch2_lon 6.3031
R9007 ch2_lon.n47 ch2_lon.n35 70.1096
R9008 ch2_lon.n35 ch2_lon.n34 70.1096
R9009 ch2_lon.n34 ch2_lon.n33 70.1096
R9010 ch2_lon.n33 ch2_lon.n31 70.1096
R9011 ch2_lon.n36 ch2_lon.n47 584.827
R9012 ch2_lon.n38 ch2_lon.n39 152
R9013 ch2_lon.n40 ch2_lon.n41 152
R9014 ch2_lon.n42 ch2_lon.n43 152
R9015 ch2_lon.n36 ch2_lon.n42 70.1096
R9016 ch2_lon.n42 ch2_lon.n40 70.1096
R9017 ch2_lon.n40 ch2_lon.n38 70.1096
R9018 ch2_lon.n38 ch2_lon.n37 70.1096
R9019 ch2_lon.n39 ch2_lon.n44 6.10787
R9020 ch2_lon.n41 ch2_lon.n45 9.3005
R9021 ch2_lon.n43 ch2_lon.n46 6.10787
R9022 ch2_lon.n36 ch2_lon.n46 158.304
R9023 ch2_lon.n43 ch2_lon.n41 36.1417
R9024 ch2_lon.n41 ch2_lon.n39 36.1417
R9025 ch2_lon.n44 ch2_lon.n37 158.304
R9026 ch2_lon.n46 ch2_lon.n45 1.92
R9027 ch2_lon.n45 ch2_lon.n44 1.92
R9028 ch2_lon.n42 ch2_lon.n35 584.827
R9029 ch2_lon.n40 ch2_lon.n34 584.827
R9030 ch2_lon.n38 ch2_lon.n33 584.827
R9031 ch2_lon.n37 ch2_lon.n31 584.827
R9032 ch2_lon.n32 ch2_lon 1.8738
R9033 ch2_lon ch2_lon.n9 9.3005
R9034 ch2_lon ch2_lon.n9 0.0466957
R9035 ch2_lon ch2_lon.n10 6.10787
R9036 ch2_lon.n9 ch2_lon.n10 1.92
R9037 ch2_lon.n11 ch2_lon 152
R9038 ch2_lon ch2_lon.n12 6.10787
R9039 ch2_lon.n13 ch2_lon 152
R9040 ch2_lon.n14 ch2_lon 152
R9041 ch2_lon.n15 ch2_lon 152
R9042 ch2_lon.n27 ch2_lon 152
R9043 ch2_lon ch2_lon.n12 6.3031
R9044 ch2_lon.n10 ch2_lon 6.3031
R9045 ch2_lon.n27 ch2_lon.n15 70.1096
R9046 ch2_lon.n15 ch2_lon.n14 70.1096
R9047 ch2_lon.n14 ch2_lon.n13 70.1096
R9048 ch2_lon.n13 ch2_lon.n11 70.1096
R9049 ch2_lon.n16 ch2_lon.n27 584.827
R9050 ch2_lon.n18 ch2_lon.n19 152
R9051 ch2_lon.n20 ch2_lon.n21 152
R9052 ch2_lon.n22 ch2_lon.n23 152
R9053 ch2_lon.n16 ch2_lon.n22 70.1096
R9054 ch2_lon.n22 ch2_lon.n20 70.1096
R9055 ch2_lon.n20 ch2_lon.n18 70.1096
R9056 ch2_lon.n18 ch2_lon.n17 70.1096
R9057 ch2_lon.n19 ch2_lon.n24 6.10787
R9058 ch2_lon.n21 ch2_lon.n25 9.3005
R9059 ch2_lon.n23 ch2_lon.n26 6.10787
R9060 ch2_lon.n16 ch2_lon.n26 158.304
R9061 ch2_lon.n23 ch2_lon.n21 36.1417
R9062 ch2_lon.n21 ch2_lon.n19 36.1417
R9063 ch2_lon.n24 ch2_lon.n17 158.304
R9064 ch2_lon.n26 ch2_lon.n25 1.92
R9065 ch2_lon.n25 ch2_lon.n24 1.92
R9066 ch2_lon.n22 ch2_lon.n15 584.827
R9067 ch2_lon.n20 ch2_lon.n14 584.827
R9068 ch2_lon.n18 ch2_lon.n13 584.827
R9069 ch2_lon.n17 ch2_lon.n11 584.827
R9070 ch2_lon.n12 ch2_lon 1.8738
R9071 ch2_lon.n8 ch2_lon.n4 14.2584
R9072 ch2_lon.n6 ch2_lon.n4 3.4105
R9073 ch2_lon.n5 ch2_lon.n4 3.5233
R9074 ch2_lon.n4 ch2_lon.n7 3.5233
R9075 ch2_lon ch2_lon.n7 0.041125
R9076 ch2_lon ch2_lon.n7 7.14887
R9077 ch2_lon ch2_lon.n6 0.041125
R9078 ch2_lon ch2_lon.n6 7.14887
R9079 ch2_lon ch2_lon.n5 0.041125
R9080 ch2_lon ch2_lon.n5 7.14887
R9081 ch2_lon.n8 ch2_lon.n0 14.5104
R9082 ch2_lon.n2 ch2_lon.n0 3.4105
R9083 ch2_lon.n1 ch2_lon.n0 3.5233
R9084 ch2_lon.n0 ch2_lon.n3 3.5233
R9085 ch2_lon ch2_lon.n3 0.041125
R9086 ch2_lon ch2_lon.n3 6.29199
R9087 ch2_lon ch2_lon.n2 0.041125
R9088 ch2_lon ch2_lon.n2 6.29199
R9089 ch2_lon ch2_lon.n1 0.041125
R9090 ch2_lon ch2_lon.n1 6.29199
R9091 ch2_lop ch2_lop.n68 9.3005
R9092 ch2_lop ch2_lop.n68 0.0466957
R9093 ch2_lop ch2_lop.n69 6.10787
R9094 ch2_lop.n69 ch2_lop.n68 1.92
R9095 ch2_lop ch2_lop.n70 152
R9096 ch2_lop ch2_lop.n71 6.10787
R9097 ch2_lop.n72 ch2_lop 152
R9098 ch2_lop.n73 ch2_lop 152
R9099 ch2_lop.n74 ch2_lop 152
R9100 ch2_lop.n86 ch2_lop 152
R9101 ch2_lop ch2_lop.n71 6.3031
R9102 ch2_lop ch2_lop.n69 6.3031
R9103 ch2_lop.n74 ch2_lop.n86 70.1096
R9104 ch2_lop.n73 ch2_lop.n74 70.1096
R9105 ch2_lop.n72 ch2_lop.n73 70.1096
R9106 ch2_lop.n70 ch2_lop.n72 70.1096
R9107 ch2_lop.n75 ch2_lop.n86 584.827
R9108 ch2_lop.n77 ch2_lop.n78 152
R9109 ch2_lop.n79 ch2_lop.n80 152
R9110 ch2_lop.n81 ch2_lop.n82 152
R9111 ch2_lop.n81 ch2_lop.n75 70.1096
R9112 ch2_lop.n79 ch2_lop.n81 70.1096
R9113 ch2_lop.n79 ch2_lop.n77 70.1096
R9114 ch2_lop.n77 ch2_lop.n76 70.1096
R9115 ch2_lop.n83 ch2_lop.n78 6.10787
R9116 ch2_lop.n84 ch2_lop.n80 9.3005
R9117 ch2_lop.n85 ch2_lop.n82 6.10787
R9118 ch2_lop.n75 ch2_lop.n85 158.304
R9119 ch2_lop.n82 ch2_lop.n80 36.1417
R9120 ch2_lop.n80 ch2_lop.n78 36.1417
R9121 ch2_lop.n76 ch2_lop.n83 158.304
R9122 ch2_lop.n84 ch2_lop.n85 1.92
R9123 ch2_lop.n83 ch2_lop.n84 1.92
R9124 ch2_lop.n81 ch2_lop.n74 584.827
R9125 ch2_lop.n73 ch2_lop.n79 584.827
R9126 ch2_lop.n72 ch2_lop.n77 584.827
R9127 ch2_lop.n70 ch2_lop.n76 584.827
R9128 ch2_lop.n71 ch2_lop 1.8738
R9129 ch2_lop.n68 ch2_lop.n67 12.5232
R9130 ch2_lop.n67 ch2_lop.n47 2.1155
R9131 ch2_lop.n47 ch2_lop 0.441125
R9132 ch2_lop.n67 ch2_lop.n48 23.0961
R9133 ch2_lop ch2_lop.n48 9.3005
R9134 ch2_lop ch2_lop.n48 0.0466957
R9135 ch2_lop ch2_lop.n49 6.10787
R9136 ch2_lop.n48 ch2_lop.n49 1.92
R9137 ch2_lop.n50 ch2_lop 152
R9138 ch2_lop ch2_lop.n51 6.10787
R9139 ch2_lop.n52 ch2_lop 152
R9140 ch2_lop.n53 ch2_lop 152
R9141 ch2_lop.n54 ch2_lop 152
R9142 ch2_lop.n66 ch2_lop 152
R9143 ch2_lop ch2_lop.n51 6.3031
R9144 ch2_lop.n49 ch2_lop 6.3031
R9145 ch2_lop.n66 ch2_lop.n54 70.1096
R9146 ch2_lop.n54 ch2_lop.n53 70.1096
R9147 ch2_lop.n53 ch2_lop.n52 70.1096
R9148 ch2_lop.n52 ch2_lop.n50 70.1096
R9149 ch2_lop.n55 ch2_lop.n66 584.827
R9150 ch2_lop.n57 ch2_lop.n58 152
R9151 ch2_lop.n59 ch2_lop.n60 152
R9152 ch2_lop.n61 ch2_lop.n62 152
R9153 ch2_lop.n55 ch2_lop.n61 70.1096
R9154 ch2_lop.n61 ch2_lop.n59 70.1096
R9155 ch2_lop.n59 ch2_lop.n57 70.1096
R9156 ch2_lop.n57 ch2_lop.n56 70.1096
R9157 ch2_lop.n58 ch2_lop.n63 6.10787
R9158 ch2_lop.n60 ch2_lop.n64 9.3005
R9159 ch2_lop.n62 ch2_lop.n65 6.10787
R9160 ch2_lop.n55 ch2_lop.n65 158.304
R9161 ch2_lop.n62 ch2_lop.n60 36.1417
R9162 ch2_lop.n60 ch2_lop.n58 36.1417
R9163 ch2_lop.n63 ch2_lop.n56 158.304
R9164 ch2_lop.n65 ch2_lop.n64 1.92
R9165 ch2_lop.n64 ch2_lop.n63 1.92
R9166 ch2_lop.n61 ch2_lop.n54 584.827
R9167 ch2_lop.n59 ch2_lop.n53 584.827
R9168 ch2_lop.n57 ch2_lop.n52 584.827
R9169 ch2_lop.n56 ch2_lop.n50 584.827
R9170 ch2_lop.n51 ch2_lop 1.8738
R9171 ch2_lop.n47 ch2_lop.n28 12.1636
R9172 ch2_lop ch2_lop.n28 9.3005
R9173 ch2_lop ch2_lop.n28 0.0466957
R9174 ch2_lop ch2_lop.n29 6.10787
R9175 ch2_lop.n28 ch2_lop.n29 1.92
R9176 ch2_lop.n30 ch2_lop 152
R9177 ch2_lop ch2_lop.n31 6.10787
R9178 ch2_lop.n32 ch2_lop 152
R9179 ch2_lop.n33 ch2_lop 152
R9180 ch2_lop.n34 ch2_lop 152
R9181 ch2_lop.n46 ch2_lop 152
R9182 ch2_lop ch2_lop.n31 6.3031
R9183 ch2_lop.n29 ch2_lop 6.3031
R9184 ch2_lop.n46 ch2_lop.n34 70.1096
R9185 ch2_lop.n34 ch2_lop.n33 70.1096
R9186 ch2_lop.n33 ch2_lop.n32 70.1096
R9187 ch2_lop.n32 ch2_lop.n30 70.1096
R9188 ch2_lop.n35 ch2_lop.n46 584.827
R9189 ch2_lop.n37 ch2_lop.n38 152
R9190 ch2_lop.n39 ch2_lop.n40 152
R9191 ch2_lop.n41 ch2_lop.n42 152
R9192 ch2_lop.n35 ch2_lop.n41 70.1096
R9193 ch2_lop.n41 ch2_lop.n39 70.1096
R9194 ch2_lop.n39 ch2_lop.n37 70.1096
R9195 ch2_lop.n37 ch2_lop.n36 70.1096
R9196 ch2_lop.n38 ch2_lop.n43 6.10787
R9197 ch2_lop.n40 ch2_lop.n44 9.3005
R9198 ch2_lop.n42 ch2_lop.n45 6.10787
R9199 ch2_lop.n35 ch2_lop.n45 158.304
R9200 ch2_lop.n42 ch2_lop.n40 36.1417
R9201 ch2_lop.n40 ch2_lop.n38 36.1417
R9202 ch2_lop.n43 ch2_lop.n36 158.304
R9203 ch2_lop.n45 ch2_lop.n44 1.92
R9204 ch2_lop.n44 ch2_lop.n43 1.92
R9205 ch2_lop.n41 ch2_lop.n34 584.827
R9206 ch2_lop.n39 ch2_lop.n33 584.827
R9207 ch2_lop.n37 ch2_lop.n32 584.827
R9208 ch2_lop.n36 ch2_lop.n30 584.827
R9209 ch2_lop.n31 ch2_lop 1.8738
R9210 ch2_lop.n9 ch2_lop 23.2148
R9211 ch2_lop ch2_lop.n9 9.3005
R9212 ch2_lop ch2_lop.n9 0.0466957
R9213 ch2_lop ch2_lop.n10 6.10787
R9214 ch2_lop.n9 ch2_lop.n10 1.92
R9215 ch2_lop.n11 ch2_lop 152
R9216 ch2_lop ch2_lop.n12 6.10787
R9217 ch2_lop.n13 ch2_lop 152
R9218 ch2_lop.n14 ch2_lop 152
R9219 ch2_lop.n15 ch2_lop 152
R9220 ch2_lop.n27 ch2_lop 152
R9221 ch2_lop ch2_lop.n12 6.3031
R9222 ch2_lop.n10 ch2_lop 6.3031
R9223 ch2_lop.n27 ch2_lop.n15 70.1096
R9224 ch2_lop.n15 ch2_lop.n14 70.1096
R9225 ch2_lop.n14 ch2_lop.n13 70.1096
R9226 ch2_lop.n13 ch2_lop.n11 70.1096
R9227 ch2_lop.n16 ch2_lop.n27 584.827
R9228 ch2_lop.n18 ch2_lop.n19 152
R9229 ch2_lop.n20 ch2_lop.n21 152
R9230 ch2_lop.n22 ch2_lop.n23 152
R9231 ch2_lop.n16 ch2_lop.n22 70.1096
R9232 ch2_lop.n22 ch2_lop.n20 70.1096
R9233 ch2_lop.n20 ch2_lop.n18 70.1096
R9234 ch2_lop.n18 ch2_lop.n17 70.1096
R9235 ch2_lop.n19 ch2_lop.n24 6.10787
R9236 ch2_lop.n21 ch2_lop.n25 9.3005
R9237 ch2_lop.n23 ch2_lop.n26 6.10787
R9238 ch2_lop.n16 ch2_lop.n26 158.304
R9239 ch2_lop.n23 ch2_lop.n21 36.1417
R9240 ch2_lop.n21 ch2_lop.n19 36.1417
R9241 ch2_lop.n24 ch2_lop.n17 158.304
R9242 ch2_lop.n26 ch2_lop.n25 1.92
R9243 ch2_lop.n25 ch2_lop.n24 1.92
R9244 ch2_lop.n22 ch2_lop.n15 584.827
R9245 ch2_lop.n20 ch2_lop.n14 584.827
R9246 ch2_lop.n18 ch2_lop.n13 584.827
R9247 ch2_lop.n17 ch2_lop.n11 584.827
R9248 ch2_lop.n12 ch2_lop 1.8738
R9249 ch2_lop.n0 ch2_lop.n5 3.58372
R9250 ch2_lop.n0 ch2_lop.n1 4.36804
R9251 ch2_lop ch2_lop.n0 20.625
R9252 ch2_lop.n7 ch2_lop.n5 3.4105
R9253 ch2_lop.n6 ch2_lop.n5 3.5233
R9254 ch2_lop.n5 ch2_lop.n8 3.5233
R9255 ch2_lop ch2_lop.n8 0.041125
R9256 ch2_lop ch2_lop.n8 7.14887
R9257 ch2_lop ch2_lop.n7 0.041125
R9258 ch2_lop ch2_lop.n7 7.14887
R9259 ch2_lop ch2_lop.n6 0.041125
R9260 ch2_lop ch2_lop.n6 7.14887
R9261 ch2_lop.n3 ch2_lop.n1 3.4105
R9262 ch2_lop.n2 ch2_lop.n1 3.5233
R9263 ch2_lop.n1 ch2_lop.n4 3.5233
R9264 ch2_lop ch2_lop.n4 0.041125
R9265 ch2_lop ch2_lop.n4 6.29199
R9266 ch2_lop ch2_lop.n3 0.041125
R9267 ch2_lop ch2_lop.n3 6.29199
R9268 ch2_lop ch2_lop.n2 0.041125
R9269 ch2_lop ch2_lop.n2 6.29199
R9270 ch1_lon ch1_lon.n70 9.3005
R9271 ch1_lon ch1_lon.n70 0.0466957
R9272 ch1_lon ch1_lon.n71 6.10787
R9273 ch1_lon.n71 ch1_lon.n70 1.92
R9274 ch1_lon ch1_lon.n72 152
R9275 ch1_lon ch1_lon.n73 6.10787
R9276 ch1_lon.n74 ch1_lon 152
R9277 ch1_lon.n75 ch1_lon 152
R9278 ch1_lon.n76 ch1_lon 152
R9279 ch1_lon.n88 ch1_lon 152
R9280 ch1_lon ch1_lon.n73 6.3031
R9281 ch1_lon ch1_lon.n71 6.3031
R9282 ch1_lon.n76 ch1_lon.n88 70.1096
R9283 ch1_lon.n75 ch1_lon.n76 70.1096
R9284 ch1_lon.n74 ch1_lon.n75 70.1096
R9285 ch1_lon.n72 ch1_lon.n74 70.1096
R9286 ch1_lon.n77 ch1_lon.n88 584.827
R9287 ch1_lon.n79 ch1_lon.n80 152
R9288 ch1_lon.n81 ch1_lon.n82 152
R9289 ch1_lon.n83 ch1_lon.n84 152
R9290 ch1_lon.n83 ch1_lon.n77 70.1096
R9291 ch1_lon.n81 ch1_lon.n83 70.1096
R9292 ch1_lon.n81 ch1_lon.n79 70.1096
R9293 ch1_lon.n79 ch1_lon.n78 70.1096
R9294 ch1_lon.n85 ch1_lon.n80 6.10787
R9295 ch1_lon.n86 ch1_lon.n82 9.3005
R9296 ch1_lon.n87 ch1_lon.n84 6.10787
R9297 ch1_lon.n77 ch1_lon.n87 158.304
R9298 ch1_lon.n84 ch1_lon.n82 36.1417
R9299 ch1_lon.n82 ch1_lon.n80 36.1417
R9300 ch1_lon.n78 ch1_lon.n85 158.304
R9301 ch1_lon.n86 ch1_lon.n87 1.92
R9302 ch1_lon.n85 ch1_lon.n86 1.92
R9303 ch1_lon.n83 ch1_lon.n76 584.827
R9304 ch1_lon.n75 ch1_lon.n81 584.827
R9305 ch1_lon.n74 ch1_lon.n79 584.827
R9306 ch1_lon.n72 ch1_lon.n78 584.827
R9307 ch1_lon.n73 ch1_lon 1.8738
R9308 ch1_lon.n70 ch1_lon.n0 23.3557
R9309 ch1_lon.n0 ch1_lon.n69 10.2055
R9310 ch1_lon.n69 ch1_lon 0.52925
R9311 ch1_lon ch1_lon.n30 14.8425
R9312 ch1_lon.n69 ch1_lon.n50 13.3692
R9313 ch1_lon ch1_lon.n50 9.3005
R9314 ch1_lon ch1_lon.n50 0.0466957
R9315 ch1_lon ch1_lon.n51 6.10787
R9316 ch1_lon.n50 ch1_lon.n51 1.92
R9317 ch1_lon.n52 ch1_lon 152
R9318 ch1_lon ch1_lon.n53 6.10787
R9319 ch1_lon.n54 ch1_lon 152
R9320 ch1_lon.n55 ch1_lon 152
R9321 ch1_lon.n56 ch1_lon 152
R9322 ch1_lon.n68 ch1_lon 152
R9323 ch1_lon ch1_lon.n53 6.3031
R9324 ch1_lon.n51 ch1_lon 6.3031
R9325 ch1_lon.n68 ch1_lon.n56 70.1096
R9326 ch1_lon.n56 ch1_lon.n55 70.1096
R9327 ch1_lon.n55 ch1_lon.n54 70.1096
R9328 ch1_lon.n54 ch1_lon.n52 70.1096
R9329 ch1_lon.n57 ch1_lon.n68 584.827
R9330 ch1_lon.n59 ch1_lon.n60 152
R9331 ch1_lon.n61 ch1_lon.n62 152
R9332 ch1_lon.n63 ch1_lon.n64 152
R9333 ch1_lon.n57 ch1_lon.n63 70.1096
R9334 ch1_lon.n63 ch1_lon.n61 70.1096
R9335 ch1_lon.n61 ch1_lon.n59 70.1096
R9336 ch1_lon.n59 ch1_lon.n58 70.1096
R9337 ch1_lon.n60 ch1_lon.n65 6.10787
R9338 ch1_lon.n62 ch1_lon.n66 9.3005
R9339 ch1_lon.n64 ch1_lon.n67 6.10787
R9340 ch1_lon.n57 ch1_lon.n67 158.304
R9341 ch1_lon.n64 ch1_lon.n62 36.1417
R9342 ch1_lon.n62 ch1_lon.n60 36.1417
R9343 ch1_lon.n65 ch1_lon.n58 158.304
R9344 ch1_lon.n67 ch1_lon.n66 1.92
R9345 ch1_lon.n66 ch1_lon.n65 1.92
R9346 ch1_lon.n63 ch1_lon.n56 584.827
R9347 ch1_lon.n61 ch1_lon.n55 584.827
R9348 ch1_lon.n59 ch1_lon.n54 584.827
R9349 ch1_lon.n58 ch1_lon.n52 584.827
R9350 ch1_lon.n53 ch1_lon 1.8738
R9351 ch1_lon.n31 ch1_lon 28.7314
R9352 ch1_lon ch1_lon.n31 9.3005
R9353 ch1_lon ch1_lon.n31 0.0466957
R9354 ch1_lon ch1_lon.n32 6.10787
R9355 ch1_lon.n31 ch1_lon.n32 1.92
R9356 ch1_lon.n33 ch1_lon 152
R9357 ch1_lon ch1_lon.n34 6.10787
R9358 ch1_lon.n35 ch1_lon 152
R9359 ch1_lon.n36 ch1_lon 152
R9360 ch1_lon.n37 ch1_lon 152
R9361 ch1_lon.n49 ch1_lon 152
R9362 ch1_lon ch1_lon.n34 6.3031
R9363 ch1_lon.n32 ch1_lon 6.3031
R9364 ch1_lon.n49 ch1_lon.n37 70.1096
R9365 ch1_lon.n37 ch1_lon.n36 70.1096
R9366 ch1_lon.n36 ch1_lon.n35 70.1096
R9367 ch1_lon.n35 ch1_lon.n33 70.1096
R9368 ch1_lon.n38 ch1_lon.n49 584.827
R9369 ch1_lon.n40 ch1_lon.n41 152
R9370 ch1_lon.n42 ch1_lon.n43 152
R9371 ch1_lon.n44 ch1_lon.n45 152
R9372 ch1_lon.n38 ch1_lon.n44 70.1096
R9373 ch1_lon.n44 ch1_lon.n42 70.1096
R9374 ch1_lon.n42 ch1_lon.n40 70.1096
R9375 ch1_lon.n40 ch1_lon.n39 70.1096
R9376 ch1_lon.n41 ch1_lon.n46 6.10787
R9377 ch1_lon.n43 ch1_lon.n47 9.3005
R9378 ch1_lon.n45 ch1_lon.n48 6.10787
R9379 ch1_lon.n38 ch1_lon.n48 158.304
R9380 ch1_lon.n45 ch1_lon.n43 36.1417
R9381 ch1_lon.n43 ch1_lon.n41 36.1417
R9382 ch1_lon.n46 ch1_lon.n39 158.304
R9383 ch1_lon.n48 ch1_lon.n47 1.92
R9384 ch1_lon.n47 ch1_lon.n46 1.92
R9385 ch1_lon.n44 ch1_lon.n37 584.827
R9386 ch1_lon.n42 ch1_lon.n36 584.827
R9387 ch1_lon.n40 ch1_lon.n35 584.827
R9388 ch1_lon.n39 ch1_lon.n33 584.827
R9389 ch1_lon.n34 ch1_lon 1.8738
R9390 ch1_lon.n26 ch1_lon.n27 3.4105
R9391 ch1_lon.n28 ch1_lon.n29 3.4105
R9392 ch1_lon.n25 ch1_lon.n27 3.5233
R9393 ch1_lon.n27 ch1_lon.n29 0.1133
R9394 ch1_lon.n29 ch1_lon.n30 4.88042
R9395 ch1_lon ch1_lon.n28 0.041125
R9396 ch1_lon ch1_lon.n28 7.14887
R9397 ch1_lon ch1_lon.n26 0.041125
R9398 ch1_lon ch1_lon.n26 7.14887
R9399 ch1_lon ch1_lon.n25 0.041125
R9400 ch1_lon ch1_lon.n25 7.14887
R9401 ch1_lon.n21 ch1_lon.n22 3.4105
R9402 ch1_lon.n23 ch1_lon.n24 3.4105
R9403 ch1_lon.n20 ch1_lon.n22 3.5233
R9404 ch1_lon.n22 ch1_lon.n24 0.1133
R9405 ch1_lon.n24 ch1_lon.n30 6.01371
R9406 ch1_lon ch1_lon.n23 0.041125
R9407 ch1_lon ch1_lon.n23 6.29199
R9408 ch1_lon ch1_lon.n21 0.041125
R9409 ch1_lon ch1_lon.n21 6.29199
R9410 ch1_lon ch1_lon.n20 0.041125
R9411 ch1_lon ch1_lon.n20 6.29199
R9412 ch1_lon.n0 ch1_lon.n1 15.5302
R9413 ch1_lon ch1_lon.n1 9.3005
R9414 ch1_lon ch1_lon.n1 0.0466957
R9415 ch1_lon ch1_lon.n2 6.10787
R9416 ch1_lon.n1 ch1_lon.n2 1.92
R9417 ch1_lon.n3 ch1_lon 152
R9418 ch1_lon ch1_lon.n4 6.10787
R9419 ch1_lon.n5 ch1_lon 152
R9420 ch1_lon.n6 ch1_lon 152
R9421 ch1_lon.n7 ch1_lon 152
R9422 ch1_lon.n19 ch1_lon 152
R9423 ch1_lon ch1_lon.n4 6.3031
R9424 ch1_lon.n2 ch1_lon 6.3031
R9425 ch1_lon.n19 ch1_lon.n7 70.1096
R9426 ch1_lon.n7 ch1_lon.n6 70.1096
R9427 ch1_lon.n6 ch1_lon.n5 70.1096
R9428 ch1_lon.n5 ch1_lon.n3 70.1096
R9429 ch1_lon.n8 ch1_lon.n19 584.827
R9430 ch1_lon.n10 ch1_lon.n11 152
R9431 ch1_lon.n12 ch1_lon.n13 152
R9432 ch1_lon.n14 ch1_lon.n15 152
R9433 ch1_lon.n8 ch1_lon.n14 70.1096
R9434 ch1_lon.n14 ch1_lon.n12 70.1096
R9435 ch1_lon.n12 ch1_lon.n10 70.1096
R9436 ch1_lon.n10 ch1_lon.n9 70.1096
R9437 ch1_lon.n11 ch1_lon.n16 6.10787
R9438 ch1_lon.n13 ch1_lon.n17 9.3005
R9439 ch1_lon.n15 ch1_lon.n18 6.10787
R9440 ch1_lon.n8 ch1_lon.n18 158.304
R9441 ch1_lon.n15 ch1_lon.n13 36.1417
R9442 ch1_lon.n13 ch1_lon.n11 36.1417
R9443 ch1_lon.n16 ch1_lon.n9 158.304
R9444 ch1_lon.n18 ch1_lon.n17 1.92
R9445 ch1_lon.n17 ch1_lon.n16 1.92
R9446 ch1_lon.n14 ch1_lon.n7 584.827
R9447 ch1_lon.n12 ch1_lon.n6 584.827
R9448 ch1_lon.n10 ch1_lon.n5 584.827
R9449 ch1_lon.n9 ch1_lon.n3 584.827
R9450 ch1_lon.n4 ch1_lon 1.8738
R9451 ch1_lop ch1_lop.n70 9.3005
R9452 ch1_lop ch1_lop.n70 0.0466957
R9453 ch1_lop ch1_lop.n71 6.10787
R9454 ch1_lop.n71 ch1_lop.n70 1.92
R9455 ch1_lop ch1_lop.n72 152
R9456 ch1_lop ch1_lop.n73 6.10787
R9457 ch1_lop.n74 ch1_lop 152
R9458 ch1_lop.n75 ch1_lop 152
R9459 ch1_lop.n76 ch1_lop 152
R9460 ch1_lop.n88 ch1_lop 152
R9461 ch1_lop ch1_lop.n73 6.3031
R9462 ch1_lop ch1_lop.n71 6.3031
R9463 ch1_lop.n76 ch1_lop.n88 70.1096
R9464 ch1_lop.n75 ch1_lop.n76 70.1096
R9465 ch1_lop.n74 ch1_lop.n75 70.1096
R9466 ch1_lop.n72 ch1_lop.n74 70.1096
R9467 ch1_lop.n77 ch1_lop.n88 584.827
R9468 ch1_lop.n79 ch1_lop.n80 152
R9469 ch1_lop.n81 ch1_lop.n82 152
R9470 ch1_lop.n83 ch1_lop.n84 152
R9471 ch1_lop.n83 ch1_lop.n77 70.1096
R9472 ch1_lop.n81 ch1_lop.n83 70.1096
R9473 ch1_lop.n81 ch1_lop.n79 70.1096
R9474 ch1_lop.n79 ch1_lop.n78 70.1096
R9475 ch1_lop.n85 ch1_lop.n80 6.10787
R9476 ch1_lop.n86 ch1_lop.n82 9.3005
R9477 ch1_lop.n87 ch1_lop.n84 6.10787
R9478 ch1_lop.n77 ch1_lop.n87 158.304
R9479 ch1_lop.n84 ch1_lop.n82 36.1417
R9480 ch1_lop.n82 ch1_lop.n80 36.1417
R9481 ch1_lop.n78 ch1_lop.n85 158.304
R9482 ch1_lop.n86 ch1_lop.n87 1.92
R9483 ch1_lop.n85 ch1_lop.n86 1.92
R9484 ch1_lop.n83 ch1_lop.n76 584.827
R9485 ch1_lop.n75 ch1_lop.n81 584.827
R9486 ch1_lop.n74 ch1_lop.n79 584.827
R9487 ch1_lop.n72 ch1_lop.n78 584.827
R9488 ch1_lop.n73 ch1_lop 1.8738
R9489 ch1_lop.n70 ch1_lop.n0 20.2008
R9490 ch1_lop.n0 ch1_lop.n69 9.04815
R9491 ch1_lop.n69 ch1_lop 0.969875
R9492 ch1_lop ch1_lop.n30 14.9306
R9493 ch1_lop.n69 ch1_lop.n50 25.1359
R9494 ch1_lop ch1_lop.n50 9.3005
R9495 ch1_lop ch1_lop.n50 0.0466957
R9496 ch1_lop ch1_lop.n51 6.10787
R9497 ch1_lop.n50 ch1_lop.n51 1.92
R9498 ch1_lop.n52 ch1_lop 152
R9499 ch1_lop ch1_lop.n53 6.10787
R9500 ch1_lop.n54 ch1_lop 152
R9501 ch1_lop.n55 ch1_lop 152
R9502 ch1_lop.n56 ch1_lop 152
R9503 ch1_lop.n68 ch1_lop 152
R9504 ch1_lop ch1_lop.n53 6.3031
R9505 ch1_lop.n51 ch1_lop 6.3031
R9506 ch1_lop.n68 ch1_lop.n56 70.1096
R9507 ch1_lop.n56 ch1_lop.n55 70.1096
R9508 ch1_lop.n55 ch1_lop.n54 70.1096
R9509 ch1_lop.n54 ch1_lop.n52 70.1096
R9510 ch1_lop.n57 ch1_lop.n68 584.827
R9511 ch1_lop.n59 ch1_lop.n60 152
R9512 ch1_lop.n61 ch1_lop.n62 152
R9513 ch1_lop.n63 ch1_lop.n64 152
R9514 ch1_lop.n57 ch1_lop.n63 70.1096
R9515 ch1_lop.n63 ch1_lop.n61 70.1096
R9516 ch1_lop.n61 ch1_lop.n59 70.1096
R9517 ch1_lop.n59 ch1_lop.n58 70.1096
R9518 ch1_lop.n60 ch1_lop.n65 6.10787
R9519 ch1_lop.n62 ch1_lop.n66 9.3005
R9520 ch1_lop.n64 ch1_lop.n67 6.10787
R9521 ch1_lop.n57 ch1_lop.n67 158.304
R9522 ch1_lop.n64 ch1_lop.n62 36.1417
R9523 ch1_lop.n62 ch1_lop.n60 36.1417
R9524 ch1_lop.n65 ch1_lop.n58 158.304
R9525 ch1_lop.n67 ch1_lop.n66 1.92
R9526 ch1_lop.n66 ch1_lop.n65 1.92
R9527 ch1_lop.n63 ch1_lop.n56 584.827
R9528 ch1_lop.n61 ch1_lop.n55 584.827
R9529 ch1_lop.n59 ch1_lop.n54 584.827
R9530 ch1_lop.n58 ch1_lop.n52 584.827
R9531 ch1_lop.n53 ch1_lop 1.8738
R9532 ch1_lop.n31 ch1_lop 20.4653
R9533 ch1_lop ch1_lop.n31 9.3005
R9534 ch1_lop ch1_lop.n31 0.0466957
R9535 ch1_lop ch1_lop.n32 6.10787
R9536 ch1_lop.n31 ch1_lop.n32 1.92
R9537 ch1_lop.n33 ch1_lop 152
R9538 ch1_lop ch1_lop.n34 6.10787
R9539 ch1_lop.n35 ch1_lop 152
R9540 ch1_lop.n36 ch1_lop 152
R9541 ch1_lop.n37 ch1_lop 152
R9542 ch1_lop.n49 ch1_lop 152
R9543 ch1_lop ch1_lop.n34 6.3031
R9544 ch1_lop.n32 ch1_lop 6.3031
R9545 ch1_lop.n49 ch1_lop.n37 70.1096
R9546 ch1_lop.n37 ch1_lop.n36 70.1096
R9547 ch1_lop.n36 ch1_lop.n35 70.1096
R9548 ch1_lop.n35 ch1_lop.n33 70.1096
R9549 ch1_lop.n38 ch1_lop.n49 584.827
R9550 ch1_lop.n40 ch1_lop.n41 152
R9551 ch1_lop.n42 ch1_lop.n43 152
R9552 ch1_lop.n44 ch1_lop.n45 152
R9553 ch1_lop.n38 ch1_lop.n44 70.1096
R9554 ch1_lop.n44 ch1_lop.n42 70.1096
R9555 ch1_lop.n42 ch1_lop.n40 70.1096
R9556 ch1_lop.n40 ch1_lop.n39 70.1096
R9557 ch1_lop.n41 ch1_lop.n46 6.10787
R9558 ch1_lop.n43 ch1_lop.n47 9.3005
R9559 ch1_lop.n45 ch1_lop.n48 6.10787
R9560 ch1_lop.n38 ch1_lop.n48 158.304
R9561 ch1_lop.n45 ch1_lop.n43 36.1417
R9562 ch1_lop.n43 ch1_lop.n41 36.1417
R9563 ch1_lop.n46 ch1_lop.n39 158.304
R9564 ch1_lop.n48 ch1_lop.n47 1.92
R9565 ch1_lop.n47 ch1_lop.n46 1.92
R9566 ch1_lop.n44 ch1_lop.n37 584.827
R9567 ch1_lop.n42 ch1_lop.n36 584.827
R9568 ch1_lop.n40 ch1_lop.n35 584.827
R9569 ch1_lop.n39 ch1_lop.n33 584.827
R9570 ch1_lop.n34 ch1_lop 1.8738
R9571 ch1_lop.n26 ch1_lop.n27 3.4105
R9572 ch1_lop.n28 ch1_lop.n29 3.4105
R9573 ch1_lop.n25 ch1_lop.n27 3.5233
R9574 ch1_lop.n27 ch1_lop.n29 0.1133
R9575 ch1_lop.n29 ch1_lop.n30 4.92742
R9576 ch1_lop ch1_lop.n28 0.041125
R9577 ch1_lop ch1_lop.n28 7.14887
R9578 ch1_lop ch1_lop.n26 0.041125
R9579 ch1_lop ch1_lop.n26 7.14887
R9580 ch1_lop ch1_lop.n25 0.041125
R9581 ch1_lop ch1_lop.n25 7.14887
R9582 ch1_lop.n21 ch1_lop.n22 3.4105
R9583 ch1_lop.n23 ch1_lop.n24 3.4105
R9584 ch1_lop.n20 ch1_lop.n22 3.5233
R9585 ch1_lop.n22 ch1_lop.n24 0.1133
R9586 ch1_lop.n24 ch1_lop.n30 6.06071
R9587 ch1_lop ch1_lop.n23 0.041125
R9588 ch1_lop ch1_lop.n23 6.29199
R9589 ch1_lop ch1_lop.n21 0.041125
R9590 ch1_lop ch1_lop.n21 6.29199
R9591 ch1_lop ch1_lop.n20 0.041125
R9592 ch1_lop ch1_lop.n20 6.29199
R9593 ch1_lop.n0 ch1_lop.n1 15.6183
R9594 ch1_lop ch1_lop.n1 9.3005
R9595 ch1_lop ch1_lop.n1 0.0466957
R9596 ch1_lop ch1_lop.n2 6.10787
R9597 ch1_lop.n1 ch1_lop.n2 1.92
R9598 ch1_lop.n3 ch1_lop 152
R9599 ch1_lop ch1_lop.n4 6.10787
R9600 ch1_lop.n5 ch1_lop 152
R9601 ch1_lop.n6 ch1_lop 152
R9602 ch1_lop.n7 ch1_lop 152
R9603 ch1_lop.n19 ch1_lop 152
R9604 ch1_lop ch1_lop.n4 6.3031
R9605 ch1_lop.n2 ch1_lop 6.3031
R9606 ch1_lop.n19 ch1_lop.n7 70.1096
R9607 ch1_lop.n7 ch1_lop.n6 70.1096
R9608 ch1_lop.n6 ch1_lop.n5 70.1096
R9609 ch1_lop.n5 ch1_lop.n3 70.1096
R9610 ch1_lop.n8 ch1_lop.n19 584.827
R9611 ch1_lop.n10 ch1_lop.n11 152
R9612 ch1_lop.n12 ch1_lop.n13 152
R9613 ch1_lop.n14 ch1_lop.n15 152
R9614 ch1_lop.n8 ch1_lop.n14 70.1096
R9615 ch1_lop.n14 ch1_lop.n12 70.1096
R9616 ch1_lop.n12 ch1_lop.n10 70.1096
R9617 ch1_lop.n10 ch1_lop.n9 70.1096
R9618 ch1_lop.n11 ch1_lop.n16 6.10787
R9619 ch1_lop.n13 ch1_lop.n17 9.3005
R9620 ch1_lop.n15 ch1_lop.n18 6.10787
R9621 ch1_lop.n8 ch1_lop.n18 158.304
R9622 ch1_lop.n15 ch1_lop.n13 36.1417
R9623 ch1_lop.n13 ch1_lop.n11 36.1417
R9624 ch1_lop.n16 ch1_lop.n9 158.304
R9625 ch1_lop.n18 ch1_lop.n17 1.92
R9626 ch1_lop.n17 ch1_lop.n16 1.92
R9627 ch1_lop.n14 ch1_lop.n7 584.827
R9628 ch1_lop.n12 ch1_lop.n6 584.827
R9629 ch1_lop.n10 ch1_lop.n5 584.827
R9630 ch1_lop.n9 ch1_lop.n3 584.827
R9631 ch1_lop.n4 ch1_lop 1.8738
R9632 ch2_lon_raw ch2_lon_raw.n50 4.6505
R9633 ch2_lon_raw ch2_lon_raw.n50 0.0226354
R9634 ch2_lon_raw.n1 ch2_lon_raw.n50 5.04235
R9635 ch2_lon_raw.n49 ch2_lon_raw.n1 5.04335
R9636 ch2_lon_raw ch2_lon_raw.n49 4.6505
R9637 ch2_lon_raw ch2_lon_raw.n49 0.0226354
R9638 ch2_lon_raw.n1 ch2_lon_raw.n48 7.97082
R9639 ch2_lon_raw.n48 ch2_lon_raw 0.353
R9640 ch2_lon_raw ch2_lon_raw.n4 0.593288
R9641 ch2_lon_raw.n48 ch2_lon_raw.n9 13.4607
R9642 ch2_lon_raw.n9 ch2_lon_raw.n29 17.9635
R9643 ch2_lon_raw ch2_lon_raw.n29 9.3005
R9644 ch2_lon_raw ch2_lon_raw.n29 0.0466957
R9645 ch2_lon_raw ch2_lon_raw.n30 6.10787
R9646 ch2_lon_raw.n29 ch2_lon_raw.n30 1.92
R9647 ch2_lon_raw.n31 ch2_lon_raw 152
R9648 ch2_lon_raw ch2_lon_raw.n32 6.10787
R9649 ch2_lon_raw.n33 ch2_lon_raw 152
R9650 ch2_lon_raw.n34 ch2_lon_raw 152
R9651 ch2_lon_raw.n35 ch2_lon_raw 152
R9652 ch2_lon_raw.n47 ch2_lon_raw 152
R9653 ch2_lon_raw ch2_lon_raw.n32 6.3031
R9654 ch2_lon_raw.n30 ch2_lon_raw 6.3031
R9655 ch2_lon_raw.n31 ch2_lon_raw.n33 70.1096
R9656 ch2_lon_raw.n33 ch2_lon_raw.n34 70.1096
R9657 ch2_lon_raw.n34 ch2_lon_raw.n35 70.1096
R9658 ch2_lon_raw.n35 ch2_lon_raw.n47 70.1096
R9659 ch2_lon_raw.n36 ch2_lon_raw.n47 1127.88
R9660 ch2_lon_raw.n37 ch2_lon_raw.n38 152
R9661 ch2_lon_raw.n39 ch2_lon_raw.n40 152
R9662 ch2_lon_raw.n41 ch2_lon_raw.n42 152
R9663 ch2_lon_raw.n43 ch2_lon_raw.n41 70.1096
R9664 ch2_lon_raw.n41 ch2_lon_raw.n39 70.1096
R9665 ch2_lon_raw.n39 ch2_lon_raw.n37 70.1096
R9666 ch2_lon_raw.n37 ch2_lon_raw.n36 70.1096
R9667 ch2_lon_raw.n38 ch2_lon_raw.n44 6.10787
R9668 ch2_lon_raw.n40 ch2_lon_raw.n45 9.3005
R9669 ch2_lon_raw.n42 ch2_lon_raw.n46 6.10787
R9670 ch2_lon_raw.n43 ch2_lon_raw.n46 158.304
R9671 ch2_lon_raw.n42 ch2_lon_raw.n40 36.1417
R9672 ch2_lon_raw.n40 ch2_lon_raw.n38 36.1417
R9673 ch2_lon_raw.n44 ch2_lon_raw.n36 158.304
R9674 ch2_lon_raw.n46 ch2_lon_raw.n45 1.92
R9675 ch2_lon_raw.n45 ch2_lon_raw.n44 1.92
R9676 ch2_lon_raw.n43 ch2_lon_raw.n31 1127.88
R9677 ch2_lon_raw.n41 ch2_lon_raw.n33 1127.88
R9678 ch2_lon_raw.n39 ch2_lon_raw.n34 1127.88
R9679 ch2_lon_raw.n37 ch2_lon_raw.n35 1127.88
R9680 ch2_lon_raw.n32 ch2_lon_raw 1.8738
R9681 ch2_lon_raw.n9 ch2_lon_raw.n10 16.0707
R9682 ch2_lon_raw ch2_lon_raw.n10 9.3005
R9683 ch2_lon_raw ch2_lon_raw.n10 0.0466957
R9684 ch2_lon_raw ch2_lon_raw.n11 6.10787
R9685 ch2_lon_raw.n10 ch2_lon_raw.n11 1.92
R9686 ch2_lon_raw.n12 ch2_lon_raw 152
R9687 ch2_lon_raw ch2_lon_raw.n13 6.10787
R9688 ch2_lon_raw.n14 ch2_lon_raw 152
R9689 ch2_lon_raw.n15 ch2_lon_raw 152
R9690 ch2_lon_raw.n16 ch2_lon_raw 152
R9691 ch2_lon_raw.n28 ch2_lon_raw 152
R9692 ch2_lon_raw ch2_lon_raw.n13 6.3031
R9693 ch2_lon_raw.n11 ch2_lon_raw 6.3031
R9694 ch2_lon_raw.n28 ch2_lon_raw.n16 70.1096
R9695 ch2_lon_raw.n16 ch2_lon_raw.n15 70.1096
R9696 ch2_lon_raw.n15 ch2_lon_raw.n14 70.1096
R9697 ch2_lon_raw.n14 ch2_lon_raw.n12 70.1096
R9698 ch2_lon_raw.n17 ch2_lon_raw.n28 584.827
R9699 ch2_lon_raw.n19 ch2_lon_raw.n20 152
R9700 ch2_lon_raw.n21 ch2_lon_raw.n22 152
R9701 ch2_lon_raw.n23 ch2_lon_raw.n24 152
R9702 ch2_lon_raw.n17 ch2_lon_raw.n23 70.1096
R9703 ch2_lon_raw.n23 ch2_lon_raw.n21 70.1096
R9704 ch2_lon_raw.n21 ch2_lon_raw.n19 70.1096
R9705 ch2_lon_raw.n19 ch2_lon_raw.n18 70.1096
R9706 ch2_lon_raw.n20 ch2_lon_raw.n25 6.10787
R9707 ch2_lon_raw.n22 ch2_lon_raw.n26 9.3005
R9708 ch2_lon_raw.n24 ch2_lon_raw.n27 6.10787
R9709 ch2_lon_raw.n17 ch2_lon_raw.n27 158.304
R9710 ch2_lon_raw.n24 ch2_lon_raw.n22 36.1417
R9711 ch2_lon_raw.n22 ch2_lon_raw.n20 36.1417
R9712 ch2_lon_raw.n25 ch2_lon_raw.n18 158.304
R9713 ch2_lon_raw.n27 ch2_lon_raw.n26 1.92
R9714 ch2_lon_raw.n26 ch2_lon_raw.n25 1.92
R9715 ch2_lon_raw.n23 ch2_lon_raw.n16 584.827
R9716 ch2_lon_raw.n21 ch2_lon_raw.n15 584.827
R9717 ch2_lon_raw.n19 ch2_lon_raw.n14 584.827
R9718 ch2_lon_raw.n18 ch2_lon_raw.n12 584.827
R9719 ch2_lon_raw.n13 ch2_lon_raw 1.8738
R9720 ch2_lon_raw ch2_lon_raw.n6 17.6367
R9721 ch2_lon_raw.n6 ch2_lon_raw.n8 5.04335
R9722 ch2_lon_raw ch2_lon_raw.n8 4.6505
R9723 ch2_lon_raw ch2_lon_raw.n8 0.0226354
R9724 ch2_lon_raw.n6 ch2_lon_raw.n7 5.04335
R9725 ch2_lon_raw ch2_lon_raw.n7 4.6505
R9726 ch2_lon_raw ch2_lon_raw.n7 0.0226354
R9727 ch2_lon_raw.n6 ch2_lon_raw.n5 4.65675
R9728 ch2_lon_raw ch2_lon_raw.n5 4.6505
R9729 ch2_lon_raw ch2_lon_raw.n5 0.0226354
R9730 ch2_lon_raw.n3 ch2_lon_raw.n4 7.97082
R9731 ch2_lon_raw.n3 ch2_lon_raw 5.04335
R9732 ch2_lon_raw.n3 ch2_lon_raw 5.04335
R9733 ch2_lon_raw.n3 ch2_lon_raw 4.65675
R9734 ch2_lon_raw.n4 ch2_lon_raw.n2 18.1654
R9735 ch2_lon_raw.n2 ch2_lon_raw 5.04335
R9736 ch2_lon_raw.n2 ch2_lon_raw 5.04335
R9737 ch2_lon_raw.n2 ch2_lon_raw 4.65675
R9738 ch2_lon_raw.n1 ch2_lon_raw.n0 4.65675
R9739 ch2_lon_raw ch2_lon_raw.n0 4.6505
R9740 ch2_lon_raw ch2_lon_raw.n0 0.0226354
R9741 ch2_lop_raw ch2_lop_raw.n51 4.6505
R9742 ch2_lop_raw ch2_lop_raw.n51 0.0226354
R9743 ch2_lop_raw.n1 ch2_lop_raw.n51 5.04235
R9744 ch2_lop_raw.n50 ch2_lop_raw.n1 5.04335
R9745 ch2_lop_raw ch2_lop_raw.n50 4.6505
R9746 ch2_lop_raw ch2_lop_raw.n50 0.0226354
R9747 ch2_lop_raw.n1 ch2_lop_raw.n49 19.0326
R9748 ch2_lop_raw.n49 ch2_lop_raw.n44 0.945787
R9749 ch2_lop_raw.n44 ch2_lop_raw 0.088625
R9750 ch2_lop_raw ch2_lop_raw.n42 3.41696
R9751 ch2_lop_raw.n49 ch2_lop_raw.n46 7.45383
R9752 ch2_lop_raw.n46 ch2_lop_raw.n48 5.04335
R9753 ch2_lop_raw ch2_lop_raw.n48 4.6505
R9754 ch2_lop_raw ch2_lop_raw.n48 0.0226354
R9755 ch2_lop_raw.n46 ch2_lop_raw.n47 5.04335
R9756 ch2_lop_raw ch2_lop_raw.n47 4.6505
R9757 ch2_lop_raw ch2_lop_raw.n47 0.0226354
R9758 ch2_lop_raw.n46 ch2_lop_raw.n45 4.65675
R9759 ch2_lop_raw ch2_lop_raw.n45 4.6505
R9760 ch2_lop_raw ch2_lop_raw.n45 0.0226354
R9761 ch2_lop_raw.n44 ch2_lop_raw.n43 7.45383
R9762 ch2_lop_raw.n43 ch2_lop_raw 5.04335
R9763 ch2_lop_raw.n43 ch2_lop_raw 5.04335
R9764 ch2_lop_raw.n43 ch2_lop_raw 4.65675
R9765 ch2_lop_raw.n42 ch2_lop_raw.n3 6.45172
R9766 ch2_lop_raw.n3 ch2_lop_raw.n23 16.2539
R9767 ch2_lop_raw ch2_lop_raw.n23 9.3005
R9768 ch2_lop_raw ch2_lop_raw.n23 0.0466957
R9769 ch2_lop_raw ch2_lop_raw.n24 6.10787
R9770 ch2_lop_raw.n23 ch2_lop_raw.n24 1.92
R9771 ch2_lop_raw.n25 ch2_lop_raw 152
R9772 ch2_lop_raw ch2_lop_raw.n26 6.10787
R9773 ch2_lop_raw.n27 ch2_lop_raw 152
R9774 ch2_lop_raw.n28 ch2_lop_raw 152
R9775 ch2_lop_raw.n29 ch2_lop_raw 152
R9776 ch2_lop_raw.n41 ch2_lop_raw 152
R9777 ch2_lop_raw ch2_lop_raw.n26 6.3031
R9778 ch2_lop_raw.n24 ch2_lop_raw 6.3031
R9779 ch2_lop_raw.n41 ch2_lop_raw.n29 70.1096
R9780 ch2_lop_raw.n29 ch2_lop_raw.n28 70.1096
R9781 ch2_lop_raw.n28 ch2_lop_raw.n27 70.1096
R9782 ch2_lop_raw.n27 ch2_lop_raw.n25 70.1096
R9783 ch2_lop_raw.n30 ch2_lop_raw.n41 584.827
R9784 ch2_lop_raw.n32 ch2_lop_raw.n33 152
R9785 ch2_lop_raw.n34 ch2_lop_raw.n35 152
R9786 ch2_lop_raw.n36 ch2_lop_raw.n37 152
R9787 ch2_lop_raw.n30 ch2_lop_raw.n36 70.1096
R9788 ch2_lop_raw.n36 ch2_lop_raw.n34 70.1096
R9789 ch2_lop_raw.n34 ch2_lop_raw.n32 70.1096
R9790 ch2_lop_raw.n32 ch2_lop_raw.n31 70.1096
R9791 ch2_lop_raw.n33 ch2_lop_raw.n38 6.10787
R9792 ch2_lop_raw.n35 ch2_lop_raw.n39 9.3005
R9793 ch2_lop_raw.n37 ch2_lop_raw.n40 6.10787
R9794 ch2_lop_raw.n30 ch2_lop_raw.n40 158.304
R9795 ch2_lop_raw.n37 ch2_lop_raw.n35 36.1417
R9796 ch2_lop_raw.n35 ch2_lop_raw.n33 36.1417
R9797 ch2_lop_raw.n38 ch2_lop_raw.n31 158.304
R9798 ch2_lop_raw.n40 ch2_lop_raw.n39 1.92
R9799 ch2_lop_raw.n39 ch2_lop_raw.n38 1.92
R9800 ch2_lop_raw.n36 ch2_lop_raw.n29 584.827
R9801 ch2_lop_raw.n34 ch2_lop_raw.n28 584.827
R9802 ch2_lop_raw.n32 ch2_lop_raw.n27 584.827
R9803 ch2_lop_raw.n31 ch2_lop_raw.n25 584.827
R9804 ch2_lop_raw.n26 ch2_lop_raw 1.8738
R9805 ch2_lop_raw.n4 ch2_lop_raw.n3 15.8063
R9806 ch2_lop_raw ch2_lop_raw.n4 9.3005
R9807 ch2_lop_raw ch2_lop_raw.n4 0.0466957
R9808 ch2_lop_raw ch2_lop_raw.n5 6.10787
R9809 ch2_lop_raw.n4 ch2_lop_raw.n5 1.92
R9810 ch2_lop_raw.n6 ch2_lop_raw 152
R9811 ch2_lop_raw ch2_lop_raw.n7 6.10787
R9812 ch2_lop_raw.n8 ch2_lop_raw 152
R9813 ch2_lop_raw.n9 ch2_lop_raw 152
R9814 ch2_lop_raw.n10 ch2_lop_raw 152
R9815 ch2_lop_raw.n22 ch2_lop_raw 152
R9816 ch2_lop_raw ch2_lop_raw.n7 6.3031
R9817 ch2_lop_raw.n5 ch2_lop_raw 6.3031
R9818 ch2_lop_raw.n6 ch2_lop_raw.n8 70.1096
R9819 ch2_lop_raw.n8 ch2_lop_raw.n9 70.1096
R9820 ch2_lop_raw.n9 ch2_lop_raw.n10 70.1096
R9821 ch2_lop_raw.n10 ch2_lop_raw.n22 70.1096
R9822 ch2_lop_raw.n11 ch2_lop_raw.n22 1127.88
R9823 ch2_lop_raw.n12 ch2_lop_raw.n13 152
R9824 ch2_lop_raw.n14 ch2_lop_raw.n15 152
R9825 ch2_lop_raw.n16 ch2_lop_raw.n17 152
R9826 ch2_lop_raw.n18 ch2_lop_raw.n16 70.1096
R9827 ch2_lop_raw.n16 ch2_lop_raw.n14 70.1096
R9828 ch2_lop_raw.n14 ch2_lop_raw.n12 70.1096
R9829 ch2_lop_raw.n12 ch2_lop_raw.n11 70.1096
R9830 ch2_lop_raw.n13 ch2_lop_raw.n19 6.10787
R9831 ch2_lop_raw.n15 ch2_lop_raw.n20 9.3005
R9832 ch2_lop_raw.n17 ch2_lop_raw.n21 6.10787
R9833 ch2_lop_raw.n18 ch2_lop_raw.n21 158.304
R9834 ch2_lop_raw.n17 ch2_lop_raw.n15 36.1417
R9835 ch2_lop_raw.n15 ch2_lop_raw.n13 36.1417
R9836 ch2_lop_raw.n19 ch2_lop_raw.n11 158.304
R9837 ch2_lop_raw.n21 ch2_lop_raw.n20 1.92
R9838 ch2_lop_raw.n20 ch2_lop_raw.n19 1.92
R9839 ch2_lop_raw.n18 ch2_lop_raw.n6 1127.88
R9840 ch2_lop_raw.n16 ch2_lop_raw.n8 1127.88
R9841 ch2_lop_raw.n14 ch2_lop_raw.n9 1127.88
R9842 ch2_lop_raw.n12 ch2_lop_raw.n10 1127.88
R9843 ch2_lop_raw.n7 ch2_lop_raw 1.8738
R9844 ch2_lop_raw.n2 ch2_lop_raw.n42 15.1741
R9845 ch2_lop_raw.n2 ch2_lop_raw 5.04335
R9846 ch2_lop_raw.n2 ch2_lop_raw 5.04335
R9847 ch2_lop_raw.n2 ch2_lop_raw 4.65675
R9848 ch2_lop_raw.n1 ch2_lop_raw.n0 4.65675
R9849 ch2_lop_raw ch2_lop_raw.n0 4.6505
R9850 ch2_lop_raw ch2_lop_raw.n0 0.0226354
R9851 ch1_lon_raw ch1_lon_raw.n47 4.6505
R9852 ch1_lon_raw ch1_lon_raw.n47 0.0226354
R9853 ch1_lon_raw.n1 ch1_lon_raw.n47 5.04235
R9854 ch1_lon_raw.n46 ch1_lon_raw.n1 5.04335
R9855 ch1_lon_raw ch1_lon_raw.n46 4.6505
R9856 ch1_lon_raw ch1_lon_raw.n46 0.0226354
R9857 ch1_lon_raw.n1 ch1_lon_raw.n45 7.31283
R9858 ch1_lon_raw.n45 ch1_lon_raw 0.945787
R9859 ch1_lon_raw.n45 ch1_lon_raw.n26 28.7085
R9860 ch1_lon_raw ch1_lon_raw.n26 9.3005
R9861 ch1_lon_raw ch1_lon_raw.n26 0.0466957
R9862 ch1_lon_raw ch1_lon_raw.n27 6.10787
R9863 ch1_lon_raw.n26 ch1_lon_raw.n27 1.92
R9864 ch1_lon_raw.n28 ch1_lon_raw 152
R9865 ch1_lon_raw ch1_lon_raw.n29 6.10787
R9866 ch1_lon_raw.n30 ch1_lon_raw 152
R9867 ch1_lon_raw.n31 ch1_lon_raw 152
R9868 ch1_lon_raw.n32 ch1_lon_raw 152
R9869 ch1_lon_raw.n44 ch1_lon_raw 152
R9870 ch1_lon_raw ch1_lon_raw.n29 6.3031
R9871 ch1_lon_raw.n27 ch1_lon_raw 6.3031
R9872 ch1_lon_raw.n28 ch1_lon_raw.n30 70.1096
R9873 ch1_lon_raw.n30 ch1_lon_raw.n31 70.1096
R9874 ch1_lon_raw.n31 ch1_lon_raw.n32 70.1096
R9875 ch1_lon_raw.n32 ch1_lon_raw.n44 70.1096
R9876 ch1_lon_raw.n33 ch1_lon_raw.n44 1127.88
R9877 ch1_lon_raw.n34 ch1_lon_raw.n35 152
R9878 ch1_lon_raw.n36 ch1_lon_raw.n37 152
R9879 ch1_lon_raw.n38 ch1_lon_raw.n39 152
R9880 ch1_lon_raw.n40 ch1_lon_raw.n38 70.1096
R9881 ch1_lon_raw.n38 ch1_lon_raw.n36 70.1096
R9882 ch1_lon_raw.n36 ch1_lon_raw.n34 70.1096
R9883 ch1_lon_raw.n34 ch1_lon_raw.n33 70.1096
R9884 ch1_lon_raw.n35 ch1_lon_raw.n41 6.10787
R9885 ch1_lon_raw.n37 ch1_lon_raw.n42 9.3005
R9886 ch1_lon_raw.n39 ch1_lon_raw.n43 6.10787
R9887 ch1_lon_raw.n40 ch1_lon_raw.n43 158.304
R9888 ch1_lon_raw.n39 ch1_lon_raw.n37 36.1417
R9889 ch1_lon_raw.n37 ch1_lon_raw.n35 36.1417
R9890 ch1_lon_raw.n41 ch1_lon_raw.n33 158.304
R9891 ch1_lon_raw.n43 ch1_lon_raw.n42 1.92
R9892 ch1_lon_raw.n42 ch1_lon_raw.n41 1.92
R9893 ch1_lon_raw.n40 ch1_lon_raw.n28 1127.88
R9894 ch1_lon_raw.n38 ch1_lon_raw.n30 1127.88
R9895 ch1_lon_raw.n36 ch1_lon_raw.n31 1127.88
R9896 ch1_lon_raw.n34 ch1_lon_raw.n32 1127.88
R9897 ch1_lon_raw.n29 ch1_lon_raw 1.8738
R9898 ch1_lon_raw.n21 ch1_lon_raw 7.31283
R9899 ch1_lon_raw.n21 ch1_lon_raw.n25 0.328625
R9900 ch1_lon_raw.n25 ch1_lon_raw 0.141125
R9901 ch1_lon_raw ch1_lon_raw.n24 0.03175
R9902 ch1_lon_raw.n25 ch1_lon_raw 0.234875
R9903 ch1_lon_raw ch1_lon_raw.n24 0.03175
R9904 ch1_lon_raw.n24 ch1_lon_raw 7.19574
R9905 ch1_lon_raw.n23 ch1_lon_raw.n21 0.328625
R9906 ch1_lon_raw.n23 ch1_lon_raw.n22 0.172375
R9907 ch1_lon_raw.n23 ch1_lon_raw 0.234875
R9908 ch1_lon_raw ch1_lon_raw.n22 0.03175
R9909 ch1_lon_raw.n22 ch1_lon_raw 7.19574
R9910 ch1_lon_raw.n21 ch1_lon_raw 0.0551875
R9911 ch1_lon_raw.n2 ch1_lon_raw 24.8962
R9912 ch1_lon_raw ch1_lon_raw.n2 9.3005
R9913 ch1_lon_raw ch1_lon_raw.n2 0.0466957
R9914 ch1_lon_raw ch1_lon_raw.n3 6.10787
R9915 ch1_lon_raw.n2 ch1_lon_raw.n3 1.92
R9916 ch1_lon_raw.n4 ch1_lon_raw 152
R9917 ch1_lon_raw ch1_lon_raw.n5 6.10787
R9918 ch1_lon_raw.n6 ch1_lon_raw 152
R9919 ch1_lon_raw.n7 ch1_lon_raw 152
R9920 ch1_lon_raw.n8 ch1_lon_raw 152
R9921 ch1_lon_raw.n20 ch1_lon_raw 152
R9922 ch1_lon_raw ch1_lon_raw.n5 6.3031
R9923 ch1_lon_raw.n3 ch1_lon_raw 6.3031
R9924 ch1_lon_raw.n20 ch1_lon_raw.n8 70.1096
R9925 ch1_lon_raw.n8 ch1_lon_raw.n7 70.1096
R9926 ch1_lon_raw.n7 ch1_lon_raw.n6 70.1096
R9927 ch1_lon_raw.n6 ch1_lon_raw.n4 70.1096
R9928 ch1_lon_raw.n9 ch1_lon_raw.n20 584.827
R9929 ch1_lon_raw.n11 ch1_lon_raw.n12 152
R9930 ch1_lon_raw.n13 ch1_lon_raw.n14 152
R9931 ch1_lon_raw.n15 ch1_lon_raw.n16 152
R9932 ch1_lon_raw.n9 ch1_lon_raw.n15 70.1096
R9933 ch1_lon_raw.n15 ch1_lon_raw.n13 70.1096
R9934 ch1_lon_raw.n13 ch1_lon_raw.n11 70.1096
R9935 ch1_lon_raw.n11 ch1_lon_raw.n10 70.1096
R9936 ch1_lon_raw.n12 ch1_lon_raw.n17 6.10787
R9937 ch1_lon_raw.n14 ch1_lon_raw.n18 9.3005
R9938 ch1_lon_raw.n16 ch1_lon_raw.n19 6.10787
R9939 ch1_lon_raw.n9 ch1_lon_raw.n19 158.304
R9940 ch1_lon_raw.n16 ch1_lon_raw.n14 36.1417
R9941 ch1_lon_raw.n14 ch1_lon_raw.n12 36.1417
R9942 ch1_lon_raw.n17 ch1_lon_raw.n10 158.304
R9943 ch1_lon_raw.n19 ch1_lon_raw.n18 1.92
R9944 ch1_lon_raw.n18 ch1_lon_raw.n17 1.92
R9945 ch1_lon_raw.n15 ch1_lon_raw.n8 584.827
R9946 ch1_lon_raw.n13 ch1_lon_raw.n7 584.827
R9947 ch1_lon_raw.n11 ch1_lon_raw.n6 584.827
R9948 ch1_lon_raw.n10 ch1_lon_raw.n4 584.827
R9949 ch1_lon_raw.n5 ch1_lon_raw 1.8738
R9950 ch1_lon_raw.n1 ch1_lon_raw.n0 4.65675
R9951 ch1_lon_raw ch1_lon_raw.n0 4.6505
R9952 ch1_lon_raw ch1_lon_raw.n0 0.0226354
R9953 ch1_lop_raw ch1_lop_raw.n47 4.6505
R9954 ch1_lop_raw ch1_lop_raw.n47 0.0226354
R9955 ch1_lop_raw.n1 ch1_lop_raw.n47 5.04235
R9956 ch1_lop_raw.n46 ch1_lop_raw.n1 5.04335
R9957 ch1_lop_raw ch1_lop_raw.n46 4.6505
R9958 ch1_lop_raw ch1_lop_raw.n46 0.0226354
R9959 ch1_lop_raw.n1 ch1_lop_raw.n45 8.30511
R9960 ch1_lop_raw.n45 ch1_lop_raw 0.946375
R9961 ch1_lop_raw.n45 ch1_lop_raw.n40 7.35983
R9962 ch1_lop_raw.n40 ch1_lop_raw.n44 0.328625
R9963 ch1_lop_raw.n44 ch1_lop_raw 0.141125
R9964 ch1_lop_raw ch1_lop_raw.n43 0.03175
R9965 ch1_lop_raw.n44 ch1_lop_raw 0.234875
R9966 ch1_lop_raw ch1_lop_raw.n43 0.03175
R9967 ch1_lop_raw.n43 ch1_lop_raw 7.19574
R9968 ch1_lop_raw.n40 ch1_lop_raw.n42 0.328625
R9969 ch1_lop_raw.n42 ch1_lop_raw 0.141125
R9970 ch1_lop_raw ch1_lop_raw.n41 0.03175
R9971 ch1_lop_raw.n42 ch1_lop_raw 0.234875
R9972 ch1_lop_raw ch1_lop_raw.n41 0.03175
R9973 ch1_lop_raw.n41 ch1_lop_raw 7.19574
R9974 ch1_lop_raw.n40 ch1_lop_raw 0.0551875
R9975 ch1_lop_raw.n21 ch1_lop_raw 25.6999
R9976 ch1_lop_raw ch1_lop_raw.n21 9.3005
R9977 ch1_lop_raw ch1_lop_raw.n21 0.0466957
R9978 ch1_lop_raw ch1_lop_raw.n22 6.10787
R9979 ch1_lop_raw.n21 ch1_lop_raw.n22 1.92
R9980 ch1_lop_raw.n23 ch1_lop_raw 152
R9981 ch1_lop_raw ch1_lop_raw.n24 6.10787
R9982 ch1_lop_raw.n25 ch1_lop_raw 152
R9983 ch1_lop_raw.n26 ch1_lop_raw 152
R9984 ch1_lop_raw.n27 ch1_lop_raw 152
R9985 ch1_lop_raw.n39 ch1_lop_raw 152
R9986 ch1_lop_raw ch1_lop_raw.n24 6.3031
R9987 ch1_lop_raw.n22 ch1_lop_raw 6.3031
R9988 ch1_lop_raw.n23 ch1_lop_raw.n25 70.1096
R9989 ch1_lop_raw.n25 ch1_lop_raw.n26 70.1096
R9990 ch1_lop_raw.n26 ch1_lop_raw.n27 70.1096
R9991 ch1_lop_raw.n27 ch1_lop_raw.n39 70.1096
R9992 ch1_lop_raw.n28 ch1_lop_raw.n39 1127.88
R9993 ch1_lop_raw.n29 ch1_lop_raw.n30 152
R9994 ch1_lop_raw.n31 ch1_lop_raw.n32 152
R9995 ch1_lop_raw.n33 ch1_lop_raw.n34 152
R9996 ch1_lop_raw.n35 ch1_lop_raw.n33 70.1096
R9997 ch1_lop_raw.n33 ch1_lop_raw.n31 70.1096
R9998 ch1_lop_raw.n31 ch1_lop_raw.n29 70.1096
R9999 ch1_lop_raw.n29 ch1_lop_raw.n28 70.1096
R10000 ch1_lop_raw.n30 ch1_lop_raw.n36 6.10787
R10001 ch1_lop_raw.n32 ch1_lop_raw.n37 9.3005
R10002 ch1_lop_raw.n34 ch1_lop_raw.n38 6.10787
R10003 ch1_lop_raw.n35 ch1_lop_raw.n38 158.304
R10004 ch1_lop_raw.n34 ch1_lop_raw.n32 36.1417
R10005 ch1_lop_raw.n32 ch1_lop_raw.n30 36.1417
R10006 ch1_lop_raw.n36 ch1_lop_raw.n28 158.304
R10007 ch1_lop_raw.n38 ch1_lop_raw.n37 1.92
R10008 ch1_lop_raw.n37 ch1_lop_raw.n36 1.92
R10009 ch1_lop_raw.n35 ch1_lop_raw.n23 1127.88
R10010 ch1_lop_raw.n33 ch1_lop_raw.n25 1127.88
R10011 ch1_lop_raw.n31 ch1_lop_raw.n26 1127.88
R10012 ch1_lop_raw.n29 ch1_lop_raw.n27 1127.88
R10013 ch1_lop_raw.n24 ch1_lop_raw 1.8738
R10014 ch1_lop_raw.n2 ch1_lop_raw 24.3734
R10015 ch1_lop_raw ch1_lop_raw.n2 9.3005
R10016 ch1_lop_raw ch1_lop_raw.n2 0.0466957
R10017 ch1_lop_raw ch1_lop_raw.n3 6.10787
R10018 ch1_lop_raw.n2 ch1_lop_raw.n3 1.92
R10019 ch1_lop_raw.n4 ch1_lop_raw 152
R10020 ch1_lop_raw ch1_lop_raw.n5 6.10787
R10021 ch1_lop_raw.n6 ch1_lop_raw 152
R10022 ch1_lop_raw.n7 ch1_lop_raw 152
R10023 ch1_lop_raw.n8 ch1_lop_raw 152
R10024 ch1_lop_raw.n20 ch1_lop_raw 152
R10025 ch1_lop_raw ch1_lop_raw.n5 6.3031
R10026 ch1_lop_raw.n3 ch1_lop_raw 6.3031
R10027 ch1_lop_raw.n20 ch1_lop_raw.n8 70.1096
R10028 ch1_lop_raw.n8 ch1_lop_raw.n7 70.1096
R10029 ch1_lop_raw.n7 ch1_lop_raw.n6 70.1096
R10030 ch1_lop_raw.n6 ch1_lop_raw.n4 70.1096
R10031 ch1_lop_raw.n9 ch1_lop_raw.n20 584.827
R10032 ch1_lop_raw.n11 ch1_lop_raw.n12 152
R10033 ch1_lop_raw.n13 ch1_lop_raw.n14 152
R10034 ch1_lop_raw.n15 ch1_lop_raw.n16 152
R10035 ch1_lop_raw.n9 ch1_lop_raw.n15 70.1096
R10036 ch1_lop_raw.n15 ch1_lop_raw.n13 70.1096
R10037 ch1_lop_raw.n13 ch1_lop_raw.n11 70.1096
R10038 ch1_lop_raw.n11 ch1_lop_raw.n10 70.1096
R10039 ch1_lop_raw.n12 ch1_lop_raw.n17 6.10787
R10040 ch1_lop_raw.n14 ch1_lop_raw.n18 9.3005
R10041 ch1_lop_raw.n16 ch1_lop_raw.n19 6.10787
R10042 ch1_lop_raw.n9 ch1_lop_raw.n19 158.304
R10043 ch1_lop_raw.n16 ch1_lop_raw.n14 36.1417
R10044 ch1_lop_raw.n14 ch1_lop_raw.n12 36.1417
R10045 ch1_lop_raw.n17 ch1_lop_raw.n10 158.304
R10046 ch1_lop_raw.n19 ch1_lop_raw.n18 1.92
R10047 ch1_lop_raw.n18 ch1_lop_raw.n17 1.92
R10048 ch1_lop_raw.n15 ch1_lop_raw.n8 584.827
R10049 ch1_lop_raw.n13 ch1_lop_raw.n7 584.827
R10050 ch1_lop_raw.n11 ch1_lop_raw.n6 584.827
R10051 ch1_lop_raw.n10 ch1_lop_raw.n4 584.827
R10052 ch1_lop_raw.n5 ch1_lop_raw 1.8738
R10053 ch1_lop_raw.n1 ch1_lop_raw.n0 4.65675
R10054 ch1_lop_raw ch1_lop_raw.n0 4.6505
R10055 ch1_lop_raw ch1_lop_raw.n0 0.0226354
R10056 w_200_0.n0 w_200_0.n1 41.7862
R10057 w_200_0.n1 w_200_0.n2 41.7862
R10058 w_200_0.n3 w_200_0.n4 73.1255
R10059 w_200_0.n4 w_200_0.n5 73.1255
R10060 w_200_0.n6 w_200_0.n7 41.7862
R10061 w_200_0.n7 VGND 41.7862
R10062 w_200_0.n3 w_200_0.n8 73.1255
R10063 w_200_0.n8 w_200_0.n9 73.1255
R10064 w_200_0.n10 w_200_0.n11 117.001
R10065 w_200_0.n11 w_200_0.n12 117.001
R10066 w_200_0.n13 w_200_0.n14 117.001
R10067 w_200_0.n14 w_200_0.n15 117.001
R10068 w_200_0.n6 w_200_0.n16 117.001
R10069 w_200_0.n16 VGND 117.001
R10070 w_200_0.n13 w_200_0.n17 117.001
R10071 w_200_0.n17 w_200_0.n18 117.001
R10072 w_200_0.n0 w_200_0.n19 41.7862
R10073 w_200_0.n19 w_200_0.n20 41.7862
R10074 w_200_0.n3 w_200_0.n21 73.1255
R10075 w_200_0.n21 w_200_0.n22 73.1255
R10076 w_200_0.n6 w_200_0.n23 41.7862
R10077 w_200_0.n23 VGND 41.7862
R10078 w_200_0.n3 w_200_0.n24 73.1255
R10079 w_200_0.n24 w_200_0.n25 73.1255
R10080 w_200_0.n10 w_200_0.n26 117.001
R10081 w_200_0.n26 w_200_0.n27 117.001
R10082 w_200_0.n13 w_200_0.n28 117.001
R10083 w_200_0.n28 w_200_0.n29 117.001
R10084 w_200_0.n6 w_200_0.n30 117.001
R10085 w_200_0.n30 VGND 117.001
R10086 w_200_0.n13 w_200_0.n31 117.001
R10087 w_200_0.n31 w_200_0.n32 117.001
R10088 w_200_0.n10 w_200_0.n33 73.1255
R10089 w_200_0.n33 w_200_0.n34 73.1255
R10090 w_200_0.n13 w_200_0.n35 117.001
R10091 w_200_0.n35 w_200_0.n36 117.001
R10092 w_200_0.n6 w_200_0.n37 73.1255
R10093 w_200_0.n37 VGND 73.1255
R10094 w_200_0.n13 w_200_0.n38 117.001
R10095 w_200_0.n38 w_200_0.n39 117.001
R10096 w_200_0.n10 w_200_0.n40 117.001
R10097 w_200_0.n40 w_200_0.n41 117.001
R10098 w_200_0.n13 w_200_0.n42 117.001
R10099 w_200_0.n42 w_200_0.n43 117.001
R10100 w_200_0.n6 w_200_0.n44 117.001
R10101 w_200_0.n44 VGND 117.001
R10102 w_200_0.n13 w_200_0.n45 117.001
R10103 w_200_0.n45 w_200_0.n46 117.001
R10104 w_200_0.n10 w_200_0.n47 73.1255
R10105 w_200_0.n47 w_200_0.n48 73.1255
R10106 w_200_0.n13 w_200_0.n49 117.001
R10107 w_200_0.n49 w_200_0.n50 117.001
R10108 w_200_0.n6 w_200_0.n51 73.1255
R10109 w_200_0.n51 VGND 73.1255
R10110 w_200_0.n13 w_200_0.n52 117.001
R10111 w_200_0.n52 w_200_0.n53 117.001
R10112 w_200_0.n10 w_200_0.n54 73.1255
R10113 w_200_0.n54 w_200_0.n55 73.1255
R10114 w_200_0.n13 w_200_0.n56 117.001
R10115 w_200_0.n56 w_200_0.n57 117.001
R10116 w_200_0.n6 w_200_0.n58 73.1255
R10117 w_200_0.n58 VGND 73.1255
R10118 w_200_0.n13 w_200_0.n59 117.001
R10119 w_200_0.n59 w_200_0.n60 117.001
R10120 w_200_0.n61 w_200_0.n62 117.001
R10121 w_200_0.n62 w_200_0.n63 117.001
R10122 w_200_0.n64 w_200_0.n65 4.00735
R10123 w_200_0.n65 w_200_0.n66 4.00735
R10124 w_200_0.n68 w_200_0.n67 117.001
R10125 w_200_0.n68 VGND 117.001
R10126 w_200_0.n64 w_200_0.n69 4.00735
R10127 w_200_0.n69 w_200_0.n70 4.00735
R10128 w_200_0.n72 w_200_0.n71 117.001
R10129 w_200_0.n73 w_200_0.n72 117.001
R10130 w_200_0.n74 w_200_0.n75 2.01774
R10131 w_200_0.n75 w_200_0.n76 2.01774
R10132 w_200_0.n77 w_200_0.n78 117.001
R10133 w_200_0.n78 VGND 117.001
R10134 w_200_0.n74 w_200_0.n79 2.01774
R10135 w_200_0.n79 w_200_0.n80 2.01774
R10136 w_200_0.n81 w_200_0.n82 26.5914
R10137 w_200_0.n82 w_200_0.n83 26.5914
R10138 w_200_0.n84 w_200_0.n85 73.1255
R10139 w_200_0.n85 w_200_0.n86 73.1255
R10140 w_200_0.n87 w_200_0.n88 26.5914
R10141 w_200_0.n88 VGND 26.5914
R10142 w_200_0.n84 w_200_0.n89 73.1255
R10143 w_200_0.n89 w_200_0.n90 73.1255
R10144 w_200_0.n81 w_200_0.n91 26.5914
R10145 w_200_0.n91 w_200_0.n92 26.5914
R10146 w_200_0.n84 w_200_0.n93 73.1255
R10147 w_200_0.n93 w_200_0.n94 73.1255
R10148 w_200_0.n87 w_200_0.n95 26.5914
R10149 w_200_0.n95 VGND 26.5914
R10150 w_200_0.n84 w_200_0.n96 73.1255
R10151 w_200_0.n96 w_200_0.n97 73.1255
R10152 w_200_0.n98 w_200_0.n99 117.001
R10153 w_200_0.n99 w_200_0.n100 117.001
R10154 w_200_0.n101 w_200_0.n102 12.4473
R10155 w_200_0.n103 w_200_0.n102 12.4473
R10156 w_200_0.n104 w_200_0.n105 117.001
R10157 w_200_0.n105 VGND 117.001
R10158 w_200_0.n106 w_200_0.n101 12.4473
R10159 w_200_0.n107 w_200_0.n106 12.4473
R10160 w_200_0.n98 w_200_0.n108 117.001
R10161 w_200_0.n108 w_200_0.n109 117.001
R10162 w_200_0.n101 w_200_0.n110 12.4473
R10163 w_200_0.n111 w_200_0.n110 12.4473
R10164 w_200_0.n104 w_200_0.n112 117.001
R10165 w_200_0.n112 VGND 117.001
R10166 w_200_0.n101 w_200_0.n113 12.4473
R10167 w_200_0.n114 w_200_0.n113 12.4473
R10168 w_200_0.n115 w_200_0.n116 117.001
R10169 w_200_0.n117 w_200_0.n116 117.001
R10170 w_200_0.n118 w_200_0.n119 2.64756
R10171 w_200_0.n119 w_200_0.n120 2.64756
R10172 w_200_0.n77 w_200_0.n121 117.001
R10173 w_200_0.n121 VGND 117.001
R10174 w_200_0.n118 w_200_0.n122 2.64756
R10175 w_200_0.n122 w_200_0.n123 2.64756
R10176 w_200_0.n124 w_200_0.n125 73.1255
R10177 w_200_0.n125 w_200_0.n126 73.1255
R10178 w_200_0.n127 w_200_0.n128 83.5719
R10179 w_200_0.n128 w_200_0.n129 83.5719
R10180 w_200_0.n130 w_200_0.n131 73.1255
R10181 w_200_0.n131 VGND 73.1255
R10182 w_200_0.n127 w_200_0.n132 83.5719
R10183 w_200_0.n132 w_200_0.n133 83.5719
R10184 w_200_0.n124 w_200_0.n134 73.1255
R10185 w_200_0.n134 w_200_0.n135 73.1255
R10186 w_200_0.n127 w_200_0.n136 83.5719
R10187 w_200_0.n136 w_200_0.n137 83.5719
R10188 w_200_0.n130 w_200_0.n138 73.1255
R10189 w_200_0.n138 VGND 73.1255
R10190 w_200_0.n127 w_200_0.n139 83.5719
R10191 w_200_0.n139 w_200_0.n140 83.5719
R10192 w_200_0.n124 w_200_0.n141 73.1255
R10193 w_200_0.n141 w_200_0.n142 73.1255
R10194 w_200_0.n127 w_200_0.n143 83.5719
R10195 w_200_0.n143 w_200_0.n144 83.5719
R10196 w_200_0.n130 w_200_0.n145 73.1255
R10197 w_200_0.n145 VGND 73.1255
R10198 w_200_0.n127 w_200_0.n146 83.5719
R10199 w_200_0.n146 w_200_0.n147 83.5719
R10200 w_200_0.n124 w_200_0.n148 73.1255
R10201 w_200_0.n148 w_200_0.n149 73.1255
R10202 w_200_0.n127 w_200_0.n150 83.5719
R10203 w_200_0.n150 w_200_0.n151 83.5719
R10204 w_200_0.n130 w_200_0.n152 73.1255
R10205 w_200_0.n152 VGND 73.1255
R10206 w_200_0.n127 w_200_0.n153 83.5719
R10207 w_200_0.n153 w_200_0.n154 83.5719
R10208 w_200_0.n124 w_200_0.n155 73.1255
R10209 w_200_0.n155 w_200_0.n156 73.1255
R10210 w_200_0.n127 w_200_0.n157 83.5719
R10211 w_200_0.n157 w_200_0.n158 83.5719
R10212 w_200_0.n130 w_200_0.n159 73.1255
R10213 w_200_0.n159 VGND 73.1255
R10214 w_200_0.n127 w_200_0.n160 83.5719
R10215 w_200_0.n160 w_200_0.n161 83.5719
R10216 w_200_0.n124 w_200_0.n162 73.1255
R10217 w_200_0.n162 w_200_0.n163 73.1255
R10218 w_200_0.n127 w_200_0.n164 83.5719
R10219 w_200_0.n164 w_200_0.n165 83.5719
R10220 w_200_0.n130 w_200_0.n166 73.1255
R10221 w_200_0.n166 VGND 73.1255
R10222 w_200_0.n127 w_200_0.n167 83.5719
R10223 w_200_0.n167 w_200_0.n168 83.5719
R10224 w_200_0.n124 w_200_0.n169 73.1255
R10225 w_200_0.n169 w_200_0.n170 73.1255
R10226 w_200_0.n127 w_200_0.n171 83.5719
R10227 w_200_0.n171 w_200_0.n172 83.5719
R10228 w_200_0.n130 w_200_0.n173 73.1255
R10229 w_200_0.n173 VGND 73.1255
R10230 w_200_0.n127 w_200_0.n174 83.5719
R10231 w_200_0.n174 w_200_0.n175 83.5719
R10232 w_200_0.n124 w_200_0.n176 73.1255
R10233 w_200_0.n176 w_200_0.n177 73.1255
R10234 w_200_0.n127 w_200_0.n178 83.5719
R10235 w_200_0.n178 w_200_0.n179 83.5719
R10236 w_200_0.n130 w_200_0.n180 73.1255
R10237 w_200_0.n180 VGND 73.1255
R10238 w_200_0.n127 w_200_0.n181 83.5719
R10239 w_200_0.n181 w_200_0.n182 83.5719
R10240 w_200_0.n183 w_200_0.n184 73.1255
R10241 w_200_0.n184 w_200_0.n185 73.1255
R10242 w_200_0.n186 w_200_0.n187 83.5719
R10243 w_200_0.n187 w_200_0.n188 83.5719
R10244 w_200_0.n189 w_200_0.n190 73.1255
R10245 w_200_0.n190 VGND 73.1255
R10246 w_200_0.n186 w_200_0.n191 83.5719
R10247 w_200_0.n191 w_200_0.n192 83.5719
R10248 w_200_0.n183 w_200_0.n193 73.1255
R10249 w_200_0.n193 w_200_0.n194 73.1255
R10250 w_200_0.n186 w_200_0.n195 83.5719
R10251 w_200_0.n195 w_200_0.n196 83.5719
R10252 w_200_0.n189 w_200_0.n197 73.1255
R10253 w_200_0.n197 VGND 73.1255
R10254 w_200_0.n186 w_200_0.n198 83.5719
R10255 w_200_0.n198 w_200_0.n199 83.5719
R10256 w_200_0.n183 w_200_0.n200 73.1255
R10257 w_200_0.n200 w_200_0.n201 73.1255
R10258 w_200_0.n186 w_200_0.n202 83.5719
R10259 w_200_0.n202 w_200_0.n203 83.5719
R10260 w_200_0.n189 w_200_0.n204 73.1255
R10261 w_200_0.n204 VGND 73.1255
R10262 w_200_0.n186 w_200_0.n205 83.5719
R10263 w_200_0.n205 w_200_0.n206 83.5719
R10264 w_200_0.n183 w_200_0.n207 73.1255
R10265 w_200_0.n207 w_200_0.n208 73.1255
R10266 w_200_0.n186 w_200_0.n209 83.5719
R10267 w_200_0.n209 w_200_0.n210 83.5719
R10268 w_200_0.n189 w_200_0.n211 73.1255
R10269 w_200_0.n211 VGND 73.1255
R10270 w_200_0.n186 w_200_0.n212 83.5719
R10271 w_200_0.n212 w_200_0.n213 83.5719
R10272 w_200_0.n183 w_200_0.n214 73.1255
R10273 w_200_0.n214 w_200_0.n215 73.1255
R10274 w_200_0.n186 w_200_0.n216 83.5719
R10275 w_200_0.n216 w_200_0.n217 83.5719
R10276 w_200_0.n189 w_200_0.n218 73.1255
R10277 w_200_0.n218 VGND 73.1255
R10278 w_200_0.n186 w_200_0.n219 83.5719
R10279 w_200_0.n219 w_200_0.n220 83.5719
R10280 w_200_0.n183 w_200_0.n221 73.1255
R10281 w_200_0.n221 w_200_0.n222 73.1255
R10282 w_200_0.n186 w_200_0.n223 83.5719
R10283 w_200_0.n223 w_200_0.n224 83.5719
R10284 w_200_0.n189 w_200_0.n225 73.1255
R10285 w_200_0.n225 VGND 73.1255
R10286 w_200_0.n186 w_200_0.n226 83.5719
R10287 w_200_0.n226 w_200_0.n227 83.5719
R10288 w_200_0.n183 w_200_0.n228 73.1255
R10289 w_200_0.n228 w_200_0.n229 73.1255
R10290 w_200_0.n186 w_200_0.n230 83.5719
R10291 w_200_0.n230 w_200_0.n231 83.5719
R10292 w_200_0.n189 w_200_0.n232 73.1255
R10293 w_200_0.n232 VGND 73.1255
R10294 w_200_0.n186 w_200_0.n233 83.5719
R10295 w_200_0.n233 w_200_0.n234 83.5719
R10296 w_200_0.n183 w_200_0.n235 73.1255
R10297 w_200_0.n235 w_200_0.n236 73.1255
R10298 w_200_0.n186 w_200_0.n237 83.5719
R10299 w_200_0.n237 w_200_0.n238 83.5719
R10300 w_200_0.n189 w_200_0.n239 73.1255
R10301 w_200_0.n239 VGND 73.1255
R10302 w_200_0.n186 w_200_0.n240 83.5719
R10303 w_200_0.n240 w_200_0.n241 83.5719
R10304 w_200_0.n242 w_200_0.n243 26.5914
R10305 w_200_0.n243 w_200_0.n244 26.5914
R10306 w_200_0.n245 w_200_0.n246 65.0005
R10307 w_200_0.n246 w_200_0.n247 65.0005
R10308 w_200_0.n248 w_200_0.n249 26.5914
R10309 w_200_0.n249 VGND 26.5914
R10310 w_200_0.n245 w_200_0.n250 65.0005
R10311 w_200_0.n250 w_200_0.n251 65.0005
R10312 w_200_0.n252 w_200_0.n253 58.5005
R10313 w_200_0.n253 w_200_0.n254 58.5005
R10314 w_200_0.n255 w_200_0.n256 83.5719
R10315 w_200_0.n256 w_200_0.n257 83.5719
R10316 w_200_0.n248 w_200_0.n258 58.5005
R10317 w_200_0.n258 VGND 58.5005
R10318 w_200_0.n255 w_200_0.n259 83.5719
R10319 w_200_0.n259 w_200_0.n260 83.5719
R10320 w_200_0.n252 w_200_0.n261 58.5005
R10321 w_200_0.n261 w_200_0.n262 58.5005
R10322 w_200_0.n255 w_200_0.n263 83.5719
R10323 w_200_0.n263 w_200_0.n264 83.5719
R10324 w_200_0.n248 w_200_0.n265 58.5005
R10325 w_200_0.n265 VGND 58.5005
R10326 w_200_0.n255 w_200_0.n266 83.5719
R10327 w_200_0.n266 w_200_0.n267 83.5719
R10328 w_200_0.n252 w_200_0.n268 58.5005
R10329 w_200_0.n268 w_200_0.n269 58.5005
R10330 w_200_0.n255 w_200_0.n270 83.5719
R10331 w_200_0.n270 w_200_0.n271 83.5719
R10332 w_200_0.n248 w_200_0.n272 58.5005
R10333 w_200_0.n272 VGND 58.5005
R10334 w_200_0.n255 w_200_0.n273 83.5719
R10335 w_200_0.n273 w_200_0.n274 83.5719
R10336 w_200_0.n252 w_200_0.n275 58.5005
R10337 w_200_0.n275 w_200_0.n276 58.5005
R10338 w_200_0.n255 w_200_0.n277 83.5719
R10339 w_200_0.n277 w_200_0.n278 83.5719
R10340 w_200_0.n248 w_200_0.n279 58.5005
R10341 w_200_0.n279 VGND 58.5005
R10342 w_200_0.n255 w_200_0.n280 83.5719
R10343 w_200_0.n280 w_200_0.n281 83.5719
R10344 w_200_0.n242 w_200_0.n282 26.5914
R10345 w_200_0.n282 w_200_0.n283 26.5914
R10346 w_200_0.n245 w_200_0.n284 65.0005
R10347 w_200_0.n284 w_200_0.n285 65.0005
R10348 w_200_0.n248 w_200_0.n286 26.5914
R10349 w_200_0.n286 VGND 26.5914
R10350 w_200_0.n245 w_200_0.n287 65.0005
R10351 w_200_0.n287 w_200_0.n288 65.0005
R10352 w_200_0.n289 w_200_0.n290 26.5914
R10353 w_200_0.n290 w_200_0.n291 26.5914
R10354 w_200_0.n292 w_200_0.n293 65.0005
R10355 w_200_0.n293 w_200_0.n294 65.0005
R10356 w_200_0.n295 w_200_0.n296 26.5914
R10357 w_200_0.n296 VGND 26.5914
R10358 w_200_0.n292 w_200_0.n297 65.0005
R10359 w_200_0.n297 w_200_0.n298 65.0005
R10360 w_200_0.n299 w_200_0.n300 58.5005
R10361 w_200_0.n300 w_200_0.n301 58.5005
R10362 w_200_0.n302 w_200_0.n303 83.5719
R10363 w_200_0.n303 w_200_0.n304 83.5719
R10364 w_200_0.n295 w_200_0.n305 58.5005
R10365 w_200_0.n305 VGND 58.5005
R10366 w_200_0.n302 w_200_0.n306 83.5719
R10367 w_200_0.n306 w_200_0.n307 83.5719
R10368 w_200_0.n299 w_200_0.n308 58.5005
R10369 w_200_0.n308 w_200_0.n309 58.5005
R10370 w_200_0.n302 w_200_0.n310 83.5719
R10371 w_200_0.n310 w_200_0.n311 83.5719
R10372 w_200_0.n295 w_200_0.n312 58.5005
R10373 w_200_0.n312 VGND 58.5005
R10374 w_200_0.n302 w_200_0.n313 83.5719
R10375 w_200_0.n313 w_200_0.n314 83.5719
R10376 w_200_0.n299 w_200_0.n315 58.5005
R10377 w_200_0.n315 w_200_0.n316 58.5005
R10378 w_200_0.n302 w_200_0.n317 83.5719
R10379 w_200_0.n317 w_200_0.n318 83.5719
R10380 w_200_0.n295 w_200_0.n319 58.5005
R10381 w_200_0.n319 VGND 58.5005
R10382 w_200_0.n302 w_200_0.n320 83.5719
R10383 w_200_0.n320 w_200_0.n321 83.5719
R10384 w_200_0.n299 w_200_0.n322 58.5005
R10385 w_200_0.n322 w_200_0.n323 58.5005
R10386 w_200_0.n302 w_200_0.n324 83.5719
R10387 w_200_0.n324 w_200_0.n325 83.5719
R10388 w_200_0.n295 w_200_0.n326 58.5005
R10389 w_200_0.n326 VGND 58.5005
R10390 w_200_0.n302 w_200_0.n327 83.5719
R10391 w_200_0.n327 w_200_0.n328 83.5719
R10392 w_200_0.n289 w_200_0.n329 26.5914
R10393 w_200_0.n329 w_200_0.n330 26.5914
R10394 w_200_0.n292 w_200_0.n331 65.0005
R10395 w_200_0.n331 w_200_0.n332 65.0005
R10396 w_200_0.n295 w_200_0.n333 26.5914
R10397 w_200_0.n333 VGND 26.5914
R10398 w_200_0.n292 w_200_0.n334 65.0005
R10399 w_200_0.n334 w_200_0.n335 65.0005
R10400 w_200_0.n337 w_200_0.n336 117.001
R10401 w_200_0.n338 w_200_0.n337 117.001
R10402 w_200_0.n339 w_200_0.n340 3.87467
R10403 w_200_0.n340 w_200_0.n341 3.87467
R10404 w_200_0.n77 w_200_0.n342 117.001
R10405 w_200_0.n342 VGND 117.001
R10406 w_200_0.n339 w_200_0.n343 3.87467
R10407 w_200_0.n343 w_200_0.n344 3.87467
R10408 w_200_0.n345 w_200_0.n115 117.001
R10409 w_200_0.n346 w_200_0.n345 117.001
R10410 w_200_0.n118 w_200_0.n347 2.64756
R10411 w_200_0.n347 w_200_0.n348 2.64756
R10412 w_200_0.n77 w_200_0.n349 117.001
R10413 w_200_0.n349 VGND 117.001
R10414 w_200_0.n118 w_200_0.n350 2.64756
R10415 w_200_0.n350 w_200_0.n351 2.64756
R10416 VGND w_200_0.n77 7.34284
R10417 VGND w_200_0.n77 352.849
R10418 VGND w_200_0.n295 7.34284
R10419 w_200_0.n295 w_200_0.n302 43.916
R10420 w_200_0.n302 w_200_0.n292 7.06577
R10421 w_200_0.n292 w_200_0.n299 36.8507
R10422 w_200_0.n299 w_200_0.n289 14.131
R10423 w_200_0.n289 w_200_0.n339 262.247
R10424 w_200_0.n339 VGND 127.175
R10425 VGND w_200_0.n248 7.34284
R10426 w_200_0.n255 w_200_0.n248 43.916
R10427 w_200_0.n245 w_200_0.n255 7.06577
R10428 w_200_0.n252 w_200_0.n245 36.8507
R10429 w_200_0.n242 w_200_0.n252 14.131
R10430 w_200_0.n118 w_200_0.n242 89.0783
R10431 w_200_0.n74 w_200_0.n118 325.557
R10432 w_200_0.n336 w_200_0.n74 73.2854
R10433 w_200_0.n336 VGND 12.3301
R10434 VGND w_200_0.n189 7.34284
R10435 w_200_0.n189 w_200_0.n186 43.916
R10436 w_200_0.n186 w_200_0.n183 43.916
R10437 w_200_0.n183 VGND 71.0688
R10438 VGND w_200_0.n67 7.34284
R10439 w_200_0.n67 VGND 325.142
R10440 VGND w_200_0.n130 7.34284
R10441 w_200_0.n127 w_200_0.n130 43.916
R10442 w_200_0.n124 w_200_0.n127 43.916
R10443 w_200_0.n115 w_200_0.n124 44.8857
R10444 w_200_0.n115 VGND 53.8905
R10445 VGND w_200_0.n104 7.34284
R10446 w_200_0.n64 w_200_0.n104 169.982
R10447 w_200_0.n101 w_200_0.n64 64.1421
R10448 w_200_0.n101 VGND 70.6532
R10449 VGND w_200_0.n87 7.34284
R10450 w_200_0.n84 w_200_0.n87 46.4096
R10451 w_200_0.n98 w_200_0.n84 6.23456
R10452 w_200_0.n81 w_200_0.n98 40.1756
R10453 w_200_0.n71 w_200_0.n81 81.4589
R10454 w_200_0.n71 w_200_0.n61 276.515
R10455 w_200_0.n61 VGND 2035.49
R10456 VGND w_200_0.n6 7.34284
R10457 w_200_0.n6 w_200_0.n13 32.8332
R10458 w_200_0.n13 w_200_0.n3 13.5769
R10459 w_200_0.n3 w_200_0.n10 19.2568
R10460 w_200_0.n10 w_200_0.n0 27.1533
R10461 w_200_0.n0 w_200_0.n612 121.496
R10462 w_200_0.n360 w_200_0.n352 956.563
R10463 w_200_0.n612 w_200_0.n353 1289.59
R10464 w_200_0.n612 w_200_0.n354 883.547
R10465 w_200_0.n612 w_200_0.n355 1040.16
R10466 w_200_0.n612 w_200_0.n356 1127.63
R10467 w_200_0.n612 w_200_0.n357 1095.42
R10468 w_200_0.n612 w_200_0.n358 1197.13
R10469 w_200_0.n612 w_200_0.n359 1040.16
R10470 w_200_0.n612 w_200_0.n360 115.835
R10471 w_200_0.n361 w_200_0.n362 73.1255
R10472 w_200_0.n362 w_200_0.n363 73.1255
R10473 w_200_0.n364 w_200_0.n365 83.5719
R10474 w_200_0.n365 w_200_0.n366 83.5719
R10475 w_200_0.n361 w_200_0.n367 73.1255
R10476 w_200_0.n367 w_200_0.n455 73.1255
R10477 w_200_0.n368 w_200_0.n369 83.5719
R10478 w_200_0.n369 w_200_0.n370 83.5719
R10479 w_200_0.n371 w_200_0.n372 73.1255
R10480 w_200_0.n372 w_200_0.n373 73.1255
R10481 w_200_0.n374 w_200_0.n375 83.5719
R10482 w_200_0.n375 w_200_0.n376 83.5719
R10483 w_200_0.n371 w_200_0.n377 73.1255
R10484 w_200_0.n377 w_200_0.n457 73.1255
R10485 w_200_0.n378 w_200_0.n379 83.5719
R10486 w_200_0.n379 w_200_0.n380 83.5719
R10487 VGND w_200_0.n368 71.9314
R10488 w_200_0.n368 w_200_0.n361 480.445
R10489 w_200_0.n361 w_200_0.n364 480.445
R10490 w_200_0.n364 w_200_0.n352 1962.49
R10491 w_200_0.n352 VGND 1890.56
R10492 VGND w_200_0.n378 71.9314
R10493 w_200_0.n378 w_200_0.n371 480.445
R10494 w_200_0.n371 w_200_0.n374 480.445
R10495 w_200_0.n381 w_200_0.n382 73.1255
R10496 w_200_0.n382 w_200_0.n383 73.1255
R10497 w_200_0.n384 w_200_0.n385 83.5719
R10498 w_200_0.n385 w_200_0.n386 83.5719
R10499 w_200_0.n381 w_200_0.n387 73.1255
R10500 w_200_0.n387 w_200_0.n453 73.1255
R10501 w_200_0.n388 w_200_0.n389 83.5719
R10502 w_200_0.n389 w_200_0.n390 83.5719
R10503 w_200_0.n391 w_200_0.n353 1603.28
R10504 w_200_0.n353 VGND 1603.28
R10505 VGND w_200_0.n388 70.7529
R10506 w_200_0.n388 w_200_0.n381 472.574
R10507 w_200_0.n381 w_200_0.n384 472.574
R10508 w_200_0.n384 w_200_0.n359 1802.18
R10509 w_200_0.n359 w_200_0.n611 128.155
R10510 w_200_0.n611 VGND 1859.59
R10511 w_200_0.n611 w_200_0.n352 9977.56
R10512 w_200_0.n374 w_200_0.n360 2996.04
R10513 w_200_0.n610 w_200_0.n353 2635.61
R10514 w_200_0.n353 w_200_0.n611 9556.21
R10515 w_200_0.n392 w_200_0.n393 73.1255
R10516 w_200_0.n393 w_200_0.n394 73.1255
R10517 w_200_0.n395 w_200_0.n396 83.5719
R10518 w_200_0.n396 w_200_0.n397 83.5719
R10519 w_200_0.n398 w_200_0.n399 73.1255
R10520 w_200_0.n399 w_200_0.n400 73.1255
R10521 w_200_0.n395 w_200_0.n401 83.5719
R10522 w_200_0.n401 w_200_0.n609 83.5719
R10523 VGND w_200_0.n398 194.659
R10524 w_200_0.n398 w_200_0.n391 448.08
R10525 w_200_0.n391 w_200_0.n395 716.194
R10526 w_200_0.n395 w_200_0.n392 1164.27
R10527 w_200_0.n392 w_200_0.n610 14834.5
R10528 w_200_0.n609 w_200_0.n400 236.048
R10529 w_200_0.n400 w_200_0.n397 236.048
R10530 w_200_0.n609 w_200_0.n394 246.213
R10531 w_200_0.n394 w_200_0.n397 246.213
R10532 w_200_0.n608 w_200_0.n400 17.3121
R10533 w_200_0.n458 w_200_0.n607 3.4105
R10534 w_200_0.n402 w_200_0.n403 2.1155
R10535 w_200_0.n403 w_200_0.n452 2.1155
R10536 w_200_0.n452 w_200_0.n608 2.1155
R10537 w_200_0.n608 w_200_0.n454 2.1155
R10538 w_200_0.n454 w_200_0.n458 0.521025
R10539 w_200_0.n458 w_200_0.n456 1.59498
R10540 w_200_0.n534 w_200_0.n535 3.4105
R10541 w_200_0.n581 w_200_0.n582 3.4105
R10542 w_200_0.n587 w_200_0.n588 3.4105
R10543 w_200_0.n595 w_200_0.n596 3.4105
R10544 w_200_0.n601 w_200_0.n602 3.4105
R10545 w_200_0.n603 w_200_0.n602 1.33412
R10546 w_200_0.n602 w_200_0.n596 0.0950875
R10547 w_200_0.n596 w_200_0.n588 2.02091
R10548 w_200_0.n588 w_200_0.n582 0.0950875
R10549 w_200_0.n582 w_200_0.n574 2.49091
R10550 w_200_0.n574 w_200_0.n566 0.52925
R10551 w_200_0.n566 w_200_0.n565 1.58675
R10552 w_200_0.n565 w_200_0.n557 0.206125
R10553 w_200_0.n557 w_200_0.n555 1.76594
R10554 w_200_0.n555 w_200_0.n537 1.49569
R10555 w_200_0.n537 w_200_0.n536 2.54437
R10556 w_200_0.n536 w_200_0.n535 7.15038
R10557 w_200_0.n535 w_200_0.n527 0.0950875
R10558 w_200_0.n527 w_200_0.n511 1.29241
R10559 w_200_0.n511 w_200_0.n607 0.964
R10560 w_200_0.n607 w_200_0.n465 3.50509
R10561 w_200_0.n603 w_200_0.n604 5.0226
R10562 w_200_0.n604 w_200_0.n605 1.1755
R10563 w_200_0.n605 w_200_0.n606 1.1755
R10564 VGND w_200_0.n606 18.4871
R10565 VGND w_200_0.n348 2932.33
R10566 w_200_0.n346 w_200_0.n348 2942.49
R10567 w_200_0.n351 w_200_0.n346 2942.49
R10568 w_200_0.n351 VGND 2932.33
R10569 VGND w_200_0.n606 17.3121
R10570 VGND w_200_0.n76 3817.04
R10571 w_200_0.n73 w_200_0.n76 3827.2
R10572 w_200_0.n80 w_200_0.n73 3827.2
R10573 w_200_0.n80 VGND 3817.04
R10574 VGND w_200_0.n605 17.3121
R10575 VGND w_200_0.n341 2047.62
R10576 w_200_0.n341 w_200_0.n338 2057.79
R10577 w_200_0.n344 w_200_0.n338 2057.79
R10578 w_200_0.n344 VGND 2047.62
R10579 VGND w_200_0.n604 17.3121
R10580 VGND w_200_0.n123 2925.93
R10581 w_200_0.n123 w_200_0.n117 2942.49
R10582 w_200_0.n120 w_200_0.n117 2942.49
R10583 VGND w_200_0.n120 2932.33
R10584 w_200_0.n603 VGND 22.617
R10585 w_200_0.n597 w_200_0.n598 2.3505
R10586 w_200_0.n598 w_200_0.n599 2.3505
R10587 w_200_0.n599 w_200_0.n600 2.5949
R10588 w_200_0.n600 w_200_0.n601 1.53681
R10589 VGND w_200_0.n601 17.8907
R10590 VGND w_200_0.n332 432.565
R10591 w_200_0.n330 w_200_0.n332 442.729
R10592 w_200_0.n335 w_200_0.n330 442.729
R10593 w_200_0.n335 VGND 432.565
R10594 VGND w_200_0.n600 17.3121
R10595 VGND w_200_0.n294 432.565
R10596 w_200_0.n291 w_200_0.n294 442.729
R10597 w_200_0.n298 w_200_0.n291 442.729
R10598 w_200_0.n298 VGND 432.565
R10599 VGND w_200_0.n599 17.3121
R10600 VGND w_200_0.n325 256.753
R10601 w_200_0.n323 w_200_0.n325 266.918
R10602 w_200_0.n328 w_200_0.n323 266.918
R10603 w_200_0.n328 VGND 256.753
R10604 VGND w_200_0.n598 17.3121
R10605 VGND w_200_0.n318 256.753
R10606 w_200_0.n316 w_200_0.n318 266.918
R10607 w_200_0.n321 w_200_0.n316 266.918
R10608 w_200_0.n321 VGND 256.753
R10609 VGND w_200_0.n597 17.3121
R10610 VGND w_200_0.n311 256.753
R10611 w_200_0.n309 w_200_0.n311 266.918
R10612 w_200_0.n314 w_200_0.n309 266.918
R10613 w_200_0.n314 VGND 256.753
R10614 VGND w_200_0.n597 19.6621
R10615 VGND w_200_0.n304 256.753
R10616 w_200_0.n301 w_200_0.n304 266.918
R10617 w_200_0.n307 w_200_0.n301 266.918
R10618 w_200_0.n307 VGND 256.753
R10619 w_200_0.n589 w_200_0.n595 4.9004
R10620 w_200_0.n595 w_200_0.n592 4.0356
R10621 w_200_0.n592 w_200_0.n594 0.602062
R10622 w_200_0.n594 VGND 4.67238
R10623 w_200_0.n594 VGND 5.30116
R10624 w_200_0.n593 w_200_0.n592 0.602062
R10625 w_200_0.n593 VGND 5.30116
R10626 w_200_0.n593 VGND 4.67238
R10627 w_200_0.n592 VGND 4.65675
R10628 w_200_0.n589 w_200_0.n591 0.602062
R10629 w_200_0.n591 VGND 4.67238
R10630 w_200_0.n591 VGND 5.30116
R10631 w_200_0.n590 w_200_0.n589 0.602062
R10632 w_200_0.n590 VGND 5.30116
R10633 w_200_0.n590 VGND 4.67238
R10634 w_200_0.n589 VGND 4.65675
R10635 w_200_0.n583 w_200_0.n584 2.3505
R10636 w_200_0.n584 w_200_0.n585 2.3505
R10637 w_200_0.n585 w_200_0.n586 2.5949
R10638 w_200_0.n586 w_200_0.n587 1.53681
R10639 VGND w_200_0.n587 17.8907
R10640 VGND w_200_0.n285 432.565
R10641 w_200_0.n283 w_200_0.n285 442.729
R10642 w_200_0.n288 w_200_0.n283 442.729
R10643 w_200_0.n288 VGND 432.565
R10644 VGND w_200_0.n586 17.3121
R10645 VGND w_200_0.n247 432.565
R10646 w_200_0.n244 w_200_0.n247 442.729
R10647 w_200_0.n251 w_200_0.n244 442.729
R10648 w_200_0.n251 VGND 432.565
R10649 VGND w_200_0.n585 17.3121
R10650 VGND w_200_0.n278 256.753
R10651 w_200_0.n276 w_200_0.n278 266.918
R10652 w_200_0.n281 w_200_0.n276 266.918
R10653 w_200_0.n281 VGND 256.753
R10654 VGND w_200_0.n584 17.3121
R10655 VGND w_200_0.n271 256.753
R10656 w_200_0.n269 w_200_0.n271 266.918
R10657 w_200_0.n274 w_200_0.n269 266.918
R10658 w_200_0.n274 VGND 256.753
R10659 VGND w_200_0.n583 17.3121
R10660 VGND w_200_0.n264 256.753
R10661 w_200_0.n262 w_200_0.n264 266.918
R10662 w_200_0.n267 w_200_0.n262 266.918
R10663 w_200_0.n267 VGND 256.753
R10664 VGND w_200_0.n583 19.6621
R10665 VGND w_200_0.n257 256.753
R10666 w_200_0.n254 w_200_0.n257 266.918
R10667 w_200_0.n260 w_200_0.n254 266.918
R10668 w_200_0.n260 VGND 256.753
R10669 w_200_0.n575 w_200_0.n581 4.9004
R10670 w_200_0.n581 w_200_0.n578 4.0356
R10671 w_200_0.n578 w_200_0.n580 0.602062
R10672 w_200_0.n580 VGND 4.67238
R10673 w_200_0.n580 VGND 5.30116
R10674 w_200_0.n579 w_200_0.n578 0.602062
R10675 w_200_0.n579 VGND 5.30116
R10676 w_200_0.n579 VGND 4.67238
R10677 w_200_0.n578 VGND 4.65675
R10678 w_200_0.n575 w_200_0.n577 0.602062
R10679 w_200_0.n577 VGND 4.67238
R10680 w_200_0.n577 VGND 5.30116
R10681 w_200_0.n576 w_200_0.n575 0.602062
R10682 w_200_0.n576 VGND 5.30116
R10683 w_200_0.n576 VGND 4.67238
R10684 w_200_0.n575 VGND 4.65675
R10685 w_200_0.n567 w_200_0.n568 1.528
R10686 w_200_0.n568 w_200_0.n569 1.528
R10687 w_200_0.n569 w_200_0.n570 1.528
R10688 w_200_0.n570 w_200_0.n571 1.528
R10689 w_200_0.n571 w_200_0.n572 1.528
R10690 w_200_0.n572 w_200_0.n573 1.528
R10691 w_200_0.n573 w_200_0.n574 4.16602
R10692 VGND w_200_0.n573 17.3121
R10693 VGND w_200_0.n238 236.048
R10694 w_200_0.n236 w_200_0.n238 246.213
R10695 w_200_0.n241 w_200_0.n236 246.213
R10696 w_200_0.n241 VGND 236.048
R10697 VGND w_200_0.n572 17.3121
R10698 VGND w_200_0.n231 236.048
R10699 w_200_0.n229 w_200_0.n231 246.213
R10700 w_200_0.n234 w_200_0.n229 246.213
R10701 w_200_0.n234 VGND 236.048
R10702 VGND w_200_0.n571 17.3121
R10703 VGND w_200_0.n224 236.048
R10704 w_200_0.n222 w_200_0.n224 246.213
R10705 w_200_0.n227 w_200_0.n222 246.213
R10706 w_200_0.n227 VGND 236.048
R10707 VGND w_200_0.n570 17.3121
R10708 VGND w_200_0.n217 236.048
R10709 w_200_0.n215 w_200_0.n217 246.213
R10710 w_200_0.n220 w_200_0.n215 246.213
R10711 w_200_0.n220 VGND 236.048
R10712 VGND w_200_0.n569 17.3121
R10713 VGND w_200_0.n210 236.048
R10714 w_200_0.n208 w_200_0.n210 246.213
R10715 w_200_0.n213 w_200_0.n208 246.213
R10716 w_200_0.n213 VGND 236.048
R10717 VGND w_200_0.n568 17.3121
R10718 VGND w_200_0.n203 236.048
R10719 w_200_0.n201 w_200_0.n203 246.213
R10720 w_200_0.n206 w_200_0.n201 246.213
R10721 w_200_0.n206 VGND 236.048
R10722 VGND w_200_0.n567 17.3121
R10723 VGND w_200_0.n196 236.048
R10724 w_200_0.n194 w_200_0.n196 246.213
R10725 w_200_0.n199 w_200_0.n194 246.213
R10726 w_200_0.n199 VGND 236.048
R10727 VGND w_200_0.n567 18.8396
R10728 VGND w_200_0.n188 236.048
R10729 w_200_0.n185 w_200_0.n188 246.213
R10730 w_200_0.n192 w_200_0.n185 246.213
R10731 w_200_0.n192 VGND 236.048
R10732 w_200_0.n566 VGND 33.249
R10733 VGND w_200_0.n66 1971.58
R10734 w_200_0.n63 w_200_0.n66 1981.74
R10735 w_200_0.n70 w_200_0.n63 1981.74
R10736 w_200_0.n70 VGND 1971.58
R10737 w_200_0.n558 w_200_0.n559 1.528
R10738 w_200_0.n559 w_200_0.n560 1.528
R10739 w_200_0.n560 w_200_0.n561 1.528
R10740 w_200_0.n561 w_200_0.n562 1.528
R10741 w_200_0.n562 w_200_0.n563 1.528
R10742 w_200_0.n563 w_200_0.n564 1.528
R10743 w_200_0.n564 w_200_0.n565 4.16602
R10744 VGND w_200_0.n564 17.3121
R10745 VGND w_200_0.n179 236.048
R10746 w_200_0.n177 w_200_0.n179 246.213
R10747 w_200_0.n182 w_200_0.n177 246.213
R10748 w_200_0.n182 VGND 236.048
R10749 VGND w_200_0.n563 17.3121
R10750 VGND w_200_0.n172 236.048
R10751 w_200_0.n170 w_200_0.n172 246.213
R10752 w_200_0.n175 w_200_0.n170 246.213
R10753 w_200_0.n175 VGND 236.048
R10754 VGND w_200_0.n562 17.3121
R10755 VGND w_200_0.n165 236.048
R10756 w_200_0.n163 w_200_0.n165 246.213
R10757 w_200_0.n168 w_200_0.n163 246.213
R10758 w_200_0.n168 VGND 236.048
R10759 VGND w_200_0.n561 17.3121
R10760 VGND w_200_0.n158 236.048
R10761 w_200_0.n156 w_200_0.n158 246.213
R10762 w_200_0.n161 w_200_0.n156 246.213
R10763 w_200_0.n161 VGND 236.048
R10764 VGND w_200_0.n560 17.3121
R10765 VGND w_200_0.n151 236.048
R10766 w_200_0.n149 w_200_0.n151 246.213
R10767 w_200_0.n154 w_200_0.n149 246.213
R10768 w_200_0.n154 VGND 236.048
R10769 VGND w_200_0.n559 17.3121
R10770 VGND w_200_0.n144 236.048
R10771 w_200_0.n142 w_200_0.n144 246.213
R10772 w_200_0.n147 w_200_0.n142 246.213
R10773 w_200_0.n147 VGND 236.048
R10774 VGND w_200_0.n558 17.3121
R10775 VGND w_200_0.n137 236.048
R10776 w_200_0.n135 w_200_0.n137 246.213
R10777 w_200_0.n140 w_200_0.n135 246.213
R10778 w_200_0.n140 VGND 236.048
R10779 VGND w_200_0.n558 18.8396
R10780 VGND w_200_0.n129 236.048
R10781 w_200_0.n126 w_200_0.n129 246.213
R10782 w_200_0.n133 w_200_0.n126 246.213
R10783 w_200_0.n133 VGND 236.048
R10784 w_200_0.n557 w_200_0.n556 5.25172
R10785 w_200_0.n556 VGND 25.8887
R10786 VGND w_200_0.n111 715.294
R10787 w_200_0.n109 w_200_0.n111 725.46
R10788 w_200_0.n109 w_200_0.n114 725.46
R10789 w_200_0.n114 VGND 715.294
R10790 VGND w_200_0.n556 24.9369
R10791 VGND w_200_0.n103 715.294
R10792 w_200_0.n100 w_200_0.n103 725.46
R10793 w_200_0.n100 w_200_0.n107 725.46
R10794 w_200_0.n107 VGND 715.294
R10795 w_200_0.n538 w_200_0.n540 1.85932
R10796 w_200_0.n540 w_200_0.n539 0.124973
R10797 w_200_0.n539 w_200_0.n555 11.4134
R10798 w_200_0.n548 w_200_0.n538 11.1667
R10799 w_200_0.n548 w_200_0.n554 0.602062
R10800 w_200_0.n554 w_200_0.n553 0.586438
R10801 w_200_0.n554 VGND 0.0708125
R10802 w_200_0.n553 VGND 0.141125
R10803 VGND w_200_0.n552 0.03175
R10804 w_200_0.n553 VGND 0.234875
R10805 VGND w_200_0.n552 0.03175
R10806 w_200_0.n552 VGND 6.77966
R10807 w_200_0.n551 w_200_0.n549 0.586438
R10808 w_200_0.n549 w_200_0.n548 0.602062
R10809 w_200_0.n551 VGND 0.141125
R10810 VGND w_200_0.n550 0.03175
R10811 w_200_0.n551 VGND 0.234875
R10812 VGND w_200_0.n550 0.03175
R10813 w_200_0.n550 VGND 6.77966
R10814 w_200_0.n549 VGND 0.0708125
R10815 w_200_0.n548 VGND 0.0551875
R10816 w_200_0.n541 w_200_0.n540 10.9355
R10817 w_200_0.n541 w_200_0.n547 0.602062
R10818 w_200_0.n547 w_200_0.n546 0.586438
R10819 w_200_0.n547 VGND 0.0708125
R10820 w_200_0.n546 VGND 0.141125
R10821 VGND w_200_0.n545 0.03175
R10822 w_200_0.n546 VGND 0.234875
R10823 VGND w_200_0.n545 0.03175
R10824 w_200_0.n545 VGND 6.77966
R10825 w_200_0.n544 w_200_0.n542 0.586438
R10826 w_200_0.n542 w_200_0.n541 0.602062
R10827 w_200_0.n544 VGND 0.141125
R10828 VGND w_200_0.n543 0.03175
R10829 w_200_0.n544 VGND 0.234875
R10830 VGND w_200_0.n543 0.03175
R10831 w_200_0.n543 VGND 6.77966
R10832 w_200_0.n542 VGND 0.0708125
R10833 w_200_0.n541 VGND 0.0551875
R10834 VGND w_200_0.n539 24.9369
R10835 VGND w_200_0.n94 420.142
R10836 w_200_0.n92 w_200_0.n94 430.307
R10837 w_200_0.n97 w_200_0.n92 430.307
R10838 w_200_0.n97 VGND 420.142
R10839 VGND w_200_0.n538 25.0309
R10840 VGND w_200_0.n86 420.142
R10841 w_200_0.n83 w_200_0.n86 430.307
R10842 w_200_0.n90 w_200_0.n83 430.307
R10843 w_200_0.n90 VGND 420.142
R10844 VGND w_200_0.n537 9.41306
R10845 VGND w_200_0.n536 22.1625
R10846 w_200_0.n528 w_200_0.n529 1.9463
R10847 w_200_0.n529 w_200_0.n530 2.1719
R10848 w_200_0.n530 w_200_0.n531 2.2283
R10849 w_200_0.n531 w_200_0.n532 1.9463
R10850 w_200_0.n532 w_200_0.n534 0.577425
R10851 w_200_0.n534 w_200_0.n533 1.59498
R10852 VGND w_200_0.n533 19.4271
R10853 VGND w_200_0.n57 205.929
R10854 w_200_0.n55 w_200_0.n57 216.095
R10855 w_200_0.n60 w_200_0.n55 216.095
R10856 w_200_0.n60 VGND 205.929
R10857 VGND w_200_0.n533 17.3121
R10858 VGND w_200_0.n50 205.929
R10859 w_200_0.n48 w_200_0.n50 216.095
R10860 w_200_0.n53 w_200_0.n48 216.095
R10861 w_200_0.n53 VGND 205.929
R10862 VGND w_200_0.n532 17.3121
R10863 VGND w_200_0.n43 169.788
R10864 w_200_0.n41 w_200_0.n43 179.953
R10865 w_200_0.n46 w_200_0.n41 179.953
R10866 w_200_0.n46 VGND 169.788
R10867 VGND w_200_0.n531 17.3121
R10868 VGND w_200_0.n22 315.106
R10869 w_200_0.n20 w_200_0.n22 325.272
R10870 w_200_0.n25 w_200_0.n20 325.272
R10871 w_200_0.n25 VGND 315.106
R10872 VGND w_200_0.n530 17.3121
R10873 VGND w_200_0.n36 205.929
R10874 w_200_0.n34 w_200_0.n36 216.095
R10875 w_200_0.n39 w_200_0.n34 216.095
R10876 w_200_0.n39 VGND 205.929
R10877 VGND w_200_0.n529 17.3121
R10878 VGND w_200_0.n29 169.788
R10879 w_200_0.n27 w_200_0.n29 179.953
R10880 w_200_0.n32 w_200_0.n27 179.953
R10881 w_200_0.n32 VGND 169.788
R10882 VGND w_200_0.n528 17.3121
R10883 VGND w_200_0.n5 315.106
R10884 w_200_0.n2 w_200_0.n5 325.272
R10885 w_200_0.n9 w_200_0.n2 325.272
R10886 w_200_0.n9 VGND 315.106
R10887 VGND w_200_0.n528 19.5963
R10888 VGND w_200_0.n15 169.788
R10889 w_200_0.n12 w_200_0.n15 179.953
R10890 w_200_0.n18 w_200_0.n12 179.953
R10891 w_200_0.n18 VGND 169.788
R10892 w_200_0.n513 w_200_0.n516 3.4105
R10893 w_200_0.n517 w_200_0.n518 3.4105
R10894 w_200_0.n519 w_200_0.n520 3.4105
R10895 w_200_0.n521 w_200_0.n524 3.4105
R10896 w_200_0.n525 w_200_0.n526 3.4105
R10897 w_200_0.n512 w_200_0.n516 5.6383
R10898 w_200_0.n516 w_200_0.n518 2.0027
R10899 w_200_0.n518 w_200_0.n520 2.1155
R10900 w_200_0.n520 w_200_0.n524 2.2283
R10901 w_200_0.n524 w_200_0.n526 2.0027
R10902 w_200_0.n526 w_200_0.n527 3.90282
R10903 w_200_0.n525 VGND 5.06549
R10904 VGND w_200_0.n525 4.67889
R10905 w_200_0.n521 w_200_0.n523 0.359875
R10906 w_200_0.n523 VGND 4.67238
R10907 w_200_0.n523 VGND 5.05898
R10908 w_200_0.n522 w_200_0.n521 0.359875
R10909 w_200_0.n522 VGND 5.05898
R10910 w_200_0.n522 VGND 4.67238
R10911 w_200_0.n521 VGND 4.65675
R10912 w_200_0.n519 VGND 5.06549
R10913 w_200_0.n519 VGND 5.06549
R10914 VGND w_200_0.n519 4.67889
R10915 w_200_0.n517 VGND 5.06549
R10916 VGND w_200_0.n517 4.67889
R10917 w_200_0.n513 w_200_0.n515 0.359875
R10918 w_200_0.n515 VGND 4.67238
R10919 w_200_0.n515 VGND 5.05898
R10920 w_200_0.n514 w_200_0.n513 0.359875
R10921 w_200_0.n514 VGND 5.05898
R10922 w_200_0.n514 VGND 4.67238
R10923 w_200_0.n513 VGND 4.65675
R10924 w_200_0.n512 VGND 5.06549
R10925 VGND w_200_0.n512 4.67889
R10926 w_200_0.n511 w_200_0.n488 5.00498
R10927 w_200_0.n489 w_200_0.n488 10.2847
R10928 w_200_0.n490 w_200_0.n489 9.3005
R10929 VGND w_200_0.n489 0.0466957
R10930 w_200_0.n491 w_200_0.n492 6.10787
R10931 w_200_0.n489 w_200_0.n492 1.92
R10932 w_200_0.n493 w_200_0.n492 158.304
R10933 w_200_0.n494 w_200_0.n495 6.10787
R10934 w_200_0.n496 w_200_0.n491 152
R10935 w_200_0.n497 w_200_0.n490 152
R10936 w_200_0.n498 w_200_0.n494 152
R10937 w_200_0.n510 w_200_0.n495 158.304
R10938 w_200_0.n494 w_200_0.n490 36.1417
R10939 w_200_0.n490 w_200_0.n491 36.1417
R10940 w_200_0.n510 w_200_0.n498 70.1096
R10941 w_200_0.n498 w_200_0.n497 70.1096
R10942 w_200_0.n497 w_200_0.n496 70.1096
R10943 w_200_0.n496 w_200_0.n493 70.1096
R10944 w_200_0.n499 w_200_0.n510 613.747
R10945 w_200_0.n501 w_200_0.n502 152
R10946 w_200_0.n503 w_200_0.n504 152
R10947 w_200_0.n505 w_200_0.n506 152
R10948 w_200_0.n499 w_200_0.n505 70.1096
R10949 w_200_0.n505 w_200_0.n503 70.1096
R10950 w_200_0.n503 w_200_0.n501 70.1096
R10951 w_200_0.n501 w_200_0.n500 70.1096
R10952 w_200_0.n502 w_200_0.n507 6.10787
R10953 w_200_0.n504 w_200_0.n508 9.3005
R10954 w_200_0.n506 w_200_0.n509 6.10787
R10955 w_200_0.n499 w_200_0.n509 158.304
R10956 w_200_0.n506 w_200_0.n504 36.1417
R10957 w_200_0.n504 w_200_0.n502 36.1417
R10958 w_200_0.n507 w_200_0.n500 158.304
R10959 w_200_0.n509 w_200_0.n508 1.92
R10960 w_200_0.n508 w_200_0.n507 1.92
R10961 w_200_0.n505 w_200_0.n498 613.747
R10962 w_200_0.n503 w_200_0.n497 613.747
R10963 w_200_0.n501 w_200_0.n496 613.747
R10964 w_200_0.n500 w_200_0.n493 613.747
R10965 w_200_0.n495 VGND 1.8738
R10966 w_200_0.n466 w_200_0.n488 8.16967
R10967 w_200_0.n467 w_200_0.n466 9.3005
R10968 VGND w_200_0.n466 0.0466957
R10969 w_200_0.n468 w_200_0.n469 6.10787
R10970 w_200_0.n466 w_200_0.n469 1.92
R10971 w_200_0.n470 w_200_0.n469 158.304
R10972 w_200_0.n471 w_200_0.n472 6.10787
R10973 w_200_0.n473 w_200_0.n468 152
R10974 w_200_0.n474 w_200_0.n467 152
R10975 w_200_0.n475 w_200_0.n471 152
R10976 w_200_0.n487 w_200_0.n472 158.304
R10977 w_200_0.n471 w_200_0.n467 36.1417
R10978 w_200_0.n467 w_200_0.n468 36.1417
R10979 w_200_0.n487 w_200_0.n475 70.1096
R10980 w_200_0.n475 w_200_0.n474 70.1096
R10981 w_200_0.n474 w_200_0.n473 70.1096
R10982 w_200_0.n473 w_200_0.n470 70.1096
R10983 w_200_0.n476 w_200_0.n487 613.747
R10984 w_200_0.n478 w_200_0.n479 152
R10985 w_200_0.n480 w_200_0.n481 152
R10986 w_200_0.n482 w_200_0.n483 152
R10987 w_200_0.n476 w_200_0.n482 70.1096
R10988 w_200_0.n482 w_200_0.n480 70.1096
R10989 w_200_0.n480 w_200_0.n478 70.1096
R10990 w_200_0.n478 w_200_0.n477 70.1096
R10991 w_200_0.n479 w_200_0.n484 6.10787
R10992 w_200_0.n481 w_200_0.n485 9.3005
R10993 w_200_0.n483 w_200_0.n486 6.10787
R10994 w_200_0.n476 w_200_0.n486 158.304
R10995 w_200_0.n483 w_200_0.n481 36.1417
R10996 w_200_0.n481 w_200_0.n479 36.1417
R10997 w_200_0.n484 w_200_0.n477 158.304
R10998 w_200_0.n486 w_200_0.n485 1.92
R10999 w_200_0.n485 w_200_0.n484 1.92
R11000 w_200_0.n482 w_200_0.n475 613.747
R11001 w_200_0.n480 w_200_0.n474 613.747
R11002 w_200_0.n478 w_200_0.n473 613.747
R11003 w_200_0.n477 w_200_0.n470 613.747
R11004 w_200_0.n472 VGND 1.8738
R11005 w_200_0.n460 w_200_0.n461 3.4105
R11006 w_200_0.n462 w_200_0.n463 3.4105
R11007 w_200_0.n459 w_200_0.n461 5.5255
R11008 w_200_0.n461 w_200_0.n465 0.492825
R11009 w_200_0.n465 w_200_0.n463 1.62318
R11010 w_200_0.n463 w_200_0.n464 5.5255
R11011 w_200_0.n464 VGND 5.04335
R11012 w_200_0.n464 VGND 5.04335
R11013 w_200_0.n464 VGND 4.65675
R11014 w_200_0.n462 VGND 5.04335
R11015 w_200_0.n462 VGND 5.04335
R11016 w_200_0.n462 VGND 4.65675
R11017 w_200_0.n460 VGND 5.04335
R11018 w_200_0.n460 VGND 5.04335
R11019 w_200_0.n460 VGND 4.65675
R11020 w_200_0.n459 VGND 5.04335
R11021 w_200_0.n459 VGND 5.04335
R11022 w_200_0.n459 VGND 4.65675
R11023 w_200_0.n457 w_200_0.n456 19.4271
R11024 w_200_0.n457 w_200_0.n376 236.048
R11025 w_200_0.n373 w_200_0.n376 246.213
R11026 w_200_0.n380 w_200_0.n373 246.213
R11027 w_200_0.n380 w_200_0.n457 236.048
R11028 w_200_0.n455 w_200_0.n456 17.3121
R11029 w_200_0.n455 w_200_0.n366 236.048
R11030 w_200_0.n363 w_200_0.n366 246.213
R11031 w_200_0.n370 w_200_0.n363 246.213
R11032 w_200_0.n370 w_200_0.n455 236.048
R11033 w_200_0.n453 w_200_0.n454 17.3121
R11034 w_200_0.n453 w_200_0.n386 236.048
R11035 w_200_0.n383 w_200_0.n386 246.213
R11036 w_200_0.n390 w_200_0.n383 246.213
R11037 w_200_0.n390 w_200_0.n453 236.048
R11038 w_200_0.n404 w_200_0.n452 17.3121
R11039 w_200_0.n405 w_200_0.n406 73.1255
R11040 w_200_0.n406 w_200_0.n404 73.1255
R11041 w_200_0.n407 w_200_0.n408 117.001
R11042 w_200_0.n408 w_200_0.n409 117.001
R11043 w_200_0.n404 w_200_0.n409 205.929
R11044 w_200_0.n405 w_200_0.n410 73.1255
R11045 w_200_0.n410 w_200_0.n411 73.1255
R11046 w_200_0.n411 w_200_0.n409 216.095
R11047 w_200_0.n449 w_200_0.n450 117.001
R11048 w_200_0.n450 w_200_0.n451 117.001
R11049 w_200_0.n451 w_200_0.n411 216.095
R11050 w_200_0.n451 w_200_0.n404 205.929
R11051 w_200_0.n450 w_200_0.n406 3325.82
R11052 w_200_0.n406 w_200_0.n408 3325.82
R11053 w_200_0.n450 w_200_0.n410 3325.82
R11054 w_200_0.n410 w_200_0.n408 3325.82
R11055 VGND w_200_0.n449 71.9314
R11056 w_200_0.n449 w_200_0.n405 480.445
R11057 w_200_0.n405 w_200_0.n407 480.445
R11058 w_200_0.n407 w_200_0.n358 1962.49
R11059 w_200_0.n358 w_200_0.n391 1890.56
R11060 w_200_0.n412 w_200_0.n413 73.1255
R11061 w_200_0.n413 w_200_0.n414 73.1255
R11062 w_200_0.n415 w_200_0.n416 117.001
R11063 w_200_0.n416 w_200_0.n417 117.001
R11064 w_200_0.n412 w_200_0.n418 73.1255
R11065 w_200_0.n418 w_200_0.n419 73.1255
R11066 w_200_0.n420 w_200_0.n421 117.001
R11067 w_200_0.n421 w_200_0.n422 117.001
R11068 w_200_0.n423 w_200_0.n357 1553.32
R11069 w_200_0.n357 VGND 1553.32
R11070 VGND w_200_0.n420 68.5484
R11071 w_200_0.n420 w_200_0.n412 457.849
R11072 w_200_0.n412 w_200_0.n415 457.849
R11073 w_200_0.n415 w_200_0.n354 1746.03
R11074 w_200_0.n354 w_200_0.n448 124.162
R11075 w_200_0.n448 VGND 1801.65
R11076 w_200_0.n448 w_200_0.n358 8986.09
R11077 w_200_0.n358 w_200_0.n610 13096.6
R11078 w_200_0.n447 w_200_0.n357 2635.61
R11079 w_200_0.n357 w_200_0.n448 8564.74
R11080 w_200_0.n436 w_200_0.n437 73.1255
R11081 w_200_0.n437 w_200_0.n438 73.1255
R11082 w_200_0.n439 w_200_0.n440 117.001
R11083 w_200_0.n440 w_200_0.n441 117.001
R11084 w_200_0.n442 w_200_0.n443 73.1255
R11085 w_200_0.n443 w_200_0.n444 73.1255
R11086 w_200_0.n439 w_200_0.n445 117.001
R11087 w_200_0.n445 w_200_0.n446 117.001
R11088 VGND w_200_0.n442 194.659
R11089 w_200_0.n442 w_200_0.n423 448.08
R11090 w_200_0.n423 w_200_0.n439 422.372
R11091 w_200_0.n439 w_200_0.n436 870.452
R11092 w_200_0.n436 w_200_0.n447 15422.2
R11093 w_200_0.n446 w_200_0.n444 205.929
R11094 w_200_0.n444 w_200_0.n441 205.929
R11095 w_200_0.n446 w_200_0.n438 216.095
R11096 w_200_0.n438 w_200_0.n441 216.095
R11097 w_200_0.n402 w_200_0.n444 17.3121
R11098 w_200_0.n445 w_200_0.n443 3325.82
R11099 w_200_0.n443 w_200_0.n440 3325.82
R11100 w_200_0.n445 w_200_0.n437 3325.82
R11101 w_200_0.n437 w_200_0.n440 3325.82
R11102 w_200_0.n435 w_200_0.n447 10271.8
R11103 w_200_0.n424 w_200_0.n425 73.1255
R11104 w_200_0.n425 w_200_0.n426 73.1255
R11105 w_200_0.n427 w_200_0.n428 117.001
R11106 w_200_0.n428 w_200_0.n429 117.001
R11107 w_200_0.n424 w_200_0.n430 73.1255
R11108 w_200_0.n430 w_200_0.n431 73.1255
R11109 w_200_0.n432 w_200_0.n433 117.001
R11110 w_200_0.n433 w_200_0.n434 117.001
R11111 w_200_0.n356 VGND 1834.22
R11112 VGND w_200_0.n432 70.7529
R11113 w_200_0.n432 w_200_0.n424 472.574
R11114 w_200_0.n424 w_200_0.n427 472.574
R11115 w_200_0.n427 w_200_0.n355 1802.18
R11116 w_200_0.n355 w_200_0.n435 128.155
R11117 w_200_0.n435 w_200_0.n423 1859.59
R11118 w_200_0.n434 w_200_0.n431 205.929
R11119 w_200_0.n431 w_200_0.n429 205.929
R11120 w_200_0.n434 w_200_0.n426 216.095
R11121 w_200_0.n426 w_200_0.n429 216.095
R11122 w_200_0.n402 w_200_0.n431 19.4271
R11123 w_200_0.n433 w_200_0.n430 3325.82
R11124 w_200_0.n430 w_200_0.n428 3325.82
R11125 w_200_0.n433 w_200_0.n425 3325.82
R11126 w_200_0.n425 w_200_0.n428 3325.82
R11127 w_200_0.n356 w_200_0.n435 8141.14
R11128 w_200_0.n422 w_200_0.n419 205.929
R11129 w_200_0.n419 w_200_0.n417 205.929
R11130 w_200_0.n422 w_200_0.n414 216.095
R11131 w_200_0.n414 w_200_0.n417 216.095
R11132 w_200_0.n403 w_200_0.n419 17.3121
R11133 w_200_0.n421 w_200_0.n418 3325.82
R11134 w_200_0.n418 w_200_0.n416 3325.82
R11135 w_200_0.n421 w_200_0.n413 3325.82
R11136 w_200_0.n413 w_200_0.n416 3325.82
R11137 w_200_0.n401 w_200_0.n399 3789.35
R11138 w_200_0.n399 w_200_0.n396 3789.35
R11139 w_200_0.n401 w_200_0.n393 3789.35
R11140 w_200_0.n393 w_200_0.n396 3789.35
R11141 w_200_0.n389 w_200_0.n387 3789.35
R11142 w_200_0.n387 w_200_0.n385 3789.35
R11143 w_200_0.n389 w_200_0.n382 3789.35
R11144 w_200_0.n382 w_200_0.n385 3789.35
R11145 w_200_0.n379 w_200_0.n377 3789.35
R11146 w_200_0.n377 w_200_0.n375 3789.35
R11147 w_200_0.n379 w_200_0.n372 3789.35
R11148 w_200_0.n372 w_200_0.n375 3789.35
R11149 w_200_0.n369 w_200_0.n367 3789.35
R11150 w_200_0.n367 w_200_0.n365 3789.35
R11151 w_200_0.n369 w_200_0.n362 3789.35
R11152 w_200_0.n362 w_200_0.n365 3789.35
R11153 w_200_0.n350 w_200_0.n349 45286.8
R11154 w_200_0.n349 w_200_0.n347 45286.8
R11155 w_200_0.n350 w_200_0.n345 45286.8
R11156 w_200_0.n345 w_200_0.n347 45286.8
R11157 w_200_0.n343 w_200_0.n342 31670.6
R11158 w_200_0.n342 w_200_0.n340 31670.6
R11159 w_200_0.n343 w_200_0.n337 31670.6
R11160 w_200_0.n337 w_200_0.n340 31670.6
R11161 w_200_0.n334 w_200_0.n333 6813.88
R11162 w_200_0.n333 w_200_0.n331 6813.88
R11163 w_200_0.n334 w_200_0.n329 6813.88
R11164 w_200_0.n329 w_200_0.n331 6813.88
R11165 w_200_0.n327 w_200_0.n326 4108.03
R11166 w_200_0.n326 w_200_0.n324 4108.03
R11167 w_200_0.n327 w_200_0.n322 4108.03
R11168 w_200_0.n322 w_200_0.n324 4108.03
R11169 w_200_0.n320 w_200_0.n319 4108.03
R11170 w_200_0.n319 w_200_0.n317 4108.03
R11171 w_200_0.n320 w_200_0.n315 4108.03
R11172 w_200_0.n315 w_200_0.n317 4108.03
R11173 w_200_0.n313 w_200_0.n312 4108.03
R11174 w_200_0.n312 w_200_0.n310 4108.03
R11175 w_200_0.n313 w_200_0.n308 4108.03
R11176 w_200_0.n308 w_200_0.n310 4108.03
R11177 w_200_0.n306 w_200_0.n305 4108.03
R11178 w_200_0.n305 w_200_0.n303 4108.03
R11179 w_200_0.n306 w_200_0.n300 4108.03
R11180 w_200_0.n300 w_200_0.n303 4108.03
R11181 w_200_0.n297 w_200_0.n296 6813.88
R11182 w_200_0.n296 w_200_0.n293 6813.88
R11183 w_200_0.n297 w_200_0.n290 6813.88
R11184 w_200_0.n290 w_200_0.n293 6813.88
R11185 w_200_0.n287 w_200_0.n286 6813.88
R11186 w_200_0.n286 w_200_0.n284 6813.88
R11187 w_200_0.n287 w_200_0.n282 6813.88
R11188 w_200_0.n282 w_200_0.n284 6813.88
R11189 w_200_0.n280 w_200_0.n279 4108.03
R11190 w_200_0.n279 w_200_0.n277 4108.03
R11191 w_200_0.n280 w_200_0.n275 4108.03
R11192 w_200_0.n275 w_200_0.n277 4108.03
R11193 w_200_0.n273 w_200_0.n272 4108.03
R11194 w_200_0.n272 w_200_0.n270 4108.03
R11195 w_200_0.n273 w_200_0.n268 4108.03
R11196 w_200_0.n268 w_200_0.n270 4108.03
R11197 w_200_0.n266 w_200_0.n265 4108.03
R11198 w_200_0.n265 w_200_0.n263 4108.03
R11199 w_200_0.n266 w_200_0.n261 4108.03
R11200 w_200_0.n261 w_200_0.n263 4108.03
R11201 w_200_0.n259 w_200_0.n258 4108.03
R11202 w_200_0.n258 w_200_0.n256 4108.03
R11203 w_200_0.n259 w_200_0.n253 4108.03
R11204 w_200_0.n253 w_200_0.n256 4108.03
R11205 w_200_0.n250 w_200_0.n249 6813.88
R11206 w_200_0.n249 w_200_0.n246 6813.88
R11207 w_200_0.n250 w_200_0.n243 6813.88
R11208 w_200_0.n243 w_200_0.n246 6813.88
R11209 w_200_0.n240 w_200_0.n239 3789.35
R11210 w_200_0.n239 w_200_0.n237 3789.35
R11211 w_200_0.n240 w_200_0.n235 3789.35
R11212 w_200_0.n235 w_200_0.n237 3789.35
R11213 w_200_0.n233 w_200_0.n232 3789.35
R11214 w_200_0.n232 w_200_0.n230 3789.35
R11215 w_200_0.n233 w_200_0.n228 3789.35
R11216 w_200_0.n228 w_200_0.n230 3789.35
R11217 w_200_0.n226 w_200_0.n225 3789.35
R11218 w_200_0.n225 w_200_0.n223 3789.35
R11219 w_200_0.n226 w_200_0.n221 3789.35
R11220 w_200_0.n221 w_200_0.n223 3789.35
R11221 w_200_0.n219 w_200_0.n218 3789.35
R11222 w_200_0.n218 w_200_0.n216 3789.35
R11223 w_200_0.n219 w_200_0.n214 3789.35
R11224 w_200_0.n214 w_200_0.n216 3789.35
R11225 w_200_0.n212 w_200_0.n211 3789.35
R11226 w_200_0.n211 w_200_0.n209 3789.35
R11227 w_200_0.n212 w_200_0.n207 3789.35
R11228 w_200_0.n207 w_200_0.n209 3789.35
R11229 w_200_0.n205 w_200_0.n204 3789.35
R11230 w_200_0.n204 w_200_0.n202 3789.35
R11231 w_200_0.n205 w_200_0.n200 3789.35
R11232 w_200_0.n200 w_200_0.n202 3789.35
R11233 w_200_0.n198 w_200_0.n197 3789.35
R11234 w_200_0.n197 w_200_0.n195 3789.35
R11235 w_200_0.n198 w_200_0.n193 3789.35
R11236 w_200_0.n193 w_200_0.n195 3789.35
R11237 w_200_0.n191 w_200_0.n190 3789.35
R11238 w_200_0.n190 w_200_0.n187 3789.35
R11239 w_200_0.n191 w_200_0.n184 3789.35
R11240 w_200_0.n184 w_200_0.n187 3789.35
R11241 w_200_0.n181 w_200_0.n180 3789.35
R11242 w_200_0.n180 w_200_0.n178 3789.35
R11243 w_200_0.n181 w_200_0.n176 3789.35
R11244 w_200_0.n176 w_200_0.n178 3789.35
R11245 w_200_0.n174 w_200_0.n173 3789.35
R11246 w_200_0.n173 w_200_0.n171 3789.35
R11247 w_200_0.n174 w_200_0.n169 3789.35
R11248 w_200_0.n169 w_200_0.n171 3789.35
R11249 w_200_0.n167 w_200_0.n166 3789.35
R11250 w_200_0.n166 w_200_0.n164 3789.35
R11251 w_200_0.n167 w_200_0.n162 3789.35
R11252 w_200_0.n162 w_200_0.n164 3789.35
R11253 w_200_0.n160 w_200_0.n159 3789.35
R11254 w_200_0.n159 w_200_0.n157 3789.35
R11255 w_200_0.n160 w_200_0.n155 3789.35
R11256 w_200_0.n155 w_200_0.n157 3789.35
R11257 w_200_0.n153 w_200_0.n152 3789.35
R11258 w_200_0.n152 w_200_0.n150 3789.35
R11259 w_200_0.n153 w_200_0.n148 3789.35
R11260 w_200_0.n148 w_200_0.n150 3789.35
R11261 w_200_0.n146 w_200_0.n145 3789.35
R11262 w_200_0.n145 w_200_0.n143 3789.35
R11263 w_200_0.n146 w_200_0.n141 3789.35
R11264 w_200_0.n141 w_200_0.n143 3789.35
R11265 w_200_0.n139 w_200_0.n138 3789.35
R11266 w_200_0.n138 w_200_0.n136 3789.35
R11267 w_200_0.n139 w_200_0.n134 3789.35
R11268 w_200_0.n134 w_200_0.n136 3789.35
R11269 w_200_0.n132 w_200_0.n131 3789.35
R11270 w_200_0.n131 w_200_0.n128 3789.35
R11271 w_200_0.n132 w_200_0.n125 3789.35
R11272 w_200_0.n125 w_200_0.n128 3789.35
R11273 w_200_0.n122 w_200_0.n121 45286.8
R11274 w_200_0.n121 w_200_0.n119 45286.8
R11275 w_200_0.n122 w_200_0.n116 45286.8
R11276 w_200_0.n116 w_200_0.n119 45286.8
R11277 w_200_0.n113 w_200_0.n112 11165.3
R11278 w_200_0.n112 w_200_0.n110 11165.3
R11279 w_200_0.n113 w_200_0.n108 11165.3
R11280 w_200_0.n108 w_200_0.n110 11165.3
R11281 w_200_0.n106 w_200_0.n105 11165.3
R11282 w_200_0.n105 w_200_0.n102 11165.3
R11283 w_200_0.n106 w_200_0.n99 11165.3
R11284 w_200_0.n99 w_200_0.n102 11165.3
R11285 w_200_0.n96 w_200_0.n95 6622.68
R11286 w_200_0.n95 w_200_0.n93 6622.68
R11287 w_200_0.n96 w_200_0.n91 6622.68
R11288 w_200_0.n91 w_200_0.n93 6622.68
R11289 w_200_0.n89 w_200_0.n88 6622.68
R11290 w_200_0.n88 w_200_0.n85 6622.68
R11291 w_200_0.n89 w_200_0.n82 6622.68
R11292 w_200_0.n82 w_200_0.n85 6622.68
R11293 w_200_0.n79 w_200_0.n78 58903
R11294 w_200_0.n78 w_200_0.n75 58903
R11295 w_200_0.n79 w_200_0.n72 58903
R11296 w_200_0.n72 w_200_0.n75 58903
R11297 w_200_0.n69 w_200_0.n68 30500.2
R11298 w_200_0.n65 w_200_0.n68 30500.2
R11299 w_200_0.n69 w_200_0.n62 30500.2
R11300 w_200_0.n62 w_200_0.n65 30500.2
R11301 w_200_0.n59 w_200_0.n58 3325.82
R11302 w_200_0.n58 w_200_0.n56 3325.82
R11303 w_200_0.n59 w_200_0.n54 3325.82
R11304 w_200_0.n54 w_200_0.n56 3325.82
R11305 w_200_0.n52 w_200_0.n51 3325.82
R11306 w_200_0.n51 w_200_0.n49 3325.82
R11307 w_200_0.n52 w_200_0.n47 3325.82
R11308 w_200_0.n47 w_200_0.n49 3325.82
R11309 w_200_0.n45 w_200_0.n44 2769.59
R11310 w_200_0.n44 w_200_0.n42 2769.59
R11311 w_200_0.n45 w_200_0.n40 2769.59
R11312 w_200_0.n40 w_200_0.n42 2769.59
R11313 w_200_0.n38 w_200_0.n37 3325.82
R11314 w_200_0.n37 w_200_0.n35 3325.82
R11315 w_200_0.n38 w_200_0.n33 3325.82
R11316 w_200_0.n33 w_200_0.n35 3325.82
R11317 w_200_0.n31 w_200_0.n30 2769.59
R11318 w_200_0.n30 w_200_0.n28 2769.59
R11319 w_200_0.n31 w_200_0.n26 2769.59
R11320 w_200_0.n26 w_200_0.n28 2769.59
R11321 w_200_0.n24 w_200_0.n23 5006.12
R11322 w_200_0.n23 w_200_0.n21 5006.12
R11323 w_200_0.n24 w_200_0.n19 5006.12
R11324 w_200_0.n19 w_200_0.n21 5006.12
R11325 w_200_0.n17 w_200_0.n16 2769.59
R11326 w_200_0.n16 w_200_0.n14 2769.59
R11327 w_200_0.n17 w_200_0.n11 2769.59
R11328 w_200_0.n11 w_200_0.n14 2769.59
R11329 w_200_0.n8 w_200_0.n7 5006.12
R11330 w_200_0.n7 w_200_0.n4 5006.12
R11331 w_200_0.n8 w_200_0.n1 5006.12
R11332 w_200_0.n1 w_200_0.n4 5006.12
C464 ua[4] VGND 0.14356f
C465 ua[5] VGND 0.14356f
C466 ua[6] VGND 0.14638f
C467 ua[7] VGND 0.14638f
C468 ena VGND 0.07027f
C469 rst_n VGND 0.04194f
C470 ui_in[1] VGND 0.04169f
C471 ui_in[2] VGND 0.04177f
C472 ui_in[3] VGND 0.04177f
C473 ui_in[4] VGND 0.04177f
C474 ui_in[5] VGND 0.03659f
C475 ui_in[6] VGND 0.0408f
C476 ui_in[7] VGND 0.04128f
C477 uio_in[0] VGND 0.04128f
C478 uio_in[1] VGND 0.04128f
C479 uio_in[2] VGND 0.04131f
C480 uio_in[3] VGND 0.0411f
C481 uio_in[4] VGND 0.04095f
C482 uio_in[5] VGND 0.03815f
C483 uio_in[6] VGND 0.04131f
C484 uio_in[7] VGND 0.04131f
C485 uo_out[0] VGND 0.04131f
C486 uo_out[1] VGND 0.04131f
C487 uo_out[2] VGND 0.04047f
C488 uo_out[3] VGND 0.04147f
C489 uo_out[4] VGND 0.04159f
C490 uo_out[5] VGND 0.04159f
C491 uo_out[6] VGND 0.04159f
C492 uo_out[7] VGND 0.04159f
C493 uio_out[0] VGND 0.04125f
C494 uio_out[1] VGND 0.04091f
C495 uio_out[2] VGND 0.04117f
C496 uio_out[3] VGND 0.04117f
C497 uio_out[4] VGND 0.04117f
C498 uio_out[5] VGND 0.03652f
C499 uio_out[6] VGND 0.0412f
C500 uio_out[7] VGND 0.04041f
C501 uio_oe[0] VGND 0.04072f
C502 uio_oe[1] VGND 0.03866f
C503 uio_oe[2] VGND 0.03871f
C504 uio_oe[3] VGND 0.04221f
C505 uio_oe[4] VGND 0.04221f
C506 uio_oe[5] VGND 0.04221f
C507 uio_oe[6] VGND 0.04204f
C508 uio_oe[7] VGND 0.06994f
C509 w_200_0.n0 VGND 0.03842f ; **FLOATING
C510 w_200_0.n1 VGND 0 ; **FLOATING
C511 w_200_0.n2 VGND 0 ; **FLOATING
C512 w_200_0.n3 VGND 0.00849f ; **FLOATING
C513 w_200_0.n4 VGND 0 ; **FLOATING
C514 w_200_0.n5 VGND 0 ; **FLOATING
C515 w_200_0.n6 VGND 0.01038f ; **FLOATING
C516 w_200_0.n7 VGND 0 ; **FLOATING
C517 w_200_0.n8 VGND 0 ; **FLOATING
C518 w_200_0.n9 VGND 0 ; **FLOATING
C519 w_200_0.n10 VGND 0.01199f ; **FLOATING
C520 w_200_0.n11 VGND 0 ; **FLOATING
C521 w_200_0.n12 VGND 0 ; **FLOATING
C522 w_200_0.n13 VGND 0.01199f ; **FLOATING
C523 w_200_0.n14 VGND 0 ; **FLOATING
C524 w_200_0.n15 VGND 0 ; **FLOATING
C525 w_200_0.n16 VGND 0 ; **FLOATING
C526 w_200_0.n17 VGND 0 ; **FLOATING
C527 w_200_0.n18 VGND 0 ; **FLOATING
C528 w_200_0.n19 VGND 0 ; **FLOATING
C529 w_200_0.n20 VGND 0 ; **FLOATING
C530 w_200_0.n21 VGND 0 ; **FLOATING
C531 w_200_0.n22 VGND 0 ; **FLOATING
C532 w_200_0.n23 VGND 0 ; **FLOATING
C533 w_200_0.n24 VGND 0 ; **FLOATING
C534 w_200_0.n25 VGND 0 ; **FLOATING
C535 w_200_0.n26 VGND 0 ; **FLOATING
C536 w_200_0.n27 VGND 0 ; **FLOATING
C537 w_200_0.n28 VGND 0 ; **FLOATING
C538 w_200_0.n29 VGND 0 ; **FLOATING
C539 w_200_0.n30 VGND 0 ; **FLOATING
C540 w_200_0.n31 VGND 0 ; **FLOATING
C541 w_200_0.n32 VGND 0 ; **FLOATING
C542 w_200_0.n33 VGND 0 ; **FLOATING
C543 w_200_0.n34 VGND 0 ; **FLOATING
C544 w_200_0.n35 VGND 0 ; **FLOATING
C545 w_200_0.n36 VGND 0 ; **FLOATING
C546 w_200_0.n37 VGND 0 ; **FLOATING
C547 w_200_0.n38 VGND 0 ; **FLOATING
C548 w_200_0.n39 VGND 0 ; **FLOATING
C549 w_200_0.n40 VGND 0 ; **FLOATING
C550 w_200_0.n41 VGND 0 ; **FLOATING
C551 w_200_0.n42 VGND 0 ; **FLOATING
C552 w_200_0.n43 VGND 0 ; **FLOATING
C553 w_200_0.n44 VGND 0 ; **FLOATING
C554 w_200_0.n45 VGND 0 ; **FLOATING
C555 w_200_0.n46 VGND 0 ; **FLOATING
C556 w_200_0.n47 VGND 0 ; **FLOATING
C557 w_200_0.n48 VGND 0 ; **FLOATING
C558 w_200_0.n49 VGND 0 ; **FLOATING
C559 w_200_0.n50 VGND 0 ; **FLOATING
C560 w_200_0.n51 VGND 0 ; **FLOATING
C561 w_200_0.n52 VGND 0 ; **FLOATING
C562 w_200_0.n53 VGND 0 ; **FLOATING
C563 w_200_0.n54 VGND 0 ; **FLOATING
C564 w_200_0.n55 VGND 0 ; **FLOATING
C565 w_200_0.n56 VGND 0 ; **FLOATING
C566 w_200_0.n57 VGND 0 ; **FLOATING
C567 w_200_0.n58 VGND 0 ; **FLOATING
C568 w_200_0.n59 VGND 0 ; **FLOATING
C569 w_200_0.n60 VGND 0 ; **FLOATING
C570 w_200_0.n61 VGND 0.5975f ; **FLOATING
C571 w_200_0.n62 VGND 0 ; **FLOATING
C572 w_200_0.n63 VGND 0 ; **FLOATING
C573 w_200_0.n64 VGND 0.06051f ; **FLOATING
C574 w_200_0.n65 VGND 0 ; **FLOATING
C575 w_200_0.n66 VGND 0 ; **FLOATING
C576 w_200_0.n67 VGND 0.08593f ; **FLOATING
C577 w_200_0.n68 VGND 0 ; **FLOATING
C578 w_200_0.n69 VGND 0 ; **FLOATING
C579 w_200_0.n70 VGND 0 ; **FLOATING
C580 w_200_0.n71 VGND 0.09251f ; **FLOATING
C581 w_200_0.n72 VGND 0 ; **FLOATING
C582 w_200_0.n73 VGND 0 ; **FLOATING
C583 w_200_0.n74 VGND 0.10307f ; **FLOATING
C584 w_200_0.n75 VGND 0 ; **FLOATING
C585 w_200_0.n76 VGND 0 ; **FLOATING
C586 w_200_0.n77 VGND 0.09309f ; **FLOATING
C587 w_200_0.n78 VGND 0 ; **FLOATING
C588 w_200_0.n79 VGND 0 ; **FLOATING
C589 w_200_0.n80 VGND 0 ; **FLOATING
C590 w_200_0.n81 VGND 0.03143f ; **FLOATING
C591 w_200_0.n82 VGND 0 ; **FLOATING
C592 w_200_0.n83 VGND 0 ; **FLOATING
C593 w_200_0.n84 VGND 0.0136f ; **FLOATING
C594 w_200_0.n85 VGND 0 ; **FLOATING
C595 w_200_0.n86 VGND 0 ; **FLOATING
C596 w_200_0.n87 VGND 0.01389f ; **FLOATING
C597 w_200_0.n88 VGND 0 ; **FLOATING
C598 w_200_0.n89 VGND 0 ; **FLOATING
C599 w_200_0.n90 VGND 0 ; **FLOATING
C600 w_200_0.n91 VGND 0 ; **FLOATING
C601 w_200_0.n92 VGND 0 ; **FLOATING
C602 w_200_0.n93 VGND 0 ; **FLOATING
C603 w_200_0.n94 VGND 0 ; **FLOATING
C604 w_200_0.n95 VGND 0 ; **FLOATING
C605 w_200_0.n96 VGND 0 ; **FLOATING
C606 w_200_0.n97 VGND 0 ; **FLOATING
C607 w_200_0.n98 VGND 0.01199f ; **FLOATING
C608 w_200_0.n99 VGND 0 ; **FLOATING
C609 w_200_0.n100 VGND 0 ; **FLOATING
C610 w_200_0.n101 VGND 0.03484f ; **FLOATING
C611 w_200_0.n102 VGND 0 ; **FLOATING
C612 w_200_0.n103 VGND 0 ; **FLOATING
C613 w_200_0.n104 VGND 0.04583f ; **FLOATING
C614 w_200_0.n105 VGND 0 ; **FLOATING
C615 w_200_0.n106 VGND 0 ; **FLOATING
C616 w_200_0.n107 VGND 0 ; **FLOATING
C617 w_200_0.n108 VGND 0 ; **FLOATING
C618 w_200_0.n109 VGND 0 ; **FLOATING
C619 w_200_0.n110 VGND 0 ; **FLOATING
C620 w_200_0.n111 VGND 0 ; **FLOATING
C621 w_200_0.n112 VGND 0 ; **FLOATING
C622 w_200_0.n113 VGND 0 ; **FLOATING
C623 w_200_0.n114 VGND 0 ; **FLOATING
C624 w_200_0.n115 VGND 0.02553f ; **FLOATING
C625 w_200_0.n116 VGND 0 ; **FLOATING
C626 w_200_0.n117 VGND 0 ; **FLOATING
C627 w_200_0.n118 VGND 0.10716f ; **FLOATING
C628 w_200_0.n119 VGND 0 ; **FLOATING
C629 w_200_0.n120 VGND 0 ; **FLOATING
C630 w_200_0.n121 VGND 0 ; **FLOATING
C631 w_200_0.n122 VGND 0 ; **FLOATING
C632 w_200_0.n123 VGND 0 ; **FLOATING
C633 w_200_0.n124 VGND 0.02295f ; **FLOATING
C634 w_200_0.n125 VGND 0 ; **FLOATING
C635 w_200_0.n126 VGND 0 ; **FLOATING
C636 w_200_0.n127 VGND 0.0227f ; **FLOATING
C637 w_200_0.n128 VGND 0 ; **FLOATING
C638 w_200_0.n129 VGND 0 ; **FLOATING
C639 w_200_0.n130 VGND 0.01325f ; **FLOATING
C640 w_200_0.n131 VGND 0 ; **FLOATING
C641 w_200_0.n132 VGND 0 ; **FLOATING
C642 w_200_0.n133 VGND 0 ; **FLOATING
C643 w_200_0.n134 VGND 0 ; **FLOATING
C644 w_200_0.n135 VGND 0 ; **FLOATING
C645 w_200_0.n136 VGND 0 ; **FLOATING
C646 w_200_0.n137 VGND 0 ; **FLOATING
C647 w_200_0.n138 VGND 0 ; **FLOATING
C648 w_200_0.n139 VGND 0 ; **FLOATING
C649 w_200_0.n140 VGND 0 ; **FLOATING
C650 w_200_0.n141 VGND 0 ; **FLOATING
C651 w_200_0.n142 VGND 0 ; **FLOATING
C652 w_200_0.n143 VGND 0 ; **FLOATING
C653 w_200_0.n144 VGND 0 ; **FLOATING
C654 w_200_0.n145 VGND 0 ; **FLOATING
C655 w_200_0.n146 VGND 0 ; **FLOATING
C656 w_200_0.n147 VGND 0 ; **FLOATING
C657 w_200_0.n148 VGND 0 ; **FLOATING
C658 w_200_0.n149 VGND 0 ; **FLOATING
C659 w_200_0.n150 VGND 0 ; **FLOATING
C660 w_200_0.n151 VGND 0 ; **FLOATING
C661 w_200_0.n152 VGND 0 ; **FLOATING
C662 w_200_0.n153 VGND 0 ; **FLOATING
C663 w_200_0.n154 VGND 0 ; **FLOATING
C664 w_200_0.n155 VGND 0 ; **FLOATING
C665 w_200_0.n156 VGND 0 ; **FLOATING
C666 w_200_0.n157 VGND 0 ; **FLOATING
C667 w_200_0.n158 VGND 0 ; **FLOATING
C668 w_200_0.n159 VGND 0 ; **FLOATING
C669 w_200_0.n160 VGND 0 ; **FLOATING
C670 w_200_0.n161 VGND 0 ; **FLOATING
C671 w_200_0.n162 VGND 0 ; **FLOATING
C672 w_200_0.n163 VGND 0 ; **FLOATING
C673 w_200_0.n164 VGND 0 ; **FLOATING
C674 w_200_0.n165 VGND 0 ; **FLOATING
C675 w_200_0.n166 VGND 0 ; **FLOATING
C676 w_200_0.n167 VGND 0 ; **FLOATING
C677 w_200_0.n168 VGND 0 ; **FLOATING
C678 w_200_0.n169 VGND 0 ; **FLOATING
C679 w_200_0.n170 VGND 0 ; **FLOATING
C680 w_200_0.n171 VGND 0 ; **FLOATING
C681 w_200_0.n172 VGND 0 ; **FLOATING
C682 w_200_0.n173 VGND 0 ; **FLOATING
C683 w_200_0.n174 VGND 0 ; **FLOATING
C684 w_200_0.n175 VGND 0 ; **FLOATING
C685 w_200_0.n176 VGND 0 ; **FLOATING
C686 w_200_0.n177 VGND 0 ; **FLOATING
C687 w_200_0.n178 VGND 0 ; **FLOATING
C688 w_200_0.n179 VGND 0 ; **FLOATING
C689 w_200_0.n180 VGND 0 ; **FLOATING
C690 w_200_0.n181 VGND 0 ; **FLOATING
C691 w_200_0.n182 VGND 0 ; **FLOATING
C692 w_200_0.n183 VGND 0.02972f ; **FLOATING
C693 w_200_0.n184 VGND 0 ; **FLOATING
C694 w_200_0.n185 VGND 0 ; **FLOATING
C695 w_200_0.n186 VGND 0.0227f ; **FLOATING
C696 w_200_0.n187 VGND 0 ; **FLOATING
C697 w_200_0.n188 VGND 0 ; **FLOATING
C698 w_200_0.n189 VGND 0.01325f ; **FLOATING
C699 w_200_0.n190 VGND 0 ; **FLOATING
C700 w_200_0.n191 VGND 0 ; **FLOATING
C701 w_200_0.n192 VGND 0 ; **FLOATING
C702 w_200_0.n193 VGND 0 ; **FLOATING
C703 w_200_0.n194 VGND 0 ; **FLOATING
C704 w_200_0.n195 VGND 0 ; **FLOATING
C705 w_200_0.n196 VGND 0 ; **FLOATING
C706 w_200_0.n197 VGND 0 ; **FLOATING
C707 w_200_0.n198 VGND 0 ; **FLOATING
C708 w_200_0.n199 VGND 0 ; **FLOATING
C709 w_200_0.n200 VGND 0 ; **FLOATING
C710 w_200_0.n201 VGND 0 ; **FLOATING
C711 w_200_0.n202 VGND 0 ; **FLOATING
C712 w_200_0.n203 VGND 0 ; **FLOATING
C713 w_200_0.n204 VGND 0 ; **FLOATING
C714 w_200_0.n205 VGND 0 ; **FLOATING
C715 w_200_0.n206 VGND 0 ; **FLOATING
C716 w_200_0.n207 VGND 0 ; **FLOATING
C717 w_200_0.n208 VGND 0 ; **FLOATING
C718 w_200_0.n209 VGND 0 ; **FLOATING
C719 w_200_0.n210 VGND 0 ; **FLOATING
C720 w_200_0.n211 VGND 0 ; **FLOATING
C721 w_200_0.n212 VGND 0 ; **FLOATING
C722 w_200_0.n213 VGND 0 ; **FLOATING
C723 w_200_0.n214 VGND 0 ; **FLOATING
C724 w_200_0.n215 VGND 0 ; **FLOATING
C725 w_200_0.n216 VGND 0 ; **FLOATING
C726 w_200_0.n217 VGND 0 ; **FLOATING
C727 w_200_0.n218 VGND 0 ; **FLOATING
C728 w_200_0.n219 VGND 0 ; **FLOATING
C729 w_200_0.n220 VGND 0 ; **FLOATING
C730 w_200_0.n221 VGND 0 ; **FLOATING
C731 w_200_0.n222 VGND 0 ; **FLOATING
C732 w_200_0.n223 VGND 0 ; **FLOATING
C733 w_200_0.n224 VGND 0 ; **FLOATING
C734 w_200_0.n225 VGND 0 ; **FLOATING
C735 w_200_0.n226 VGND 0 ; **FLOATING
C736 w_200_0.n227 VGND 0 ; **FLOATING
C737 w_200_0.n228 VGND 0 ; **FLOATING
C738 w_200_0.n229 VGND 0 ; **FLOATING
C739 w_200_0.n230 VGND 0 ; **FLOATING
C740 w_200_0.n231 VGND 0 ; **FLOATING
C741 w_200_0.n232 VGND 0 ; **FLOATING
C742 w_200_0.n233 VGND 0 ; **FLOATING
C743 w_200_0.n234 VGND 0 ; **FLOATING
C744 w_200_0.n235 VGND 0 ; **FLOATING
C745 w_200_0.n236 VGND 0 ; **FLOATING
C746 w_200_0.n237 VGND 0 ; **FLOATING
C747 w_200_0.n238 VGND 0 ; **FLOATING
C748 w_200_0.n239 VGND 0 ; **FLOATING
C749 w_200_0.n240 VGND 0 ; **FLOATING
C750 w_200_0.n241 VGND 0 ; **FLOATING
C751 w_200_0.n242 VGND 0.02667f ; **FLOATING
C752 w_200_0.n243 VGND 0 ; **FLOATING
C753 w_200_0.n244 VGND 0 ; **FLOATING
C754 w_200_0.n245 VGND 0.01135f ; **FLOATING
C755 w_200_0.n246 VGND 0 ; **FLOATING
C756 w_200_0.n247 VGND 0 ; **FLOATING
C757 w_200_0.n248 VGND 0.01325f ; **FLOATING
C758 w_200_0.n249 VGND 0 ; **FLOATING
C759 w_200_0.n250 VGND 0 ; **FLOATING
C760 w_200_0.n251 VGND 0 ; **FLOATING
C761 w_200_0.n252 VGND 0.01318f ; **FLOATING
C762 w_200_0.n253 VGND 0 ; **FLOATING
C763 w_200_0.n254 VGND 0 ; **FLOATING
C764 w_200_0.n255 VGND 0.01318f ; **FLOATING
C765 w_200_0.n256 VGND 0 ; **FLOATING
C766 w_200_0.n257 VGND 0 ; **FLOATING
C767 w_200_0.n258 VGND 0 ; **FLOATING
C768 w_200_0.n259 VGND 0 ; **FLOATING
C769 w_200_0.n260 VGND 0 ; **FLOATING
C770 w_200_0.n261 VGND 0 ; **FLOATING
C771 w_200_0.n262 VGND 0 ; **FLOATING
C772 w_200_0.n263 VGND 0 ; **FLOATING
C773 w_200_0.n264 VGND 0 ; **FLOATING
C774 w_200_0.n265 VGND 0 ; **FLOATING
C775 w_200_0.n266 VGND 0 ; **FLOATING
C776 w_200_0.n267 VGND 0 ; **FLOATING
C777 w_200_0.n268 VGND 0 ; **FLOATING
C778 w_200_0.n269 VGND 0 ; **FLOATING
C779 w_200_0.n270 VGND 0 ; **FLOATING
C780 w_200_0.n271 VGND 0 ; **FLOATING
C781 w_200_0.n272 VGND 0 ; **FLOATING
C782 w_200_0.n273 VGND 0 ; **FLOATING
C783 w_200_0.n274 VGND 0 ; **FLOATING
C784 w_200_0.n275 VGND 0 ; **FLOATING
C785 w_200_0.n276 VGND 0 ; **FLOATING
C786 w_200_0.n277 VGND 0 ; **FLOATING
C787 w_200_0.n278 VGND 0 ; **FLOATING
C788 w_200_0.n279 VGND 0 ; **FLOATING
C789 w_200_0.n280 VGND 0 ; **FLOATING
C790 w_200_0.n281 VGND 0 ; **FLOATING
C791 w_200_0.n282 VGND 0 ; **FLOATING
C792 w_200_0.n283 VGND 0 ; **FLOATING
C793 w_200_0.n284 VGND 0 ; **FLOATING
C794 w_200_0.n285 VGND 0 ; **FLOATING
C795 w_200_0.n286 VGND 0 ; **FLOATING
C796 w_200_0.n287 VGND 0 ; **FLOATING
C797 w_200_0.n288 VGND 0 ; **FLOATING
C798 w_200_0.n289 VGND 0.07143f ; **FLOATING
C799 w_200_0.n290 VGND 0 ; **FLOATING
C800 w_200_0.n291 VGND 0 ; **FLOATING
C801 w_200_0.n292 VGND 0.01135f ; **FLOATING
C802 w_200_0.n293 VGND 0 ; **FLOATING
C803 w_200_0.n294 VGND 0 ; **FLOATING
C804 w_200_0.n295 VGND 0.01325f ; **FLOATING
C805 w_200_0.n296 VGND 0 ; **FLOATING
C806 w_200_0.n297 VGND 0 ; **FLOATING
C807 w_200_0.n298 VGND 0 ; **FLOATING
C808 w_200_0.n299 VGND 0.01318f ; **FLOATING
C809 w_200_0.n300 VGND 0 ; **FLOATING
C810 w_200_0.n301 VGND 0 ; **FLOATING
C811 w_200_0.n302 VGND 0.01318f ; **FLOATING
C812 w_200_0.n303 VGND 0 ; **FLOATING
C813 w_200_0.n304 VGND 0 ; **FLOATING
C814 w_200_0.n305 VGND 0 ; **FLOATING
C815 w_200_0.n306 VGND 0 ; **FLOATING
C816 w_200_0.n307 VGND 0 ; **FLOATING
C817 w_200_0.n308 VGND 0 ; **FLOATING
C818 w_200_0.n309 VGND 0 ; **FLOATING
C819 w_200_0.n310 VGND 0 ; **FLOATING
C820 w_200_0.n311 VGND 0 ; **FLOATING
C821 w_200_0.n312 VGND 0 ; **FLOATING
C822 w_200_0.n313 VGND 0 ; **FLOATING
C823 w_200_0.n314 VGND 0 ; **FLOATING
C824 w_200_0.n315 VGND 0 ; **FLOATING
C825 w_200_0.n316 VGND 0 ; **FLOATING
C826 w_200_0.n317 VGND 0 ; **FLOATING
C827 w_200_0.n318 VGND 0 ; **FLOATING
C828 w_200_0.n319 VGND 0 ; **FLOATING
C829 w_200_0.n320 VGND 0 ; **FLOATING
C830 w_200_0.n321 VGND 0 ; **FLOATING
C831 w_200_0.n322 VGND 0 ; **FLOATING
C832 w_200_0.n323 VGND 0 ; **FLOATING
C833 w_200_0.n324 VGND 0 ; **FLOATING
C834 w_200_0.n325 VGND 0 ; **FLOATING
C835 w_200_0.n326 VGND 0 ; **FLOATING
C836 w_200_0.n327 VGND 0 ; **FLOATING
C837 w_200_0.n328 VGND 0 ; **FLOATING
C838 w_200_0.n329 VGND 0 ; **FLOATING
C839 w_200_0.n330 VGND 0 ; **FLOATING
C840 w_200_0.n331 VGND 0 ; **FLOATING
C841 w_200_0.n332 VGND 0 ; **FLOATING
C842 w_200_0.n333 VGND 0 ; **FLOATING
C843 w_200_0.n334 VGND 0 ; **FLOATING
C844 w_200_0.n335 VGND 0 ; **FLOATING
C845 w_200_0.n336 VGND 0.02213f ; **FLOATING
C846 w_200_0.n337 VGND 0 ; **FLOATING
C847 w_200_0.n338 VGND 0 ; **FLOATING
C848 w_200_0.n339 VGND 0.10064f ; **FLOATING
C849 w_200_0.n340 VGND 0 ; **FLOATING
C850 w_200_0.n341 VGND 0 ; **FLOATING
C851 w_200_0.n342 VGND 0 ; **FLOATING
C852 w_200_0.n343 VGND 0 ; **FLOATING
C853 w_200_0.n344 VGND 0 ; **FLOATING
C854 w_200_0.n345 VGND 0 ; **FLOATING
C855 w_200_0.n346 VGND 0 ; **FLOATING
C856 w_200_0.n347 VGND 0 ; **FLOATING
C857 w_200_0.n348 VGND 0 ; **FLOATING
C858 w_200_0.n349 VGND 0 ; **FLOATING
C859 w_200_0.n350 VGND 0 ; **FLOATING
C860 w_200_0.n351 VGND 0 ; **FLOATING
C861 w_200_0.n352 VGND 0.02798f ; **FLOATING
C862 w_200_0.n353 VGND 0.02012f ; **FLOATING
C863 w_200_0.n354 VGND 0.00755f ; **FLOATING
C864 w_200_0.n355 VGND 0.00774f ; **FLOATING
C865 w_200_0.n356 VGND 0.03014f ; **FLOATING
C866 w_200_0.n357 VGND 0.02046f ; **FLOATING
C867 w_200_0.n358 VGND 0.02711f ; **FLOATING
C868 w_200_0.n359 VGND 0.00774f ; **FLOATING
C869 w_200_0.n360 VGND 0.02299f ; **FLOATING
C870 w_200_0.n361 VGND 0.00259f ; **FLOATING
C871 w_200_0.n362 VGND 0 ; **FLOATING
C872 w_200_0.n363 VGND 0 ; **FLOATING
C873 w_200_0.n364 VGND 0.00658f ; **FLOATING
C874 w_200_0.n365 VGND 0 ; **FLOATING
C875 w_200_0.n366 VGND 0 ; **FLOATING
C876 w_200_0.n367 VGND 0 ; **FLOATING
C877 w_200_0.n368 VGND 0.00149f ; **FLOATING
C878 w_200_0.n369 VGND 0 ; **FLOATING
C879 w_200_0.n370 VGND 0 ; **FLOATING
C880 w_200_0.n371 VGND 0.00259f ; **FLOATING
C881 w_200_0.n372 VGND 0 ; **FLOATING
C882 w_200_0.n373 VGND 0 ; **FLOATING
C883 w_200_0.n374 VGND 0.01666f ; **FLOATING
C884 w_200_0.n375 VGND 0 ; **FLOATING
C885 w_200_0.n376 VGND 0 ; **FLOATING
C886 w_200_0.n377 VGND 0 ; **FLOATING
C887 w_200_0.n378 VGND 0.00149f ; **FLOATING
C888 w_200_0.n379 VGND 0 ; **FLOATING
C889 w_200_0.n380 VGND 0 ; **FLOATING
C890 w_200_0.n381 VGND 0.00263f ; **FLOATING
C891 w_200_0.n382 VGND 0 ; **FLOATING
C892 w_200_0.n383 VGND 0 ; **FLOATING
C893 w_200_0.n384 VGND 0.00633f ; **FLOATING
C894 w_200_0.n385 VGND 0 ; **FLOATING
C895 w_200_0.n386 VGND 0 ; **FLOATING
C896 w_200_0.n387 VGND 0 ; **FLOATING
C897 w_200_0.n388 VGND 0.00151f ; **FLOATING
C898 w_200_0.n389 VGND 0 ; **FLOATING
C899 w_200_0.n390 VGND 0 ; **FLOATING
C900 w_200_0.n391 VGND 0.00998f ; **FLOATING
C901 w_200_0.n392 VGND 0.00295f ; **FLOATING
C902 w_200_0.n393 VGND 0 ; **FLOATING
C903 w_200_0.n394 VGND 0 ; **FLOATING
C904 w_200_0.n395 VGND 0 ; **FLOATING
C905 w_200_0.n396 VGND 0 ; **FLOATING
C906 w_200_0.n397 VGND 0 ; **FLOATING
C907 w_200_0.n398 VGND 0 ; **FLOATING
C908 w_200_0.n399 VGND 0 ; **FLOATING
C909 w_200_0.n400 VGND 0 ; **FLOATING
C910 w_200_0.n401 VGND 0 ; **FLOATING
C911 w_200_0.n402 VGND 0 ; **FLOATING
C912 w_200_0.n403 VGND 0 ; **FLOATING
C913 w_200_0.n404 VGND 0 ; **FLOATING
C914 w_200_0.n405 VGND 0.00259f ; **FLOATING
C915 w_200_0.n406 VGND 0 ; **FLOATING
C916 w_200_0.n407 VGND 0.00658f ; **FLOATING
C917 w_200_0.n408 VGND 0 ; **FLOATING
C918 w_200_0.n409 VGND 0 ; **FLOATING
C919 w_200_0.n410 VGND 0 ; **FLOATING
C920 w_200_0.n411 VGND 0 ; **FLOATING
C921 w_200_0.n412 VGND 0.00272f ; **FLOATING
C922 w_200_0.n413 VGND 0 ; **FLOATING
C923 w_200_0.n414 VGND 0 ; **FLOATING
C924 w_200_0.n415 VGND 0.00653f ; **FLOATING
C925 w_200_0.n416 VGND 0 ; **FLOATING
C926 w_200_0.n417 VGND 0 ; **FLOATING
C927 w_200_0.n418 VGND 0 ; **FLOATING
C928 w_200_0.n419 VGND 0 ; **FLOATING
C929 w_200_0.n420 VGND 0.00156f ; **FLOATING
C930 w_200_0.n421 VGND 0 ; **FLOATING
C931 w_200_0.n422 VGND 0 ; **FLOATING
C932 w_200_0.n423 VGND 0.0101f ; **FLOATING
C933 w_200_0.n424 VGND 0.00263f ; **FLOATING
C934 w_200_0.n425 VGND 0 ; **FLOATING
C935 w_200_0.n426 VGND 0 ; **FLOATING
C936 w_200_0.n427 VGND 0.00633f ; **FLOATING
C937 w_200_0.n428 VGND 0 ; **FLOATING
C938 w_200_0.n429 VGND 0 ; **FLOATING
C939 w_200_0.n430 VGND 0 ; **FLOATING
C940 w_200_0.n431 VGND 0 ; **FLOATING
C941 w_200_0.n432 VGND 0.00151f ; **FLOATING
C942 w_200_0.n433 VGND 0 ; **FLOATING
C943 w_200_0.n434 VGND 0 ; **FLOATING
C944 w_200_0.n435 VGND 0.02083f ; **FLOATING
C945 w_200_0.n436 VGND 0.00317f ; **FLOATING
C946 w_200_0.n437 VGND 0 ; **FLOATING
C947 w_200_0.n438 VGND 0 ; **FLOATING
C948 w_200_0.n439 VGND 0 ; **FLOATING
C949 w_200_0.n440 VGND 0 ; **FLOATING
C950 w_200_0.n441 VGND 0 ; **FLOATING
C951 w_200_0.n442 VGND 0 ; **FLOATING
C952 w_200_0.n443 VGND 0 ; **FLOATING
C953 w_200_0.n444 VGND 0 ; **FLOATING
C954 w_200_0.n445 VGND 0 ; **FLOATING
C955 w_200_0.n446 VGND 0 ; **FLOATING
C956 w_200_0.n447 VGND 0.00614f ; **FLOATING
C957 w_200_0.n448 VGND 0.02025f ; **FLOATING
C958 w_200_0.n449 VGND 0.00149f ; **FLOATING
C959 w_200_0.n450 VGND 0 ; **FLOATING
C960 w_200_0.n451 VGND 0 ; **FLOATING
C961 w_200_0.n452 VGND 0 ; **FLOATING
C962 w_200_0.n453 VGND 0 ; **FLOATING
C963 w_200_0.n454 VGND 0 ; **FLOATING
C964 w_200_0.n455 VGND 0 ; **FLOATING
C965 w_200_0.n456 VGND 0 ; **FLOATING
C966 w_200_0.n457 VGND 0 ; **FLOATING
C967 w_200_0.n458 VGND 0 ; **FLOATING
C968 w_200_0.n459 VGND 0 ; **FLOATING
C969 w_200_0.n460 VGND 0 ; **FLOATING
C970 w_200_0.n461 VGND 0 ; **FLOATING
C971 w_200_0.n462 VGND 0 ; **FLOATING
C972 w_200_0.n463 VGND 0 ; **FLOATING
C973 w_200_0.n464 VGND 0 ; **FLOATING
C974 w_200_0.n465 VGND 0 ; **FLOATING
C975 w_200_0.n466 VGND 0 ; **FLOATING
C976 w_200_0.n467 VGND 0 ; **FLOATING
C977 w_200_0.n468 VGND 0 ; **FLOATING
C978 w_200_0.n469 VGND 0 ; **FLOATING
C979 w_200_0.n470 VGND 0 ; **FLOATING
C980 w_200_0.n471 VGND 0 ; **FLOATING
C981 w_200_0.n472 VGND 0 ; **FLOATING
C982 w_200_0.n473 VGND 0 ; **FLOATING
C983 w_200_0.n474 VGND 0 ; **FLOATING
C984 w_200_0.n475 VGND 0 ; **FLOATING
C985 w_200_0.n476 VGND 0 ; **FLOATING
C986 w_200_0.n477 VGND 0 ; **FLOATING
C987 w_200_0.n478 VGND 0 ; **FLOATING
C988 w_200_0.n479 VGND 0 ; **FLOATING
C989 w_200_0.n480 VGND 0 ; **FLOATING
C990 w_200_0.n481 VGND 0 ; **FLOATING
C991 w_200_0.n482 VGND 0 ; **FLOATING
C992 w_200_0.n483 VGND 0 ; **FLOATING
C993 w_200_0.n484 VGND 0 ; **FLOATING
C994 w_200_0.n485 VGND 0 ; **FLOATING
C995 w_200_0.n486 VGND 0 ; **FLOATING
C996 w_200_0.n487 VGND 0 ; **FLOATING
C997 w_200_0.n488 VGND 0.00103f ; **FLOATING
C998 w_200_0.n489 VGND 0 ; **FLOATING
C999 w_200_0.n490 VGND 0 ; **FLOATING
C1000 w_200_0.n491 VGND 0 ; **FLOATING
C1001 w_200_0.n492 VGND 0 ; **FLOATING
C1002 w_200_0.n493 VGND 0 ; **FLOATING
C1003 w_200_0.n494 VGND 0 ; **FLOATING
C1004 w_200_0.n495 VGND 0 ; **FLOATING
C1005 w_200_0.n496 VGND 0 ; **FLOATING
C1006 w_200_0.n497 VGND 0 ; **FLOATING
C1007 w_200_0.n498 VGND 0 ; **FLOATING
C1008 w_200_0.n499 VGND 0 ; **FLOATING
C1009 w_200_0.n500 VGND 0 ; **FLOATING
C1010 w_200_0.n501 VGND 0 ; **FLOATING
C1011 w_200_0.n502 VGND 0 ; **FLOATING
C1012 w_200_0.n503 VGND 0 ; **FLOATING
C1013 w_200_0.n504 VGND 0 ; **FLOATING
C1014 w_200_0.n505 VGND 0 ; **FLOATING
C1015 w_200_0.n506 VGND 0 ; **FLOATING
C1016 w_200_0.n507 VGND 0 ; **FLOATING
C1017 w_200_0.n508 VGND 0 ; **FLOATING
C1018 w_200_0.n509 VGND 0 ; **FLOATING
C1019 w_200_0.n510 VGND 0 ; **FLOATING
C1020 w_200_0.n511 VGND 0 ; **FLOATING
C1021 w_200_0.n512 VGND 0 ; **FLOATING
C1022 w_200_0.n513 VGND 0 ; **FLOATING
C1023 w_200_0.n514 VGND 0 ; **FLOATING
C1024 w_200_0.n515 VGND 0 ; **FLOATING
C1025 w_200_0.n516 VGND 0 ; **FLOATING
C1026 w_200_0.n517 VGND 0 ; **FLOATING
C1027 w_200_0.n518 VGND 0 ; **FLOATING
C1028 w_200_0.n519 VGND 0 ; **FLOATING
C1029 w_200_0.n520 VGND 0 ; **FLOATING
C1030 w_200_0.n521 VGND 0 ; **FLOATING
C1031 w_200_0.n522 VGND 0 ; **FLOATING
C1032 w_200_0.n523 VGND 0 ; **FLOATING
C1033 w_200_0.n524 VGND 0 ; **FLOATING
C1034 w_200_0.n525 VGND 0 ; **FLOATING
C1035 w_200_0.n526 VGND 0 ; **FLOATING
C1036 w_200_0.n527 VGND 0 ; **FLOATING
C1037 w_200_0.n528 VGND 0.00102f ; **FLOATING
C1038 w_200_0.n529 VGND 0 ; **FLOATING
C1039 w_200_0.n530 VGND 0 ; **FLOATING
C1040 w_200_0.n531 VGND 0 ; **FLOATING
C1041 w_200_0.n532 VGND 0 ; **FLOATING
C1042 w_200_0.n533 VGND 0 ; **FLOATING
C1043 w_200_0.n534 VGND 0 ; **FLOATING
C1044 w_200_0.n535 VGND 0.00111f ; **FLOATING
C1045 w_200_0.n536 VGND 0.00727f ; **FLOATING
C1046 w_200_0.n537 VGND 0.00102f ; **FLOATING
C1047 w_200_0.n538 VGND 0 ; **FLOATING
C1048 w_200_0.n539 VGND 0.00234f ; **FLOATING
C1049 w_200_0.n540 VGND 0 ; **FLOATING
C1050 w_200_0.n541 VGND 0 ; **FLOATING
C1051 w_200_0.n542 VGND 0 ; **FLOATING
C1052 w_200_0.n543 VGND 0 ; **FLOATING
C1053 w_200_0.n544 VGND 0 ; **FLOATING
C1054 w_200_0.n545 VGND 0 ; **FLOATING
C1055 w_200_0.n546 VGND 0 ; **FLOATING
C1056 w_200_0.n547 VGND 0 ; **FLOATING
C1057 w_200_0.n548 VGND 0 ; **FLOATING
C1058 w_200_0.n549 VGND 0 ; **FLOATING
C1059 w_200_0.n550 VGND 0 ; **FLOATING
C1060 w_200_0.n551 VGND 0 ; **FLOATING
C1061 w_200_0.n552 VGND 0 ; **FLOATING
C1062 w_200_0.n553 VGND 0 ; **FLOATING
C1063 w_200_0.n554 VGND 0 ; **FLOATING
C1064 w_200_0.n555 VGND 0.00162f ; **FLOATING
C1065 w_200_0.n556 VGND 0.00127f ; **FLOATING
C1066 w_200_0.n557 VGND 0 ; **FLOATING
C1067 w_200_0.n558 VGND 0 ; **FLOATING
C1068 w_200_0.n559 VGND 0 ; **FLOATING
C1069 w_200_0.n560 VGND 0 ; **FLOATING
C1070 w_200_0.n561 VGND 0 ; **FLOATING
C1071 w_200_0.n562 VGND 0 ; **FLOATING
C1072 w_200_0.n563 VGND 0 ; **FLOATING
C1073 w_200_0.n564 VGND 0 ; **FLOATING
C1074 w_200_0.n565 VGND 0 ; **FLOATING
C1075 w_200_0.n566 VGND 0.00176f ; **FLOATING
C1076 w_200_0.n567 VGND 0 ; **FLOATING
C1077 w_200_0.n568 VGND 0 ; **FLOATING
C1078 w_200_0.n569 VGND 0 ; **FLOATING
C1079 w_200_0.n570 VGND 0 ; **FLOATING
C1080 w_200_0.n571 VGND 0 ; **FLOATING
C1081 w_200_0.n572 VGND 0 ; **FLOATING
C1082 w_200_0.n573 VGND 0 ; **FLOATING
C1083 w_200_0.n574 VGND 0 ; **FLOATING
C1084 w_200_0.n575 VGND 0 ; **FLOATING
C1085 w_200_0.n576 VGND 0 ; **FLOATING
C1086 w_200_0.n577 VGND 0 ; **FLOATING
C1087 w_200_0.n578 VGND 0 ; **FLOATING
C1088 w_200_0.n579 VGND 0 ; **FLOATING
C1089 w_200_0.n580 VGND 0 ; **FLOATING
C1090 w_200_0.n581 VGND 0 ; **FLOATING
C1091 w_200_0.n582 VGND 0 ; **FLOATING
C1092 w_200_0.n583 VGND 0.0011f ; **FLOATING
C1093 w_200_0.n584 VGND 0 ; **FLOATING
C1094 w_200_0.n585 VGND 0 ; **FLOATING
C1095 w_200_0.n586 VGND 0 ; **FLOATING
C1096 w_200_0.n587 VGND 0 ; **FLOATING
C1097 w_200_0.n588 VGND 0 ; **FLOATING
C1098 w_200_0.n589 VGND 0 ; **FLOATING
C1099 w_200_0.n590 VGND 0 ; **FLOATING
C1100 w_200_0.n591 VGND 0 ; **FLOATING
C1101 w_200_0.n592 VGND 0 ; **FLOATING
C1102 w_200_0.n593 VGND 0 ; **FLOATING
C1103 w_200_0.n594 VGND 0 ; **FLOATING
C1104 w_200_0.n595 VGND 0 ; **FLOATING
C1105 w_200_0.n596 VGND 0 ; **FLOATING
C1106 w_200_0.n597 VGND 0.0011f ; **FLOATING
C1107 w_200_0.n598 VGND 0 ; **FLOATING
C1108 w_200_0.n599 VGND 0 ; **FLOATING
C1109 w_200_0.n600 VGND 0 ; **FLOATING
C1110 w_200_0.n601 VGND 0 ; **FLOATING
C1111 w_200_0.n602 VGND 0 ; **FLOATING
C1112 w_200_0.n603 VGND 0.00136f ; **FLOATING
C1113 w_200_0.n604 VGND 0 ; **FLOATING
C1114 w_200_0.n605 VGND 0 ; **FLOATING
C1115 w_200_0.n606 VGND 0 ; **FLOATING
C1116 w_200_0.n607 VGND 0 ; **FLOATING
C1117 w_200_0.n608 VGND 0 ; **FLOATING
C1118 w_200_0.n609 VGND 0 ; **FLOATING
C1119 w_200_0.n610 VGND 0.00548f ; **FLOATING
C1120 w_200_0.n611 VGND 0.01953f ; **FLOATING
C1121 w_200_0.n612 VGND 0.05116f ; **FLOATING
C1122 ch1_lop_raw.n0 VGND 0.05207f ; **FLOATING
C1123 ch1_lop_raw.n1 VGND 0.70276f ; **FLOATING
C1124 ch1_lop_raw.n2 VGND 1.89597f ; **FLOATING
C1125 ch1_lop_raw.n3 VGND 0.00879f ; **FLOATING
C1126 ch1_lop_raw.n4 VGND 0.08589f ; **FLOATING
C1127 ch1_lop_raw.n5 VGND 0.00733f ; **FLOATING
C1128 ch1_lop_raw.n6 VGND 0.08589f ; **FLOATING
C1129 ch1_lop_raw.n7 VGND 0.08589f ; **FLOATING
C1130 ch1_lop_raw.n8 VGND 0.08589f ; **FLOATING
C1131 ch1_lop_raw.n9 VGND 0.08687f ; **FLOATING
C1132 ch1_lop_raw.n10 VGND 0.08687f ; **FLOATING
C1133 ch1_lop_raw.n11 VGND 0.08589f ; **FLOATING
C1134 ch1_lop_raw.n12 VGND 0.02377f ; **FLOATING
C1135 ch1_lop_raw.n13 VGND 0.08589f ; **FLOATING
C1136 ch1_lop_raw.n14 VGND 0.02377f ; **FLOATING
C1137 ch1_lop_raw.n15 VGND 0.08589f ; **FLOATING
C1138 ch1_lop_raw.n16 VGND 0.02377f ; **FLOATING
C1139 ch1_lop_raw.n17 VGND 0.03247f ; **FLOATING
C1140 ch1_lop_raw.n18 VGND 0.12479f ; **FLOATING
C1141 ch1_lop_raw.n19 VGND 0.03247f ; **FLOATING
C1142 ch1_lop_raw.n20 VGND 0.08589f ; **FLOATING
C1143 ch1_lop_raw.n21 VGND 2.57109f ; **FLOATING
C1144 ch1_lop_raw.n22 VGND 0.00879f ; **FLOATING
C1145 ch1_lop_raw.n23 VGND 0.12281f ; **FLOATING
C1146 ch1_lop_raw.n24 VGND 0.00733f ; **FLOATING
C1147 ch1_lop_raw.n25 VGND 0.12281f ; **FLOATING
C1148 ch1_lop_raw.n26 VGND 0.12281f ; **FLOATING
C1149 ch1_lop_raw.n27 VGND 0.12281f ; **FLOATING
C1150 ch1_lop_raw.n28 VGND 0.12379f ; **FLOATING
C1151 ch1_lop_raw.n29 VGND 0.12281f ; **FLOATING
C1152 ch1_lop_raw.n30 VGND 0.02377f ; **FLOATING
C1153 ch1_lop_raw.n31 VGND 0.12281f ; **FLOATING
C1154 ch1_lop_raw.n32 VGND 0.02377f ; **FLOATING
C1155 ch1_lop_raw.n33 VGND 0.12281f ; **FLOATING
C1156 ch1_lop_raw.n34 VGND 0.02377f ; **FLOATING
C1157 ch1_lop_raw.n35 VGND 0.12379f ; **FLOATING
C1158 ch1_lop_raw.n36 VGND 0.03247f ; **FLOATING
C1159 ch1_lop_raw.n37 VGND 0.12479f ; **FLOATING
C1160 ch1_lop_raw.n38 VGND 0.03247f ; **FLOATING
C1161 ch1_lop_raw.n39 VGND 0.12281f ; **FLOATING
C1162 ch1_lop_raw.n40 VGND 0.40347f ; **FLOATING
C1163 ch1_lop_raw.n41 VGND 0.06151f ; **FLOATING
C1164 ch1_lop_raw.n42 VGND 0.05958f ; **FLOATING
C1165 ch1_lop_raw.n43 VGND 0.06151f ; **FLOATING
C1166 ch1_lop_raw.n44 VGND 0.05958f ; **FLOATING
C1167 ch1_lop_raw.n45 VGND 1.94589f ; **FLOATING
C1168 ch1_lop_raw.n46 VGND 0.0586f ; **FLOATING
C1169 ch1_lop_raw.n47 VGND 0.0586f ; **FLOATING
C1170 ch1_lon_raw.n0 VGND 0.03789f ; **FLOATING
C1171 ch1_lon_raw.n1 VGND 0.42854f ; **FLOATING
C1172 ch1_lon_raw.n2 VGND 1.40892f ; **FLOATING
C1173 ch1_lon_raw.n3 VGND 0.0064f ; **FLOATING
C1174 ch1_lon_raw.n4 VGND 0.0625f ; **FLOATING
C1175 ch1_lon_raw.n5 VGND 0.00533f ; **FLOATING
C1176 ch1_lon_raw.n6 VGND 0.0625f ; **FLOATING
C1177 ch1_lon_raw.n7 VGND 0.0625f ; **FLOATING
C1178 ch1_lon_raw.n8 VGND 0.0625f ; **FLOATING
C1179 ch1_lon_raw.n9 VGND 0.06321f ; **FLOATING
C1180 ch1_lon_raw.n10 VGND 0.06321f ; **FLOATING
C1181 ch1_lon_raw.n11 VGND 0.0625f ; **FLOATING
C1182 ch1_lon_raw.n12 VGND 0.01729f ; **FLOATING
C1183 ch1_lon_raw.n13 VGND 0.0625f ; **FLOATING
C1184 ch1_lon_raw.n14 VGND 0.01729f ; **FLOATING
C1185 ch1_lon_raw.n15 VGND 0.0625f ; **FLOATING
C1186 ch1_lon_raw.n16 VGND 0.01729f ; **FLOATING
C1187 ch1_lon_raw.n17 VGND 0.02363f ; **FLOATING
C1188 ch1_lon_raw.n18 VGND 0.09081f ; **FLOATING
C1189 ch1_lon_raw.n19 VGND 0.02363f ; **FLOATING
C1190 ch1_lon_raw.n20 VGND 0.0625f ; **FLOATING
C1191 ch1_lon_raw.n21 VGND 0.335f ; **FLOATING
C1192 ch1_lon_raw.n22 VGND 0.04781f ; **FLOATING
C1193 ch1_lon_raw.n23 VGND 0.04403f ; **FLOATING
C1194 ch1_lon_raw.n24 VGND 0.04476f ; **FLOATING
C1195 ch1_lon_raw.n25 VGND 0.04335f ; **FLOATING
C1196 ch1_lon_raw.n26 VGND 2.79879f ; **FLOATING
C1197 ch1_lon_raw.n27 VGND 0.0064f ; **FLOATING
C1198 ch1_lon_raw.n28 VGND 0.08936f ; **FLOATING
C1199 ch1_lon_raw.n29 VGND 0.00533f ; **FLOATING
C1200 ch1_lon_raw.n30 VGND 0.08936f ; **FLOATING
C1201 ch1_lon_raw.n31 VGND 0.08936f ; **FLOATING
C1202 ch1_lon_raw.n32 VGND 0.08936f ; **FLOATING
C1203 ch1_lon_raw.n33 VGND 0.09008f ; **FLOATING
C1204 ch1_lon_raw.n34 VGND 0.08936f ; **FLOATING
C1205 ch1_lon_raw.n35 VGND 0.01729f ; **FLOATING
C1206 ch1_lon_raw.n36 VGND 0.08936f ; **FLOATING
C1207 ch1_lon_raw.n37 VGND 0.01729f ; **FLOATING
C1208 ch1_lon_raw.n38 VGND 0.08936f ; **FLOATING
C1209 ch1_lon_raw.n39 VGND 0.01729f ; **FLOATING
C1210 ch1_lon_raw.n40 VGND 0.09008f ; **FLOATING
C1211 ch1_lon_raw.n41 VGND 0.02363f ; **FLOATING
C1212 ch1_lon_raw.n42 VGND 0.09081f ; **FLOATING
C1213 ch1_lon_raw.n43 VGND 0.02363f ; **FLOATING
C1214 ch1_lon_raw.n44 VGND 0.08936f ; **FLOATING
C1215 ch1_lon_raw.n45 VGND 5.46892f ; **FLOATING
C1216 ch1_lon_raw.n46 VGND 0.04264f ; **FLOATING
C1217 ch1_lon_raw.n47 VGND 0.04264f ; **FLOATING
C1218 ch2_lop_raw.n0 VGND 0.04295f ; **FLOATING
C1219 ch2_lop_raw.n1 VGND 1.84326f ; **FLOATING
C1220 ch2_lop_raw.n2 VGND 1.10805f ; **FLOATING
C1221 ch2_lop_raw.n3 VGND 4.96112f ; **FLOATING
C1222 ch2_lop_raw.n4 VGND 0.3934f ; **FLOATING
C1223 ch2_lop_raw.n5 VGND 0.00725f ; **FLOATING
C1224 ch2_lop_raw.n6 VGND 0.10129f ; **FLOATING
C1225 ch2_lop_raw.n7 VGND 0.00604f ; **FLOATING
C1226 ch2_lop_raw.n8 VGND 0.10129f ; **FLOATING
C1227 ch2_lop_raw.n9 VGND 0.10129f ; **FLOATING
C1228 ch2_lop_raw.n10 VGND 0.10129f ; **FLOATING
C1229 ch2_lop_raw.n11 VGND 0.1021f ; **FLOATING
C1230 ch2_lop_raw.n12 VGND 0.10129f ; **FLOATING
C1231 ch2_lop_raw.n13 VGND 0.0196f ; **FLOATING
C1232 ch2_lop_raw.n14 VGND 0.10129f ; **FLOATING
C1233 ch2_lop_raw.n15 VGND 0.0196f ; **FLOATING
C1234 ch2_lop_raw.n16 VGND 0.10129f ; **FLOATING
C1235 ch2_lop_raw.n17 VGND 0.0196f ; **FLOATING
C1236 ch2_lop_raw.n18 VGND 0.1021f ; **FLOATING
C1237 ch2_lop_raw.n19 VGND 0.02678f ; **FLOATING
C1238 ch2_lop_raw.n20 VGND 0.10293f ; **FLOATING
C1239 ch2_lop_raw.n21 VGND 0.02678f ; **FLOATING
C1240 ch2_lop_raw.n22 VGND 0.10129f ; **FLOATING
C1241 ch2_lop_raw.n23 VGND 0.36306f ; **FLOATING
C1242 ch2_lop_raw.n24 VGND 0.00725f ; **FLOATING
C1243 ch2_lop_raw.n25 VGND 0.07084f ; **FLOATING
C1244 ch2_lop_raw.n26 VGND 0.00604f ; **FLOATING
C1245 ch2_lop_raw.n27 VGND 0.07084f ; **FLOATING
C1246 ch2_lop_raw.n28 VGND 0.07084f ; **FLOATING
C1247 ch2_lop_raw.n29 VGND 0.07084f ; **FLOATING
C1248 ch2_lop_raw.n30 VGND 0.07165f ; **FLOATING
C1249 ch2_lop_raw.n31 VGND 0.07165f ; **FLOATING
C1250 ch2_lop_raw.n32 VGND 0.07084f ; **FLOATING
C1251 ch2_lop_raw.n33 VGND 0.0196f ; **FLOATING
C1252 ch2_lop_raw.n34 VGND 0.07084f ; **FLOATING
C1253 ch2_lop_raw.n35 VGND 0.0196f ; **FLOATING
C1254 ch2_lop_raw.n36 VGND 0.07084f ; **FLOATING
C1255 ch2_lop_raw.n37 VGND 0.0196f ; **FLOATING
C1256 ch2_lop_raw.n38 VGND 0.02678f ; **FLOATING
C1257 ch2_lop_raw.n39 VGND 0.10293f ; **FLOATING
C1258 ch2_lop_raw.n40 VGND 0.02678f ; **FLOATING
C1259 ch2_lop_raw.n41 VGND 0.07084f ; **FLOATING
C1260 ch2_lop_raw.n42 VGND 6.82765f ; **FLOATING
C1261 ch2_lop_raw.n43 VGND 0.5434f ; **FLOATING
C1262 ch2_lop_raw.n44 VGND 0.71132f ; **FLOATING
C1263 ch2_lop_raw.n45 VGND 0.04295f ; **FLOATING
C1264 ch2_lop_raw.n46 VGND 0.5434f ; **FLOATING
C1265 ch2_lop_raw.n47 VGND 0.04834f ; **FLOATING
C1266 ch2_lop_raw.n48 VGND 0.04834f ; **FLOATING
C1267 ch2_lop_raw.n49 VGND 3.67313f ; **FLOATING
C1268 ch2_lop_raw.n50 VGND 0.04834f ; **FLOATING
C1269 ch2_lop_raw.n51 VGND 0.04833f ; **FLOATING
C1270 ch2_lon_raw.n0 VGND 0.04644f ; **FLOATING
C1271 ch2_lon_raw.n1 VGND 0.81623f ; **FLOATING
C1272 ch2_lon_raw.n2 VGND 1.71537f ; **FLOATING
C1273 ch2_lon_raw.n3 VGND 0.81622f ; **FLOATING
C1274 ch2_lon_raw.n4 VGND 3.55578f ; **FLOATING
C1275 ch2_lon_raw.n5 VGND 0.04644f ; **FLOATING
C1276 ch2_lon_raw.n6 VGND 1.61024f ; **FLOATING
C1277 ch2_lon_raw.n7 VGND 0.05227f ; **FLOATING
C1278 ch2_lon_raw.n8 VGND 0.05227f ; **FLOATING
C1279 ch2_lon_raw.n9 VGND 10.0932f ; **FLOATING
C1280 ch2_lon_raw.n10 VGND 0.48584f ; **FLOATING
C1281 ch2_lon_raw.n11 VGND 0.00784f ; **FLOATING
C1282 ch2_lon_raw.n12 VGND 0.07661f ; **FLOATING
C1283 ch2_lon_raw.n13 VGND 0.00653f ; **FLOATING
C1284 ch2_lon_raw.n14 VGND 0.07661f ; **FLOATING
C1285 ch2_lon_raw.n15 VGND 0.07661f ; **FLOATING
C1286 ch2_lon_raw.n16 VGND 0.07661f ; **FLOATING
C1287 ch2_lon_raw.n17 VGND 0.07748f ; **FLOATING
C1288 ch2_lon_raw.n18 VGND 0.07748f ; **FLOATING
C1289 ch2_lon_raw.n19 VGND 0.07661f ; **FLOATING
C1290 ch2_lon_raw.n20 VGND 0.0212f ; **FLOATING
C1291 ch2_lon_raw.n21 VGND 0.07661f ; **FLOATING
C1292 ch2_lon_raw.n22 VGND 0.0212f ; **FLOATING
C1293 ch2_lon_raw.n23 VGND 0.07661f ; **FLOATING
C1294 ch2_lon_raw.n24 VGND 0.0212f ; **FLOATING
C1295 ch2_lon_raw.n25 VGND 0.02896f ; **FLOATING
C1296 ch2_lon_raw.n26 VGND 0.11131f ; **FLOATING
C1297 ch2_lon_raw.n27 VGND 0.02896f ; **FLOATING
C1298 ch2_lon_raw.n28 VGND 0.07661f ; **FLOATING
C1299 ch2_lon_raw.n29 VGND 0.84379f ; **FLOATING
C1300 ch2_lon_raw.n30 VGND 0.00784f ; **FLOATING
C1301 ch2_lon_raw.n31 VGND 0.10954f ; **FLOATING
C1302 ch2_lon_raw.n32 VGND 0.00653f ; **FLOATING
C1303 ch2_lon_raw.n33 VGND 0.10954f ; **FLOATING
C1304 ch2_lon_raw.n34 VGND 0.10954f ; **FLOATING
C1305 ch2_lon_raw.n35 VGND 0.10954f ; **FLOATING
C1306 ch2_lon_raw.n36 VGND 0.11041f ; **FLOATING
C1307 ch2_lon_raw.n37 VGND 0.10954f ; **FLOATING
C1308 ch2_lon_raw.n38 VGND 0.0212f ; **FLOATING
C1309 ch2_lon_raw.n39 VGND 0.10954f ; **FLOATING
C1310 ch2_lon_raw.n40 VGND 0.0212f ; **FLOATING
C1311 ch2_lon_raw.n41 VGND 0.10954f ; **FLOATING
C1312 ch2_lon_raw.n42 VGND 0.0212f ; **FLOATING
C1313 ch2_lon_raw.n43 VGND 0.11041f ; **FLOATING
C1314 ch2_lon_raw.n44 VGND 0.02896f ; **FLOATING
C1315 ch2_lon_raw.n45 VGND 0.11131f ; **FLOATING
C1316 ch2_lon_raw.n46 VGND 0.02896f ; **FLOATING
C1317 ch2_lon_raw.n47 VGND 0.10954f ; **FLOATING
C1318 ch2_lon_raw.n48 VGND 5.14033f ; **FLOATING
C1319 ch2_lon_raw.n49 VGND 0.05227f ; **FLOATING
C1320 ch2_lon_raw.n50 VGND 0.05226f ; **FLOATING
C1321 ch1_lop.n0 VGND 6.07452f ; **FLOATING
C1322 ch1_lop.n1 VGND 0.28089f ; **FLOATING
C1323 ch1_lop.n2 VGND 0.00633f ; **FLOATING
C1324 ch1_lop.n3 VGND 0.06184f ; **FLOATING
C1325 ch1_lop.n4 VGND 0.00527f ; **FLOATING
C1326 ch1_lop.n5 VGND 0.06184f ; **FLOATING
C1327 ch1_lop.n6 VGND 0.06184f ; **FLOATING
C1328 ch1_lop.n7 VGND 0.06184f ; **FLOATING
C1329 ch1_lop.n8 VGND 0.06255f ; **FLOATING
C1330 ch1_lop.n9 VGND 0.06255f ; **FLOATING
C1331 ch1_lop.n10 VGND 0.06184f ; **FLOATING
C1332 ch1_lop.n11 VGND 0.01711f ; **FLOATING
C1333 ch1_lop.n12 VGND 0.06184f ; **FLOATING
C1334 ch1_lop.n13 VGND 0.01711f ; **FLOATING
C1335 ch1_lop.n14 VGND 0.06184f ; **FLOATING
C1336 ch1_lop.n15 VGND 0.01711f ; **FLOATING
C1337 ch1_lop.n16 VGND 0.02338f ; **FLOATING
C1338 ch1_lop.n17 VGND 0.08986f ; **FLOATING
C1339 ch1_lop.n18 VGND 0.02338f ; **FLOATING
C1340 ch1_lop.n19 VGND 0.06184f ; **FLOATING
C1341 ch1_lop.n20 VGND 0.05664f ; **FLOATING
C1342 ch1_lop.n21 VGND 0.05452f ; **FLOATING
C1343 ch1_lop.n22 VGND 0.14468f ; **FLOATING
C1344 ch1_lop.n23 VGND 0.05452f ; **FLOATING
C1345 ch1_lop.n24 VGND 1.08596f ; **FLOATING
C1346 ch1_lop.n25 VGND 0.05276f ; **FLOATING
C1347 ch1_lop.n26 VGND 0.05064f ; **FLOATING
C1348 ch1_lop.n27 VGND 0.14468f ; **FLOATING
C1349 ch1_lop.n28 VGND 0.05064f ; **FLOATING
C1350 ch1_lop.n29 VGND 0.9745f ; **FLOATING
C1351 ch1_lop.n30 VGND 6.3932f ; **FLOATING
C1352 ch1_lop.n31 VGND 0.58866f ; **FLOATING
C1353 ch1_lop.n32 VGND 0.00633f ; **FLOATING
C1354 ch1_lop.n33 VGND 0.06184f ; **FLOATING
C1355 ch1_lop.n34 VGND 0.00527f ; **FLOATING
C1356 ch1_lop.n35 VGND 0.06184f ; **FLOATING
C1357 ch1_lop.n36 VGND 0.06184f ; **FLOATING
C1358 ch1_lop.n37 VGND 0.06184f ; **FLOATING
C1359 ch1_lop.n38 VGND 0.06255f ; **FLOATING
C1360 ch1_lop.n39 VGND 0.06255f ; **FLOATING
C1361 ch1_lop.n40 VGND 0.06184f ; **FLOATING
C1362 ch1_lop.n41 VGND 0.01711f ; **FLOATING
C1363 ch1_lop.n42 VGND 0.06184f ; **FLOATING
C1364 ch1_lop.n43 VGND 0.01711f ; **FLOATING
C1365 ch1_lop.n44 VGND 0.06184f ; **FLOATING
C1366 ch1_lop.n45 VGND 0.01711f ; **FLOATING
C1367 ch1_lop.n46 VGND 0.02338f ; **FLOATING
C1368 ch1_lop.n47 VGND 0.08986f ; **FLOATING
C1369 ch1_lop.n48 VGND 0.02338f ; **FLOATING
C1370 ch1_lop.n49 VGND 0.06184f ; **FLOATING
C1371 ch1_lop.n50 VGND 1.56834f ; **FLOATING
C1372 ch1_lop.n51 VGND 0.00633f ; **FLOATING
C1373 ch1_lop.n52 VGND 0.06184f ; **FLOATING
C1374 ch1_lop.n53 VGND 0.00527f ; **FLOATING
C1375 ch1_lop.n54 VGND 0.06184f ; **FLOATING
C1376 ch1_lop.n55 VGND 0.06184f ; **FLOATING
C1377 ch1_lop.n56 VGND 0.06184f ; **FLOATING
C1378 ch1_lop.n57 VGND 0.06255f ; **FLOATING
C1379 ch1_lop.n58 VGND 0.06255f ; **FLOATING
C1380 ch1_lop.n59 VGND 0.06184f ; **FLOATING
C1381 ch1_lop.n60 VGND 0.01711f ; **FLOATING
C1382 ch1_lop.n61 VGND 0.06184f ; **FLOATING
C1383 ch1_lop.n62 VGND 0.01711f ; **FLOATING
C1384 ch1_lop.n63 VGND 0.06184f ; **FLOATING
C1385 ch1_lop.n64 VGND 0.01711f ; **FLOATING
C1386 ch1_lop.n65 VGND 0.02338f ; **FLOATING
C1387 ch1_lop.n66 VGND 0.08986f ; **FLOATING
C1388 ch1_lop.n67 VGND 0.02338f ; **FLOATING
C1389 ch1_lop.n68 VGND 0.06184f ; **FLOATING
C1390 ch1_lop.n69 VGND 5.44198f ; **FLOATING
C1391 ch1_lop.n70 VGND 0.74437f ; **FLOATING
C1392 ch1_lop.n71 VGND 0.00633f ; **FLOATING
C1393 ch1_lop.n72 VGND 0.06184f ; **FLOATING
C1394 ch1_lop.n73 VGND 0.00527f ; **FLOATING
C1395 ch1_lop.n74 VGND 0.06184f ; **FLOATING
C1396 ch1_lop.n75 VGND 0.06184f ; **FLOATING
C1397 ch1_lop.n76 VGND 0.06184f ; **FLOATING
C1398 ch1_lop.n77 VGND 0.06255f ; **FLOATING
C1399 ch1_lop.n78 VGND 0.06255f ; **FLOATING
C1400 ch1_lop.n79 VGND 0.06184f ; **FLOATING
C1401 ch1_lop.n80 VGND 0.01711f ; **FLOATING
C1402 ch1_lop.n81 VGND 0.06184f ; **FLOATING
C1403 ch1_lop.n82 VGND 0.01711f ; **FLOATING
C1404 ch1_lop.n83 VGND 0.06184f ; **FLOATING
C1405 ch1_lop.n84 VGND 0.01711f ; **FLOATING
C1406 ch1_lop.n85 VGND 0.02338f ; **FLOATING
C1407 ch1_lop.n86 VGND 0.08986f ; **FLOATING
C1408 ch1_lop.n87 VGND 0.02338f ; **FLOATING
C1409 ch1_lop.n88 VGND 0.06184f ; **FLOATING
C1410 ch1_lon.n0 VGND 8.57783f ; **FLOATING
C1411 ch1_lon.n1 VGND 0.28304f ; **FLOATING
C1412 ch1_lon.n2 VGND 0.00676f ; **FLOATING
C1413 ch1_lon.n3 VGND 0.06601f ; **FLOATING
C1414 ch1_lon.n4 VGND 0.00563f ; **FLOATING
C1415 ch1_lon.n5 VGND 0.06601f ; **FLOATING
C1416 ch1_lon.n6 VGND 0.06601f ; **FLOATING
C1417 ch1_lon.n7 VGND 0.06601f ; **FLOATING
C1418 ch1_lon.n8 VGND 0.06676f ; **FLOATING
C1419 ch1_lon.n9 VGND 0.06676f ; **FLOATING
C1420 ch1_lon.n10 VGND 0.06601f ; **FLOATING
C1421 ch1_lon.n11 VGND 0.01826f ; **FLOATING
C1422 ch1_lon.n12 VGND 0.06601f ; **FLOATING
C1423 ch1_lon.n13 VGND 0.01826f ; **FLOATING
C1424 ch1_lon.n14 VGND 0.06601f ; **FLOATING
C1425 ch1_lon.n15 VGND 0.01826f ; **FLOATING
C1426 ch1_lon.n16 VGND 0.02495f ; **FLOATING
C1427 ch1_lon.n17 VGND 0.09591f ; **FLOATING
C1428 ch1_lon.n18 VGND 0.02495f ; **FLOATING
C1429 ch1_lon.n19 VGND 0.06601f ; **FLOATING
C1430 ch1_lon.n20 VGND 0.06045f ; **FLOATING
C1431 ch1_lon.n21 VGND 0.05819f ; **FLOATING
C1432 ch1_lon.n22 VGND 0.15442f ; **FLOATING
C1433 ch1_lon.n23 VGND 0.05819f ; **FLOATING
C1434 ch1_lon.n24 VGND 1.13184f ; **FLOATING
C1435 ch1_lon.n25 VGND 0.05632f ; **FLOATING
C1436 ch1_lon.n26 VGND 0.05405f ; **FLOATING
C1437 ch1_lon.n27 VGND 0.15442f ; **FLOATING
C1438 ch1_lon.n28 VGND 0.05405f ; **FLOATING
C1439 ch1_lon.n29 VGND 1.01373f ; **FLOATING
C1440 ch1_lon.n30 VGND 6.77205f ; **FLOATING
C1441 ch1_lon.n31 VGND 2.63538f ; **FLOATING
C1442 ch1_lon.n32 VGND 0.00676f ; **FLOATING
C1443 ch1_lon.n33 VGND 0.06601f ; **FLOATING
C1444 ch1_lon.n34 VGND 0.00563f ; **FLOATING
C1445 ch1_lon.n35 VGND 0.06601f ; **FLOATING
C1446 ch1_lon.n36 VGND 0.06601f ; **FLOATING
C1447 ch1_lon.n37 VGND 0.06601f ; **FLOATING
C1448 ch1_lon.n38 VGND 0.06676f ; **FLOATING
C1449 ch1_lon.n39 VGND 0.06676f ; **FLOATING
C1450 ch1_lon.n40 VGND 0.06601f ; **FLOATING
C1451 ch1_lon.n41 VGND 0.01826f ; **FLOATING
C1452 ch1_lon.n42 VGND 0.06601f ; **FLOATING
C1453 ch1_lon.n43 VGND 0.01826f ; **FLOATING
C1454 ch1_lon.n44 VGND 0.06601f ; **FLOATING
C1455 ch1_lon.n45 VGND 0.01826f ; **FLOATING
C1456 ch1_lon.n46 VGND 0.02495f ; **FLOATING
C1457 ch1_lon.n47 VGND 0.09591f ; **FLOATING
C1458 ch1_lon.n48 VGND 0.02495f ; **FLOATING
C1459 ch1_lon.n49 VGND 0.06601f ; **FLOATING
C1460 ch1_lon.n50 VGND 0.61889f ; **FLOATING
C1461 ch1_lon.n51 VGND 0.00676f ; **FLOATING
C1462 ch1_lon.n52 VGND 0.06601f ; **FLOATING
C1463 ch1_lon.n53 VGND 0.00563f ; **FLOATING
C1464 ch1_lon.n54 VGND 0.06601f ; **FLOATING
C1465 ch1_lon.n55 VGND 0.06601f ; **FLOATING
C1466 ch1_lon.n56 VGND 0.06601f ; **FLOATING
C1467 ch1_lon.n57 VGND 0.06676f ; **FLOATING
C1468 ch1_lon.n58 VGND 0.06676f ; **FLOATING
C1469 ch1_lon.n59 VGND 0.06601f ; **FLOATING
C1470 ch1_lon.n60 VGND 0.01826f ; **FLOATING
C1471 ch1_lon.n61 VGND 0.06601f ; **FLOATING
C1472 ch1_lon.n62 VGND 0.01826f ; **FLOATING
C1473 ch1_lon.n63 VGND 0.06601f ; **FLOATING
C1474 ch1_lon.n64 VGND 0.01826f ; **FLOATING
C1475 ch1_lon.n65 VGND 0.02495f ; **FLOATING
C1476 ch1_lon.n66 VGND 0.09591f ; **FLOATING
C1477 ch1_lon.n67 VGND 0.02495f ; **FLOATING
C1478 ch1_lon.n68 VGND 0.06601f ; **FLOATING
C1479 ch1_lon.n69 VGND 3.45466f ; **FLOATING
C1480 ch1_lon.n70 VGND 1.43135f ; **FLOATING
C1481 ch1_lon.n71 VGND 0.00676f ; **FLOATING
C1482 ch1_lon.n72 VGND 0.06601f ; **FLOATING
C1483 ch1_lon.n73 VGND 0.00563f ; **FLOATING
C1484 ch1_lon.n74 VGND 0.06601f ; **FLOATING
C1485 ch1_lon.n75 VGND 0.06601f ; **FLOATING
C1486 ch1_lon.n76 VGND 0.06601f ; **FLOATING
C1487 ch1_lon.n77 VGND 0.06676f ; **FLOATING
C1488 ch1_lon.n78 VGND 0.06676f ; **FLOATING
C1489 ch1_lon.n79 VGND 0.06601f ; **FLOATING
C1490 ch1_lon.n80 VGND 0.01826f ; **FLOATING
C1491 ch1_lon.n81 VGND 0.06601f ; **FLOATING
C1492 ch1_lon.n82 VGND 0.01826f ; **FLOATING
C1493 ch1_lon.n83 VGND 0.06601f ; **FLOATING
C1494 ch1_lon.n84 VGND 0.01826f ; **FLOATING
C1495 ch1_lon.n85 VGND 0.02495f ; **FLOATING
C1496 ch1_lon.n86 VGND 0.09591f ; **FLOATING
C1497 ch1_lon.n87 VGND 0.02495f ; **FLOATING
C1498 ch1_lon.n88 VGND 0.06601f ; **FLOATING
C1499 ch2_lop.n0 VGND 14.2397f ; **FLOATING
C1500 ch2_lop.n1 VGND 0.40826f ; **FLOATING
C1501 ch2_lop.n2 VGND 0.05397f ; **FLOATING
C1502 ch2_lop.n3 VGND 0.05195f ; **FLOATING
C1503 ch2_lop.n4 VGND 0.05397f ; **FLOATING
C1504 ch2_lop.n5 VGND 0.39656f ; **FLOATING
C1505 ch2_lop.n6 VGND 0.05028f ; **FLOATING
C1506 ch2_lop.n7 VGND 0.04825f ; **FLOATING
C1507 ch2_lop.n8 VGND 0.05028f ; **FLOATING
C1508 ch2_lop.n9 VGND 1.07343f ; **FLOATING
C1509 ch2_lop.n10 VGND 0.00603f ; **FLOATING
C1510 ch2_lop.n11 VGND 0.05893f ; **FLOATING
C1511 ch2_lop.n12 VGND 0.00503f ; **FLOATING
C1512 ch2_lop.n13 VGND 0.05893f ; **FLOATING
C1513 ch2_lop.n14 VGND 0.05893f ; **FLOATING
C1514 ch2_lop.n15 VGND 0.05893f ; **FLOATING
C1515 ch2_lop.n16 VGND 0.0596f ; **FLOATING
C1516 ch2_lop.n17 VGND 0.0596f ; **FLOATING
C1517 ch2_lop.n18 VGND 0.05893f ; **FLOATING
C1518 ch2_lop.n19 VGND 0.01631f ; **FLOATING
C1519 ch2_lop.n20 VGND 0.05893f ; **FLOATING
C1520 ch2_lop.n21 VGND 0.01631f ; **FLOATING
C1521 ch2_lop.n22 VGND 0.05893f ; **FLOATING
C1522 ch2_lop.n23 VGND 0.01631f ; **FLOATING
C1523 ch2_lop.n24 VGND 0.02228f ; **FLOATING
C1524 ch2_lop.n25 VGND 0.08562f ; **FLOATING
C1525 ch2_lop.n26 VGND 0.02228f ; **FLOATING
C1526 ch2_lop.n27 VGND 0.05893f ; **FLOATING
C1527 ch2_lop.n28 VGND 0.23874f ; **FLOATING
C1528 ch2_lop.n29 VGND 0.00603f ; **FLOATING
C1529 ch2_lop.n30 VGND 0.05893f ; **FLOATING
C1530 ch2_lop.n31 VGND 0.00503f ; **FLOATING
C1531 ch2_lop.n32 VGND 0.05893f ; **FLOATING
C1532 ch2_lop.n33 VGND 0.05893f ; **FLOATING
C1533 ch2_lop.n34 VGND 0.05893f ; **FLOATING
C1534 ch2_lop.n35 VGND 0.0596f ; **FLOATING
C1535 ch2_lop.n36 VGND 0.0596f ; **FLOATING
C1536 ch2_lop.n37 VGND 0.05893f ; **FLOATING
C1537 ch2_lop.n38 VGND 0.01631f ; **FLOATING
C1538 ch2_lop.n39 VGND 0.05893f ; **FLOATING
C1539 ch2_lop.n40 VGND 0.01631f ; **FLOATING
C1540 ch2_lop.n41 VGND 0.05893f ; **FLOATING
C1541 ch2_lop.n42 VGND 0.01631f ; **FLOATING
C1542 ch2_lop.n43 VGND 0.02228f ; **FLOATING
C1543 ch2_lop.n44 VGND 0.08562f ; **FLOATING
C1544 ch2_lop.n45 VGND 0.02228f ; **FLOATING
C1545 ch2_lop.n46 VGND 0.05893f ; **FLOATING
C1546 ch2_lop.n47 VGND 1.19916f ; **FLOATING
C1547 ch2_lop.n48 VGND 1.00575f ; **FLOATING
C1548 ch2_lop.n49 VGND 0.00603f ; **FLOATING
C1549 ch2_lop.n50 VGND 0.05893f ; **FLOATING
C1550 ch2_lop.n51 VGND 0.00503f ; **FLOATING
C1551 ch2_lop.n52 VGND 0.05893f ; **FLOATING
C1552 ch2_lop.n53 VGND 0.05893f ; **FLOATING
C1553 ch2_lop.n54 VGND 0.05893f ; **FLOATING
C1554 ch2_lop.n55 VGND 0.0596f ; **FLOATING
C1555 ch2_lop.n56 VGND 0.0596f ; **FLOATING
C1556 ch2_lop.n57 VGND 0.05893f ; **FLOATING
C1557 ch2_lop.n58 VGND 0.01631f ; **FLOATING
C1558 ch2_lop.n59 VGND 0.05893f ; **FLOATING
C1559 ch2_lop.n60 VGND 0.01631f ; **FLOATING
C1560 ch2_lop.n61 VGND 0.05893f ; **FLOATING
C1561 ch2_lop.n62 VGND 0.01631f ; **FLOATING
C1562 ch2_lop.n63 VGND 0.02228f ; **FLOATING
C1563 ch2_lop.n64 VGND 0.08562f ; **FLOATING
C1564 ch2_lop.n65 VGND 0.02228f ; **FLOATING
C1565 ch2_lop.n66 VGND 0.05893f ; **FLOATING
C1566 ch2_lop.n67 VGND 3.74023f ; **FLOATING
C1567 ch2_lop.n68 VGND 0.35346f ; **FLOATING
C1568 ch2_lop.n69 VGND 0.00603f ; **FLOATING
C1569 ch2_lop.n70 VGND 0.05893f ; **FLOATING
C1570 ch2_lop.n71 VGND 0.00503f ; **FLOATING
C1571 ch2_lop.n72 VGND 0.05893f ; **FLOATING
C1572 ch2_lop.n73 VGND 0.05893f ; **FLOATING
C1573 ch2_lop.n74 VGND 0.05893f ; **FLOATING
C1574 ch2_lop.n75 VGND 0.0596f ; **FLOATING
C1575 ch2_lop.n76 VGND 0.0596f ; **FLOATING
C1576 ch2_lop.n77 VGND 0.05893f ; **FLOATING
C1577 ch2_lop.n78 VGND 0.01631f ; **FLOATING
C1578 ch2_lop.n79 VGND 0.05893f ; **FLOATING
C1579 ch2_lop.n80 VGND 0.01631f ; **FLOATING
C1580 ch2_lop.n81 VGND 0.05893f ; **FLOATING
C1581 ch2_lop.n82 VGND 0.01631f ; **FLOATING
C1582 ch2_lop.n83 VGND 0.02228f ; **FLOATING
C1583 ch2_lop.n84 VGND 0.08562f ; **FLOATING
C1584 ch2_lop.n85 VGND 0.02228f ; **FLOATING
C1585 ch2_lop.n86 VGND 0.05893f ; **FLOATING
C1586 ch2_lon.n0 VGND 1.69554f ; **FLOATING
C1587 ch2_lon.n1 VGND 0.07178f ; **FLOATING
C1588 ch2_lon.n2 VGND 0.06909f ; **FLOATING
C1589 ch2_lon.n3 VGND 0.07178f ; **FLOATING
C1590 ch2_lon.n4 VGND 1.80198f ; **FLOATING
C1591 ch2_lon.n5 VGND 0.06686f ; **FLOATING
C1592 ch2_lon.n6 VGND 0.06418f ; **FLOATING
C1593 ch2_lon.n7 VGND 0.06686f ; **FLOATING
C1594 ch2_lon.n8 VGND 11.7788f ; **FLOATING
C1595 ch2_lon.n9 VGND 1.69946f ; **FLOATING
C1596 ch2_lon.n10 VGND 0.00802f ; **FLOATING
C1597 ch2_lon.n11 VGND 0.07837f ; **FLOATING
C1598 ch2_lon.n12 VGND 0.00668f ; **FLOATING
C1599 ch2_lon.n13 VGND 0.07837f ; **FLOATING
C1600 ch2_lon.n14 VGND 0.07837f ; **FLOATING
C1601 ch2_lon.n15 VGND 0.07837f ; **FLOATING
C1602 ch2_lon.n16 VGND 0.07927f ; **FLOATING
C1603 ch2_lon.n17 VGND 0.07927f ; **FLOATING
C1604 ch2_lon.n18 VGND 0.07837f ; **FLOATING
C1605 ch2_lon.n19 VGND 0.02169f ; **FLOATING
C1606 ch2_lon.n20 VGND 0.07837f ; **FLOATING
C1607 ch2_lon.n21 VGND 0.02169f ; **FLOATING
C1608 ch2_lon.n22 VGND 0.07837f ; **FLOATING
C1609 ch2_lon.n23 VGND 0.02169f ; **FLOATING
C1610 ch2_lon.n24 VGND 0.02963f ; **FLOATING
C1611 ch2_lon.n25 VGND 0.11387f ; **FLOATING
C1612 ch2_lon.n26 VGND 0.02963f ; **FLOATING
C1613 ch2_lon.n27 VGND 0.07837f ; **FLOATING
C1614 ch2_lon.n28 VGND 9.30383f ; **FLOATING
C1615 ch2_lon.n29 VGND 0.33605f ; **FLOATING
C1616 ch2_lon.n30 VGND 0.00802f ; **FLOATING
C1617 ch2_lon.n31 VGND 0.07837f ; **FLOATING
C1618 ch2_lon.n32 VGND 0.00668f ; **FLOATING
C1619 ch2_lon.n33 VGND 0.07837f ; **FLOATING
C1620 ch2_lon.n34 VGND 0.07837f ; **FLOATING
C1621 ch2_lon.n35 VGND 0.07837f ; **FLOATING
C1622 ch2_lon.n36 VGND 0.07927f ; **FLOATING
C1623 ch2_lon.n37 VGND 0.07927f ; **FLOATING
C1624 ch2_lon.n38 VGND 0.07837f ; **FLOATING
C1625 ch2_lon.n39 VGND 0.02169f ; **FLOATING
C1626 ch2_lon.n40 VGND 0.07837f ; **FLOATING
C1627 ch2_lon.n41 VGND 0.02169f ; **FLOATING
C1628 ch2_lon.n42 VGND 0.07837f ; **FLOATING
C1629 ch2_lon.n43 VGND 0.02169f ; **FLOATING
C1630 ch2_lon.n44 VGND 0.02963f ; **FLOATING
C1631 ch2_lon.n45 VGND 0.11387f ; **FLOATING
C1632 ch2_lon.n46 VGND 0.02963f ; **FLOATING
C1633 ch2_lon.n47 VGND 0.07837f ; **FLOATING
C1634 ch2_lon.n48 VGND 0.48053f ; **FLOATING
C1635 ch2_lon.n49 VGND 0.00802f ; **FLOATING
C1636 ch2_lon.n50 VGND 0.07837f ; **FLOATING
C1637 ch2_lon.n51 VGND 0.00668f ; **FLOATING
C1638 ch2_lon.n52 VGND 0.07837f ; **FLOATING
C1639 ch2_lon.n53 VGND 0.07837f ; **FLOATING
C1640 ch2_lon.n54 VGND 0.07837f ; **FLOATING
C1641 ch2_lon.n55 VGND 0.07927f ; **FLOATING
C1642 ch2_lon.n56 VGND 0.07927f ; **FLOATING
C1643 ch2_lon.n57 VGND 0.07837f ; **FLOATING
C1644 ch2_lon.n58 VGND 0.02169f ; **FLOATING
C1645 ch2_lon.n59 VGND 0.07837f ; **FLOATING
C1646 ch2_lon.n60 VGND 0.02169f ; **FLOATING
C1647 ch2_lon.n61 VGND 0.07837f ; **FLOATING
C1648 ch2_lon.n62 VGND 0.02169f ; **FLOATING
C1649 ch2_lon.n63 VGND 0.02963f ; **FLOATING
C1650 ch2_lon.n64 VGND 0.11387f ; **FLOATING
C1651 ch2_lon.n65 VGND 0.02963f ; **FLOATING
C1652 ch2_lon.n66 VGND 0.07837f ; **FLOATING
C1653 ch2_lon.n67 VGND 8.04447f ; **FLOATING
C1654 ch2_lon.n68 VGND 2.81846f ; **FLOATING
C1655 ch2_lon.n69 VGND 0.00802f ; **FLOATING
C1656 ch2_lon.n70 VGND 0.07837f ; **FLOATING
C1657 ch2_lon.n71 VGND 0.00668f ; **FLOATING
C1658 ch2_lon.n72 VGND 0.07837f ; **FLOATING
C1659 ch2_lon.n73 VGND 0.07837f ; **FLOATING
C1660 ch2_lon.n74 VGND 0.07837f ; **FLOATING
C1661 ch2_lon.n75 VGND 0.07927f ; **FLOATING
C1662 ch2_lon.n76 VGND 0.07927f ; **FLOATING
C1663 ch2_lon.n77 VGND 0.07837f ; **FLOATING
C1664 ch2_lon.n78 VGND 0.02169f ; **FLOATING
C1665 ch2_lon.n79 VGND 0.07837f ; **FLOATING
C1666 ch2_lon.n80 VGND 0.02169f ; **FLOATING
C1667 ch2_lon.n81 VGND 0.07837f ; **FLOATING
C1668 ch2_lon.n82 VGND 0.02169f ; **FLOATING
C1669 ch2_lon.n83 VGND 0.02963f ; **FLOATING
C1670 ch2_lon.n84 VGND 0.11387f ; **FLOATING
C1671 ch2_lon.n85 VGND 0.02963f ; **FLOATING
C1672 ch2_lon.n86 VGND 0.07837f ; **FLOATING
C1673 select_b.n0 VGND 0.05828f ; **FLOATING
C1674 select_b.n1 VGND 0.03233f ; **FLOATING
C1675 select_b.n2 VGND 0.05916f ; **FLOATING
C1676 select_b.n3 VGND 3.4532f ; **FLOATING
C1677 select_b.n4 VGND 3.26733f ; **FLOATING
C1678 select_b.n5 VGND 0.39056f ; **FLOATING
C1679 select_b.n6 VGND 0.00835f ; **FLOATING
C1680 select_b.n7 VGND 0.08341f ; **FLOATING
C1681 select_b.n8 VGND 0.00695f ; **FLOATING
C1682 select_b.n9 VGND 0.08341f ; **FLOATING
C1683 select_b.n10 VGND 0.08341f ; **FLOATING
C1684 select_b.n11 VGND 0.08341f ; **FLOATING
C1685 select_b.n12 VGND 0.08435f ; **FLOATING
C1686 select_b.n13 VGND 0.08341f ; **FLOATING
C1687 select_b.n14 VGND 0.02256f ; **FLOATING
C1688 select_b.n15 VGND 0.08341f ; **FLOATING
C1689 select_b.n16 VGND 0.02256f ; **FLOATING
C1690 select_b.n17 VGND 0.08341f ; **FLOATING
C1691 select_b.n18 VGND 0.02256f ; **FLOATING
C1692 select_b.n19 VGND 0.08435f ; **FLOATING
C1693 select_b.n20 VGND 0.03083f ; **FLOATING
C1694 select_b.n21 VGND 0.11848f ; **FLOATING
C1695 select_b.n22 VGND 0.03083f ; **FLOATING
C1696 select_b.n23 VGND 0.08341f ; **FLOATING
C1697 select_b.n24 VGND 0.56312f ; **FLOATING
C1698 select_b.n25 VGND 0.00835f ; **FLOATING
C1699 select_b.n26 VGND 0.08341f ; **FLOATING
C1700 select_b.n27 VGND 0.00695f ; **FLOATING
C1701 select_b.n28 VGND 0.08341f ; **FLOATING
C1702 select_b.n29 VGND 0.08341f ; **FLOATING
C1703 select_b.n30 VGND 0.08341f ; **FLOATING
C1704 select_b.n31 VGND 0.08435f ; **FLOATING
C1705 select_b.n32 VGND 0.08435f ; **FLOATING
C1706 select_b.n33 VGND 0.08341f ; **FLOATING
C1707 select_b.n34 VGND 0.02256f ; **FLOATING
C1708 select_b.n35 VGND 0.08341f ; **FLOATING
C1709 select_b.n36 VGND 0.02256f ; **FLOATING
C1710 select_b.n37 VGND 0.08341f ; **FLOATING
C1711 select_b.n38 VGND 0.02256f ; **FLOATING
C1712 select_b.n39 VGND 0.03083f ; **FLOATING
C1713 select_b.n40 VGND 0.11848f ; **FLOATING
C1714 select_b.n41 VGND 0.03083f ; **FLOATING
C1715 select_b.n42 VGND 0.08341f ; **FLOATING
C1716 select_b.n43 VGND 0.34913f ; **FLOATING
C1717 select_b.n44 VGND 0.00835f ; **FLOATING
C1718 select_b.n45 VGND 0.06496f ; **FLOATING
C1719 select_b.n46 VGND 0.00695f ; **FLOATING
C1720 select_b.n47 VGND 0.06496f ; **FLOATING
C1721 select_b.n48 VGND 0.06496f ; **FLOATING
C1722 select_b.n49 VGND 0.06496f ; **FLOATING
C1723 select_b.n50 VGND 0.06589f ; **FLOATING
C1724 select_b.n51 VGND 0.06589f ; **FLOATING
C1725 select_b.n52 VGND 0.06496f ; **FLOATING
C1726 select_b.n53 VGND 0.02256f ; **FLOATING
C1727 select_b.n54 VGND 0.06496f ; **FLOATING
C1728 select_b.n55 VGND 0.02256f ; **FLOATING
C1729 select_b.n56 VGND 0.06496f ; **FLOATING
C1730 select_b.n57 VGND 0.02256f ; **FLOATING
C1731 select_b.n58 VGND 0.03083f ; **FLOATING
C1732 select_b.n59 VGND 0.11848f ; **FLOATING
C1733 select_b.n60 VGND 0.03083f ; **FLOATING
C1734 select_b.n61 VGND 0.06496f ; **FLOATING
C1735 select_b.n62 VGND 0.12926f ; **FLOATING
C1736 select_b.n63 VGND 0.00835f ; **FLOATING
C1737 select_b.n64 VGND 0.06496f ; **FLOATING
C1738 select_b.n65 VGND 0.00695f ; **FLOATING
C1739 select_b.n66 VGND 0.06496f ; **FLOATING
C1740 select_b.n67 VGND 0.06496f ; **FLOATING
C1741 select_b.n68 VGND 0.06496f ; **FLOATING
C1742 select_b.n69 VGND 0.06589f ; **FLOATING
C1743 select_b.n70 VGND 0.06589f ; **FLOATING
C1744 select_b.n71 VGND 0.06496f ; **FLOATING
C1745 select_b.n72 VGND 0.02256f ; **FLOATING
C1746 select_b.n73 VGND 0.06496f ; **FLOATING
C1747 select_b.n74 VGND 0.02256f ; **FLOATING
C1748 select_b.n75 VGND 0.06496f ; **FLOATING
C1749 select_b.n76 VGND 0.02256f ; **FLOATING
C1750 select_b.n77 VGND 0.03083f ; **FLOATING
C1751 select_b.n78 VGND 0.11848f ; **FLOATING
C1752 select_b.n79 VGND 0.03083f ; **FLOATING
C1753 select_b.n80 VGND 0.06496f ; **FLOATING
C1754 select_b.n81 VGND 2.94425f ; **FLOATING
C1755 select_b.n82 VGND 3.25854f ; **FLOATING
C1756 select_b.n83 VGND 0.06977f ; **FLOATING
C1757 select_b.n84 VGND 0.06697f ; **FLOATING
C1758 select_b.n85 VGND 9.75128f ; **FLOATING
C1759 lon.n0 VGND 0.2083f ; **FLOATING
C1760 lon.n1 VGND 1.14173f ; **FLOATING
C1761 lon.n2 VGND 0.20752f ; **FLOATING
C1762 lon.n3 VGND 2.90358f ; **FLOATING
C1763 lon.n4 VGND 0.35257f ; **FLOATING
C1764 lon.n5 VGND 0.24551f ; **FLOATING
C1765 lon.n6 VGND 0.05207f ; **FLOATING
C1766 lon.n7 VGND 0.04972f ; **FLOATING
C1767 lon.n8 VGND 0.05207f ; **FLOATING
C1768 lon.n9 VGND 7.04355f ; **FLOATING
C1769 lon.n10 VGND 7.98606f ; **FLOATING
C1770 lon.n11 VGND 0.05207f ; **FLOATING
C1771 lon.n12 VGND 0.04972f ; **FLOATING
C1772 lon.n13 VGND 0.16032f ; **FLOATING
C1773 lon.n14 VGND 0.04972f ; **FLOATING
C1774 lon.n15 VGND 2.76872f ; **FLOATING
C1775 lon.n16 VGND 0.06423f ; **FLOATING
C1776 lon.n17 VGND 0.06188f ; **FLOATING
C1777 lon.n18 VGND 0.16032f ; **FLOATING
C1778 lon.n19 VGND 0.06188f ; **FLOATING
C1779 lon.n20 VGND 0.08924f ; **FLOATING
C1780 lon.n21 VGND 0.06188f ; **FLOATING
C1781 lon.n22 VGND 0.08924f ; **FLOATING
C1782 lon.n23 VGND 0.06188f ; **FLOATING
C1783 lon.n24 VGND 1.62767f ; **FLOATING
C1784 lon.n25 VGND 0.9525f ; **FLOATING
C1785 lon.n26 VGND 0.05612f ; **FLOATING
C1786 lon.n27 VGND 0.93127f ; **FLOATING
C1787 lon.n28 VGND 0.05612f ; **FLOATING
C1788 lon.n29 VGND 0.16032f ; **FLOATING
C1789 lon.n30 VGND 0.05847f ; **FLOATING
C1790 lon.n31 VGND 0.46049f ; **FLOATING
C1791 lon.n32 VGND 0.04972f ; **FLOATING
C1792 lon.n33 VGND 0.96281f ; **FLOATING
C1793 lon.n34 VGND 0.04972f ; **FLOATING
C1794 lon.n35 VGND 0.16032f ; **FLOATING
C1795 lon.n36 VGND 0.05207f ; **FLOATING
C1796 lon.n37 VGND 2.23781f ; **FLOATING
C1797 lon.n38 VGND 0.2083f ; **FLOATING
C1798 lop.n0 VGND 0.21181f ; **FLOATING
C1799 lop.n1 VGND 0.1146f ; **FLOATING
C1800 lop.n2 VGND 0.1146f ; **FLOATING
C1801 lop.n3 VGND 0.8998f ; **FLOATING
C1802 lop.n4 VGND 0.21102f ; **FLOATING
C1803 lop.n5 VGND 0.62226f ; **FLOATING
C1804 lop.n6 VGND 0.27537f ; **FLOATING
C1805 lop.n7 VGND 0.21102f ; **FLOATING
C1806 lop.n8 VGND 0.86201f ; **FLOATING
C1807 lop.n9 VGND 0.05295f ; **FLOATING
C1808 lop.n10 VGND 0.05056f ; **FLOATING
C1809 lop.n11 VGND 0.16302f ; **FLOATING
C1810 lop.n12 VGND 0.05056f ; **FLOATING
C1811 lop.n13 VGND 0.59879f ; **FLOATING
C1812 lop.n14 VGND 0.05056f ; **FLOATING
C1813 lop.n15 VGND 0.2519f ; **FLOATING
C1814 lop.n16 VGND 0.05056f ; **FLOATING
C1815 lop.n17 VGND 0.16302f ; **FLOATING
C1816 lop.n18 VGND 0.05295f ; **FLOATING
C1817 lop.n19 VGND 0.75995f ; **FLOATING
C1818 lop.n20 VGND 4.38572f ; **FLOATING
C1819 lop.n21 VGND 0.05945f ; **FLOATING
C1820 lop.n22 VGND 0.05706f ; **FLOATING
C1821 lop.n23 VGND 0.05945f ; **FLOATING
C1822 lop.n24 VGND 5.88748f ; **FLOATING
C1823 lop.n25 VGND 0.06531f ; **FLOATING
C1824 lop.n26 VGND 0.06292f ; **FLOATING
C1825 lop.n27 VGND 0.16302f ; **FLOATING
C1826 lop.n28 VGND 0.06292f ; **FLOATING
C1827 lop.n29 VGND 0.09074f ; **FLOATING
C1828 lop.n30 VGND 0.06292f ; **FLOATING
C1829 lop.n31 VGND 0.09074f ; **FLOATING
C1830 lop.n32 VGND 0.06292f ; **FLOATING
C1831 lop.n33 VGND 0.87593f ; **FLOATING
C1832 lop.n34 VGND 0.74392f ; **FLOATING
C1833 lop.n35 VGND 4.37242f ; **FLOATING
C1834 lop.n36 VGND 0.05295f ; **FLOATING
C1835 lop.n37 VGND 0.05056f ; **FLOATING
C1836 lop.n38 VGND 0.05295f ; **FLOATING
C1837 lop.n39 VGND 6.23709f ; **FLOATING
C1838 lp1.n0 VGND 0.02871f ; **FLOATING
C1839 lp1.n1 VGND 0.01592f ; **FLOATING
C1840 lp1.n2 VGND 0.02914f ; **FLOATING
C1841 lp1.n3 VGND 1.19752f ; **FLOATING
C1842 lp1.n4 VGND 0.19742f ; **FLOATING
C1843 lp1.n5 VGND 0.01348f ; **FLOATING
C1844 lp1.n6 VGND 0.03592f ; **FLOATING
C1845 lp1.n7 VGND 0.00411f ; **FLOATING
C1846 lp1.n8 VGND 0.0611f ; **FLOATING
C1847 lp1.n9 VGND 0.00411f ; **FLOATING
C1848 lp1.n10 VGND 0.03592f ; **FLOATING
C1849 lp1.n11 VGND 0.01249f ; **FLOATING
C1850 lp1.n12 VGND 0.0611f ; **FLOATING
C1851 lp1.n13 VGND 0.0611f ; **FLOATING
C1852 lp1.n14 VGND 0.0611f ; **FLOATING
C1853 lp1.n15 VGND 0.0611f ; **FLOATING
C1854 lp1.n16 VGND 0.0611f ; **FLOATING
C1855 lp1.n17 VGND 0.0611f ; **FLOATING
C1856 lp1.n18 VGND 0.0611f ; **FLOATING
C1857 lp1.n19 VGND 0.06156f ; **FLOATING
C1858 lp1.n20 VGND 0.0611f ; **FLOATING
C1859 lp1.n21 VGND 0.01111f ; **FLOATING
C1860 lp1.n22 VGND 0.0611f ; **FLOATING
C1861 lp1.n23 VGND 0.01111f ; **FLOATING
C1862 lp1.n24 VGND 0.0611f ; **FLOATING
C1863 lp1.n25 VGND 0.01111f ; **FLOATING
C1864 lp1.n26 VGND 0.0611f ; **FLOATING
C1865 lp1.n27 VGND 0.01111f ; **FLOATING
C1866 lp1.n28 VGND 0.0611f ; **FLOATING
C1867 lp1.n29 VGND 0.01111f ; **FLOATING
C1868 lp1.n30 VGND 0.0611f ; **FLOATING
C1869 lp1.n31 VGND 0.01111f ; **FLOATING
C1870 lp1.n32 VGND 0.0611f ; **FLOATING
C1871 lp1.n33 VGND 0.01111f ; **FLOATING
C1872 lp1.n34 VGND 0.06156f ; **FLOATING
C1873 lp1.n35 VGND 0.01518f ; **FLOATING
C1874 lp1.n36 VGND 0.03592f ; **FLOATING
C1875 lp1.n37 VGND 0.01348f ; **FLOATING
C1876 lp1.n38 VGND 0.01348f ; **FLOATING
C1877 lp1.n39 VGND 0.01348f ; **FLOATING
C1878 lp1.n40 VGND 0.03592f ; **FLOATING
C1879 lp1.n41 VGND 0.01518f ; **FLOATING
C1880 lp1.n42 VGND 0.0611f ; **FLOATING
C1881 lp1.n43 VGND 0.03436f ; **FLOATING
C1882 lp1.n44 VGND 0.03298f ; **FLOATING
C1883 lp1.n45 VGND 1.18159f ; **FLOATING
C1884 lp1.n46 VGND 0.20826f ; **FLOATING
C1885 lp1.n47 VGND 0.01348f ; **FLOATING
C1886 lp1.n48 VGND 0.03592f ; **FLOATING
C1887 lp1.n49 VGND 0.00411f ; **FLOATING
C1888 lp1.n50 VGND 0.042f ; **FLOATING
C1889 lp1.n51 VGND 0.01249f ; **FLOATING
C1890 lp1.n52 VGND 0.03592f ; **FLOATING
C1891 lp1.n53 VGND 0.00411f ; **FLOATING
C1892 lp1.n54 VGND 0.042f ; **FLOATING
C1893 lp1.n55 VGND 0.042f ; **FLOATING
C1894 lp1.n56 VGND 0.042f ; **FLOATING
C1895 lp1.n57 VGND 0.042f ; **FLOATING
C1896 lp1.n58 VGND 0.042f ; **FLOATING
C1897 lp1.n59 VGND 0.042f ; **FLOATING
C1898 lp1.n60 VGND 0.042f ; **FLOATING
C1899 lp1.n61 VGND 0.04246f ; **FLOATING
C1900 lp1.n62 VGND 0.04246f ; **FLOATING
C1901 lp1.n63 VGND 0.042f ; **FLOATING
C1902 lp1.n64 VGND 0.01111f ; **FLOATING
C1903 lp1.n65 VGND 0.042f ; **FLOATING
C1904 lp1.n66 VGND 0.01111f ; **FLOATING
C1905 lp1.n67 VGND 0.042f ; **FLOATING
C1906 lp1.n68 VGND 0.01111f ; **FLOATING
C1907 lp1.n69 VGND 0.042f ; **FLOATING
C1908 lp1.n70 VGND 0.01111f ; **FLOATING
C1909 lp1.n71 VGND 0.042f ; **FLOATING
C1910 lp1.n72 VGND 0.01111f ; **FLOATING
C1911 lp1.n73 VGND 0.042f ; **FLOATING
C1912 lp1.n74 VGND 0.01111f ; **FLOATING
C1913 lp1.n75 VGND 0.042f ; **FLOATING
C1914 lp1.n76 VGND 0.01111f ; **FLOATING
C1915 lp1.n77 VGND 0.01518f ; **FLOATING
C1916 lp1.n78 VGND 0.03592f ; **FLOATING
C1917 lp1.n79 VGND 0.01348f ; **FLOATING
C1918 lp1.n80 VGND 0.01348f ; **FLOATING
C1919 lp1.n81 VGND 0.01348f ; **FLOATING
C1920 lp1.n82 VGND 0.03592f ; **FLOATING
C1921 lp1.n83 VGND 0.01518f ; **FLOATING
C1922 lp1.n84 VGND 0.042f ; **FLOATING
C1923 lp1.n85 VGND 1.00681f ; **FLOATING
C1924 ln2.n0 VGND 0.03712f ; **FLOATING
C1925 ln2.n1 VGND 0.02059f ; **FLOATING
C1926 ln2.n2 VGND 0.03768f ; **FLOATING
C1927 ln2.n3 VGND 0.45573f ; **FLOATING
C1928 ln2.n4 VGND 0.05331f ; **FLOATING
C1929 ln2.n5 VGND 0.01743f ; **FLOATING
C1930 ln2.n6 VGND 0.04645f ; **FLOATING
C1931 ln2.n7 VGND 0.00532f ; **FLOATING
C1932 ln2.n8 VGND 0.05431f ; **FLOATING
C1933 ln2.n9 VGND 0.01615f ; **FLOATING
C1934 ln2.n10 VGND 0.04645f ; **FLOATING
C1935 ln2.n11 VGND 0.00532f ; **FLOATING
C1936 ln2.n12 VGND 0.05431f ; **FLOATING
C1937 ln2.n13 VGND 0.05431f ; **FLOATING
C1938 ln2.n14 VGND 0.05431f ; **FLOATING
C1939 ln2.n15 VGND 0.05431f ; **FLOATING
C1940 ln2.n16 VGND 0.05431f ; **FLOATING
C1941 ln2.n17 VGND 0.05431f ; **FLOATING
C1942 ln2.n18 VGND 0.05431f ; **FLOATING
C1943 ln2.n19 VGND 0.05491f ; **FLOATING
C1944 ln2.n20 VGND 0.05491f ; **FLOATING
C1945 ln2.n21 VGND 0.05431f ; **FLOATING
C1946 ln2.n22 VGND 0.01437f ; **FLOATING
C1947 ln2.n23 VGND 0.05431f ; **FLOATING
C1948 ln2.n24 VGND 0.01437f ; **FLOATING
C1949 ln2.n25 VGND 0.05431f ; **FLOATING
C1950 ln2.n26 VGND 0.01437f ; **FLOATING
C1951 ln2.n27 VGND 0.05431f ; **FLOATING
C1952 ln2.n28 VGND 0.01437f ; **FLOATING
C1953 ln2.n29 VGND 0.05431f ; **FLOATING
C1954 ln2.n30 VGND 0.01437f ; **FLOATING
C1955 ln2.n31 VGND 0.05431f ; **FLOATING
C1956 ln2.n32 VGND 0.01437f ; **FLOATING
C1957 ln2.n33 VGND 0.05431f ; **FLOATING
C1958 ln2.n34 VGND 0.01437f ; **FLOATING
C1959 ln2.n35 VGND 0.01963f ; **FLOATING
C1960 ln2.n36 VGND 0.04645f ; **FLOATING
C1961 ln2.n37 VGND 0.01743f ; **FLOATING
C1962 ln2.n38 VGND 0.01743f ; **FLOATING
C1963 ln2.n39 VGND 0.01743f ; **FLOATING
C1964 ln2.n40 VGND 0.04645f ; **FLOATING
C1965 ln2.n41 VGND 0.01963f ; **FLOATING
C1966 ln2.n42 VGND 0.05431f ; **FLOATING
C1967 ln2.n43 VGND 3.43179f ; **FLOATING
C1968 ln2.n44 VGND 0.05331f ; **FLOATING
C1969 ln2.n45 VGND 0.01743f ; **FLOATING
C1970 ln2.n46 VGND 0.04645f ; **FLOATING
C1971 ln2.n47 VGND 0.00532f ; **FLOATING
C1972 ln2.n48 VGND 0.07901f ; **FLOATING
C1973 ln2.n49 VGND 0.00532f ; **FLOATING
C1974 ln2.n50 VGND 0.04645f ; **FLOATING
C1975 ln2.n51 VGND 0.01615f ; **FLOATING
C1976 ln2.n52 VGND 0.07901f ; **FLOATING
C1977 ln2.n53 VGND 0.07901f ; **FLOATING
C1978 ln2.n54 VGND 0.07901f ; **FLOATING
C1979 ln2.n55 VGND 0.07901f ; **FLOATING
C1980 ln2.n56 VGND 0.07901f ; **FLOATING
C1981 ln2.n57 VGND 0.07901f ; **FLOATING
C1982 ln2.n58 VGND 0.07901f ; **FLOATING
C1983 ln2.n59 VGND 0.0796f ; **FLOATING
C1984 ln2.n60 VGND 0.07901f ; **FLOATING
C1985 ln2.n61 VGND 0.01437f ; **FLOATING
C1986 ln2.n62 VGND 0.07901f ; **FLOATING
C1987 ln2.n63 VGND 0.01437f ; **FLOATING
C1988 ln2.n64 VGND 0.07901f ; **FLOATING
C1989 ln2.n65 VGND 0.01437f ; **FLOATING
C1990 ln2.n66 VGND 0.07901f ; **FLOATING
C1991 ln2.n67 VGND 0.01437f ; **FLOATING
C1992 ln2.n68 VGND 0.07901f ; **FLOATING
C1993 ln2.n69 VGND 0.01437f ; **FLOATING
C1994 ln2.n70 VGND 0.07901f ; **FLOATING
C1995 ln2.n71 VGND 0.01437f ; **FLOATING
C1996 ln2.n72 VGND 0.07901f ; **FLOATING
C1997 ln2.n73 VGND 0.01437f ; **FLOATING
C1998 ln2.n74 VGND 0.0796f ; **FLOATING
C1999 ln2.n75 VGND 0.01963f ; **FLOATING
C2000 ln2.n76 VGND 0.04645f ; **FLOATING
C2001 ln2.n77 VGND 0.01743f ; **FLOATING
C2002 ln2.n78 VGND 0.01743f ; **FLOATING
C2003 ln2.n79 VGND 0.01743f ; **FLOATING
C2004 ln2.n80 VGND 0.04645f ; **FLOATING
C2005 ln2.n81 VGND 0.01963f ; **FLOATING
C2006 ln2.n82 VGND 0.07901f ; **FLOATING
C2007 ln2.n83 VGND 3.79358f ; **FLOATING
C2008 ln2.n84 VGND 0.48921f ; **FLOATING
C2009 ln2.n85 VGND 0.04431f ; **FLOATING
C2010 ln2.n86 VGND 0.04253f ; **FLOATING
C2011 ln2.n87 VGND 0.04431f ; **FLOATING
C2012 ln2.n88 VGND 0.03946f ; **FLOATING
C2013 ln1.n0 VGND 0.03319f ; **FLOATING
C2014 ln1.n1 VGND 0.01841f ; **FLOATING
C2015 ln1.n2 VGND 0.03369f ; **FLOATING
C2016 ln1.n3 VGND 0.60024f ; **FLOATING
C2017 ln1.n4 VGND 0.23124f ; **FLOATING
C2018 ln1.n5 VGND 0.03528f ; **FLOATING
C2019 ln1.n6 VGND 0.03369f ; **FLOATING
C2020 ln1.n7 VGND 0.11136f ; **FLOATING
C2021 ln1.n8 VGND 0.00475f ; **FLOATING
C2022 ln1.n9 VGND 0.0475f ; **FLOATING
C2023 ln1.n10 VGND 0.00396f ; **FLOATING
C2024 ln1.n11 VGND 0.0475f ; **FLOATING
C2025 ln1.n12 VGND 0.0475f ; **FLOATING
C2026 ln1.n13 VGND 0.0475f ; **FLOATING
C2027 ln1.n14 VGND 0.04803f ; **FLOATING
C2028 ln1.n15 VGND 0.0475f ; **FLOATING
C2029 ln1.n16 VGND 0.01285f ; **FLOATING
C2030 ln1.n17 VGND 0.0475f ; **FLOATING
C2031 ln1.n18 VGND 0.01285f ; **FLOATING
C2032 ln1.n19 VGND 0.0475f ; **FLOATING
C2033 ln1.n20 VGND 0.01285f ; **FLOATING
C2034 ln1.n21 VGND 0.04803f ; **FLOATING
C2035 ln1.n22 VGND 0.01756f ; **FLOATING
C2036 ln1.n23 VGND 0.06747f ; **FLOATING
C2037 ln1.n24 VGND 0.01756f ; **FLOATING
C2038 ln1.n25 VGND 0.0475f ; **FLOATING
C2039 ln1.n26 VGND 1.22775f ; **FLOATING
C2040 ln1.n27 VGND 0.27394f ; **FLOATING
C2041 ln1.n28 VGND 0.00475f ; **FLOATING
C2042 ln1.n29 VGND 0.03699f ; **FLOATING
C2043 ln1.n30 VGND 0.00396f ; **FLOATING
C2044 ln1.n31 VGND 0.03699f ; **FLOATING
C2045 ln1.n32 VGND 0.03699f ; **FLOATING
C2046 ln1.n33 VGND 0.03699f ; **FLOATING
C2047 ln1.n34 VGND 0.03752f ; **FLOATING
C2048 ln1.n35 VGND 0.03752f ; **FLOATING
C2049 ln1.n36 VGND 0.03699f ; **FLOATING
C2050 ln1.n37 VGND 0.01285f ; **FLOATING
C2051 ln1.n38 VGND 0.03699f ; **FLOATING
C2052 ln1.n39 VGND 0.01285f ; **FLOATING
C2053 ln1.n40 VGND 0.03699f ; **FLOATING
C2054 ln1.n41 VGND 0.01285f ; **FLOATING
C2055 ln1.n42 VGND 0.01756f ; **FLOATING
C2056 ln1.n43 VGND 0.06747f ; **FLOATING
C2057 ln1.n44 VGND 0.01756f ; **FLOATING
C2058 ln1.n45 VGND 0.03699f ; **FLOATING
C2059 ln1.n46 VGND 0.8749f ; **FLOATING
C2060 vcm.n0 VGND 1.28702f ; **FLOATING
C2061 vcm.n1 VGND 0.1211f ; **FLOATING
C2062 vcm.n2 VGND 0.00123f ; **FLOATING
C2063 vcm.n3 VGND 0.00107f ; **FLOATING
C2064 vcm.n4 VGND 0.01342f ; **FLOATING
C2065 vcm.n5 VGND 0.0122f ; **FLOATING
C2066 vcm.n6 VGND 0.0122f ; **FLOATING
C2067 vcm.n7 VGND 0.0122f ; **FLOATING
C2068 vcm.n8 VGND 0.0122f ; **FLOATING
C2069 vcm.n9 VGND 0.01342f ; **FLOATING
C2070 vcm.n10 VGND 0.60301f ; **FLOATING
C2071 vcm.n11 VGND 0.05514f ; **FLOATING
C2072 vcm.n12 VGND 0.00123f ; **FLOATING
C2073 vcm.n13 VGND 0.00107f ; **FLOATING
C2074 vcm.n14 VGND 0.01342f ; **FLOATING
C2075 vcm.n15 VGND 0.0122f ; **FLOATING
C2076 vcm.n16 VGND 0.0122f ; **FLOATING
C2077 vcm.n17 VGND 0.0122f ; **FLOATING
C2078 vcm.n18 VGND 0.0122f ; **FLOATING
C2079 vcm.n19 VGND 0.01342f ; **FLOATING
C2080 vcm.n20 VGND 0.21712f ; **FLOATING
C2081 vcm.n21 VGND 0.01251f ; **FLOATING
C2082 vcm.n22 VGND 0.00123f ; **FLOATING
C2083 vcm.n23 VGND 0.00107f ; **FLOATING
C2084 vcm.n24 VGND 0.01342f ; **FLOATING
C2085 vcm.n25 VGND 0.0122f ; **FLOATING
C2086 vcm.n26 VGND 0.0122f ; **FLOATING
C2087 vcm.n27 VGND 0.0122f ; **FLOATING
C2088 vcm.n28 VGND 0.0122f ; **FLOATING
C2089 vcm.n29 VGND 0.01342f ; **FLOATING
C2090 vcm.n30 VGND 0.29489f ; **FLOATING
C2091 vcm.n31 VGND 0.03662f ; **FLOATING
C2092 vcm.n32 VGND 0.00123f ; **FLOATING
C2093 vcm.n33 VGND 0.00107f ; **FLOATING
C2094 vcm.n34 VGND 0.01342f ; **FLOATING
C2095 vcm.n35 VGND 0.0122f ; **FLOATING
C2096 vcm.n36 VGND 0.0122f ; **FLOATING
C2097 vcm.n37 VGND 0.0122f ; **FLOATING
C2098 vcm.n38 VGND 0.0122f ; **FLOATING
C2099 vcm.n39 VGND 0.01342f ; **FLOATING
C2100 vcm.n40 VGND 1.14744f ; **FLOATING
C2101 vcm.n41 VGND 0.62061f ; **FLOATING
C2102 vbias.n0 VGND 0.02389f ; **FLOATING
C2103 vbias.n1 VGND 0.01146f ; **FLOATING
C2104 vbias.n2 VGND 0.02714f ; **FLOATING
C2105 vbias.n3 VGND 0.00666f ; **FLOATING
C2106 vbias.n4 VGND 0.00666f ; **FLOATING
C2107 vbias.n5 VGND 0.02714f ; **FLOATING
C2108 vbias.n6 VGND 0.01076f ; **FLOATING
C2109 vbias.n7 VGND 0.06883f ; **FLOATING
C2110 vbias.n8 VGND 0.06241f ; **FLOATING
C2111 vbias.n9 VGND 0.06241f ; **FLOATING
C2112 vbias.n10 VGND 0.02714f ; **FLOATING
C2113 vbias.n11 VGND 0.06241f ; **FLOATING
C2114 vbias.n12 VGND 0.01146f ; **FLOATING
C2115 vbias.n13 VGND 0.06241f ; **FLOATING
C2116 vbias.n14 VGND 0.01146f ; **FLOATING
C2117 vbias.n15 VGND 0.06241f ; **FLOATING
C2118 vbias.n16 VGND 0.01146f ; **FLOATING
C2119 vbias.n17 VGND 0.06241f ; **FLOATING
C2120 vbias.n18 VGND 0.02714f ; **FLOATING
C2121 vbias.n19 VGND 0.06241f ; **FLOATING
C2122 vbias.n20 VGND 0.06883f ; **FLOATING
C2123 vbias.n21 VGND 0.73634f ; **FLOATING
C2124 vbias.n22 VGND 0.92577f ; **FLOATING
C2125 vbias.n23 VGND 0.1778f ; **FLOATING
C2126 vbias.n24 VGND 0.01828f ; **FLOATING
C2127 vbias.n25 VGND 0.01667f ; **FLOATING
C2128 vbias.n26 VGND 0.07427f ; **FLOATING
C2129 vbias.n27 VGND 0.01667f ; **FLOATING
C2130 vbias.n28 VGND 0.01667f ; **FLOATING
C2131 vbias.n29 VGND 0.07427f ; **FLOATING
C2132 vbias.n30 VGND 0.01828f ; **FLOATING
C2133 vbias.n31 VGND 0.77562f ; **FLOATING
C2134 vbias.n32 VGND 0.13589f ; **FLOATING
C2135 vbias.n33 VGND 0.01146f ; **FLOATING
C2136 vbias.n34 VGND 0.02714f ; **FLOATING
C2137 vbias.n35 VGND 0.00666f ; **FLOATING
C2138 vbias.n36 VGND 0.00666f ; **FLOATING
C2139 vbias.n37 VGND 0.02714f ; **FLOATING
C2140 vbias.n38 VGND 0.01076f ; **FLOATING
C2141 vbias.n39 VGND 0.06302f ; **FLOATING
C2142 vbias.n40 VGND 0.05657f ; **FLOATING
C2143 vbias.n41 VGND 0.05657f ; **FLOATING
C2144 vbias.n42 VGND 0.02714f ; **FLOATING
C2145 vbias.n43 VGND 0.05657f ; **FLOATING
C2146 vbias.n44 VGND 0.01146f ; **FLOATING
C2147 vbias.n45 VGND 0.05657f ; **FLOATING
C2148 vbias.n46 VGND 0.01146f ; **FLOATING
C2149 vbias.n47 VGND 0.05657f ; **FLOATING
C2150 vbias.n48 VGND 0.01146f ; **FLOATING
C2151 vbias.n49 VGND 0.05657f ; **FLOATING
C2152 vbias.n50 VGND 0.02714f ; **FLOATING
C2153 vbias.n51 VGND 0.05657f ; **FLOATING
C2154 vbias.n52 VGND 0.06302f ; **FLOATING
C2155 vbias.n53 VGND 3.70204f ; **FLOATING
C2156 vbias.n54 VGND 0.1778f ; **FLOATING
C2157 vbias.n55 VGND 0.01828f ; **FLOATING
C2158 vbias.n56 VGND 0.01667f ; **FLOATING
C2159 vbias.n57 VGND 0.07427f ; **FLOATING
C2160 vbias.n58 VGND 0.01667f ; **FLOATING
C2161 vbias.n59 VGND 0.01667f ; **FLOATING
C2162 vbias.n60 VGND 0.07427f ; **FLOATING
C2163 vbias.n61 VGND 0.01828f ; **FLOATING
C2164 vbias.n62 VGND 0.13812f ; **FLOATING
C2165 vbias.n63 VGND 0.01146f ; **FLOATING
C2166 vbias.n64 VGND 0.02714f ; **FLOATING
C2167 vbias.n65 VGND 0.00666f ; **FLOATING
C2168 vbias.n66 VGND 0.00666f ; **FLOATING
C2169 vbias.n67 VGND 0.02714f ; **FLOATING
C2170 vbias.n68 VGND 0.01076f ; **FLOATING
C2171 vbias.n69 VGND 0.06302f ; **FLOATING
C2172 vbias.n70 VGND 0.05657f ; **FLOATING
C2173 vbias.n71 VGND 0.05657f ; **FLOATING
C2174 vbias.n72 VGND 0.02714f ; **FLOATING
C2175 vbias.n73 VGND 0.05657f ; **FLOATING
C2176 vbias.n74 VGND 0.01146f ; **FLOATING
C2177 vbias.n75 VGND 0.05657f ; **FLOATING
C2178 vbias.n76 VGND 0.01146f ; **FLOATING
C2179 vbias.n77 VGND 0.05657f ; **FLOATING
C2180 vbias.n78 VGND 0.01146f ; **FLOATING
C2181 vbias.n79 VGND 0.05657f ; **FLOATING
C2182 vbias.n80 VGND 0.02714f ; **FLOATING
C2183 vbias.n81 VGND 0.05657f ; **FLOATING
C2184 vbias.n82 VGND 0.06302f ; **FLOATING
C2185 vbias.n83 VGND 0.08769f ; **FLOATING
C2186 vbias.n84 VGND 0.01146f ; **FLOATING
C2187 vbias.n85 VGND 0.02714f ; **FLOATING
C2188 vbias.n86 VGND 0.00666f ; **FLOATING
C2189 vbias.n87 VGND 0.00666f ; **FLOATING
C2190 vbias.n88 VGND 0.02714f ; **FLOATING
C2191 vbias.n89 VGND 0.01076f ; **FLOATING
C2192 vbias.n90 VGND 0.06883f ; **FLOATING
C2193 vbias.n91 VGND 0.06241f ; **FLOATING
C2194 vbias.n92 VGND 0.06241f ; **FLOATING
C2195 vbias.n93 VGND 0.02714f ; **FLOATING
C2196 vbias.n94 VGND 0.06241f ; **FLOATING
C2197 vbias.n95 VGND 0.01146f ; **FLOATING
C2198 vbias.n96 VGND 0.06241f ; **FLOATING
C2199 vbias.n97 VGND 0.01146f ; **FLOATING
C2200 vbias.n98 VGND 0.06241f ; **FLOATING
C2201 vbias.n99 VGND 0.01146f ; **FLOATING
C2202 vbias.n100 VGND 0.06241f ; **FLOATING
C2203 vbias.n101 VGND 0.02714f ; **FLOATING
C2204 vbias.n102 VGND 0.06241f ; **FLOATING
C2205 vbias.n103 VGND 0.06883f ; **FLOATING
C2206 vbias.n104 VGND 0.02389f ; **FLOATING
C2207 vbias.n105 VGND 0.01146f ; **FLOATING
C2208 vbias.n106 VGND 0.02714f ; **FLOATING
C2209 vbias.n107 VGND 0.00666f ; **FLOATING
C2210 vbias.n108 VGND 0.00666f ; **FLOATING
C2211 vbias.n109 VGND 0.02714f ; **FLOATING
C2212 vbias.n110 VGND 0.01076f ; **FLOATING
C2213 vbias.n111 VGND 0.06883f ; **FLOATING
C2214 vbias.n112 VGND 0.06241f ; **FLOATING
C2215 vbias.n113 VGND 0.06241f ; **FLOATING
C2216 vbias.n114 VGND 0.02714f ; **FLOATING
C2217 vbias.n115 VGND 0.06241f ; **FLOATING
C2218 vbias.n116 VGND 0.01146f ; **FLOATING
C2219 vbias.n117 VGND 0.06241f ; **FLOATING
C2220 vbias.n118 VGND 0.01146f ; **FLOATING
C2221 vbias.n119 VGND 0.06241f ; **FLOATING
C2222 vbias.n120 VGND 0.01146f ; **FLOATING
C2223 vbias.n121 VGND 0.06241f ; **FLOATING
C2224 vbias.n122 VGND 0.02714f ; **FLOATING
C2225 vbias.n123 VGND 0.06241f ; **FLOATING
C2226 vbias.n124 VGND 0.06883f ; **FLOATING
C2227 vbias.n125 VGND 0.64203f ; **FLOATING
C2228 vbias.n126 VGND 0.80034f ; **FLOATING
C2229 vbias.n127 VGND 0.08769f ; **FLOATING
C2230 vbias.n128 VGND 0.01146f ; **FLOATING
C2231 vbias.n129 VGND 0.02714f ; **FLOATING
C2232 vbias.n130 VGND 0.00666f ; **FLOATING
C2233 vbias.n131 VGND 0.00666f ; **FLOATING
C2234 vbias.n132 VGND 0.02714f ; **FLOATING
C2235 vbias.n133 VGND 0.01076f ; **FLOATING
C2236 vbias.n134 VGND 0.06883f ; **FLOATING
C2237 vbias.n135 VGND 0.06241f ; **FLOATING
C2238 vbias.n136 VGND 0.06241f ; **FLOATING
C2239 vbias.n137 VGND 0.02714f ; **FLOATING
C2240 vbias.n138 VGND 0.06241f ; **FLOATING
C2241 vbias.n139 VGND 0.01146f ; **FLOATING
C2242 vbias.n140 VGND 0.06241f ; **FLOATING
C2243 vbias.n141 VGND 0.01146f ; **FLOATING
C2244 vbias.n142 VGND 0.06241f ; **FLOATING
C2245 vbias.n143 VGND 0.01146f ; **FLOATING
C2246 vbias.n144 VGND 0.06241f ; **FLOATING
C2247 vbias.n145 VGND 0.02714f ; **FLOATING
C2248 vbias.n146 VGND 0.06241f ; **FLOATING
C2249 vbias.n147 VGND 0.06883f ; **FLOATING
C2250 gm2_p.n0 VGND 0.06831f ; **FLOATING
C2251 gm2_p.n1 VGND 0.02228f ; **FLOATING
C2252 gm2_p.n2 VGND 0.04451f ; **FLOATING
C2253 gm2_p.n3 VGND 0.83518f ; **FLOATING
C2254 gm2_p.n4 VGND 0.29554f ; **FLOATING
C2255 gm2_p.n5 VGND 0.22244f ; **FLOATING
C2256 gm2_p.n6 VGND 1.34393f ; **FLOATING
C2257 gm2_p.n7 VGND 2.41057f ; **FLOATING
C2258 gm2_p.n8 VGND 0.40889f ; **FLOATING
C2259 gm2_p.n9 VGND 0.49662f ; **FLOATING
C2260 gm2_p.n10 VGND 0.0471f ; **FLOATING
C2261 gm2_p.n11 VGND 0.04451f ; **FLOATING
C2262 gm2_p.n12 VGND 0.15076f ; **FLOATING
C2263 gm2_p.n13 VGND 0.04451f ; **FLOATING
C2264 gm2_p.n14 VGND 0.53209f ; **FLOATING
C2265 gm2_p.n15 VGND 2.38293f ; **FLOATING
C2266 gm2_p.n16 VGND 0.0471f ; **FLOATING
C2267 gm1_p.n0 VGND 0.06511f ; **FLOATING
C2268 gm1_p.n1 VGND 0.02123f ; **FLOATING
C2269 gm1_p.n2 VGND 0.04242f ; **FLOATING
C2270 gm1_p.n3 VGND 0.14368f ; **FLOATING
C2271 gm1_p.n4 VGND 0.04242f ; **FLOATING
C2272 gm1_p.n5 VGND 0.741f ; **FLOATING
C2273 gm1_p.n6 VGND 2.47044f ; **FLOATING
C2274 gm1_p.n7 VGND 0.35366f ; **FLOATING
C2275 gm1_p.n8 VGND 0.42974f ; **FLOATING
C2276 gm1_p.n9 VGND 0.2691f ; **FLOATING
C2277 gm1_p.n10 VGND 0.22131f ; **FLOATING
C2278 gm1_p.n11 VGND 0.9859f ; **FLOATING
C2279 gm1_p.n12 VGND 0.65622f ; **FLOATING
C2280 gm1_p.n13 VGND 0.04489f ; **FLOATING
C2281 gm1_p.n14 VGND 0.04242f ; **FLOATING
C2282 gm1_p.n15 VGND 0.04489f ; **FLOATING
C2283 gm1_p.n16 VGND 2.4931f ; **FLOATING
C2284 gm2_n.n0 VGND 0.09723f ; **FLOATING
C2285 gm2_n.n1 VGND 0.03171f ; **FLOATING
C2286 gm2_n.n2 VGND 0.06335f ; **FLOATING
C2287 gm2_n.n3 VGND 1.33257f ; **FLOATING
C2288 gm2_n.n4 VGND 0.27809f ; **FLOATING
C2289 gm2_n.n5 VGND 2.25591f ; **FLOATING
C2290 gm2_n.n6 VGND 0.56702f ; **FLOATING
C2291 gm2_n.n7 VGND 4.31128f ; **FLOATING
C2292 gm2_n.n8 VGND 0.58306f ; **FLOATING
C2293 gm2_n.n9 VGND 0.63063f ; **FLOATING
C2294 gm2_n.n10 VGND 0.06704f ; **FLOATING
C2295 gm2_n.n11 VGND 0.06335f ; **FLOATING
C2296 gm2_n.n12 VGND 0.21458f ; **FLOATING
C2297 gm2_n.n13 VGND 0.06335f ; **FLOATING
C2298 gm2_n.n14 VGND 0.39809f ; **FLOATING
C2299 gm2_n.n15 VGND 3.92184f ; **FLOATING
C2300 gm2_n.n16 VGND 0.06704f ; **FLOATING
C2301 gm1_n.n0 VGND 0.09142f ; **FLOATING
C2302 gm1_n.n1 VGND 0.02981f ; **FLOATING
C2303 gm1_n.n2 VGND 0.05956f ; **FLOATING
C2304 gm1_n.n3 VGND 0.20175f ; **FLOATING
C2305 gm1_n.n4 VGND 0.05956f ; **FLOATING
C2306 gm1_n.n5 VGND 0.70672f ; **FLOATING
C2307 gm1_n.n6 VGND 4.5361f ; **FLOATING
C2308 gm1_n.n7 VGND 0.5482f ; **FLOATING
C2309 gm1_n.n8 VGND 0.59292f ; **FLOATING
C2310 gm1_n.n9 VGND 0.26146f ; **FLOATING
C2311 gm1_n.n10 VGND 1.88059f ; **FLOATING
C2312 gm1_n.n11 VGND 0.53312f ; **FLOATING
C2313 gm1_n.n12 VGND 1.07091f ; **FLOATING
C2314 gm1_n.n13 VGND 0.06303f ; **FLOATING
C2315 gm1_n.n14 VGND 0.05956f ; **FLOATING
C2316 gm1_n.n15 VGND 0.06303f ; **FLOATING
C2317 gm1_n.n16 VGND 3.68487f ; **FLOATING
C2318 tail2.n0 VGND 0.85217f ; **FLOATING
C2319 tail2.n1 VGND 0.79702f ; **FLOATING
C2320 tail2.n2 VGND 0.03991f ; **FLOATING
C2321 tail2.n3 VGND 0.03647f ; **FLOATING
C2322 tail2.n4 VGND 0.15906f ; **FLOATING
C2323 tail2.n5 VGND 0.03647f ; **FLOATING
C2324 tail2.n6 VGND 0.07216f ; **FLOATING
C2325 tail2.n7 VGND 0.03647f ; **FLOATING
C2326 tail2.n8 VGND 0.1348f ; **FLOATING
C2327 tail2.n9 VGND 0.03991f ; **FLOATING
C2328 tail2.n10 VGND 0.54774f ; **FLOATING
C2329 tail2.n11 VGND 4.12923f ; **FLOATING
C2330 tail2.n12 VGND 0.47805f ; **FLOATING
C2331 tail2.n13 VGND 1.72809f ; **FLOATING
C2332 tail2.n14 VGND 0.03991f ; **FLOATING
C2333 tail2.n15 VGND 0.03647f ; **FLOATING
C2334 tail2.n16 VGND 0.15906f ; **FLOATING
C2335 tail2.n17 VGND 0.03647f ; **FLOATING
C2336 tail2.n18 VGND 0.03647f ; **FLOATING
C2337 tail2.n19 VGND 0.15906f ; **FLOATING
C2338 tail2.n20 VGND 0.03991f ; **FLOATING
C2339 tail2.n21 VGND 2.70796f ; **FLOATING
C2340 tail2.n22 VGND 0.69668f ; **FLOATING
C2341 tail2.n23 VGND 2.10167f ; **FLOATING
C2342 tail1.n0 VGND 1.01843f ; **FLOATING
C2343 tail1.n1 VGND 1.68247f ; **FLOATING
C2344 tail1.n2 VGND 0.0374f ; **FLOATING
C2345 tail1.n3 VGND 0.03417f ; **FLOATING
C2346 tail1.n4 VGND 0.14905f ; **FLOATING
C2347 tail1.n5 VGND 0.03417f ; **FLOATING
C2348 tail1.n6 VGND 0.03417f ; **FLOATING
C2349 tail1.n7 VGND 0.14905f ; **FLOATING
C2350 tail1.n8 VGND 0.0374f ; **FLOATING
C2351 tail1.n9 VGND 0.44611f ; **FLOATING
C2352 tail1.n10 VGND 0.48703f ; **FLOATING
C2353 tail1.n11 VGND 2.35589f ; **FLOATING
C2354 tail1.n12 VGND 0.0374f ; **FLOATING
C2355 tail1.n13 VGND 0.03417f ; **FLOATING
C2356 tail1.n14 VGND 0.14905f ; **FLOATING
C2357 tail1.n15 VGND 0.03417f ; **FLOATING
C2358 tail1.n16 VGND 0.06762f ; **FLOATING
C2359 tail1.n17 VGND 0.03417f ; **FLOATING
C2360 tail1.n18 VGND 0.12632f ; **FLOATING
C2361 tail1.n19 VGND 0.0374f ; **FLOATING
C2362 tail1.n20 VGND 1.07688f ; **FLOATING
C2363 tail1.n21 VGND 1.95108f ; **FLOATING
C2364 tail1.n22 VGND 0.28359f ; **FLOATING
C2365 tail1.n23 VGND 1.85491f ; **FLOATING
C2366 VDPWR.n0 VGND 0.11199f ; **FLOATING
C2367 VDPWR.n1 VGND 0.04776f ; **FLOATING
C2368 VDPWR.n2 VGND 0.42796f ; **FLOATING
C2369 VDPWR.n3 VGND 0.04776f ; **FLOATING
C2370 VDPWR.n4 VGND 0.19635f ; **FLOATING
C2371 VDPWR.n5 VGND 0.09168f ; **FLOATING
C2372 VDPWR.n6 VGND 0.25223f ; **FLOATING
C2373 VDPWR.n7 VGND 0.0435f ; **FLOATING
C2374 VDPWR.n8 VGND 0.16216f ; **FLOATING
C2375 VDPWR.n9 VGND 0.026f ; **FLOATING
C2376 VDPWR.n10 VGND 0.21142f ; **FLOATING
C2377 VDPWR.n11 VGND 0.02522f ; **FLOATING
C2378 VDPWR.n12 VGND 0.16216f ; **FLOATING
C2379 VDPWR.n13 VGND 0.026f ; **FLOATING
C2380 VDPWR.n14 VGND 0.026f ; **FLOATING
C2381 VDPWR.n15 VGND 0.21142f ; **FLOATING
C2382 VDPWR.n16 VGND 0.02561f ; **FLOATING
C2383 VDPWR.n17 VGND 0.02386f ; **FLOATING
C2384 VDPWR.n18 VGND 0.16216f ; **FLOATING
C2385 VDPWR.n19 VGND 0.026f ; **FLOATING
C2386 VDPWR.n20 VGND 0.21142f ; **FLOATING
C2387 VDPWR.n21 VGND 0.02522f ; **FLOATING
C2388 VDPWR.n22 VGND 0.16216f ; **FLOATING
C2389 VDPWR.n23 VGND 0.026f ; **FLOATING
C2390 VDPWR.n24 VGND 0.026f ; **FLOATING
C2391 VDPWR.n25 VGND 0.21142f ; **FLOATING
C2392 VDPWR.n26 VGND 0.02561f ; **FLOATING
C2393 VDPWR.n27 VGND 0.49783f ; **FLOATING
C2394 VDPWR.n28 VGND 0.02386f ; **FLOATING
C2395 VDPWR.n29 VGND 0.16216f ; **FLOATING
C2396 VDPWR.n30 VGND 0.026f ; **FLOATING
C2397 VDPWR.n31 VGND 0.21142f ; **FLOATING
C2398 VDPWR.n32 VGND 0.02522f ; **FLOATING
C2399 VDPWR.n33 VGND 0.16216f ; **FLOATING
C2400 VDPWR.n34 VGND 0.026f ; **FLOATING
C2401 VDPWR.n35 VGND 0.026f ; **FLOATING
C2402 VDPWR.n36 VGND 0.21142f ; **FLOATING
C2403 VDPWR.n37 VGND 0.02561f ; **FLOATING
C2404 VDPWR.n38 VGND 0.33705f ; **FLOATING
C2405 VDPWR.n39 VGND 0.02386f ; **FLOATING
C2406 VDPWR.n40 VGND 0.16216f ; **FLOATING
C2407 VDPWR.n41 VGND 0.026f ; **FLOATING
C2408 VDPWR.n42 VGND 0.21142f ; **FLOATING
C2409 VDPWR.n43 VGND 0.02522f ; **FLOATING
C2410 VDPWR.n44 VGND 0.16216f ; **FLOATING
C2411 VDPWR.n45 VGND 0.026f ; **FLOATING
C2412 VDPWR.n46 VGND 0.026f ; **FLOATING
C2413 VDPWR.n47 VGND 0.21142f ; **FLOATING
C2414 VDPWR.n48 VGND 0.02561f ; **FLOATING
C2415 VDPWR.n49 VGND 0.33705f ; **FLOATING
C2416 VDPWR.n50 VGND 0.027f ; **FLOATING
C2417 VDPWR.n51 VGND 0.23343f ; **FLOATING
C2418 VDPWR.n52 VGND 0.29303f ; **FLOATING
C2419 VDPWR.n53 VGND 0.03208f ; **FLOATING
C2420 VDPWR.n54 VGND 0.03122f ; **FLOATING
C2421 VDPWR.n55 VGND 0.23343f ; **FLOATING
C2422 VDPWR.n56 VGND 0.29303f ; **FLOATING
C2423 VDPWR.n57 VGND 0.03226f ; **FLOATING
C2424 VDPWR.n58 VGND 0.03208f ; **FLOATING
C2425 VDPWR.n59 VGND 0.03159f ; **FLOATING
C2426 VDPWR.n60 VGND 0.33705f ; **FLOATING
C2427 VDPWR.n61 VGND 0.027f ; **FLOATING
C2428 VDPWR.n62 VGND 0.23343f ; **FLOATING
C2429 VDPWR.n63 VGND 0.29303f ; **FLOATING
C2430 VDPWR.n64 VGND 0.03208f ; **FLOATING
C2431 VDPWR.n65 VGND 0.03122f ; **FLOATING
C2432 VDPWR.n66 VGND 0.23343f ; **FLOATING
C2433 VDPWR.n67 VGND 0.29303f ; **FLOATING
C2434 VDPWR.n68 VGND 0.03226f ; **FLOATING
C2435 VDPWR.n69 VGND 0.03208f ; **FLOATING
C2436 VDPWR.n70 VGND 0.03159f ; **FLOATING
C2437 VDPWR.n71 VGND 0.33705f ; **FLOATING
C2438 VDPWR.n72 VGND 0.027f ; **FLOATING
C2439 VDPWR.n73 VGND 0.23343f ; **FLOATING
C2440 VDPWR.n74 VGND 0.29303f ; **FLOATING
C2441 VDPWR.n75 VGND 0.03208f ; **FLOATING
C2442 VDPWR.n76 VGND 0.03122f ; **FLOATING
C2443 VDPWR.n77 VGND 0.23343f ; **FLOATING
C2444 VDPWR.n78 VGND 0.29303f ; **FLOATING
C2445 VDPWR.n79 VGND 0.03226f ; **FLOATING
C2446 VDPWR.n80 VGND 0.03208f ; **FLOATING
C2447 VDPWR.n81 VGND 0.03159f ; **FLOATING
C2448 VDPWR.n82 VGND 0.21116f ; **FLOATING
C2449 VDPWR.n83 VGND 0.04274f ; **FLOATING
C2450 VDPWR.n84 VGND 0.23343f ; **FLOATING
C2451 VDPWR.n85 VGND 0.29303f ; **FLOATING
C2452 VDPWR.n86 VGND 0.03208f ; **FLOATING
C2453 VDPWR.n87 VGND 0.03122f ; **FLOATING
C2454 VDPWR.n88 VGND 0.23343f ; **FLOATING
C2455 VDPWR.n89 VGND 0.29303f ; **FLOATING
C2456 VDPWR.n90 VGND 0.03226f ; **FLOATING
C2457 VDPWR.n91 VGND 0.03208f ; **FLOATING
C2458 VDPWR.n92 VGND 0.03159f ; **FLOATING
C2459 VDPWR.n93 VGND 0.32824f ; **FLOATING
C2460 VDPWR.n94 VGND 0.18441f ; **FLOATING
C2461 VDPWR.n95 VGND 0.08806f ; **FLOATING
C2462 VDPWR.n96 VGND 0.00922f ; **FLOATING
C2463 VDPWR.n97 VGND 0.68553f ; **FLOATING
C2464 VDPWR.n98 VGND 0.05842f ; **FLOATING
C2465 VDPWR.n99 VGND 0.00922f ; **FLOATING
C2466 VDPWR.n100 VGND 0.00922f ; **FLOATING
C2467 VDPWR.n101 VGND 0.63942f ; **FLOATING
C2468 VDPWR.n102 VGND 0.05479f ; **FLOATING
C2469 VDPWR.n103 VGND 0.00922f ; **FLOATING
C2470 VDPWR.n104 VGND 0.25199f ; **FLOATING
C2471 VDPWR.n105 VGND 0.03131f ; **FLOATING
C2472 VDPWR.n106 VGND 0.36655f ; **FLOATING
C2473 VDPWR.n107 VGND 0.04088f ; **FLOATING
C2474 VDPWR.n108 VGND 0.45029f ; **FLOATING
C2475 VDPWR.n109 VGND 0.04007f ; **FLOATING
C2476 VDPWR.n110 VGND 0.36655f ; **FLOATING
C2477 VDPWR.n111 VGND 0.04088f ; **FLOATING
C2478 VDPWR.n112 VGND 0.04088f ; **FLOATING
C2479 VDPWR.n113 VGND 0.45029f ; **FLOATING
C2480 VDPWR.n114 VGND 0.04043f ; **FLOATING
C2481 VDPWR.n115 VGND 0.22621f ; **FLOATING
C2482 VDPWR.n116 VGND 0.02048f ; **FLOATING
C2483 VDPWR.n117 VGND 0.09704f ; **FLOATING
C2484 VDPWR.n118 VGND 0.01926f ; **FLOATING
C2485 VDPWR.n119 VGND 0.13178f ; **FLOATING
C2486 VDPWR.n120 VGND 0.01847f ; **FLOATING
C2487 VDPWR.n121 VGND 0.09704f ; **FLOATING
C2488 VDPWR.n122 VGND 0.01926f ; **FLOATING
C2489 VDPWR.n123 VGND 0.01926f ; **FLOATING
C2490 VDPWR.n124 VGND 0.13178f ; **FLOATING
C2491 VDPWR.n125 VGND 0.01887f ; **FLOATING
C2492 VDPWR.n126 VGND 0.3776f ; **FLOATING
C2493 VDPWR.n127 VGND 0.02386f ; **FLOATING
C2494 VDPWR.n128 VGND 0.16216f ; **FLOATING
C2495 VDPWR.n129 VGND 0.026f ; **FLOATING
C2496 VDPWR.n130 VGND 0.21142f ; **FLOATING
C2497 VDPWR.n131 VGND 0.02522f ; **FLOATING
C2498 VDPWR.n132 VGND 0.16216f ; **FLOATING
C2499 VDPWR.n133 VGND 0.026f ; **FLOATING
C2500 VDPWR.n134 VGND 0.026f ; **FLOATING
C2501 VDPWR.n135 VGND 0.21142f ; **FLOATING
C2502 VDPWR.n136 VGND 0.02561f ; **FLOATING
C2503 VDPWR.n137 VGND 0.43436f ; **FLOATING
C2504 VDPWR.n138 VGND 0.03131f ; **FLOATING
C2505 VDPWR.n139 VGND 0.36655f ; **FLOATING
C2506 VDPWR.n140 VGND 0.04088f ; **FLOATING
C2507 VDPWR.n141 VGND 0.45029f ; **FLOATING
C2508 VDPWR.n142 VGND 0.04007f ; **FLOATING
C2509 VDPWR.n143 VGND 0.36655f ; **FLOATING
C2510 VDPWR.n144 VGND 0.04088f ; **FLOATING
C2511 VDPWR.n145 VGND 0.04088f ; **FLOATING
C2512 VDPWR.n146 VGND 0.45029f ; **FLOATING
C2513 VDPWR.n147 VGND 0.04043f ; **FLOATING
C2514 VDPWR.n148 VGND 0.25594f ; **FLOATING
C2515 VDPWR.n149 VGND 0.02153f ; **FLOATING
C2516 VDPWR.n150 VGND 0.11538f ; **FLOATING
C2517 VDPWR.n151 VGND 0.1526f ; **FLOATING
C2518 VDPWR.n152 VGND 0.0213f ; **FLOATING
C2519 VDPWR.n153 VGND 0.02043f ; **FLOATING
C2520 VDPWR.n154 VGND 0.11538f ; **FLOATING
C2521 VDPWR.n155 VGND 0.1526f ; **FLOATING
C2522 VDPWR.n156 VGND 0.02136f ; **FLOATING
C2523 VDPWR.n157 VGND 0.0213f ; **FLOATING
C2524 VDPWR.n158 VGND 0.02083f ; **FLOATING
C2525 VDPWR.n159 VGND 0.3776f ; **FLOATING
C2526 VDPWR.n160 VGND 0.02386f ; **FLOATING
C2527 VDPWR.n161 VGND 0.16216f ; **FLOATING
C2528 VDPWR.n162 VGND 0.026f ; **FLOATING
C2529 VDPWR.n163 VGND 0.21142f ; **FLOATING
C2530 VDPWR.n164 VGND 0.02522f ; **FLOATING
C2531 VDPWR.n165 VGND 0.16216f ; **FLOATING
C2532 VDPWR.n166 VGND 0.026f ; **FLOATING
C2533 VDPWR.n167 VGND 0.026f ; **FLOATING
C2534 VDPWR.n168 VGND 0.21142f ; **FLOATING
C2535 VDPWR.n169 VGND 0.02561f ; **FLOATING
C2536 VDPWR.n170 VGND 0.26619f ; **FLOATING
C2537 VDPWR.n171 VGND 0.29096f ; **FLOATING
C2538 VDPWR.n172 VGND 0.05479f ; **FLOATING
C2539 VDPWR.n173 VGND 0.01697f ; **FLOATING
C2540 VDPWR.n174 VGND 0.21873f ; **FLOATING
C2541 VDPWR.n175 VGND 0.05959f ; **FLOATING
C2542 VDPWR.n176 VGND 0.01439f ; **FLOATING
C2543 VDPWR.n177 VGND 0.00938f ; **FLOATING
C2544 VDPWR.n178 VGND 0.00938f ; **FLOATING
C2545 VDPWR.n179 VGND 0.01439f ; **FLOATING
C2546 VDPWR.n180 VGND 0.21873f ; **FLOATING
C2547 VDPWR.n181 VGND 0.05959f ; **FLOATING
C2548 VDPWR.n182 VGND 0.01439f ; **FLOATING
C2549 VDPWR.n183 VGND 0.00938f ; **FLOATING
C2550 VDPWR.n184 VGND 0.00938f ; **FLOATING
C2551 VDPWR.n185 VGND 0.01439f ; **FLOATING
C2552 VDPWR.n186 VGND 0.02247f ; **FLOATING
C2553 VDPWR.n187 VGND 0.11538f ; **FLOATING
C2554 VDPWR.n188 VGND 0.1526f ; **FLOATING
C2555 VDPWR.n189 VGND 0.0213f ; **FLOATING
C2556 VDPWR.n190 VGND 0.02043f ; **FLOATING
C2557 VDPWR.n191 VGND 0.11538f ; **FLOATING
C2558 VDPWR.n192 VGND 0.1526f ; **FLOATING
C2559 VDPWR.n193 VGND 0.02136f ; **FLOATING
C2560 VDPWR.n194 VGND 0.0213f ; **FLOATING
C2561 VDPWR.n195 VGND 0.02083f ; **FLOATING
C2562 VDPWR.n196 VGND 0.03949f ; **FLOATING
C2563 VDPWR.n197 VGND 0.16216f ; **FLOATING
C2564 VDPWR.n198 VGND 0.026f ; **FLOATING
C2565 VDPWR.n199 VGND 0.21142f ; **FLOATING
C2566 VDPWR.n200 VGND 0.02522f ; **FLOATING
C2567 VDPWR.n201 VGND 0.16216f ; **FLOATING
C2568 VDPWR.n202 VGND 0.026f ; **FLOATING
C2569 VDPWR.n203 VGND 0.026f ; **FLOATING
C2570 VDPWR.n204 VGND 0.21142f ; **FLOATING
C2571 VDPWR.n205 VGND 0.02561f ; **FLOATING
C2572 VDPWR.n206 VGND 0.33883f ; **FLOATING
C2573 VDPWR.n207 VGND 0.06028f ; **FLOATING
C2574 VDPWR.n208 VGND 0.02498f ; **FLOATING
C2575 VDPWR.n209 VGND 0.00368f ; **FLOATING
C2576 VDPWR.n210 VGND 0.00368f ; **FLOATING
C2577 VDPWR.n211 VGND 0.00502f ; **FLOATING
C2578 VDPWR.n212 VGND 0.01074f ; **FLOATING
C2579 VDPWR.n213 VGND 0.00368f ; **FLOATING
C2580 VDPWR.n214 VGND 0.0048f ; **FLOATING
C2581 VDPWR.n215 VGND 0.01058f ; **FLOATING
C2582 VDPWR.n216 VGND 0.01058f ; **FLOATING
C2583 VDPWR.n217 VGND 0.01058f ; **FLOATING
C2584 VDPWR.n218 VGND 0.01074f ; **FLOATING
C2585 VDPWR.n219 VGND 0.01074f ; **FLOATING
C2586 VDPWR.n220 VGND 0.01058f ; **FLOATING
C2587 VDPWR.n221 VGND 0.00368f ; **FLOATING
C2588 VDPWR.n222 VGND 0.01058f ; **FLOATING
C2589 VDPWR.n223 VGND 0.00368f ; **FLOATING
C2590 VDPWR.n224 VGND 0.01058f ; **FLOATING
C2591 VDPWR.n225 VGND 0.00368f ; **FLOATING
C2592 VDPWR.n226 VGND 0.00502f ; **FLOATING
C2593 VDPWR.n227 VGND 0.01931f ; **FLOATING
C2594 VDPWR.n228 VGND 0.00502f ; **FLOATING
C2595 VDPWR.n229 VGND 0.01074f ; **FLOATING
C2596 VDPWR.n230 VGND 0.04413f ; **FLOATING
C2597 VDPWR.n231 VGND 0.00368f ; **FLOATING
C2598 VDPWR.n232 VGND 0.00368f ; **FLOATING
C2599 VDPWR.n233 VGND 0.00502f ; **FLOATING
C2600 VDPWR.n234 VGND 0.01074f ; **FLOATING
C2601 VDPWR.n235 VGND 0.00368f ; **FLOATING
C2602 VDPWR.n236 VGND 0.0048f ; **FLOATING
C2603 VDPWR.n237 VGND 0.01058f ; **FLOATING
C2604 VDPWR.n238 VGND 0.01058f ; **FLOATING
C2605 VDPWR.n239 VGND 0.01058f ; **FLOATING
C2606 VDPWR.n240 VGND 0.01074f ; **FLOATING
C2607 VDPWR.n241 VGND 0.01074f ; **FLOATING
C2608 VDPWR.n242 VGND 0.01058f ; **FLOATING
C2609 VDPWR.n243 VGND 0.00368f ; **FLOATING
C2610 VDPWR.n244 VGND 0.01058f ; **FLOATING
C2611 VDPWR.n245 VGND 0.00368f ; **FLOATING
C2612 VDPWR.n246 VGND 0.01058f ; **FLOATING
C2613 VDPWR.n247 VGND 0.00368f ; **FLOATING
C2614 VDPWR.n248 VGND 0.00502f ; **FLOATING
C2615 VDPWR.n249 VGND 0.01931f ; **FLOATING
C2616 VDPWR.n250 VGND 0.00502f ; **FLOATING
C2617 VDPWR.n251 VGND 0.01074f ; **FLOATING
C2618 VDPWR.n252 VGND 0.34467f ; **FLOATING
C2619 VDPWR.n253 VGND 0.63754f ; **FLOATING
C2620 VDPWR.n254 VGND 0.5887f ; **FLOATING
C2621 VDPWR.n255 VGND 0.22761f ; **FLOATING
C2622 VDPWR.n256 VGND 0.83557f ; **FLOATING
C2623 VDPWR.n257 VGND 3.58504f ; **FLOATING
C2624 VGND.n0 VGND 0.00948f ; **FLOATING
C2625 VGND.n1 VGND 0.00404f ; **FLOATING
C2626 VGND.n2 VGND 0.0257f ; **FLOATING
C2627 VGND.n3 VGND 0.00404f ; **FLOATING
C2628 VGND.n4 VGND 0.03304f ; **FLOATING
C2629 VGND.n5 VGND 0.00948f ; **FLOATING
C2630 VGND.n6 VGND 0.01376f ; **FLOATING
C2631 VGND.n7 VGND 0.01373f ; **FLOATING
C2632 VGND.n8 VGND 0.00777f ; **FLOATING
C2633 VGND.n9 VGND 0.00178f ; **FLOATING
C2634 VGND.n10 VGND 0 ; **FLOATING
C2635 VGND.n11 VGND 0 ; **FLOATING
C2636 VGND.n12 VGND 0 ; **FLOATING
C2637 VGND.n13 VGND 0.00116f ; **FLOATING
C2638 VGND.n14 VGND 0 ; **FLOATING
C2639 VGND.n15 VGND 0 ; **FLOATING
C2640 VGND.n16 VGND 0.00115f ; **FLOATING
C2641 VGND.n17 VGND 0.00115f ; **FLOATING
C2642 VGND.n18 VGND 0.00115f ; **FLOATING
C2643 VGND.n19 VGND 0.00116f ; **FLOATING
C2644 VGND.n20 VGND 0.00116f ; **FLOATING
C2645 VGND.n21 VGND 0.00115f ; **FLOATING
C2646 VGND.n22 VGND 0 ; **FLOATING
C2647 VGND.n23 VGND 0.00115f ; **FLOATING
C2648 VGND.n24 VGND 0 ; **FLOATING
C2649 VGND.n25 VGND 0.00115f ; **FLOATING
C2650 VGND.n26 VGND 0 ; **FLOATING
C2651 VGND.n27 VGND 0 ; **FLOATING
C2652 VGND.n28 VGND 0.00163f ; **FLOATING
C2653 VGND.n29 VGND 0 ; **FLOATING
C2654 VGND.n30 VGND 0.00116f ; **FLOATING
C2655 VGND.n31 VGND 0.04373f ; **FLOATING
C2656 VGND.n32 VGND 0.00482f ; **FLOATING
C2657 VGND.n33 VGND 0 ; **FLOATING
C2658 VGND.n34 VGND 0 ; **FLOATING
C2659 VGND.n35 VGND 0 ; **FLOATING
C2660 VGND.n36 VGND 0.00116f ; **FLOATING
C2661 VGND.n37 VGND 0 ; **FLOATING
C2662 VGND.n38 VGND 0 ; **FLOATING
C2663 VGND.n39 VGND 0.00115f ; **FLOATING
C2664 VGND.n40 VGND 0.00115f ; **FLOATING
C2665 VGND.n41 VGND 0.00115f ; **FLOATING
C2666 VGND.n42 VGND 0.00116f ; **FLOATING
C2667 VGND.n43 VGND 0.00116f ; **FLOATING
C2668 VGND.n44 VGND 0.00115f ; **FLOATING
C2669 VGND.n45 VGND 0 ; **FLOATING
C2670 VGND.n46 VGND 0.00115f ; **FLOATING
C2671 VGND.n47 VGND 0 ; **FLOATING
C2672 VGND.n48 VGND 0.00115f ; **FLOATING
C2673 VGND.n49 VGND 0 ; **FLOATING
C2674 VGND.n50 VGND 0 ; **FLOATING
C2675 VGND.n51 VGND 0.00163f ; **FLOATING
C2676 VGND.n52 VGND 0 ; **FLOATING
C2677 VGND.n53 VGND 0.00116f ; **FLOATING
C2678 VGND.n54 VGND 0.0181f ; **FLOATING
C2679 VGND.n55 VGND 0.00849f ; **FLOATING
C2680 VGND.n56 VGND 0.00181f ; **FLOATING
C2681 VGND.n57 VGND 0.00282f ; **FLOATING
C2682 VGND.n58 VGND 0.00282f ; **FLOATING
C2683 VGND.n59 VGND 0.03651f ; **FLOATING
C2684 VGND.n60 VGND 0.00259f ; **FLOATING
C2685 VGND.n61 VGND 0.02674f ; **FLOATING
C2686 VGND.n62 VGND 0.00407f ; **FLOATING
C2687 VGND.n63 VGND 0.0282f ; **FLOATING
C2688 VGND.n64 VGND 0.00181f ; **FLOATING
C2689 VGND.n65 VGND 0.00282f ; **FLOATING
C2690 VGND.n66 VGND 0.00282f ; **FLOATING
C2691 VGND.n67 VGND 0.02747f ; **FLOATING
C2692 VGND.n68 VGND 0.00259f ; **FLOATING
C2693 VGND.n69 VGND 0.01941f ; **FLOATING
C2694 VGND.n70 VGND 0.00947f ; **FLOATING
C2695 VGND.n71 VGND 0.0141f ; **FLOATING
C2696 VGND.n72 VGND 0.04704f ; **FLOATING
C2697 VGND.n73 VGND 0.04296f ; **FLOATING
C2698 VGND.n74 VGND 0.0687f ; **FLOATING
C2699 VGND.n75 VGND 0.01716f ; **FLOATING
C2700 VGND.n76 VGND 0.01261f ; **FLOATING
C2701 VGND.n77 VGND 0.07438f ; **FLOATING
C2702 VGND.n78 VGND 0.02058f ; **FLOATING
C2703 VGND.n79 VGND 0.00566f ; **FLOATING
C2704 VGND.n80 VGND 0.00385f ; **FLOATING
C2705 VGND.n81 VGND 0.00385f ; **FLOATING
C2706 VGND.n82 VGND 0.00328f ; **FLOATING
C2707 VGND.n83 VGND 0.00385f ; **FLOATING
C2708 VGND.n84 VGND 0.00385f ; **FLOATING
C2709 VGND.n85 VGND 0.02463f ; **FLOATING
C2710 VGND.n86 VGND 0.01679f ; **FLOATING
C2711 VGND.n87 VGND 0.02077f ; **FLOATING
C2712 VGND.n88 VGND 0.01373f ; **FLOATING
C2713 VGND.n89 VGND 0.00566f ; **FLOATING
C2714 VGND.n90 VGND 0.00385f ; **FLOATING
C2715 VGND.n91 VGND 0.00385f ; **FLOATING
C2716 VGND.n92 VGND 0.00328f ; **FLOATING
C2717 VGND.n93 VGND 0.00385f ; **FLOATING
C2718 VGND.n94 VGND 0.00385f ; **FLOATING
C2719 VGND.n95 VGND 0.02463f ; **FLOATING
C2720 VGND.n96 VGND 0.01373f ; **FLOATING
C2721 VGND.n97 VGND 0.02077f ; **FLOATING
C2722 VGND.n98 VGND 0.00927f ; **FLOATING
C2723 VGND.n99 VGND 0.05755f ; **FLOATING
C2724 VGND.n100 VGND 0.02492f ; **FLOATING
C2725 VGND.n101 VGND 0.01633f ; **FLOATING
C2726 VGND.n102 VGND 0.02562f ; **FLOATING
C2727 VGND.n103 VGND 0.0141f ; **FLOATING
C2728 VGND.n104 VGND 3.93807f ; **FLOATING
C2729 VGND.n105 VGND 0.02545f ; **FLOATING
C2730 VGND.n106 VGND 0.02535f ; **FLOATING
C2731 VGND.n107 VGND 0.02531f ; **FLOATING
C2732 VGND.n108 VGND 1.07994f ; **FLOATING
C2733 VGND.n109 VGND 0.02545f ; **FLOATING
C2734 VGND.n110 VGND 0.02545f ; **FLOATING
C2735 VGND.n111 VGND 4.53333f ; **FLOATING
C2736 VGND.n112 VGND 1.62521f ; **FLOATING
C2737 VGND.n113 VGND 0.00284f ; **FLOATING
C2738 VGND.n114 VGND 0.00284f ; **FLOATING
C2739 VGND.n115 VGND 0.35897f ; **FLOATING
C2740 VGND.n116 VGND 0.00287f ; **FLOATING
C2741 VGND.n117 VGND 0.00283f ; **FLOATING
C2742 VGND.n118 VGND 0.43925f ; **FLOATING
C2743 VGND.n119 VGND 0.00284f ; **FLOATING
C2744 VGND.n120 VGND 0.00287f ; **FLOATING
C2745 VGND.n121 VGND 0.00283f ; **FLOATING
C2746 VGND.n122 VGND 0.50741f ; **FLOATING
C2747 VGND.n123 VGND 0.0016f ; **FLOATING
C2748 VGND.n124 VGND 0.0016f ; **FLOATING
C2749 VGND.n125 VGND 0.50741f ; **FLOATING
C2750 VGND.n126 VGND 0.00161f ; **FLOATING
C2751 VGND.n127 VGND 0.00157f ; **FLOATING
C2752 VGND.n128 VGND 0.0016f ; **FLOATING
C2753 VGND.n129 VGND 0.00161f ; **FLOATING
C2754 VGND.n130 VGND 0.00157f ; **FLOATING
C2755 VGND.n131 VGND 0.00284f ; **FLOATING
C2756 VGND.n132 VGND 0.00284f ; **FLOATING
C2757 VGND.n133 VGND 0.00287f ; **FLOATING
C2758 VGND.n134 VGND 0.00283f ; **FLOATING
C2759 VGND.n135 VGND 0.00284f ; **FLOATING
C2760 VGND.n136 VGND 0.00287f ; **FLOATING
C2761 VGND.n137 VGND 0.00283f ; **FLOATING
C2762 VGND.n138 VGND 0.0016f ; **FLOATING
C2763 VGND.n139 VGND 0.0016f ; **FLOATING
C2764 VGND.n140 VGND 0.00161f ; **FLOATING
C2765 VGND.n141 VGND 0.00157f ; **FLOATING
C2766 VGND.n142 VGND 0.0016f ; **FLOATING
C2767 VGND.n143 VGND 0.00161f ; **FLOATING
C2768 VGND.n144 VGND 0.00157f ; **FLOATING
C2769 VGND.n145 VGND 0.0019f ; **FLOATING
C2770 VGND.n146 VGND 0.0019f ; **FLOATING
C2771 VGND.n147 VGND 0.00193f ; **FLOATING
C2772 VGND.n148 VGND 0.00189f ; **FLOATING
C2773 VGND.n149 VGND 0.0019f ; **FLOATING
C2774 VGND.n150 VGND 0.00193f ; **FLOATING
C2775 VGND.n151 VGND 0.00189f ; **FLOATING
C2776 VGND.n152 VGND 0.0016f ; **FLOATING
C2777 VGND.n153 VGND 0.0016f ; **FLOATING
C2778 VGND.n154 VGND 0.00161f ; **FLOATING
C2779 VGND.n155 VGND 0.00157f ; **FLOATING
C2780 VGND.n156 VGND 0.0016f ; **FLOATING
C2781 VGND.n157 VGND 0.00161f ; **FLOATING
C2782 VGND.n158 VGND 0.00157f ; **FLOATING
C2783 VGND.n159 VGND 0.0019f ; **FLOATING
C2784 VGND.n160 VGND 0.0019f ; **FLOATING
C2785 VGND.n161 VGND 0.00193f ; **FLOATING
C2786 VGND.n162 VGND 0.00189f ; **FLOATING
C2787 VGND.n163 VGND 0.0019f ; **FLOATING
C2788 VGND.n164 VGND 0.00193f ; **FLOATING
C2789 VGND.n165 VGND 0.00189f ; **FLOATING
C2790 VGND.n166 VGND 0.0019f ; **FLOATING
C2791 VGND.n167 VGND 0.0019f ; **FLOATING
C2792 VGND.n168 VGND 0.00193f ; **FLOATING
C2793 VGND.n169 VGND 0.00189f ; **FLOATING
C2794 VGND.n170 VGND 0.0019f ; **FLOATING
C2795 VGND.n171 VGND 0.0037f ; **FLOATING
C2796 VGND.n172 VGND 0.00193f ; **FLOATING
C2797 VGND.n173 VGND 0.00345f ; **FLOATING
C2798 VGND.n174 VGND 0.00216f ; **FLOATING
C2799 VGND.n175 VGND 0.04301f ; **FLOATING
C2800 VGND.n176 VGND 0.00154f ; **FLOATING
C2801 VGND.n177 VGND 0.02781f ; **FLOATING
C2802 VGND.n178 VGND 0.00169f ; **FLOATING
C2803 VGND.n179 VGND 0.02964f ; **FLOATING
C2804 VGND.n180 VGND 0.00216f ; **FLOATING
C2805 VGND.n181 VGND 0.02817f ; **FLOATING
C2806 VGND.n182 VGND 0.00154f ; **FLOATING
C2807 VGND.n183 VGND 0.01745f ; **FLOATING
C2808 VGND.n184 VGND 0.00169f ; **FLOATING
C2809 VGND.n185 VGND 0.04162f ; **FLOATING
C2810 VGND.n186 VGND 0.00189f ; **FLOATING
C2811 VGND.n187 VGND 25.2779f ; **FLOATING
C2812 VGND.n188 VGND 0.01718f ; **FLOATING
C2813 VGND.n189 VGND 0.01718f ; **FLOATING
C2814 VGND.n190 VGND 2.55975f ; **FLOATING
C2815 VGND.n191 VGND 0.01708f ; **FLOATING
C2816 VGND.n192 VGND 0.01703f ; **FLOATING
C2817 VGND.n193 VGND 3.63514f ; **FLOATING
C2818 VGND.n194 VGND 0.01718f ; **FLOATING
C2819 VGND.n195 VGND 0.02637f ; **FLOATING
C2820 VGND.n196 VGND 0.01708f ; **FLOATING
C2821 VGND.n197 VGND 0.01703f ; **FLOATING
C2822 VGND.n198 VGND 3.91384f ; **FLOATING
C2823 VGND.n199 VGND 0.03307f ; **FLOATING
C2824 VGND.n200 VGND 0.03307f ; **FLOATING
C2825 VGND.n201 VGND 4.36066f ; **FLOATING
C2826 VGND.n202 VGND 0.03297f ; **FLOATING
C2827 VGND.n203 VGND 0.03293f ; **FLOATING
C2828 VGND.n204 VGND 0.03307f ; **FLOATING
C2829 VGND.n205 VGND 0.01728f ; **FLOATING
C2830 VGND.n206 VGND 0.03297f ; **FLOATING
C2831 VGND.n207 VGND 0.03293f ; **FLOATING
C2832 VGND.n208 VGND 1.32986f ; **FLOATING
C2833 VGND.n209 VGND 0.00374f ; **FLOATING
C2834 VGND.n210 VGND 0.00374f ; **FLOATING
C2835 VGND.n211 VGND 0.57556f ; **FLOATING
C2836 VGND.n212 VGND 0.00379f ; **FLOATING
C2837 VGND.n213 VGND 0.00374f ; **FLOATING
C2838 VGND.n214 VGND 0.58768f ; **FLOATING
C2839 VGND.n215 VGND 0.00374f ; **FLOATING
C2840 VGND.n216 VGND 0.00379f ; **FLOATING
C2841 VGND.n217 VGND 0.00374f ; **FLOATING
C2842 VGND.n218 VGND 0.00374f ; **FLOATING
C2843 VGND.n219 VGND 0.00374f ; **FLOATING
C2844 VGND.n220 VGND 0.00379f ; **FLOATING
C2845 VGND.n221 VGND 0.00374f ; **FLOATING
C2846 VGND.n222 VGND 0.00374f ; **FLOATING
C2847 VGND.n223 VGND 0.00524f ; **FLOATING
C2848 VGND.n224 VGND 0.00379f ; **FLOATING
C2849 VGND.n225 VGND 0.03703f ; **FLOATING
C2850 VGND.n226 VGND 0.00562f ; **FLOATING
C2851 VGND.n227 VGND 0.02337f ; **FLOATING
C2852 VGND.n228 VGND 0.00619f ; **FLOATING
C2853 VGND.n229 VGND 0.00197f ; **FLOATING
C2854 VGND.n230 VGND 0 ; **FLOATING
C2855 VGND.n231 VGND 0.00117f ; **FLOATING
C2856 VGND.n232 VGND 0 ; **FLOATING
C2857 VGND.n233 VGND 0.00117f ; **FLOATING
C2858 VGND.n234 VGND 0.00197f ; **FLOATING
C2859 VGND.n235 VGND 0.00637f ; **FLOATING
C2860 VGND.n236 VGND 0.00197f ; **FLOATING
C2861 VGND.n237 VGND 0 ; **FLOATING
C2862 VGND.n238 VGND 0.00117f ; **FLOATING
C2863 VGND.n239 VGND 0 ; **FLOATING
C2864 VGND.n240 VGND 0.00117f ; **FLOATING
C2865 VGND.n241 VGND 0.00197f ; **FLOATING
C2866 VGND.n242 VGND 0.09899f ; **FLOATING
C2867 VGND.n243 VGND 0.00374f ; **FLOATING
C2868 VGND.n244 VGND 0.50741f ; **FLOATING
C2869 VGND.n245 VGND 0.00634f ; **FLOATING
C2870 VGND.n246 VGND 0.00634f ; **FLOATING
C2871 VGND.n247 VGND 1.47375f ; **FLOATING
C2872 VGND.n248 VGND 0.00626f ; **FLOATING
C2873 VGND.n249 VGND 0.00622f ; **FLOATING
C2874 VGND.n250 VGND 1.93874f ; **FLOATING
C2875 VGND.n251 VGND 0.00634f ; **FLOATING
C2876 VGND.n252 VGND 0.00626f ; **FLOATING
C2877 VGND.n253 VGND 0.00622f ; **FLOATING
C2878 VGND.n254 VGND 0.00634f ; **FLOATING
C2879 VGND.n255 VGND 0.00634f ; **FLOATING
C2880 VGND.n256 VGND 0.00626f ; **FLOATING
C2881 VGND.n257 VGND 0.00622f ; **FLOATING
C2882 VGND.n258 VGND 0.00634f ; **FLOATING
C2883 VGND.n259 VGND 0.00655f ; **FLOATING
C2884 VGND.n260 VGND 0.00626f ; **FLOATING
C2885 VGND.n261 VGND 0.05375f ; **FLOATING
C2886 VGND.n262 VGND 0.00655f ; **FLOATING
C2887 VGND.n263 VGND 0.00622f ; **FLOATING
C2888 VGND.n264 VGND 0.02545f ; **FLOATING
C2889 VGND.n265 VGND 0.02545f ; **FLOATING
C2890 VGND.n266 VGND 0.02535f ; **FLOATING
C2891 VGND.n267 VGND 0.02531f ; **FLOATING
C2892 VGND.n268 VGND 0.02545f ; **FLOATING
C2893 VGND.n269 VGND 0.01347f ; **FLOATING
C2894 VGND.n270 VGND 0.02535f ; **FLOATING
C2895 VGND.n271 VGND 0.02528f ; **FLOATING
C2896 VGND.n272 VGND 0.97089f ; **FLOATING
C2897 VGND.n273 VGND 0.00217f ; **FLOATING
C2898 VGND.n274 VGND 0.00217f ; **FLOATING
C2899 VGND.n275 VGND 0.96028f ; **FLOATING
C2900 VGND.n276 VGND 0.00218f ; **FLOATING
C2901 VGND.n277 VGND 0.00214f ; **FLOATING
C2902 VGND.n278 VGND 0.56042f ; **FLOATING
C2903 VGND.n279 VGND 0.00217f ; **FLOATING
C2904 VGND.n280 VGND 0.00218f ; **FLOATING
C2905 VGND.n281 VGND 0.00214f ; **FLOATING
C2906 VGND.n282 VGND 0.00217f ; **FLOATING
C2907 VGND.n283 VGND 0.00217f ; **FLOATING
C2908 VGND.n284 VGND 0.00218f ; **FLOATING
C2909 VGND.n285 VGND 0.00214f ; **FLOATING
C2910 VGND.n286 VGND 0.00217f ; **FLOATING
C2911 VGND.n287 VGND 0.00218f ; **FLOATING
C2912 VGND.n288 VGND 0.00214f ; **FLOATING
C2913 VGND.n289 VGND 0.00217f ; **FLOATING
C2914 VGND.n290 VGND 0.00217f ; **FLOATING
C2915 VGND.n291 VGND 0.00218f ; **FLOATING
C2916 VGND.n292 VGND 0.00214f ; **FLOATING
C2917 VGND.n293 VGND 0.00217f ; **FLOATING
C2918 VGND.n294 VGND 0.00218f ; **FLOATING
C2919 VGND.n295 VGND 0.00214f ; **FLOATING
C2920 VGND.n296 VGND 0.00217f ; **FLOATING
C2921 VGND.n297 VGND 0.00217f ; **FLOATING
C2922 VGND.n298 VGND 0.00218f ; **FLOATING
C2923 VGND.n299 VGND 0.00214f ; **FLOATING
C2924 VGND.n300 VGND 0.00217f ; **FLOATING
C2925 VGND.n301 VGND 0.00218f ; **FLOATING
C2926 VGND.n302 VGND 0.00214f ; **FLOATING
C2927 VGND.n303 VGND 0.00217f ; **FLOATING
C2928 VGND.n304 VGND 0.00217f ; **FLOATING
C2929 VGND.n305 VGND 0.00218f ; **FLOATING
C2930 VGND.n306 VGND 0.00214f ; **FLOATING
C2931 VGND.n307 VGND 0.00217f ; **FLOATING
C2932 VGND.n308 VGND 0.00218f ; **FLOATING
C2933 VGND.n309 VGND 0.00214f ; **FLOATING
C2934 VGND.n310 VGND 0.00217f ; **FLOATING
C2935 VGND.n311 VGND 0.00217f ; **FLOATING
C2936 VGND.n312 VGND 0.00218f ; **FLOATING
C2937 VGND.n313 VGND 0.00214f ; **FLOATING
C2938 VGND.n314 VGND 0.00217f ; **FLOATING
C2939 VGND.n315 VGND 0.00218f ; **FLOATING
C2940 VGND.n316 VGND 0.00214f ; **FLOATING
C2941 VGND.n317 VGND 0.00217f ; **FLOATING
C2942 VGND.n318 VGND 0.00217f ; **FLOATING
C2943 VGND.n319 VGND 0.00218f ; **FLOATING
C2944 VGND.n320 VGND 0.00214f ; **FLOATING
C2945 VGND.n321 VGND 0.00217f ; **FLOATING
C2946 VGND.n322 VGND 0.00218f ; **FLOATING
C2947 VGND.n323 VGND 0.00214f ; **FLOATING
C2948 VGND.n324 VGND 0.00217f ; **FLOATING
C2949 VGND.n325 VGND 0.00217f ; **FLOATING
C2950 VGND.n326 VGND 0.00218f ; **FLOATING
C2951 VGND.n327 VGND 0.00214f ; **FLOATING
C2952 VGND.n328 VGND 0.00217f ; **FLOATING
C2953 VGND.n329 VGND 0.00182f ; **FLOATING
C2954 VGND.n330 VGND 0.00218f ; **FLOATING
C2955 VGND.n331 VGND 0.00275f ; **FLOATING
C2956 VGND.n332 VGND 0.00182f ; **FLOATING
C2957 VGND.n333 VGND 0.03144f ; **FLOATING
C2958 VGND.n334 VGND 0.00182f ; **FLOATING
C2959 VGND.n335 VGND 0.02091f ; **FLOATING
C2960 VGND.n336 VGND 0.00182f ; **FLOATING
C2961 VGND.n337 VGND 0.02091f ; **FLOATING
C2962 VGND.n338 VGND 0.00182f ; **FLOATING
C2963 VGND.n339 VGND 0.02091f ; **FLOATING
C2964 VGND.n340 VGND 0.00182f ; **FLOATING
C2965 VGND.n341 VGND 0.02091f ; **FLOATING
C2966 VGND.n342 VGND 0.00182f ; **FLOATING
C2967 VGND.n343 VGND 0.02091f ; **FLOATING
C2968 VGND.n344 VGND 0.0203f ; **FLOATING
C2969 VGND.n345 VGND 0.00214f ; **FLOATING
C2970 VGND.n346 VGND 1.25715f ; **FLOATING
C2971 VGND.n347 VGND 0.00217f ; **FLOATING
C2972 VGND.n348 VGND 0.00217f ; **FLOATING
C2973 VGND.n349 VGND 0.96028f ; **FLOATING
C2974 VGND.n350 VGND 0.00218f ; **FLOATING
C2975 VGND.n351 VGND 0.00214f ; **FLOATING
C2976 VGND.n352 VGND 0.56042f ; **FLOATING
C2977 VGND.n353 VGND 0.00217f ; **FLOATING
C2978 VGND.n354 VGND 0.00218f ; **FLOATING
C2979 VGND.n355 VGND 0.00214f ; **FLOATING
C2980 VGND.n356 VGND 0.00217f ; **FLOATING
C2981 VGND.n357 VGND 0.00217f ; **FLOATING
C2982 VGND.n358 VGND 0.00218f ; **FLOATING
C2983 VGND.n359 VGND 0.00214f ; **FLOATING
C2984 VGND.n360 VGND 0.00217f ; **FLOATING
C2985 VGND.n361 VGND 0.00218f ; **FLOATING
C2986 VGND.n362 VGND 0.00214f ; **FLOATING
C2987 VGND.n363 VGND 0.00217f ; **FLOATING
C2988 VGND.n364 VGND 0.00217f ; **FLOATING
C2989 VGND.n365 VGND 0.00218f ; **FLOATING
C2990 VGND.n366 VGND 0.00214f ; **FLOATING
C2991 VGND.n367 VGND 0.00217f ; **FLOATING
C2992 VGND.n368 VGND 0.00218f ; **FLOATING
C2993 VGND.n369 VGND 0.00214f ; **FLOATING
C2994 VGND.n370 VGND 0.00217f ; **FLOATING
C2995 VGND.n371 VGND 0.00217f ; **FLOATING
C2996 VGND.n372 VGND 0.00218f ; **FLOATING
C2997 VGND.n373 VGND 0.00214f ; **FLOATING
C2998 VGND.n374 VGND 0.00217f ; **FLOATING
C2999 VGND.n375 VGND 0.00218f ; **FLOATING
C3000 VGND.n376 VGND 0.00214f ; **FLOATING
C3001 VGND.n377 VGND 0.00217f ; **FLOATING
C3002 VGND.n378 VGND 0.00217f ; **FLOATING
C3003 VGND.n379 VGND 0.00218f ; **FLOATING
C3004 VGND.n380 VGND 0.00214f ; **FLOATING
C3005 VGND.n381 VGND 0.00217f ; **FLOATING
C3006 VGND.n382 VGND 0.00218f ; **FLOATING
C3007 VGND.n383 VGND 0.00214f ; **FLOATING
C3008 VGND.n384 VGND 0.00217f ; **FLOATING
C3009 VGND.n385 VGND 0.00217f ; **FLOATING
C3010 VGND.n386 VGND 0.00218f ; **FLOATING
C3011 VGND.n387 VGND 0.00214f ; **FLOATING
C3012 VGND.n388 VGND 0.00217f ; **FLOATING
C3013 VGND.n389 VGND 0.00218f ; **FLOATING
C3014 VGND.n390 VGND 0.00214f ; **FLOATING
C3015 VGND.n391 VGND 0.00217f ; **FLOATING
C3016 VGND.n392 VGND 0.00217f ; **FLOATING
C3017 VGND.n393 VGND 0.00218f ; **FLOATING
C3018 VGND.n394 VGND 0.00214f ; **FLOATING
C3019 VGND.n395 VGND 0.00217f ; **FLOATING
C3020 VGND.n396 VGND 0.00218f ; **FLOATING
C3021 VGND.n397 VGND 0.00214f ; **FLOATING
C3022 VGND.n398 VGND 0.00217f ; **FLOATING
C3023 VGND.n399 VGND 0.00217f ; **FLOATING
C3024 VGND.n400 VGND 0.00218f ; **FLOATING
C3025 VGND.n401 VGND 0.00214f ; **FLOATING
C3026 VGND.n402 VGND 0.00217f ; **FLOATING
C3027 VGND.n403 VGND 0.00182f ; **FLOATING
C3028 VGND.n404 VGND 0.00218f ; **FLOATING
C3029 VGND.n405 VGND 0.00275f ; **FLOATING
C3030 VGND.n406 VGND 0.00182f ; **FLOATING
C3031 VGND.n407 VGND 0.03144f ; **FLOATING
C3032 VGND.n408 VGND 0.00182f ; **FLOATING
C3033 VGND.n409 VGND 0.02091f ; **FLOATING
C3034 VGND.n410 VGND 0.00182f ; **FLOATING
C3035 VGND.n411 VGND 0.02091f ; **FLOATING
C3036 VGND.n412 VGND 0.00182f ; **FLOATING
C3037 VGND.n413 VGND 0.02091f ; **FLOATING
C3038 VGND.n414 VGND 0.00182f ; **FLOATING
C3039 VGND.n415 VGND 0.02091f ; **FLOATING
C3040 VGND.n416 VGND 0.00182f ; **FLOATING
C3041 VGND.n417 VGND 0.02091f ; **FLOATING
C3042 VGND.n418 VGND 0.0203f ; **FLOATING
C3043 VGND.n419 VGND 0.00214f ; **FLOATING
C3044 VGND.n420 VGND 1.12841f ; **FLOATING
C3045 VGND.n421 VGND 0.00385f ; **FLOATING
C3046 VGND.n422 VGND 0.00385f ; **FLOATING
C3047 VGND.n423 VGND 0.48014f ; **FLOATING
C3048 VGND.n424 VGND 0.00389f ; **FLOATING
C3049 VGND.n425 VGND 0.00385f ; **FLOATING
C3050 VGND.n426 VGND 0.56042f ; **FLOATING
C3051 VGND.n427 VGND 0.00385f ; **FLOATING
C3052 VGND.n428 VGND 0.00389f ; **FLOATING
C3053 VGND.n429 VGND 0.00385f ; **FLOATING
C3054 VGND.n430 VGND 0.55739f ; **FLOATING
C3055 VGND.n431 VGND 0.00235f ; **FLOATING
C3056 VGND.n432 VGND 0.00235f ; **FLOATING
C3057 VGND.n433 VGND 0.55739f ; **FLOATING
C3058 VGND.n434 VGND 0.00236f ; **FLOATING
C3059 VGND.n435 VGND 0.00232f ; **FLOATING
C3060 VGND.n436 VGND 0.00235f ; **FLOATING
C3061 VGND.n437 VGND 0.00236f ; **FLOATING
C3062 VGND.n438 VGND 0.00232f ; **FLOATING
C3063 VGND.n439 VGND 0.00235f ; **FLOATING
C3064 VGND.n440 VGND 0.00235f ; **FLOATING
C3065 VGND.n441 VGND 0.00236f ; **FLOATING
C3066 VGND.n442 VGND 0.00232f ; **FLOATING
C3067 VGND.n443 VGND 0.00235f ; **FLOATING
C3068 VGND.n444 VGND 0.00236f ; **FLOATING
C3069 VGND.n445 VGND 0.00232f ; **FLOATING
C3070 VGND.n446 VGND 0.00235f ; **FLOATING
C3071 VGND.n447 VGND 0.00235f ; **FLOATING
C3072 VGND.n448 VGND 0.00236f ; **FLOATING
C3073 VGND.n449 VGND 0.00232f ; **FLOATING
C3074 VGND.n450 VGND 0.00235f ; **FLOATING
C3075 VGND.n451 VGND 0.00236f ; **FLOATING
C3076 VGND.n452 VGND 0.00232f ; **FLOATING
C3077 VGND.n453 VGND 0.00235f ; **FLOATING
C3078 VGND.n454 VGND 0.00235f ; **FLOATING
C3079 VGND.n455 VGND 0.00236f ; **FLOATING
C3080 VGND.n456 VGND 0.00232f ; **FLOATING
C3081 VGND.n457 VGND 0.00235f ; **FLOATING
C3082 VGND.n458 VGND 0.00236f ; **FLOATING
C3083 VGND.n459 VGND 0.00232f ; **FLOATING
C3084 VGND.n460 VGND 0.00385f ; **FLOATING
C3085 VGND.n461 VGND 0.00385f ; **FLOATING
C3086 VGND.n462 VGND 0.00389f ; **FLOATING
C3087 VGND.n463 VGND 0.00385f ; **FLOATING
C3088 VGND.n464 VGND 0.00385f ; **FLOATING
C3089 VGND.n465 VGND 0.0029f ; **FLOATING
C3090 VGND.n466 VGND 0.00389f ; **FLOATING
C3091 VGND.n467 VGND 0.00392f ; **FLOATING
C3092 VGND.n468 VGND 0.00191f ; **FLOATING
C3093 VGND.n469 VGND 0.04639f ; **FLOATING
C3094 VGND.n470 VGND 0.00191f ; **FLOATING
C3095 VGND.n471 VGND 0.03159f ; **FLOATING
C3096 VGND.n472 VGND 0.00191f ; **FLOATING
C3097 VGND.n473 VGND 0.03318f ; **FLOATING
C3098 VGND.n474 VGND 0.00266f ; **FLOATING
C3099 VGND.n475 VGND 0.02789f ; **FLOATING
C3100 VGND.n476 VGND 0.00385f ; **FLOATING
C3101 VGND.n477 VGND 3.02171f ; **FLOATING
C3102 VGND.n478 VGND 0.00385f ; **FLOATING
C3103 VGND.n479 VGND 0.00385f ; **FLOATING
C3104 VGND.n480 VGND 0.48014f ; **FLOATING
C3105 VGND.n481 VGND 0.00389f ; **FLOATING
C3106 VGND.n482 VGND 0.00385f ; **FLOATING
C3107 VGND.n483 VGND 0.56042f ; **FLOATING
C3108 VGND.n484 VGND 0.00385f ; **FLOATING
C3109 VGND.n485 VGND 0.00389f ; **FLOATING
C3110 VGND.n486 VGND 0.00385f ; **FLOATING
C3111 VGND.n487 VGND 0.55739f ; **FLOATING
C3112 VGND.n488 VGND 0.00235f ; **FLOATING
C3113 VGND.n489 VGND 0.00235f ; **FLOATING
C3114 VGND.n490 VGND 0.55739f ; **FLOATING
C3115 VGND.n491 VGND 0.00236f ; **FLOATING
C3116 VGND.n492 VGND 0.00232f ; **FLOATING
C3117 VGND.n493 VGND 0.00235f ; **FLOATING
C3118 VGND.n494 VGND 0.00236f ; **FLOATING
C3119 VGND.n495 VGND 0.00232f ; **FLOATING
C3120 VGND.n496 VGND 0.00235f ; **FLOATING
C3121 VGND.n497 VGND 0.00235f ; **FLOATING
C3122 VGND.n498 VGND 0.00236f ; **FLOATING
C3123 VGND.n499 VGND 0.00232f ; **FLOATING
C3124 VGND.n500 VGND 0.00235f ; **FLOATING
C3125 VGND.n501 VGND 0.00236f ; **FLOATING
C3126 VGND.n502 VGND 0.00232f ; **FLOATING
C3127 VGND.n503 VGND 0.00235f ; **FLOATING
C3128 VGND.n504 VGND 0.00235f ; **FLOATING
C3129 VGND.n505 VGND 0.00236f ; **FLOATING
C3130 VGND.n506 VGND 0.00232f ; **FLOATING
C3131 VGND.n507 VGND 0.00235f ; **FLOATING
C3132 VGND.n508 VGND 0.00236f ; **FLOATING
C3133 VGND.n509 VGND 0.00232f ; **FLOATING
C3134 VGND.n510 VGND 0.00235f ; **FLOATING
C3135 VGND.n511 VGND 0.00235f ; **FLOATING
C3136 VGND.n512 VGND 0.00236f ; **FLOATING
C3137 VGND.n513 VGND 0.00232f ; **FLOATING
C3138 VGND.n514 VGND 0.00235f ; **FLOATING
C3139 VGND.n515 VGND 0.00236f ; **FLOATING
C3140 VGND.n516 VGND 0.00232f ; **FLOATING
C3141 VGND.n517 VGND 0.00385f ; **FLOATING
C3142 VGND.n518 VGND 0.00385f ; **FLOATING
C3143 VGND.n519 VGND 0.00389f ; **FLOATING
C3144 VGND.n520 VGND 0.00385f ; **FLOATING
C3145 VGND.n521 VGND 0.00385f ; **FLOATING
C3146 VGND.n522 VGND 0.0029f ; **FLOATING
C3147 VGND.n523 VGND 0.00389f ; **FLOATING
C3148 VGND.n524 VGND 0.00392f ; **FLOATING
C3149 VGND.n525 VGND 0.00191f ; **FLOATING
C3150 VGND.n526 VGND 0.04639f ; **FLOATING
C3151 VGND.n527 VGND 0.00191f ; **FLOATING
C3152 VGND.n528 VGND 0.03159f ; **FLOATING
C3153 VGND.n529 VGND 0.00191f ; **FLOATING
C3154 VGND.n530 VGND 0.03318f ; **FLOATING
C3155 VGND.n531 VGND 0.00266f ; **FLOATING
C3156 VGND.n532 VGND 0.02789f ; **FLOATING
C3157 VGND.n533 VGND 0.00385f ; **FLOATING
C3158 VGND.n534 VGND 0.93605f ; **FLOATING
C3159 VGND.n535 VGND 0.01783f ; **FLOATING
C3160 VGND.n536 VGND 0.01783f ; **FLOATING
C3161 VGND.n537 VGND 4.25766f ; **FLOATING
C3162 VGND.n538 VGND 0.01773f ; **FLOATING
C3163 VGND.n539 VGND 0.01769f ; **FLOATING
C3164 VGND.n540 VGND 0.01783f ; **FLOATING
C3165 VGND.n541 VGND 0.00966f ; **FLOATING
C3166 VGND.n542 VGND 0.01773f ; **FLOATING
C3167 VGND.n543 VGND 0.01769f ; **FLOATING
C3168 VGND.n544 VGND 1.18387f ; **FLOATING
C3169 VGND.n545 VGND 0.85121f ; **FLOATING
C3170 VGND.n546 VGND 0.31952f ; **FLOATING
C3171 VGND.n547 VGND 0.32727f ; **FLOATING
C3172 VGND.n548 VGND 1.275f ; **FLOATING
C3173 VGND.n549 VGND 0.86569f ; **FLOATING
C3174 VGND.n550 VGND 1.14695f ; **FLOATING
C3175 VGND.n551 VGND 0.32727f ; **FLOATING
C3176 VGND.n552 VGND 0.97263f ; **FLOATING
C3177 VGND.n553 VGND 0.10946f ; **FLOATING
C3178 VGND.n554 VGND 0.00217f ; **FLOATING
C3179 VGND.n555 VGND 0.00217f ; **FLOATING
C3180 VGND.n556 VGND 0.27829f ; **FLOATING
C3181 VGND.n557 VGND 0.00218f ; **FLOATING
C3182 VGND.n558 VGND 0.00214f ; **FLOATING
C3183 VGND.n559 VGND 0.00217f ; **FLOATING
C3184 VGND.n560 VGND 0.06293f ; **FLOATING
C3185 VGND.n561 VGND 0.00218f ; **FLOATING
C3186 VGND.n562 VGND 0.00214f ; **FLOATING
C3187 VGND.n563 VGND 0.10946f ; **FLOATING
C3188 VGND.n564 VGND 0.00217f ; **FLOATING
C3189 VGND.n565 VGND 0.00217f ; **FLOATING
C3190 VGND.n566 VGND 0.70477f ; **FLOATING
C3191 VGND.n567 VGND 0.00218f ; **FLOATING
C3192 VGND.n568 VGND 0.00214f ; **FLOATING
C3193 VGND.n569 VGND 0.00217f ; **FLOATING
C3194 VGND.n570 VGND 0.06293f ; **FLOATING
C3195 VGND.n571 VGND 0.00218f ; **FLOATING
C3196 VGND.n572 VGND 0.00214f ; **FLOATING
C3197 VGND.n573 VGND 0.11129f ; **FLOATING
C3198 VGND.n574 VGND 0.00217f ; **FLOATING
C3199 VGND.n575 VGND 0.00217f ; **FLOATING
C3200 VGND.n576 VGND 0.26784f ; **FLOATING
C3201 VGND.n577 VGND 0.00218f ; **FLOATING
C3202 VGND.n578 VGND 0.00214f ; **FLOATING
C3203 VGND.n579 VGND 0.00217f ; **FLOATING
C3204 VGND.n580 VGND 0.06397f ; **FLOATING
C3205 VGND.n581 VGND 0.00218f ; **FLOATING
C3206 VGND.n582 VGND 0.00214f ; **FLOATING
C3207 VGND.n583 VGND 0.42225f ; **FLOATING
C3208 VGND.n584 VGND 0.12484f ; **FLOATING
C3209 VGND.n585 VGND 0.00217f ; **FLOATING
C3210 VGND.n586 VGND 0.00217f ; **FLOATING
C3211 VGND.n587 VGND 0.02925f ; **FLOATING
C3212 VGND.n588 VGND 0.00218f ; **FLOATING
C3213 VGND.n589 VGND 0.00214f ; **FLOATING
C3214 VGND.n590 VGND 0.01f ; **FLOATING
C3215 VGND.n591 VGND 0.00217f ; **FLOATING
C3216 VGND.n592 VGND 0.00317f ; **FLOATING
C3217 VGND.n593 VGND 0.00218f ; **FLOATING
C3218 VGND.n594 VGND 0.04215f ; **FLOATING
C3219 VGND.n595 VGND 0.02854f ; **FLOATING
C3220 VGND.n596 VGND 0.0029f ; **FLOATING
C3221 VGND.n597 VGND 0.10946f ; **FLOATING
C3222 VGND.n598 VGND 0.0019f ; **FLOATING
C3223 VGND.n599 VGND 0.27829f ; **FLOATING
C3224 VGND.n600 VGND 0.00193f ; **FLOATING
C3225 VGND.n601 VGND 0.00189f ; **FLOATING
C3226 VGND.n602 VGND 0.0019f ; **FLOATING
C3227 VGND.n603 VGND 0.0019f ; **FLOATING
C3228 VGND.n604 VGND 0.11486f ; **FLOATING
C3229 VGND.n605 VGND 0.0019f ; **FLOATING
C3230 VGND.n606 VGND 0.0019f ; **FLOATING
C3231 VGND.n607 VGND 0.27645f ; **FLOATING
C3232 VGND.n608 VGND 0.00193f ; **FLOATING
C3233 VGND.n609 VGND 0.00189f ; **FLOATING
C3234 VGND.n610 VGND 0.0019f ; **FLOATING
C3235 VGND.n611 VGND 0.0029f ; **FLOATING
C3236 VGND.n612 VGND 0.06603f ; **FLOATING
C3237 VGND.n613 VGND 0.00193f ; **FLOATING
C3238 VGND.n614 VGND 0.00189f ; **FLOATING
C3239 VGND.n615 VGND 0.42734f ; **FLOATING
C3240 VGND.n616 VGND 0.11129f ; **FLOATING
C3241 VGND.n617 VGND 0.0019f ; **FLOATING
C3242 VGND.n618 VGND 0.0019f ; **FLOATING
C3243 VGND.n619 VGND 0.26784f ; **FLOATING
C3244 VGND.n620 VGND 0.00193f ; **FLOATING
C3245 VGND.n621 VGND 0.00189f ; **FLOATING
C3246 VGND.n622 VGND 0.0019f ; **FLOATING
C3247 VGND.n623 VGND 0.00457f ; **FLOATING
C3248 VGND.n624 VGND 0.06397f ; **FLOATING
C3249 VGND.n625 VGND 0.00193f ; **FLOATING
C3250 VGND.n626 VGND 0.00189f ; **FLOATING
C3251 VGND.n627 VGND 0.88119f ; **FLOATING
C3252 VGND.n628 VGND 0.13414f ; **FLOATING
C3253 VGND.n629 VGND 0.0019f ; **FLOATING
C3254 VGND.n630 VGND 0.0019f ; **FLOATING
C3255 VGND.n631 VGND 0.02011f ; **FLOATING
C3256 VGND.n632 VGND 0.00193f ; **FLOATING
C3257 VGND.n633 VGND 0.00189f ; **FLOATING
C3258 VGND.n634 VGND 0.01f ; **FLOATING
C3259 VGND.n635 VGND 0.0019f ; **FLOATING
C3260 VGND.n636 VGND 0.0029f ; **FLOATING
C3261 VGND.n637 VGND 0.00193f ; **FLOATING
C3262 VGND.n638 VGND 0.00189f ; **FLOATING
C3263 VGND.n639 VGND 0.25966f ; **FLOATING
C3264 VGND.n640 VGND 0.85657f ; **FLOATING
C3265 VGND.n641 VGND 0.06293f ; **FLOATING
C3266 VGND.n642 VGND 0.00193f ; **FLOATING
C3267 VGND.n643 VGND 0.00189f ; **FLOATING
C3268 VGND.n644 VGND 0.02854f ; **FLOATING
C3269 VGND.n645 VGND 0.00317f ; **FLOATING
C3270 VGND.n646 VGND 0.01819f ; **FLOATING
C3271 VGND.n647 VGND 0.00317f ; **FLOATING
C3272 VGND.n648 VGND 0.04162f ; **FLOATING
C3273 VGND.n649 VGND 0.00518f ; **FLOATING
C3274 VGND.n650 VGND 0.02854f ; **FLOATING
C3275 VGND.n651 VGND 0.00214f ; **FLOATING
C3276 VGND.n652 VGND 0.23169f ; **FLOATING
C3277 VGND.n653 VGND 0.82626f ; **FLOATING
C3278 VGND.n654 VGND 2.16446f ; **FLOATING
C3279 VGND.n655 VGND 0.02535f ; **FLOATING
C3280 VGND.n656 VGND 0.02531f ; **FLOATING
C3281 VGND.n657 VGND 0.30775f ; **FLOATING
C3282 ui_in[0].n0 VGND 0.32493f ; **FLOATING
C3283 ui_in[0].n1 VGND 0.01693f ; **FLOATING
C3284 ui_in[0].n2 VGND 0.01693f ; **FLOATING
C3285 ui_in[0].n3 VGND 0.02313f ; **FLOATING
C3286 ui_in[0].n4 VGND 0.06328f ; **FLOATING
C3287 ui_in[0].n5 VGND 0.02208f ; **FLOATING
C3288 ui_in[0].n6 VGND 0.01693f ; **FLOATING
C3289 ui_in[0].n7 VGND 0.06258f ; **FLOATING
C3290 ui_in[0].n8 VGND 0.06258f ; **FLOATING
C3291 ui_in[0].n9 VGND 0.06258f ; **FLOATING
C3292 ui_in[0].n10 VGND 0.06328f ; **FLOATING
C3293 ui_in[0].n11 VGND 0.06258f ; **FLOATING
C3294 ui_in[0].n12 VGND 0.01693f ; **FLOATING
C3295 ui_in[0].n13 VGND 0.06258f ; **FLOATING
C3296 ui_in[0].n14 VGND 0.01693f ; **FLOATING
C3297 ui_in[0].n15 VGND 0.06258f ; **FLOATING
C3298 ui_in[0].n16 VGND 0.01693f ; **FLOATING
C3299 ui_in[0].n17 VGND 0.06328f ; **FLOATING
C3300 ui_in[0].n18 VGND 0.02313f ; **FLOATING
C3301 ui_in[0].n19 VGND 0.0889f ; **FLOATING
C3302 ui_in[0].n20 VGND 0.02313f ; **FLOATING
C3303 ui_in[0].n21 VGND 0.06328f ; **FLOATING
C3304 ui_in[0].n22 VGND 0.09698f ; **FLOATING
C3305 ui_in[0].n23 VGND 0.01693f ; **FLOATING
C3306 ui_in[0].n24 VGND 0.01693f ; **FLOATING
C3307 ui_in[0].n25 VGND 0.02313f ; **FLOATING
C3308 ui_in[0].n26 VGND 0.06328f ; **FLOATING
C3309 ui_in[0].n27 VGND 0.01693f ; **FLOATING
C3310 ui_in[0].n28 VGND 0.02208f ; **FLOATING
C3311 ui_in[0].n29 VGND 0.06258f ; **FLOATING
C3312 ui_in[0].n30 VGND 0.06258f ; **FLOATING
C3313 ui_in[0].n31 VGND 0.06258f ; **FLOATING
C3314 ui_in[0].n32 VGND 0.06328f ; **FLOATING
C3315 ui_in[0].n33 VGND 0.06328f ; **FLOATING
C3316 ui_in[0].n34 VGND 0.06258f ; **FLOATING
C3317 ui_in[0].n35 VGND 0.01693f ; **FLOATING
C3318 ui_in[0].n36 VGND 0.06258f ; **FLOATING
C3319 ui_in[0].n37 VGND 0.01693f ; **FLOATING
C3320 ui_in[0].n38 VGND 0.06258f ; **FLOATING
C3321 ui_in[0].n39 VGND 0.01693f ; **FLOATING
C3322 ui_in[0].n40 VGND 0.02313f ; **FLOATING
C3323 ui_in[0].n41 VGND 0.0889f ; **FLOATING
C3324 ui_in[0].n42 VGND 0.02313f ; **FLOATING
C3325 ui_in[0].n43 VGND 0.06328f ; **FLOATING
C3326 ui_in[0].n44 VGND 2.50236f ; **FLOATING
C3327 ui_in[0].n45 VGND 4.45339f ; **FLOATING
C3328 ui_in[0].n46 VGND 0.82437f ; **FLOATING
C3329 ui_in[0].n47 VGND 0.01693f ; **FLOATING
C3330 ui_in[0].n48 VGND 0.01693f ; **FLOATING
C3331 ui_in[0].n49 VGND 0.02313f ; **FLOATING
C3332 ui_in[0].n50 VGND 0.04943f ; **FLOATING
C3333 ui_in[0].n51 VGND 0.01693f ; **FLOATING
C3334 ui_in[0].n52 VGND 0.02208f ; **FLOATING
C3335 ui_in[0].n53 VGND 0.04873f ; **FLOATING
C3336 ui_in[0].n54 VGND 0.04873f ; **FLOATING
C3337 ui_in[0].n55 VGND 0.04873f ; **FLOATING
C3338 ui_in[0].n56 VGND 0.04943f ; **FLOATING
C3339 ui_in[0].n57 VGND 0.04943f ; **FLOATING
C3340 ui_in[0].n58 VGND 0.04873f ; **FLOATING
C3341 ui_in[0].n59 VGND 0.01693f ; **FLOATING
C3342 ui_in[0].n60 VGND 0.04873f ; **FLOATING
C3343 ui_in[0].n61 VGND 0.01693f ; **FLOATING
C3344 ui_in[0].n62 VGND 0.04873f ; **FLOATING
C3345 ui_in[0].n63 VGND 0.01693f ; **FLOATING
C3346 ui_in[0].n64 VGND 0.02313f ; **FLOATING
C3347 ui_in[0].n65 VGND 0.0889f ; **FLOATING
C3348 ui_in[0].n66 VGND 0.02313f ; **FLOATING
C3349 ui_in[0].n67 VGND 0.04943f ; **FLOATING
C3350 ui_in[0].n68 VGND 2.14908f ; **FLOATING
C3351 ui_in[0].n69 VGND 0.42108f ; **FLOATING
C3352 ui_in[0].n70 VGND 0.01693f ; **FLOATING
C3353 ui_in[0].n71 VGND 0.01693f ; **FLOATING
C3354 ui_in[0].n72 VGND 0.02313f ; **FLOATING
C3355 ui_in[0].n73 VGND 0.04943f ; **FLOATING
C3356 ui_in[0].n74 VGND 0.01693f ; **FLOATING
C3357 ui_in[0].n75 VGND 0.02208f ; **FLOATING
C3358 ui_in[0].n76 VGND 0.04873f ; **FLOATING
C3359 ui_in[0].n77 VGND 0.04873f ; **FLOATING
C3360 ui_in[0].n78 VGND 0.04873f ; **FLOATING
C3361 ui_in[0].n79 VGND 0.04943f ; **FLOATING
C3362 ui_in[0].n80 VGND 0.04943f ; **FLOATING
C3363 ui_in[0].n81 VGND 0.04873f ; **FLOATING
C3364 ui_in[0].n82 VGND 0.01693f ; **FLOATING
C3365 ui_in[0].n83 VGND 0.04873f ; **FLOATING
C3366 ui_in[0].n84 VGND 0.01693f ; **FLOATING
C3367 ui_in[0].n85 VGND 0.04873f ; **FLOATING
C3368 ui_in[0].n86 VGND 0.01693f ; **FLOATING
C3369 ui_in[0].n87 VGND 0.02313f ; **FLOATING
C3370 ui_in[0].n88 VGND 0.0889f ; **FLOATING
C3371 ui_in[0].n89 VGND 0.02313f ; **FLOATING
C3372 ui_in[0].n90 VGND 0.04943f ; **FLOATING
C3373 ui_in[0].n91 VGND 4.3828f ; **FLOATING
C3374 ui_in[0].n92 VGND 8.25891f ; **FLOATING
C3375 clk.n0 VGND 6.04793f ; **FLOATING
C3376 clk.n1 VGND 0.54769f ; **FLOATING
C3377 clk.n2 VGND 2.37138f ; **FLOATING
C3378 ua[3].n0 VGND 0.16043f ; **FLOATING
C3379 ua[3].n1 VGND 0.52682f ; **FLOATING
C3380 ua[3].n2 VGND 2.84219f ; **FLOATING
C3381 ua[3].n3 VGND 0.34149f ; **FLOATING
C3382 ua[3].n4 VGND 2.84153f ; **FLOATING
C3383 ua[3].n5 VGND 0.34149f ; **FLOATING
C3384 ua[3].n6 VGND 0.95162f ; **FLOATING
C3385 ua[3].n7 VGND 0.1664f ; **FLOATING
C3386 ua[3].n8 VGND 0.42628f ; **FLOATING
C3387 ua[3].n9 VGND 0.70276f ; **FLOATING
C3388 ua[3].n10 VGND 0.12826f ; **FLOATING
C3389 ua[3].n11 VGND 0.51106f ; **FLOATING
C3390 ua[3].n12 VGND 2.84219f ; **FLOATING
C3391 ua[3].n13 VGND 0.29271f ; **FLOATING
C3392 ua[3].n14 VGND 2.84153f ; **FLOATING
C3393 ua[3].n15 VGND 0.29271f ; **FLOATING
C3394 ua[3].n16 VGND 1.43295f ; **FLOATING
C3395 ua[3].n17 VGND 0.13415f ; **FLOATING
C3396 ua[3].n18 VGND 0.41873f ; **FLOATING
C3397 ua[3].n19 VGND 4.45106f ; **FLOATING
C3398 ua[2].n0 VGND 3.01483f ; **FLOATING
C3399 ua[2].n1 VGND 0.48838f ; **FLOATING
C3400 ua[2].n2 VGND 3.76638f ; **FLOATING
C3401 ua[2].n3 VGND 0.48838f ; **FLOATING
C3402 ua[2].n4 VGND 0.93014f ; **FLOATING
C3403 ua[2].n5 VGND 4.3242f ; **FLOATING
C3404 ua[2].n6 VGND 3.47658f ; **FLOATING
C3405 ua[2].n7 VGND 0.21996f ; **FLOATING
C3406 ua[2].n8 VGND 0.54665f ; **FLOATING
C3407 ua[2].n9 VGND 0.92913f ; **FLOATING
C3408 ua[2].n10 VGND 0.86565f ; **FLOATING
C3409 ua[2].n11 VGND 3.76638f ; **FLOATING
C3410 ua[2].n12 VGND 0.42389f ; **FLOATING
C3411 ua[2].n13 VGND 3.78126f ; **FLOATING
C3412 ua[2].n14 VGND 0.42389f ; **FLOATING
C3413 ua[2].n15 VGND 1.9146f ; **FLOATING
C3414 ua[2].n16 VGND 0.17735f ; **FLOATING
C3415 ua[2].n17 VGND 0.54279f ; **FLOATING
C3416 ua[1].n0 VGND 0.16237f ; **FLOATING
C3417 ua[1].n1 VGND 0.08644f ; **FLOATING
C3418 ua[1].n2 VGND 0.08644f ; **FLOATING
C3419 ua[1].n3 VGND 0.09596f ; **FLOATING
C3420 ua[1].n4 VGND 0.09487f ; **FLOATING
C3421 ua[1].n5 VGND 0.08644f ; **FLOATING
C3422 ua[1].n6 VGND 0.09596f ; **FLOATING
C3423 ua[1].n7 VGND 0.08644f ; **FLOATING
C3424 ua[1].n8 VGND 0.08644f ; **FLOATING
C3425 ua[1].n9 VGND 0.08644f ; **FLOATING
C3426 ua[1].n10 VGND 0.08644f ; **FLOATING
C3427 ua[1].n11 VGND 0.09596f ; **FLOATING
C3428 ua[1].n12 VGND 8.62004f ; **FLOATING
C3429 ua[1].n13 VGND 0.64322f ; **FLOATING
C3430 ua[1].n14 VGND 0.08644f ; **FLOATING
C3431 ua[1].n15 VGND 0.08644f ; **FLOATING
C3432 ua[1].n16 VGND 0.09596f ; **FLOATING
C3433 ua[1].n17 VGND 0.09487f ; **FLOATING
C3434 ua[1].n18 VGND 0.08644f ; **FLOATING
C3435 ua[1].n19 VGND 0.09596f ; **FLOATING
C3436 ua[1].n20 VGND 0.08644f ; **FLOATING
C3437 ua[1].n21 VGND 0.08644f ; **FLOATING
C3438 ua[1].n22 VGND 0.08644f ; **FLOATING
C3439 ua[1].n23 VGND 0.08644f ; **FLOATING
C3440 ua[1].n24 VGND 0.09596f ; **FLOATING
C3441 ua[1].n25 VGND 7.21649f ; **FLOATING
C3442 ua[0].n0 VGND 0.37502f ; **FLOATING
C3443 ua[0].n1 VGND 0.07184f ; **FLOATING
C3444 ua[0].n2 VGND 0.07184f ; **FLOATING
C3445 ua[0].n3 VGND 0.07976f ; **FLOATING
C3446 ua[0].n4 VGND 0.07885f ; **FLOATING
C3447 ua[0].n5 VGND 0.07184f ; **FLOATING
C3448 ua[0].n6 VGND 0.07976f ; **FLOATING
C3449 ua[0].n7 VGND 0.07184f ; **FLOATING
C3450 ua[0].n8 VGND 0.07184f ; **FLOATING
C3451 ua[0].n9 VGND 0.07184f ; **FLOATING
C3452 ua[0].n10 VGND 0.07184f ; **FLOATING
C3453 ua[0].n11 VGND 0.07976f ; **FLOATING
C3454 ua[0].n12 VGND 7.5217f ; **FLOATING
C3455 ua[0].n13 VGND 0.75771f ; **FLOATING
C3456 ua[0].n14 VGND 0.07184f ; **FLOATING
C3457 ua[0].n15 VGND 0.07184f ; **FLOATING
C3458 ua[0].n16 VGND 0.07976f ; **FLOATING
C3459 ua[0].n17 VGND 0.07885f ; **FLOATING
C3460 ua[0].n18 VGND 0.07184f ; **FLOATING
C3461 ua[0].n19 VGND 0.07976f ; **FLOATING
C3462 ua[0].n20 VGND 0.07184f ; **FLOATING
C3463 ua[0].n21 VGND 0.07184f ; **FLOATING
C3464 ua[0].n22 VGND 0.07184f ; **FLOATING
C3465 ua[0].n23 VGND 0.07184f ; **FLOATING
C3466 ua[0].n24 VGND 0.07976f ; **FLOATING
C3467 ua[0].n25 VGND 6.19236f ; **FLOATING
C3468 XCH2_GM1B/G.n0 VGND 0.03407f ; **FLOATING
C3469 XCH2_GM1B/G.n1 VGND 0.00659f ; **FLOATING
C3470 XCH2_GM1B/G.n2 VGND 0.00576f ; **FLOATING
C3471 XCH2_GM1B/G.t0 VGND 0.07246f ; **FLOATING
C3472 XCH2_GM1B/G.t4 VGND 0.07246f ; **FLOATING
C3473 XCH2_GM1B/G.n3 VGND 0.03617f ; **FLOATING
C3474 XCH2_GM1B/G.n4 VGND 0.02957f ; **FLOATING
C3475 XCH2_GM1B/G.n5 VGND 0.02957f ; **FLOATING
C3476 XCH2_GM1B/G.n6 VGND 0.06549f ; **FLOATING
C3477 XCH2_GM1B/G.n7 VGND 0.02957f ; **FLOATING
C3478 XCH2_GM1B/G.n8 VGND 0.03617f ; **FLOATING
C3479 XCH2_GM1B/G.t3 VGND 0.07184f ; **FLOATING
C3480 XCH2_GM1B/G.t2 VGND 0.07184f ; **FLOATING
C3481 XCH2_GM1B/G.t1 VGND 0.07184f ; **FLOATING
C3482 XCH2_GM1B/D0.n0 VGND 0.08652f ; **FLOATING
C3483 XCH2_GM1B/D0.t0 VGND 0.10058f ; **FLOATING
C3484 XCH2_GM1B/S1.t0 VGND 0.05867f ; **FLOATING
C3485 XCH2_GM1B/S1.t1 VGND 0.05867f ; **FLOATING
C3486 XCH2_GM1B/S1.n0 VGND 0.11734f ; **FLOATING
C3487 XCH2_GM1B/D2.n0 VGND 0.17305f ; **FLOATING
C3488 XCH2_GM1B/D2.t1 VGND 0.05867f ; **FLOATING
C3489 XCH2_GM1B/D2.t0 VGND 0.05867f ; **FLOATING
C3490 XCH2_GM1B/D2.n1 VGND 0.11734f ; **FLOATING
C3491 XCH2_GM1B/S3.t0 VGND 0.05867f ; **FLOATING
C3492 XCH2_GM1B/S3.t1 VGND 0.05867f ; **FLOATING
C3493 XCH2_GM1B/S3.n0 VGND 0.11734f ; **FLOATING
C3494 XCH2_GM1B/D4.n0 VGND 0.17305f ; **FLOATING
C3495 XCH2_GM1B/D4.t1 VGND 0.05867f ; **FLOATING
C3496 XCH2_GM1B/D4.t0 VGND 0.05867f ; **FLOATING
C3497 XCH2_GM1B/D4.n1 VGND 0.11734f ; **FLOATING
C3498 XCH2_GM1B/S4.t0 VGND 0.10058f ; **FLOATING
C3499 ch1_lon_raw VGND 17.71165f
C3500 X1DN_N/G.n0 VGND 0.03082f ; **FLOATING
C3501 X1DN_N/G.n1 VGND 0.00415f ; **FLOATING
C3502 X1DN_N/G.n2 VGND 0.02705f ; **FLOATING
C3503 X1DN_N/G.n3 VGND 0.00346f ; **FLOATING
C3504 X1DN_N/G.n4 VGND 0.02705f ; **FLOATING
C3505 X1DN_N/G.n5 VGND 0.02705f ; **FLOATING
C3506 X1DN_N/G.n6 VGND 0.02705f ; **FLOATING
C3507 X1DN_N/G.t0 VGND 0.01052f ; **FLOATING
C3508 X1DN_N/G.n7 VGND 0.02752f ; **FLOATING
C3509 X1DN_N/G.t1 VGND 0.01052f ; **FLOATING
C3510 X1DN_N/G.n8 VGND 0.02705f ; **FLOATING
C3511 X1DN_N/G.n9 VGND 0.01123f ; **FLOATING
C3512 X1DN_N/G.t2 VGND 0.01052f ; **FLOATING
C3513 X1DN_N/G.n10 VGND 0.02705f ; **FLOATING
C3514 X1DN_N/G.n11 VGND 0.01123f ; **FLOATING
C3515 X1DN_N/G.t3 VGND 0.01052f ; **FLOATING
C3516 X1DN_N/G.n12 VGND 0.02705f ; **FLOATING
C3517 X1DN_N/G.n13 VGND 0.01123f ; **FLOATING
C3518 X1DN_N/G.t4 VGND 0.01052f ; **FLOATING
C3519 X1DN_N/G.n14 VGND 0.02752f ; **FLOATING
C3520 X1DN_N/G.n15 VGND 0.01534f ; **FLOATING
C3521 X1DN_N/G.n16 VGND 0.05894f ; **FLOATING
C3522 X1DN_N/G.n17 VGND 0.01534f ; **FLOATING
C3523 X1DN_N/G.n18 VGND 0.02705f ; **FLOATING
C3524 X1DN_N/D0.n0 VGND 0.05782f ; **FLOATING
C3525 X1DN_N/D0.t0 VGND 0.06633f ; **FLOATING
C3526 X1DN_N/S1.t0 VGND 0.04065f ; **FLOATING
C3527 X1DN_N/S1.t1 VGND 0.04065f ; **FLOATING
C3528 X1DN_N/S1.n0 VGND 0.08129f ; **FLOATING
C3529 X1DN_N/D2.n0 VGND 0.1125f ; **FLOATING
C3530 X1DN_N/D2.t0 VGND 0.04065f ; **FLOATING
C3531 X1DN_N/D2.t1 VGND 0.04065f ; **FLOATING
C3532 X1DN_N/D2.n1 VGND 0.08129f ; **FLOATING
C3533 X1DN_N/S3.t0 VGND 0.04065f ; **FLOATING
C3534 X1DN_N/S3.t1 VGND 0.04065f ; **FLOATING
C3535 X1DN_N/S3.n0 VGND 0.08129f ; **FLOATING
C3536 X1DN_N/D4.n0 VGND 0.1125f ; **FLOATING
C3537 X1DN_N/D4.t1 VGND 0.04065f ; **FLOATING
C3538 X1DN_N/D4.t0 VGND 0.04065f ; **FLOATING
C3539 X1DN_N/D4.n1 VGND 0.08129f ; **FLOATING
C3540 X1DN_N/S4.t0 VGND 0.06633f ; **FLOATING
C3541 tail2 VGND 33.12272f
C3542 gm2_p VGND 21.95495f
C3543 ua[1] VGND 31.20032f
C3544 XCH2_GM1A/G.n0 VGND 0.03407f ; **FLOATING
C3545 XCH2_GM1A/G.n1 VGND 0.00659f ; **FLOATING
C3546 XCH2_GM1A/G.n2 VGND 0.00576f ; **FLOATING
C3547 XCH2_GM1A/G.t0 VGND 0.07246f ; **FLOATING
C3548 XCH2_GM1A/G.t4 VGND 0.07246f ; **FLOATING
C3549 XCH2_GM1A/G.n3 VGND 0.03617f ; **FLOATING
C3550 XCH2_GM1A/G.n4 VGND 0.02957f ; **FLOATING
C3551 XCH2_GM1A/G.n5 VGND 0.02957f ; **FLOATING
C3552 XCH2_GM1A/G.n6 VGND 0.06549f ; **FLOATING
C3553 XCH2_GM1A/G.n7 VGND 0.02957f ; **FLOATING
C3554 XCH2_GM1A/G.n8 VGND 0.03617f ; **FLOATING
C3555 XCH2_GM1A/G.t3 VGND 0.07184f ; **FLOATING
C3556 XCH2_GM1A/G.t2 VGND 0.07184f ; **FLOATING
C3557 XCH2_GM1A/G.t1 VGND 0.07184f ; **FLOATING
C3558 XCH2_GM1A/D0.n0 VGND 0.08652f ; **FLOATING
C3559 XCH2_GM1A/D0.t0 VGND 0.10058f ; **FLOATING
C3560 XCH2_GM1A/S1.t0 VGND 0.05867f ; **FLOATING
C3561 XCH2_GM1A/S1.t1 VGND 0.05867f ; **FLOATING
C3562 XCH2_GM1A/S1.n0 VGND 0.11734f ; **FLOATING
C3563 XCH2_GM1A/D2.n0 VGND 0.17305f ; **FLOATING
C3564 XCH2_GM1A/D2.t1 VGND 0.05867f ; **FLOATING
C3565 XCH2_GM1A/D2.t0 VGND 0.05867f ; **FLOATING
C3566 XCH2_GM1A/D2.n1 VGND 0.11734f ; **FLOATING
C3567 XCH2_GM1A/S3.t0 VGND 0.05867f ; **FLOATING
C3568 XCH2_GM1A/S3.t1 VGND 0.05867f ; **FLOATING
C3569 XCH2_GM1A/S3.n0 VGND 0.11734f ; **FLOATING
C3570 XCH2_GM1A/D4.n0 VGND 0.17305f ; **FLOATING
C3571 XCH2_GM1A/D4.t1 VGND 0.05867f ; **FLOATING
C3572 XCH2_GM1A/D4.t0 VGND 0.05867f ; **FLOATING
C3573 XCH2_GM1A/D4.n1 VGND 0.11734f ; **FLOATING
C3574 XCH2_GM1A/S4.t0 VGND 0.10058f ; **FLOATING
C3575 XCH2_GM2B/G.n0 VGND 0.03407f ; **FLOATING
C3576 XCH2_GM2B/G.n1 VGND 0.00659f ; **FLOATING
C3577 XCH2_GM2B/G.n2 VGND 0.00576f ; **FLOATING
C3578 XCH2_GM2B/G.t0 VGND 0.07246f ; **FLOATING
C3579 XCH2_GM2B/G.t4 VGND 0.07246f ; **FLOATING
C3580 XCH2_GM2B/G.n3 VGND 0.03617f ; **FLOATING
C3581 XCH2_GM2B/G.n4 VGND 0.02957f ; **FLOATING
C3582 XCH2_GM2B/G.n5 VGND 0.02957f ; **FLOATING
C3583 XCH2_GM2B/G.n6 VGND 0.06549f ; **FLOATING
C3584 XCH2_GM2B/G.n7 VGND 0.02957f ; **FLOATING
C3585 XCH2_GM2B/G.n8 VGND 0.03617f ; **FLOATING
C3586 XCH2_GM2B/G.t3 VGND 0.07184f ; **FLOATING
C3587 XCH2_GM2B/G.t2 VGND 0.07184f ; **FLOATING
C3588 XCH2_GM2B/G.t1 VGND 0.07184f ; **FLOATING
C3589 XCH2_GM2B/D0.n0 VGND 0.08652f ; **FLOATING
C3590 XCH2_GM2B/D0.t0 VGND 0.10058f ; **FLOATING
C3591 XCH2_GM2B/S1.t0 VGND 0.05867f ; **FLOATING
C3592 XCH2_GM2B/S1.t1 VGND 0.05867f ; **FLOATING
C3593 XCH2_GM2B/S1.n0 VGND 0.11734f ; **FLOATING
C3594 XCH2_GM2B/D2.n0 VGND 0.17305f ; **FLOATING
C3595 XCH2_GM2B/D2.t1 VGND 0.05867f ; **FLOATING
C3596 XCH2_GM2B/D2.t0 VGND 0.05867f ; **FLOATING
C3597 XCH2_GM2B/D2.n1 VGND 0.11734f ; **FLOATING
C3598 XCH2_GM2B/S3.t0 VGND 0.05867f ; **FLOATING
C3599 XCH2_GM2B/S3.t1 VGND 0.05867f ; **FLOATING
C3600 XCH2_GM2B/S3.n0 VGND 0.11734f ; **FLOATING
C3601 XCH2_GM2B/D4.n0 VGND 0.17305f ; **FLOATING
C3602 XCH2_GM2B/D4.t1 VGND 0.05867f ; **FLOATING
C3603 XCH2_GM2B/D4.t0 VGND 0.05867f ; **FLOATING
C3604 XCH2_GM2B/D4.n1 VGND 0.11734f ; **FLOATING
C3605 XCH2_GM2B/S4.t0 VGND 0.10058f ; **FLOATING
C3606 X1DP_P/B.n0 VGND 0.02158f ; **FLOATING
C3607 X1DP_P/B.n1 VGND 0.04309f ; **FLOATING
C3608 X1DP_P/B.n2 VGND 0.21103f ; **FLOATING
C3609 X1DP_P/B.n3 VGND 0.04181f ; **FLOATING
C3610 X1DP_P/B.t2 VGND 0.13586f ; **FLOATING
C3611 X1DP_P/B.n4 VGND 0.04309f ; **FLOATING
C3612 X1DP_P/B.n5 VGND 0.04309f ; **FLOATING
C3613 X1DP_P/B.t0 VGND 0.2044f ; **FLOATING
C3614 X1DP_P/B.t1 VGND 0.13586f ; **FLOATING
C3615 X1DP_P/B.t3 VGND 0.13586f ; **FLOATING
C3616 X1DP_P/B.t4 VGND 0.2044f ; **FLOATING
C3617 X1DP_P/B.n6 VGND 0.21103f ; **FLOATING
C3618 X1DP_P/B.n7 VGND 0.04324f ; **FLOATING
C3619 X1DP_P/G.n0 VGND 0.08361f ; **FLOATING
C3620 X1DP_P/G.n1 VGND 0.01127f ; **FLOATING
C3621 X1DP_P/G.n2 VGND 0.08585f ; **FLOATING
C3622 X1DP_P/G.n3 VGND 0.00939f ; **FLOATING
C3623 X1DP_P/G.n4 VGND 0.08585f ; **FLOATING
C3624 X1DP_P/G.n5 VGND 0.08585f ; **FLOATING
C3625 X1DP_P/G.n6 VGND 0.08585f ; **FLOATING
C3626 X1DP_P/G.t0 VGND 0.05347f ; **FLOATING
C3627 X1DP_P/G.n7 VGND 0.08711f ; **FLOATING
C3628 X1DP_P/G.t1 VGND 0.05347f ; **FLOATING
C3629 X1DP_P/G.n8 VGND 0.08585f ; **FLOATING
C3630 X1DP_P/G.n9 VGND 0.03046f ; **FLOATING
C3631 X1DP_P/G.t2 VGND 0.05347f ; **FLOATING
C3632 X1DP_P/G.n10 VGND 0.08585f ; **FLOATING
C3633 X1DP_P/G.n11 VGND 0.03046f ; **FLOATING
C3634 X1DP_P/G.t3 VGND 0.05347f ; **FLOATING
C3635 X1DP_P/G.n12 VGND 0.08585f ; **FLOATING
C3636 X1DP_P/G.n13 VGND 0.03046f ; **FLOATING
C3637 X1DP_P/G.t4 VGND 0.05347f ; **FLOATING
C3638 X1DP_P/G.n14 VGND 0.08711f ; **FLOATING
C3639 X1DP_P/G.n15 VGND 0.04161f ; **FLOATING
C3640 X1DP_P/G.n16 VGND 0.15992f ; **FLOATING
C3641 X1DP_P/G.n17 VGND 0.04161f ; **FLOATING
C3642 X1DP_P/G.n18 VGND 0.08585f ; **FLOATING
C3643 X1DP_P/D0.n0 VGND 0.04947f ; **FLOATING
C3644 X1DP_P/D0.t0 VGND 0.17821f ; **FLOATING
C3645 X1DP_P/S1.n0 VGND 0.02401f ; **FLOATING
C3646 X1DP_P/S1.t0 VGND 0.07252f ; **FLOATING
C3647 X1DP_P/S1.t1 VGND 0.07252f ; **FLOATING
C3648 X1DP_P/S1.n1 VGND 0.14503f ; **FLOATING
C3649 X1DP_P/D2.n0 VGND 0.06886f ; **FLOATING
C3650 X1DP_P/D2.t1 VGND 0.07252f ; **FLOATING
C3651 X1DP_P/D2.t0 VGND 0.07252f ; **FLOATING
C3652 X1DP_P/D2.n1 VGND 0.14503f ; **FLOATING
C3653 X1DP_P/S3.n0 VGND 0.02401f ; **FLOATING
C3654 X1DP_P/S3.t1 VGND 0.07252f ; **FLOATING
C3655 X1DP_P/S3.t0 VGND 0.07252f ; **FLOATING
C3656 X1DP_P/S3.n1 VGND 0.14503f ; **FLOATING
C3657 X1DP_P/D4.n0 VGND 0.06886f ; **FLOATING
C3658 X1DP_P/D4.t0 VGND 0.07252f ; **FLOATING
C3659 X1DP_P/D4.t1 VGND 0.07252f ; **FLOATING
C3660 X1DP_P/D4.n1 VGND 0.14503f ; **FLOATING
C3661 X1DP_P/S4.n0 VGND 0.01725f ; **FLOATING
C3662 X1DP_P/S4.t0 VGND 0.17821f ; **FLOATING
C3663 XXN_N/G.n0 VGND 0.03082f ; **FLOATING
C3664 XXN_N/G.n1 VGND 0.00415f ; **FLOATING
C3665 XXN_N/G.n2 VGND 0.02705f ; **FLOATING
C3666 XXN_N/G.n3 VGND 0.00346f ; **FLOATING
C3667 XXN_N/G.n4 VGND 0.02705f ; **FLOATING
C3668 XXN_N/G.n5 VGND 0.02705f ; **FLOATING
C3669 XXN_N/G.n6 VGND 0.02705f ; **FLOATING
C3670 XXN_N/G.t0 VGND 0.01052f ; **FLOATING
C3671 XXN_N/G.n7 VGND 0.02752f ; **FLOATING
C3672 XXN_N/G.t1 VGND 0.01052f ; **FLOATING
C3673 XXN_N/G.n8 VGND 0.02705f ; **FLOATING
C3674 XXN_N/G.n9 VGND 0.01123f ; **FLOATING
C3675 XXN_N/G.t2 VGND 0.01052f ; **FLOATING
C3676 XXN_N/G.n10 VGND 0.02705f ; **FLOATING
C3677 XXN_N/G.n11 VGND 0.01123f ; **FLOATING
C3678 XXN_N/G.t3 VGND 0.01052f ; **FLOATING
C3679 XXN_N/G.n12 VGND 0.02705f ; **FLOATING
C3680 XXN_N/G.n13 VGND 0.01123f ; **FLOATING
C3681 XXN_N/G.t4 VGND 0.01052f ; **FLOATING
C3682 XXN_N/G.n14 VGND 0.02752f ; **FLOATING
C3683 XXN_N/G.n15 VGND 0.01534f ; **FLOATING
C3684 XXN_N/G.n16 VGND 0.05894f ; **FLOATING
C3685 XXN_N/G.n17 VGND 0.01534f ; **FLOATING
C3686 XXN_N/G.n18 VGND 0.02705f ; **FLOATING
C3687 XXN_N/D0.n0 VGND 0.05782f ; **FLOATING
C3688 XXN_N/D0.t0 VGND 0.06633f ; **FLOATING
C3689 XXN_N/S1.t0 VGND 0.04065f ; **FLOATING
C3690 XXN_N/S1.t1 VGND 0.04065f ; **FLOATING
C3691 XXN_N/S1.n0 VGND 0.08129f ; **FLOATING
C3692 XXN_N/D2.n0 VGND 0.1125f ; **FLOATING
C3693 XXN_N/D2.t0 VGND 0.04065f ; **FLOATING
C3694 XXN_N/D2.t1 VGND 0.04065f ; **FLOATING
C3695 XXN_N/D2.n1 VGND 0.08129f ; **FLOATING
C3696 XXN_N/S3.t0 VGND 0.04065f ; **FLOATING
C3697 XXN_N/S3.t1 VGND 0.04065f ; **FLOATING
C3698 XXN_N/S3.n0 VGND 0.08129f ; **FLOATING
C3699 XXN_N/D4.n0 VGND 0.1125f ; **FLOATING
C3700 XXN_N/D4.t1 VGND 0.04065f ; **FLOATING
C3701 XXN_N/D4.t0 VGND 0.04065f ; **FLOATING
C3702 XXN_N/D4.n1 VGND 0.08129f ; **FLOATING
C3703 XXN_N/S4.t0 VGND 0.06633f ; **FLOATING
C3704 XCH1LN_N/G.n0 VGND 0.03309f ; **FLOATING
C3705 XCH1LN_N/G.n1 VGND 0.00446f ; **FLOATING
C3706 XCH1LN_N/G.n2 VGND 0.03348f ; **FLOATING
C3707 XCH1LN_N/G.n3 VGND 0.00371f ; **FLOATING
C3708 XCH1LN_N/G.n4 VGND 0.03348f ; **FLOATING
C3709 XCH1LN_N/G.n5 VGND 0.03348f ; **FLOATING
C3710 XCH1LN_N/G.n6 VGND 0.03348f ; **FLOATING
C3711 XCH1LN_N/G.t0 VGND 0.02016f ; **FLOATING
C3712 XCH1LN_N/G.n7 VGND 0.03397f ; **FLOATING
C3713 XCH1LN_N/G.t1 VGND 0.02016f ; **FLOATING
C3714 XCH1LN_N/G.n8 VGND 0.03348f ; **FLOATING
C3715 XCH1LN_N/G.n9 VGND 0.01205f ; **FLOATING
C3716 XCH1LN_N/G.t2 VGND 0.02016f ; **FLOATING
C3717 XCH1LN_N/G.n10 VGND 0.03348f ; **FLOATING
C3718 XCH1LN_N/G.n11 VGND 0.01205f ; **FLOATING
C3719 XCH1LN_N/G.t3 VGND 0.02016f ; **FLOATING
C3720 XCH1LN_N/G.n12 VGND 0.03348f ; **FLOATING
C3721 XCH1LN_N/G.n13 VGND 0.01205f ; **FLOATING
C3722 XCH1LN_N/G.t4 VGND 0.02016f ; **FLOATING
C3723 XCH1LN_N/G.n14 VGND 0.03397f ; **FLOATING
C3724 XCH1LN_N/G.n15 VGND 0.01647f ; **FLOATING
C3725 XCH1LN_N/G.n16 VGND 0.06329f ; **FLOATING
C3726 XCH1LN_N/G.n17 VGND 0.01647f ; **FLOATING
C3727 XCH1LN_N/G.n18 VGND 0.03348f ; **FLOATING
C3728 XCH1LN_N/D0.n0 VGND 0.03483f ; **FLOATING
C3729 XCH1LN_N/D0.t0 VGND 0.11646f ; **FLOATING
C3730 XCH1LN_N/S1.t0 VGND 0.07135f ; **FLOATING
C3731 XCH1LN_N/S1.t1 VGND 0.07135f ; **FLOATING
C3732 XCH1LN_N/S1.n0 VGND 0.1427f ; **FLOATING
C3733 XCH1LN_N/D2.n0 VGND 0.06775f ; **FLOATING
C3734 XCH1LN_N/D2.t0 VGND 0.07135f ; **FLOATING
C3735 XCH1LN_N/D2.t1 VGND 0.07135f ; **FLOATING
C3736 XCH1LN_N/D2.n1 VGND 0.1427f ; **FLOATING
C3737 XCH1LN_N/S3.t1 VGND 0.07135f ; **FLOATING
C3738 XCH1LN_N/S3.t0 VGND 0.07135f ; **FLOATING
C3739 XCH1LN_N/S3.n0 VGND 0.1427f ; **FLOATING
C3740 XCH1LN_N/D4.n0 VGND 0.06775f ; **FLOATING
C3741 XCH1LN_N/D4.t0 VGND 0.07135f ; **FLOATING
C3742 XCH1LN_N/D4.t1 VGND 0.07135f ; **FLOATING
C3743 XCH1LN_N/D4.n1 VGND 0.1427f ; **FLOATING
C3744 XCH1LN_N/S4.t0 VGND 0.11646f ; **FLOATING
C3745 XCH1_SW1B/G.n0 VGND 0.03309f ; **FLOATING
C3746 XCH1_SW1B/G.n1 VGND 0.00446f ; **FLOATING
C3747 XCH1_SW1B/G.n2 VGND 0.03348f ; **FLOATING
C3748 XCH1_SW1B/G.n3 VGND 0.00371f ; **FLOATING
C3749 XCH1_SW1B/G.n4 VGND 0.03348f ; **FLOATING
C3750 XCH1_SW1B/G.n5 VGND 0.03348f ; **FLOATING
C3751 XCH1_SW1B/G.n6 VGND 0.03348f ; **FLOATING
C3752 XCH1_SW1B/G.t0 VGND 0.02016f ; **FLOATING
C3753 XCH1_SW1B/G.n7 VGND 0.03397f ; **FLOATING
C3754 XCH1_SW1B/G.t1 VGND 0.02016f ; **FLOATING
C3755 XCH1_SW1B/G.n8 VGND 0.03348f ; **FLOATING
C3756 XCH1_SW1B/G.n9 VGND 0.01205f ; **FLOATING
C3757 XCH1_SW1B/G.t2 VGND 0.02016f ; **FLOATING
C3758 XCH1_SW1B/G.n10 VGND 0.03348f ; **FLOATING
C3759 XCH1_SW1B/G.n11 VGND 0.01205f ; **FLOATING
C3760 XCH1_SW1B/G.t3 VGND 0.02016f ; **FLOATING
C3761 XCH1_SW1B/G.n12 VGND 0.03348f ; **FLOATING
C3762 XCH1_SW1B/G.n13 VGND 0.01205f ; **FLOATING
C3763 XCH1_SW1B/G.t4 VGND 0.02016f ; **FLOATING
C3764 XCH1_SW1B/G.n14 VGND 0.03397f ; **FLOATING
C3765 XCH1_SW1B/G.n15 VGND 0.01647f ; **FLOATING
C3766 XCH1_SW1B/G.n16 VGND 0.06329f ; **FLOATING
C3767 XCH1_SW1B/G.n17 VGND 0.01647f ; **FLOATING
C3768 XCH1_SW1B/G.n18 VGND 0.03348f ; **FLOATING
C3769 XCH1_SW1B/D0.n0 VGND 0.03483f ; **FLOATING
C3770 XCH1_SW1B/D0.t0 VGND 0.11646f ; **FLOATING
C3771 XCH1_SW1B/S1.t0 VGND 0.07135f ; **FLOATING
C3772 XCH1_SW1B/S1.t1 VGND 0.07135f ; **FLOATING
C3773 XCH1_SW1B/S1.n0 VGND 0.1427f ; **FLOATING
C3774 XCH1_SW1B/D2.n0 VGND 0.06775f ; **FLOATING
C3775 XCH1_SW1B/D2.t0 VGND 0.07135f ; **FLOATING
C3776 XCH1_SW1B/D2.t1 VGND 0.07135f ; **FLOATING
C3777 XCH1_SW1B/D2.n1 VGND 0.1427f ; **FLOATING
C3778 XCH1_SW1B/S3.t1 VGND 0.07135f ; **FLOATING
C3779 XCH1_SW1B/S3.t0 VGND 0.07135f ; **FLOATING
C3780 XCH1_SW1B/S3.n0 VGND 0.1427f ; **FLOATING
C3781 XCH1_SW1B/D4.n0 VGND 0.06775f ; **FLOATING
C3782 XCH1_SW1B/D4.t0 VGND 0.07135f ; **FLOATING
C3783 XCH1_SW1B/D4.t1 VGND 0.07135f ; **FLOATING
C3784 XCH1_SW1B/D4.n1 VGND 0.1427f ; **FLOATING
C3785 XCH1_SW1B/S4.t0 VGND 0.11646f ; **FLOATING
C3786 gm2_n VGND 22.83779f
C3787 XCH2_GM2A/G.n0 VGND 0.03407f ; **FLOATING
C3788 XCH2_GM2A/G.n1 VGND 0.00659f ; **FLOATING
C3789 XCH2_GM2A/G.n2 VGND 0.00576f ; **FLOATING
C3790 XCH2_GM2A/G.t0 VGND 0.07246f ; **FLOATING
C3791 XCH2_GM2A/G.t4 VGND 0.07246f ; **FLOATING
C3792 XCH2_GM2A/G.n3 VGND 0.03617f ; **FLOATING
C3793 XCH2_GM2A/G.n4 VGND 0.02957f ; **FLOATING
C3794 XCH2_GM2A/G.n5 VGND 0.02957f ; **FLOATING
C3795 XCH2_GM2A/G.n6 VGND 0.06549f ; **FLOATING
C3796 XCH2_GM2A/G.n7 VGND 0.02957f ; **FLOATING
C3797 XCH2_GM2A/G.n8 VGND 0.03617f ; **FLOATING
C3798 XCH2_GM2A/G.t3 VGND 0.07184f ; **FLOATING
C3799 XCH2_GM2A/G.t2 VGND 0.07184f ; **FLOATING
C3800 XCH2_GM2A/G.t1 VGND 0.07184f ; **FLOATING
C3801 XCH2_GM2A/D0.n0 VGND 0.08652f ; **FLOATING
C3802 XCH2_GM2A/D0.t0 VGND 0.10058f ; **FLOATING
C3803 XCH2_GM2A/S1.t0 VGND 0.05867f ; **FLOATING
C3804 XCH2_GM2A/S1.t1 VGND 0.05867f ; **FLOATING
C3805 XCH2_GM2A/S1.n0 VGND 0.11734f ; **FLOATING
C3806 XCH2_GM2A/D2.n0 VGND 0.17305f ; **FLOATING
C3807 XCH2_GM2A/D2.t1 VGND 0.05867f ; **FLOATING
C3808 XCH2_GM2A/D2.t0 VGND 0.05867f ; **FLOATING
C3809 XCH2_GM2A/D2.n1 VGND 0.11734f ; **FLOATING
C3810 XCH2_GM2A/S3.t0 VGND 0.05867f ; **FLOATING
C3811 XCH2_GM2A/S3.t1 VGND 0.05867f ; **FLOATING
C3812 XCH2_GM2A/S3.n0 VGND 0.11734f ; **FLOATING
C3813 XCH2_GM2A/D4.n0 VGND 0.17305f ; **FLOATING
C3814 XCH2_GM2A/D4.t1 VGND 0.05867f ; **FLOATING
C3815 XCH2_GM2A/D4.t0 VGND 0.05867f ; **FLOATING
C3816 XCH2_GM2A/D4.n1 VGND 0.11734f ; **FLOATING
C3817 XCH2_GM2A/S4.t0 VGND 0.10058f ; **FLOATING
C3818 XLN1_P/B.n0 VGND 0.01502f ; **FLOATING
C3819 XLN1_P/B.n1 VGND 0.02994f ; **FLOATING
C3820 XLN1_P/B.n2 VGND 0.15272f ; **FLOATING
C3821 XLN1_P/B.n3 VGND 0.02871f ; **FLOATING
C3822 XLN1_P/B.t1 VGND 0.10051f ; **FLOATING
C3823 XLN1_P/B.n4 VGND 0.02994f ; **FLOATING
C3824 XLN1_P/B.n5 VGND 0.02994f ; **FLOATING
C3825 XLN1_P/B.t0 VGND 0.1527f ; **FLOATING
C3826 XLN1_P/B.t2 VGND 0.1527f ; **FLOATING
C3827 XLN1_P/B.n6 VGND 0.15272f ; **FLOATING
C3828 XLN1_P/B.n7 VGND 0.03006f ; **FLOATING
C3829 XLN1_P/G.n0 VGND 0.00176f ; **FLOATING
C3830 XLN1_P/G.n1 VGND 0.08174f ; **FLOATING
C3831 XLN1_P/G.n2 VGND 0.08174f ; **FLOATING
C3832 XLN1_P/G.t0 VGND 0.06541f ; **FLOATING
C3833 XLN1_P/G.n3 VGND 0.4011f ; **FLOATING
C3834 XLN1_P/G.t1 VGND 0.03678f ; **FLOATING
C3835 XLN1_P/G.t2 VGND 0.06541f ; **FLOATING
C3836 XLN1_P/G.n4 VGND 0.08174f ; **FLOATING
C3837 XLN1_P/D0.n0 VGND 0.08056f ; **FLOATING
C3838 XLN1_P/D0.t0 VGND 0.09958f ; **FLOATING
C3839 XLN1_P/S1.n0 VGND 0.11064f ; **FLOATING
C3840 XLN1_P/S1.t0 VGND 0.0408f ; **FLOATING
C3841 XLN1_P/S1.t1 VGND 0.0408f ; **FLOATING
C3842 XLN1_P/S1.n1 VGND 0.08159f ; **FLOATING
C3843 XLN1_P/D2.n0 VGND 0.11291f ; **FLOATING
C3844 XLN1_P/D2.t0 VGND 0.0408f ; **FLOATING
C3845 XLN1_P/D2.t1 VGND 0.0408f ; **FLOATING
C3846 XLN1_P/D2.n1 VGND 0.08159f ; **FLOATING
C3847 XLN1_P/S2.n0 VGND 0.07894f ; **FLOATING
C3848 XLN1_P/S2.t0 VGND 0.09958f ; **FLOATING
C3849 XXP_P/B.n0 VGND 0.02158f ; **FLOATING
C3850 XXP_P/B.n1 VGND 0.04309f ; **FLOATING
C3851 XXP_P/B.n2 VGND 0.21103f ; **FLOATING
C3852 XXP_P/B.n3 VGND 0.04181f ; **FLOATING
C3853 XXP_P/B.t2 VGND 0.13586f ; **FLOATING
C3854 XXP_P/B.n4 VGND 0.04309f ; **FLOATING
C3855 XXP_P/B.n5 VGND 0.04309f ; **FLOATING
C3856 XXP_P/B.t0 VGND 0.2044f ; **FLOATING
C3857 XXP_P/B.t1 VGND 0.13586f ; **FLOATING
C3858 XXP_P/B.t3 VGND 0.13586f ; **FLOATING
C3859 XXP_P/B.t4 VGND 0.2044f ; **FLOATING
C3860 XXP_P/B.n6 VGND 0.21103f ; **FLOATING
C3861 XXP_P/B.n7 VGND 0.04324f ; **FLOATING
C3862 XXP_P/G.n0 VGND 0.08361f ; **FLOATING
C3863 XXP_P/G.n1 VGND 0.01127f ; **FLOATING
C3864 XXP_P/G.n2 VGND 0.08585f ; **FLOATING
C3865 XXP_P/G.n3 VGND 0.00939f ; **FLOATING
C3866 XXP_P/G.n4 VGND 0.08585f ; **FLOATING
C3867 XXP_P/G.n5 VGND 0.08585f ; **FLOATING
C3868 XXP_P/G.n6 VGND 0.08585f ; **FLOATING
C3869 XXP_P/G.t0 VGND 0.05347f ; **FLOATING
C3870 XXP_P/G.n7 VGND 0.08711f ; **FLOATING
C3871 XXP_P/G.t1 VGND 0.05347f ; **FLOATING
C3872 XXP_P/G.n8 VGND 0.08585f ; **FLOATING
C3873 XXP_P/G.n9 VGND 0.03046f ; **FLOATING
C3874 XXP_P/G.t2 VGND 0.05347f ; **FLOATING
C3875 XXP_P/G.n10 VGND 0.08585f ; **FLOATING
C3876 XXP_P/G.n11 VGND 0.03046f ; **FLOATING
C3877 XXP_P/G.t3 VGND 0.05347f ; **FLOATING
C3878 XXP_P/G.n12 VGND 0.08585f ; **FLOATING
C3879 XXP_P/G.n13 VGND 0.03046f ; **FLOATING
C3880 XXP_P/G.t4 VGND 0.05347f ; **FLOATING
C3881 XXP_P/G.n14 VGND 0.08711f ; **FLOATING
C3882 XXP_P/G.n15 VGND 0.04161f ; **FLOATING
C3883 XXP_P/G.n16 VGND 0.15992f ; **FLOATING
C3884 XXP_P/G.n17 VGND 0.04161f ; **FLOATING
C3885 XXP_P/G.n18 VGND 0.08585f ; **FLOATING
C3886 XXP_P/D0.n0 VGND 0.04947f ; **FLOATING
C3887 XXP_P/D0.t0 VGND 0.17821f ; **FLOATING
C3888 XXP_P/S1.n0 VGND 0.02401f ; **FLOATING
C3889 XXP_P/S1.t0 VGND 0.07252f ; **FLOATING
C3890 XXP_P/S1.t1 VGND 0.07252f ; **FLOATING
C3891 XXP_P/S1.n1 VGND 0.14503f ; **FLOATING
C3892 XXP_P/D2.n0 VGND 0.06886f ; **FLOATING
C3893 XXP_P/D2.t1 VGND 0.07252f ; **FLOATING
C3894 XXP_P/D2.t0 VGND 0.07252f ; **FLOATING
C3895 XXP_P/D2.n1 VGND 0.14503f ; **FLOATING
C3896 XXP_P/S3.n0 VGND 0.02401f ; **FLOATING
C3897 XXP_P/S3.t1 VGND 0.07252f ; **FLOATING
C3898 XXP_P/S3.t0 VGND 0.07252f ; **FLOATING
C3899 XXP_P/S3.n1 VGND 0.14503f ; **FLOATING
C3900 XXP_P/D4.n0 VGND 0.06886f ; **FLOATING
C3901 XXP_P/D4.t0 VGND 0.07252f ; **FLOATING
C3902 XXP_P/D4.t1 VGND 0.07252f ; **FLOATING
C3903 XXP_P/D4.n1 VGND 0.14503f ; **FLOATING
C3904 XXP_P/S4.n0 VGND 0.01725f ; **FLOATING
C3905 XXP_P/S4.t0 VGND 0.17821f ; **FLOATING
C3906 XCH1LP_P/B.n0 VGND 0.02385f ; **FLOATING
C3907 XCH1LP_P/B.n1 VGND 0.04765f ; **FLOATING
C3908 XCH1LP_P/B.n2 VGND 0.26426f ; **FLOATING
C3909 XCH1LP_P/B.n3 VGND 0.0461f ; **FLOATING
C3910 XCH1LP_P/B.t2 VGND 0.17216f ; **FLOATING
C3911 XCH1LP_P/B.n4 VGND 0.04765f ; **FLOATING
C3912 XCH1LP_P/B.n5 VGND 0.04765f ; **FLOATING
C3913 XCH1LP_P/B.t0 VGND 0.25476f ; **FLOATING
C3914 XCH1LP_P/B.t1 VGND 0.17216f ; **FLOATING
C3915 XCH1LP_P/B.t3 VGND 0.17216f ; **FLOATING
C3916 XCH1LP_P/B.t4 VGND 0.25476f ; **FLOATING
C3917 XCH1LP_P/B.n6 VGND 0.26426f ; **FLOATING
C3918 XCH1LP_P/B.n7 VGND 0.04738f ; **FLOATING
C3919 XCH1LP_P/G.n0 VGND 0.07604f ; **FLOATING
C3920 XCH1LP_P/G.n1 VGND 0.01025f ; **FLOATING
C3921 XCH1LP_P/G.n2 VGND 0.09845f ; **FLOATING
C3922 XCH1LP_P/G.n3 VGND 0.00854f ; **FLOATING
C3923 XCH1LP_P/G.n4 VGND 0.09845f ; **FLOATING
C3924 XCH1LP_P/G.n5 VGND 0.09845f ; **FLOATING
C3925 XCH1LP_P/G.n6 VGND 0.09845f ; **FLOATING
C3926 XCH1LP_P/G.t0 VGND 0.08936f ; **FLOATING
C3927 XCH1LP_P/G.n7 VGND 0.09959f ; **FLOATING
C3928 XCH1LP_P/G.t1 VGND 0.08936f ; **FLOATING
C3929 XCH1LP_P/G.n8 VGND 0.09845f ; **FLOATING
C3930 XCH1LP_P/G.n9 VGND 0.0277f ; **FLOATING
C3931 XCH1LP_P/G.t2 VGND 0.08936f ; **FLOATING
C3932 XCH1LP_P/G.n10 VGND 0.09845f ; **FLOATING
C3933 XCH1LP_P/G.n11 VGND 0.0277f ; **FLOATING
C3934 XCH1LP_P/G.t3 VGND 0.08936f ; **FLOATING
C3935 XCH1LP_P/G.n12 VGND 0.09845f ; **FLOATING
C3936 XCH1LP_P/G.n13 VGND 0.0277f ; **FLOATING
C3937 XCH1LP_P/G.t4 VGND 0.08936f ; **FLOATING
C3938 XCH1LP_P/G.n14 VGND 0.09959f ; **FLOATING
C3939 XCH1LP_P/G.n15 VGND 0.03784f ; **FLOATING
C3940 XCH1LP_P/G.n16 VGND 0.14544f ; **FLOATING
C3941 XCH1LP_P/G.n17 VGND 0.03784f ; **FLOATING
C3942 XCH1LP_P/G.n18 VGND 0.09845f ; **FLOATING
C3943 XCH1LP_P/D0.n0 VGND 0.19369f ; **FLOATING
C3944 XCH1LP_P/D0.t0 VGND 0.33005f ; **FLOATING
C3945 XCH1LP_P/S1.t0 VGND 0.13508f ; **FLOATING
C3946 XCH1LP_P/S1.t1 VGND 0.13508f ; **FLOATING
C3947 XCH1LP_P/S1.n0 VGND 0.27017f ; **FLOATING
C3948 XCH1LP_P/D2.n0 VGND 0.26834f ; **FLOATING
C3949 XCH1LP_P/D2.t1 VGND 0.13508f ; **FLOATING
C3950 XCH1LP_P/D2.t0 VGND 0.13508f ; **FLOATING
C3951 XCH1LP_P/D2.n1 VGND 0.27017f ; **FLOATING
C3952 XCH1LP_P/S3.t0 VGND 0.13508f ; **FLOATING
C3953 XCH1LP_P/S3.t1 VGND 0.13508f ; **FLOATING
C3954 XCH1LP_P/S3.n0 VGND 0.27017f ; **FLOATING
C3955 XCH1LP_P/D4.n0 VGND 0.26834f ; **FLOATING
C3956 XCH1LP_P/D4.t0 VGND 0.13508f ; **FLOATING
C3957 XCH1LP_P/D4.t1 VGND 0.13508f ; **FLOATING
C3958 XCH1LP_P/D4.n1 VGND 0.27017f ; **FLOATING
C3959 XCH1LP_P/S4.t0 VGND 0.33005f ; **FLOATING
C3960 ua[2] VGND 41.38372f
C3961 ch1_lop VGND 38.76258f
C3962 XCH1_SW1A/G.n0 VGND 0.03309f ; **FLOATING
C3963 XCH1_SW1A/G.n1 VGND 0.00446f ; **FLOATING
C3964 XCH1_SW1A/G.n2 VGND 0.03348f ; **FLOATING
C3965 XCH1_SW1A/G.n3 VGND 0.00371f ; **FLOATING
C3966 XCH1_SW1A/G.n4 VGND 0.03348f ; **FLOATING
C3967 XCH1_SW1A/G.n5 VGND 0.03348f ; **FLOATING
C3968 XCH1_SW1A/G.n6 VGND 0.03348f ; **FLOATING
C3969 XCH1_SW1A/G.t0 VGND 0.02016f ; **FLOATING
C3970 XCH1_SW1A/G.n7 VGND 0.03397f ; **FLOATING
C3971 XCH1_SW1A/G.t1 VGND 0.02016f ; **FLOATING
C3972 XCH1_SW1A/G.n8 VGND 0.03348f ; **FLOATING
C3973 XCH1_SW1A/G.n9 VGND 0.01205f ; **FLOATING
C3974 XCH1_SW1A/G.t2 VGND 0.02016f ; **FLOATING
C3975 XCH1_SW1A/G.n10 VGND 0.03348f ; **FLOATING
C3976 XCH1_SW1A/G.n11 VGND 0.01205f ; **FLOATING
C3977 XCH1_SW1A/G.t3 VGND 0.02016f ; **FLOATING
C3978 XCH1_SW1A/G.n12 VGND 0.03348f ; **FLOATING
C3979 XCH1_SW1A/G.n13 VGND 0.01205f ; **FLOATING
C3980 XCH1_SW1A/G.t4 VGND 0.02016f ; **FLOATING
C3981 XCH1_SW1A/G.n14 VGND 0.03397f ; **FLOATING
C3982 XCH1_SW1A/G.n15 VGND 0.01647f ; **FLOATING
C3983 XCH1_SW1A/G.n16 VGND 0.06329f ; **FLOATING
C3984 XCH1_SW1A/G.n17 VGND 0.01647f ; **FLOATING
C3985 XCH1_SW1A/G.n18 VGND 0.03348f ; **FLOATING
C3986 XCH1_SW1A/D0.n0 VGND 0.03483f ; **FLOATING
C3987 XCH1_SW1A/D0.t0 VGND 0.11646f ; **FLOATING
C3988 XCH1_SW1A/S1.t0 VGND 0.07135f ; **FLOATING
C3989 XCH1_SW1A/S1.t1 VGND 0.07135f ; **FLOATING
C3990 XCH1_SW1A/S1.n0 VGND 0.1427f ; **FLOATING
C3991 XCH1_SW1A/D2.n0 VGND 0.06775f ; **FLOATING
C3992 XCH1_SW1A/D2.t0 VGND 0.07135f ; **FLOATING
C3993 XCH1_SW1A/D2.t1 VGND 0.07135f ; **FLOATING
C3994 XCH1_SW1A/D2.n1 VGND 0.1427f ; **FLOATING
C3995 XCH1_SW1A/S3.t1 VGND 0.07135f ; **FLOATING
C3996 XCH1_SW1A/S3.t0 VGND 0.07135f ; **FLOATING
C3997 XCH1_SW1A/S3.n0 VGND 0.1427f ; **FLOATING
C3998 XCH1_SW1A/D4.n0 VGND 0.06775f ; **FLOATING
C3999 XCH1_SW1A/D4.t0 VGND 0.07135f ; **FLOATING
C4000 XCH1_SW1A/D4.t1 VGND 0.07135f ; **FLOATING
C4001 XCH1_SW1A/D4.n1 VGND 0.1427f ; **FLOATING
C4002 XCH1_SW1A/S4.t0 VGND 0.11646f ; **FLOATING
C4003 XCH1_SW2B/G.n0 VGND 0.03309f ; **FLOATING
C4004 XCH1_SW2B/G.n1 VGND 0.00446f ; **FLOATING
C4005 XCH1_SW2B/G.n2 VGND 0.03348f ; **FLOATING
C4006 XCH1_SW2B/G.n3 VGND 0.00371f ; **FLOATING
C4007 XCH1_SW2B/G.n4 VGND 0.03348f ; **FLOATING
C4008 XCH1_SW2B/G.n5 VGND 0.03348f ; **FLOATING
C4009 XCH1_SW2B/G.n6 VGND 0.03348f ; **FLOATING
C4010 XCH1_SW2B/G.t0 VGND 0.02016f ; **FLOATING
C4011 XCH1_SW2B/G.n7 VGND 0.03397f ; **FLOATING
C4012 XCH1_SW2B/G.t1 VGND 0.02016f ; **FLOATING
C4013 XCH1_SW2B/G.n8 VGND 0.03348f ; **FLOATING
C4014 XCH1_SW2B/G.n9 VGND 0.01205f ; **FLOATING
C4015 XCH1_SW2B/G.t2 VGND 0.02016f ; **FLOATING
C4016 XCH1_SW2B/G.n10 VGND 0.03348f ; **FLOATING
C4017 XCH1_SW2B/G.n11 VGND 0.01205f ; **FLOATING
C4018 XCH1_SW2B/G.t3 VGND 0.02016f ; **FLOATING
C4019 XCH1_SW2B/G.n12 VGND 0.03348f ; **FLOATING
C4020 XCH1_SW2B/G.n13 VGND 0.01205f ; **FLOATING
C4021 XCH1_SW2B/G.t4 VGND 0.02016f ; **FLOATING
C4022 XCH1_SW2B/G.n14 VGND 0.03397f ; **FLOATING
C4023 XCH1_SW2B/G.n15 VGND 0.01647f ; **FLOATING
C4024 XCH1_SW2B/G.n16 VGND 0.06329f ; **FLOATING
C4025 XCH1_SW2B/G.n17 VGND 0.01647f ; **FLOATING
C4026 XCH1_SW2B/G.n18 VGND 0.03348f ; **FLOATING
C4027 XCH1_SW2B/D0.n0 VGND 0.03483f ; **FLOATING
C4028 XCH1_SW2B/D0.t0 VGND 0.11646f ; **FLOATING
C4029 XCH1_SW2B/S1.t0 VGND 0.07135f ; **FLOATING
C4030 XCH1_SW2B/S1.t1 VGND 0.07135f ; **FLOATING
C4031 XCH1_SW2B/S1.n0 VGND 0.1427f ; **FLOATING
C4032 XCH1_SW2B/D2.n0 VGND 0.06775f ; **FLOATING
C4033 XCH1_SW2B/D2.t0 VGND 0.07135f ; **FLOATING
C4034 XCH1_SW2B/D2.t1 VGND 0.07135f ; **FLOATING
C4035 XCH1_SW2B/D2.n1 VGND 0.1427f ; **FLOATING
C4036 XCH1_SW2B/S3.t1 VGND 0.07135f ; **FLOATING
C4037 XCH1_SW2B/S3.t0 VGND 0.07135f ; **FLOATING
C4038 XCH1_SW2B/S3.n0 VGND 0.1427f ; **FLOATING
C4039 XCH1_SW2B/D4.n0 VGND 0.06775f ; **FLOATING
C4040 XCH1_SW2B/D4.t0 VGND 0.07135f ; **FLOATING
C4041 XCH1_SW2B/D4.t1 VGND 0.07135f ; **FLOATING
C4042 XCH1_SW2B/D4.n1 VGND 0.1427f ; **FLOATING
C4043 XCH1_SW2B/S4.t0 VGND 0.11646f ; **FLOATING
C4044 ln1 VGND 7.31957f
C4045 XLN1_N/G.n0 VGND 0 ; **FLOATING
C4046 XLN1_N/G.n1 VGND 0.02705f ; **FLOATING
C4047 XLN1_N/G.n2 VGND 0.02705f ; **FLOATING
C4048 XLN1_N/G.t0 VGND 0.0217f ; **FLOATING
C4049 XLN1_N/G.n3 VGND 0.13234f ; **FLOATING
C4050 XLN1_N/G.t1 VGND 0.01152f ; **FLOATING
C4051 XLN1_N/G.t2 VGND 0.0217f ; **FLOATING
C4052 XLN1_N/G.n4 VGND 0.02705f ; **FLOATING
C4053 XLN1_N/D0.n0 VGND 0.05782f ; **FLOATING
C4054 XLN1_N/D0.t0 VGND 0.06633f ; **FLOATING
C4055 XLN1_N/S1.t1 VGND 0.04065f ; **FLOATING
C4056 XLN1_N/S1.t0 VGND 0.04065f ; **FLOATING
C4057 XLN1_N/S1.n0 VGND 0.08129f ; **FLOATING
C4058 XLN1_N/D2.n0 VGND 0.1125f ; **FLOATING
C4059 XLN1_N/D2.t0 VGND 0.04065f ; **FLOATING
C4060 XLN1_N/D2.t1 VGND 0.04065f ; **FLOATING
C4061 XLN1_N/D2.n1 VGND 0.08129f ; **FLOATING
C4062 XLN1_N/S2.t0 VGND 0.06633f ; **FLOATING
C4063 ch1_lop_raw VGND 24.95815f
C4064 X1DP_N/G.n0 VGND 0.03082f ; **FLOATING
C4065 X1DP_N/G.n1 VGND 0.00415f ; **FLOATING
C4066 X1DP_N/G.n2 VGND 0.02705f ; **FLOATING
C4067 X1DP_N/G.n3 VGND 0.00346f ; **FLOATING
C4068 X1DP_N/G.n4 VGND 0.02705f ; **FLOATING
C4069 X1DP_N/G.n5 VGND 0.02705f ; **FLOATING
C4070 X1DP_N/G.n6 VGND 0.02705f ; **FLOATING
C4071 X1DP_N/G.t0 VGND 0.01052f ; **FLOATING
C4072 X1DP_N/G.n7 VGND 0.02752f ; **FLOATING
C4073 X1DP_N/G.t1 VGND 0.01052f ; **FLOATING
C4074 X1DP_N/G.n8 VGND 0.02705f ; **FLOATING
C4075 X1DP_N/G.n9 VGND 0.01123f ; **FLOATING
C4076 X1DP_N/G.t2 VGND 0.01052f ; **FLOATING
C4077 X1DP_N/G.n10 VGND 0.02705f ; **FLOATING
C4078 X1DP_N/G.n11 VGND 0.01123f ; **FLOATING
C4079 X1DP_N/G.t3 VGND 0.01052f ; **FLOATING
C4080 X1DP_N/G.n12 VGND 0.02705f ; **FLOATING
C4081 X1DP_N/G.n13 VGND 0.01123f ; **FLOATING
C4082 X1DP_N/G.t4 VGND 0.01052f ; **FLOATING
C4083 X1DP_N/G.n14 VGND 0.02752f ; **FLOATING
C4084 X1DP_N/G.n15 VGND 0.01534f ; **FLOATING
C4085 X1DP_N/G.n16 VGND 0.05894f ; **FLOATING
C4086 X1DP_N/G.n17 VGND 0.01534f ; **FLOATING
C4087 X1DP_N/G.n18 VGND 0.02705f ; **FLOATING
C4088 X1DP_N/D0.n0 VGND 0.05782f ; **FLOATING
C4089 X1DP_N/D0.t0 VGND 0.06633f ; **FLOATING
C4090 X1DP_N/S1.t0 VGND 0.04065f ; **FLOATING
C4091 X1DP_N/S1.t1 VGND 0.04065f ; **FLOATING
C4092 X1DP_N/S1.n0 VGND 0.08129f ; **FLOATING
C4093 X1DP_N/D2.n0 VGND 0.1125f ; **FLOATING
C4094 X1DP_N/D2.t0 VGND 0.04065f ; **FLOATING
C4095 X1DP_N/D2.t1 VGND 0.04065f ; **FLOATING
C4096 X1DP_N/D2.n1 VGND 0.08129f ; **FLOATING
C4097 X1DP_N/S3.t0 VGND 0.04065f ; **FLOATING
C4098 X1DP_N/S3.t1 VGND 0.04065f ; **FLOATING
C4099 X1DP_N/S3.n0 VGND 0.08129f ; **FLOATING
C4100 X1DP_N/D4.n0 VGND 0.1125f ; **FLOATING
C4101 X1DP_N/D4.t1 VGND 0.04065f ; **FLOATING
C4102 X1DP_N/D4.t0 VGND 0.04065f ; **FLOATING
C4103 X1DP_N/D4.n1 VGND 0.08129f ; **FLOATING
C4104 X1DP_N/S4.t0 VGND 0.06633f ; **FLOATING
C4105 ua[3] VGND 35.40382f
C4106 ch1_lon VGND 37.93843f
C4107 XCH1_SW2A/G.n0 VGND 0.03309f ; **FLOATING
C4108 XCH1_SW2A/G.n1 VGND 0.00446f ; **FLOATING
C4109 XCH1_SW2A/G.n2 VGND 0.03348f ; **FLOATING
C4110 XCH1_SW2A/G.n3 VGND 0.00371f ; **FLOATING
C4111 XCH1_SW2A/G.n4 VGND 0.03348f ; **FLOATING
C4112 XCH1_SW2A/G.n5 VGND 0.03348f ; **FLOATING
C4113 XCH1_SW2A/G.n6 VGND 0.03348f ; **FLOATING
C4114 XCH1_SW2A/G.t0 VGND 0.02016f ; **FLOATING
C4115 XCH1_SW2A/G.n7 VGND 0.03397f ; **FLOATING
C4116 XCH1_SW2A/G.t1 VGND 0.02016f ; **FLOATING
C4117 XCH1_SW2A/G.n8 VGND 0.03348f ; **FLOATING
C4118 XCH1_SW2A/G.n9 VGND 0.01205f ; **FLOATING
C4119 XCH1_SW2A/G.t2 VGND 0.02016f ; **FLOATING
C4120 XCH1_SW2A/G.n10 VGND 0.03348f ; **FLOATING
C4121 XCH1_SW2A/G.n11 VGND 0.01205f ; **FLOATING
C4122 XCH1_SW2A/G.t3 VGND 0.02016f ; **FLOATING
C4123 XCH1_SW2A/G.n12 VGND 0.03348f ; **FLOATING
C4124 XCH1_SW2A/G.n13 VGND 0.01205f ; **FLOATING
C4125 XCH1_SW2A/G.t4 VGND 0.02016f ; **FLOATING
C4126 XCH1_SW2A/G.n14 VGND 0.03397f ; **FLOATING
C4127 XCH1_SW2A/G.n15 VGND 0.01647f ; **FLOATING
C4128 XCH1_SW2A/G.n16 VGND 0.06329f ; **FLOATING
C4129 XCH1_SW2A/G.n17 VGND 0.01647f ; **FLOATING
C4130 XCH1_SW2A/G.n18 VGND 0.03348f ; **FLOATING
C4131 XCH1_SW2A/D0.n0 VGND 0.03483f ; **FLOATING
C4132 XCH1_SW2A/D0.t0 VGND 0.11646f ; **FLOATING
C4133 XCH1_SW2A/S1.t0 VGND 0.07135f ; **FLOATING
C4134 XCH1_SW2A/S1.t1 VGND 0.07135f ; **FLOATING
C4135 XCH1_SW2A/S1.n0 VGND 0.1427f ; **FLOATING
C4136 XCH1_SW2A/D2.n0 VGND 0.06775f ; **FLOATING
C4137 XCH1_SW2A/D2.t0 VGND 0.07135f ; **FLOATING
C4138 XCH1_SW2A/D2.t1 VGND 0.07135f ; **FLOATING
C4139 XCH1_SW2A/D2.n1 VGND 0.1427f ; **FLOATING
C4140 XCH1_SW2A/S3.t1 VGND 0.07135f ; **FLOATING
C4141 XCH1_SW2A/S3.t0 VGND 0.07135f ; **FLOATING
C4142 XCH1_SW2A/S3.n0 VGND 0.1427f ; **FLOATING
C4143 XCH1_SW2A/D4.n0 VGND 0.06775f ; **FLOATING
C4144 XCH1_SW2A/D4.t0 VGND 0.07135f ; **FLOATING
C4145 XCH1_SW2A/D4.t1 VGND 0.07135f ; **FLOATING
C4146 XCH1_SW2A/D4.n1 VGND 0.1427f ; **FLOATING
C4147 XCH1_SW2A/S4.t0 VGND 0.11646f ; **FLOATING
C4148 XCH1_SW3B/G.n0 VGND 0.03309f ; **FLOATING
C4149 XCH1_SW3B/G.n1 VGND 0.00446f ; **FLOATING
C4150 XCH1_SW3B/G.n2 VGND 0.03348f ; **FLOATING
C4151 XCH1_SW3B/G.n3 VGND 0.00371f ; **FLOATING
C4152 XCH1_SW3B/G.n4 VGND 0.03348f ; **FLOATING
C4153 XCH1_SW3B/G.n5 VGND 0.03348f ; **FLOATING
C4154 XCH1_SW3B/G.n6 VGND 0.03348f ; **FLOATING
C4155 XCH1_SW3B/G.t0 VGND 0.02016f ; **FLOATING
C4156 XCH1_SW3B/G.n7 VGND 0.03397f ; **FLOATING
C4157 XCH1_SW3B/G.t1 VGND 0.02016f ; **FLOATING
C4158 XCH1_SW3B/G.n8 VGND 0.03348f ; **FLOATING
C4159 XCH1_SW3B/G.n9 VGND 0.01205f ; **FLOATING
C4160 XCH1_SW3B/G.t2 VGND 0.02016f ; **FLOATING
C4161 XCH1_SW3B/G.n10 VGND 0.03348f ; **FLOATING
C4162 XCH1_SW3B/G.n11 VGND 0.01205f ; **FLOATING
C4163 XCH1_SW3B/G.t3 VGND 0.02016f ; **FLOATING
C4164 XCH1_SW3B/G.n12 VGND 0.03348f ; **FLOATING
C4165 XCH1_SW3B/G.n13 VGND 0.01205f ; **FLOATING
C4166 XCH1_SW3B/G.t4 VGND 0.02016f ; **FLOATING
C4167 XCH1_SW3B/G.n14 VGND 0.03397f ; **FLOATING
C4168 XCH1_SW3B/G.n15 VGND 0.01647f ; **FLOATING
C4169 XCH1_SW3B/G.n16 VGND 0.06329f ; **FLOATING
C4170 XCH1_SW3B/G.n17 VGND 0.01647f ; **FLOATING
C4171 XCH1_SW3B/G.n18 VGND 0.03348f ; **FLOATING
C4172 XCH1_SW3B/D0.n0 VGND 0.03483f ; **FLOATING
C4173 XCH1_SW3B/D0.t0 VGND 0.11646f ; **FLOATING
C4174 XCH1_SW3B/S1.t0 VGND 0.07135f ; **FLOATING
C4175 XCH1_SW3B/S1.t1 VGND 0.07135f ; **FLOATING
C4176 XCH1_SW3B/S1.n0 VGND 0.1427f ; **FLOATING
C4177 XCH1_SW3B/D2.n0 VGND 0.06775f ; **FLOATING
C4178 XCH1_SW3B/D2.t0 VGND 0.07135f ; **FLOATING
C4179 XCH1_SW3B/D2.t1 VGND 0.07135f ; **FLOATING
C4180 XCH1_SW3B/D2.n1 VGND 0.1427f ; **FLOATING
C4181 XCH1_SW3B/S3.t1 VGND 0.07135f ; **FLOATING
C4182 XCH1_SW3B/S3.t0 VGND 0.07135f ; **FLOATING
C4183 XCH1_SW3B/S3.n0 VGND 0.1427f ; **FLOATING
C4184 XCH1_SW3B/D4.n0 VGND 0.06775f ; **FLOATING
C4185 XCH1_SW3B/D4.t0 VGND 0.07135f ; **FLOATING
C4186 XCH1_SW3B/D4.t1 VGND 0.07135f ; **FLOATING
C4187 XCH1_SW3B/D4.n1 VGND 0.1427f ; **FLOATING
C4188 XCH1_SW3B/S4.t0 VGND 0.11646f ; **FLOATING
C4189 XLN3_P/B.n0 VGND 0.03174f ; **FLOATING
C4190 XLN3_P/B.n1 VGND 0.06343f ; **FLOATING
C4191 XLN3_P/B.n2 VGND 0.30697f ; **FLOATING
C4192 XLN3_P/B.n3 VGND 0.06218f ; **FLOATING
C4193 XLN3_P/B.t4 VGND 0.19297f ; **FLOATING
C4194 XLN3_P/B.n4 VGND 0.06343f ; **FLOATING
C4195 XLN3_P/B.n5 VGND 0.06343f ; **FLOATING
C4196 XLN3_P/B.t0 VGND 0.28519f ; **FLOATING
C4197 XLN3_P/B.t1 VGND 0.19297f ; **FLOATING
C4198 XLN3_P/B.t2 VGND 0.19297f ; **FLOATING
C4199 XLN3_P/B.t3 VGND 0.19297f ; **FLOATING
C4200 XLN3_P/B.t5 VGND 0.19297f ; **FLOATING
C4201 XLN3_P/B.t6 VGND 0.19297f ; **FLOATING
C4202 XLN3_P/B.t7 VGND 0.19297f ; **FLOATING
C4203 XLN3_P/B.t8 VGND 0.28519f ; **FLOATING
C4204 XLN3_P/B.n6 VGND 0.30697f ; **FLOATING
C4205 XLN3_P/B.n7 VGND 0.06351f ; **FLOATING
C4206 XLN3_P/G.n0 VGND 0.0192f ; **FLOATING
C4207 XLN3_P/G.n1 VGND 0.03206f ; **FLOATING
C4208 XLN3_P/G.n2 VGND 0.08542f ; **FLOATING
C4209 XLN3_P/G.n3 VGND 0.00978f ; **FLOATING
C4210 XLN3_P/G.n4 VGND 0.09831f ; **FLOATING
C4211 XLN3_P/G.n5 VGND 0.00978f ; **FLOATING
C4212 XLN3_P/G.n6 VGND 0.08542f ; **FLOATING
C4213 XLN3_P/G.n7 VGND 0.0297f ; **FLOATING
C4214 XLN3_P/G.n8 VGND 0.09831f ; **FLOATING
C4215 XLN3_P/G.n9 VGND 0.09831f ; **FLOATING
C4216 XLN3_P/G.n10 VGND 0.09831f ; **FLOATING
C4217 XLN3_P/G.n11 VGND 0.09831f ; **FLOATING
C4218 XLN3_P/G.n12 VGND 0.09831f ; **FLOATING
C4219 XLN3_P/G.n13 VGND 0.09831f ; **FLOATING
C4220 XLN3_P/G.n14 VGND 0.09831f ; **FLOATING
C4221 XLN3_P/G.t0 VGND 0.09401f ; **FLOATING
C4222 XLN3_P/G.n15 VGND 0.0994f ; **FLOATING
C4223 XLN3_P/G.t1 VGND 0.09401f ; **FLOATING
C4224 XLN3_P/G.n16 VGND 0.09831f ; **FLOATING
C4225 XLN3_P/G.n17 VGND 0.02643f ; **FLOATING
C4226 XLN3_P/G.t2 VGND 0.09401f ; **FLOATING
C4227 XLN3_P/G.n18 VGND 0.09831f ; **FLOATING
C4228 XLN3_P/G.n19 VGND 0.02643f ; **FLOATING
C4229 XLN3_P/G.t3 VGND 0.09401f ; **FLOATING
C4230 XLN3_P/G.n20 VGND 0.09831f ; **FLOATING
C4231 XLN3_P/G.n21 VGND 0.02643f ; **FLOATING
C4232 XLN3_P/G.t4 VGND 0.09401f ; **FLOATING
C4233 XLN3_P/G.n22 VGND 0.09831f ; **FLOATING
C4234 XLN3_P/G.n23 VGND 0.02643f ; **FLOATING
C4235 XLN3_P/G.t5 VGND 0.09401f ; **FLOATING
C4236 XLN3_P/G.n24 VGND 0.09831f ; **FLOATING
C4237 XLN3_P/G.n25 VGND 0.02643f ; **FLOATING
C4238 XLN3_P/G.t6 VGND 0.09401f ; **FLOATING
C4239 XLN3_P/G.n26 VGND 0.09831f ; **FLOATING
C4240 XLN3_P/G.n27 VGND 0.02643f ; **FLOATING
C4241 XLN3_P/G.t7 VGND 0.09401f ; **FLOATING
C4242 XLN3_P/G.n28 VGND 0.09831f ; **FLOATING
C4243 XLN3_P/G.n29 VGND 0.02643f ; **FLOATING
C4244 XLN3_P/G.t8 VGND 0.09401f ; **FLOATING
C4245 XLN3_P/G.n30 VGND 0.0994f ; **FLOATING
C4246 XLN3_P/G.n31 VGND 0.03611f ; **FLOATING
C4247 XLN3_P/G.n32 VGND 0.08542f ; **FLOATING
C4248 XLN3_P/G.n33 VGND 0.03206f ; **FLOATING
C4249 XLN3_P/G.n34 VGND 0.03206f ; **FLOATING
C4250 XLN3_P/G.n35 VGND 0.03206f ; **FLOATING
C4251 XLN3_P/G.n36 VGND 0.08542f ; **FLOATING
C4252 XLN3_P/G.n37 VGND 0.03611f ; **FLOATING
C4253 XLN3_P/G.n38 VGND 0.09831f ; **FLOATING
C4254 XLN3_P/D0.n0 VGND 0.20111f ; **FLOATING
C4255 XLN3_P/D0.t0 VGND 0.36455f ; **FLOATING
C4256 XLN3_P/S1.n0 VGND 0.26116f ; **FLOATING
C4257 XLN3_P/S1.t0 VGND 0.1491f ; **FLOATING
C4258 XLN3_P/S1.t1 VGND 0.1491f ; **FLOATING
C4259 XLN3_P/S1.n1 VGND 0.2982f ; **FLOATING
C4260 XLN3_P/D2.n0 VGND 0.27845f ; **FLOATING
C4261 XLN3_P/D2.t1 VGND 0.1491f ; **FLOATING
C4262 XLN3_P/D2.t0 VGND 0.1491f ; **FLOATING
C4263 XLN3_P/D2.n1 VGND 0.2982f ; **FLOATING
C4264 XLN3_P/S3.n0 VGND 0.26116f ; **FLOATING
C4265 XLN3_P/S3.t1 VGND 0.1491f ; **FLOATING
C4266 XLN3_P/S3.t0 VGND 0.1491f ; **FLOATING
C4267 XLN3_P/S3.n1 VGND 0.2982f ; **FLOATING
C4268 XLN3_P/D4.n0 VGND 0.27845f ; **FLOATING
C4269 XLN3_P/D4.t1 VGND 0.1491f ; **FLOATING
C4270 XLN3_P/D4.t0 VGND 0.1491f ; **FLOATING
C4271 XLN3_P/D4.n1 VGND 0.2982f ; **FLOATING
C4272 XLN3_P/S5.n0 VGND 0.26116f ; **FLOATING
C4273 XLN3_P/S5.t0 VGND 0.1491f ; **FLOATING
C4274 XLN3_P/S5.t1 VGND 0.1491f ; **FLOATING
C4275 XLN3_P/S5.n1 VGND 0.2982f ; **FLOATING
C4276 XLN3_P/D6.n0 VGND 0.27845f ; **FLOATING
C4277 XLN3_P/D6.t1 VGND 0.1491f ; **FLOATING
C4278 XLN3_P/D6.t0 VGND 0.1491f ; **FLOATING
C4279 XLN3_P/D6.n1 VGND 0.2982f ; **FLOATING
C4280 XLN3_P/S7.n0 VGND 0.26116f ; **FLOATING
C4281 XLN3_P/S7.t1 VGND 0.1491f ; **FLOATING
C4282 XLN3_P/S7.t0 VGND 0.1491f ; **FLOATING
C4283 XLN3_P/S7.n1 VGND 0.2982f ; **FLOATING
C4284 XLN3_P/D8.n0 VGND 0.27845f ; **FLOATING
C4285 XLN3_P/D8.t0 VGND 0.1491f ; **FLOATING
C4286 XLN3_P/D8.t1 VGND 0.1491f ; **FLOATING
C4287 XLN3_P/D8.n1 VGND 0.2982f ; **FLOATING
C4288 XLN3_P/S8.n0 VGND 0.18862f ; **FLOATING
C4289 XLN3_P/S8.t0 VGND 0.36455f ; **FLOATING
C4290 XXP_N/G.n0 VGND 0.03082f ; **FLOATING
C4291 XXP_N/G.n1 VGND 0.00415f ; **FLOATING
C4292 XXP_N/G.n2 VGND 0.02705f ; **FLOATING
C4293 XXP_N/G.n3 VGND 0.00346f ; **FLOATING
C4294 XXP_N/G.n4 VGND 0.02705f ; **FLOATING
C4295 XXP_N/G.n5 VGND 0.02705f ; **FLOATING
C4296 XXP_N/G.n6 VGND 0.02705f ; **FLOATING
C4297 XXP_N/G.t0 VGND 0.01052f ; **FLOATING
C4298 XXP_N/G.n7 VGND 0.02752f ; **FLOATING
C4299 XXP_N/G.t1 VGND 0.01052f ; **FLOATING
C4300 XXP_N/G.n8 VGND 0.02705f ; **FLOATING
C4301 XXP_N/G.n9 VGND 0.01123f ; **FLOATING
C4302 XXP_N/G.t2 VGND 0.01052f ; **FLOATING
C4303 XXP_N/G.n10 VGND 0.02705f ; **FLOATING
C4304 XXP_N/G.n11 VGND 0.01123f ; **FLOATING
C4305 XXP_N/G.t3 VGND 0.01052f ; **FLOATING
C4306 XXP_N/G.n12 VGND 0.02705f ; **FLOATING
C4307 XXP_N/G.n13 VGND 0.01123f ; **FLOATING
C4308 XXP_N/G.t4 VGND 0.01052f ; **FLOATING
C4309 XXP_N/G.n14 VGND 0.02752f ; **FLOATING
C4310 XXP_N/G.n15 VGND 0.01534f ; **FLOATING
C4311 XXP_N/G.n16 VGND 0.05894f ; **FLOATING
C4312 XXP_N/G.n17 VGND 0.01534f ; **FLOATING
C4313 XXP_N/G.n18 VGND 0.02705f ; **FLOATING
C4314 XXP_N/D0.n0 VGND 0.05782f ; **FLOATING
C4315 XXP_N/D0.t0 VGND 0.06633f ; **FLOATING
C4316 XXP_N/S1.t0 VGND 0.04065f ; **FLOATING
C4317 XXP_N/S1.t1 VGND 0.04065f ; **FLOATING
C4318 XXP_N/S1.n0 VGND 0.08129f ; **FLOATING
C4319 XXP_N/D2.n0 VGND 0.1125f ; **FLOATING
C4320 XXP_N/D2.t0 VGND 0.04065f ; **FLOATING
C4321 XXP_N/D2.t1 VGND 0.04065f ; **FLOATING
C4322 XXP_N/D2.n1 VGND 0.08129f ; **FLOATING
C4323 XXP_N/S3.t0 VGND 0.04065f ; **FLOATING
C4324 XXP_N/S3.t1 VGND 0.04065f ; **FLOATING
C4325 XXP_N/S3.n0 VGND 0.08129f ; **FLOATING
C4326 XXP_N/D4.n0 VGND 0.1125f ; **FLOATING
C4327 XXP_N/D4.t1 VGND 0.04065f ; **FLOATING
C4328 XXP_N/D4.t0 VGND 0.04065f ; **FLOATING
C4329 XXP_N/D4.n1 VGND 0.08129f ; **FLOATING
C4330 XXP_N/S4.t0 VGND 0.06633f ; **FLOATING
C4331 XCH1LP_N/G.n0 VGND 0.03309f ; **FLOATING
C4332 XCH1LP_N/G.n1 VGND 0.00446f ; **FLOATING
C4333 XCH1LP_N/G.n2 VGND 0.03348f ; **FLOATING
C4334 XCH1LP_N/G.n3 VGND 0.00371f ; **FLOATING
C4335 XCH1LP_N/G.n4 VGND 0.03348f ; **FLOATING
C4336 XCH1LP_N/G.n5 VGND 0.03348f ; **FLOATING
C4337 XCH1LP_N/G.n6 VGND 0.03348f ; **FLOATING
C4338 XCH1LP_N/G.t0 VGND 0.02016f ; **FLOATING
C4339 XCH1LP_N/G.n7 VGND 0.03397f ; **FLOATING
C4340 XCH1LP_N/G.t1 VGND 0.02016f ; **FLOATING
C4341 XCH1LP_N/G.n8 VGND 0.03348f ; **FLOATING
C4342 XCH1LP_N/G.n9 VGND 0.01205f ; **FLOATING
C4343 XCH1LP_N/G.t2 VGND 0.02016f ; **FLOATING
C4344 XCH1LP_N/G.n10 VGND 0.03348f ; **FLOATING
C4345 XCH1LP_N/G.n11 VGND 0.01205f ; **FLOATING
C4346 XCH1LP_N/G.t3 VGND 0.02016f ; **FLOATING
C4347 XCH1LP_N/G.n12 VGND 0.03348f ; **FLOATING
C4348 XCH1LP_N/G.n13 VGND 0.01205f ; **FLOATING
C4349 XCH1LP_N/G.t4 VGND 0.02016f ; **FLOATING
C4350 XCH1LP_N/G.n14 VGND 0.03397f ; **FLOATING
C4351 XCH1LP_N/G.n15 VGND 0.01647f ; **FLOATING
C4352 XCH1LP_N/G.n16 VGND 0.06329f ; **FLOATING
C4353 XCH1LP_N/G.n17 VGND 0.01647f ; **FLOATING
C4354 XCH1LP_N/G.n18 VGND 0.03348f ; **FLOATING
C4355 XCH1LP_N/D0.n0 VGND 0.03483f ; **FLOATING
C4356 XCH1LP_N/D0.t0 VGND 0.11646f ; **FLOATING
C4357 XCH1LP_N/S1.t0 VGND 0.07135f ; **FLOATING
C4358 XCH1LP_N/S1.t1 VGND 0.07135f ; **FLOATING
C4359 XCH1LP_N/S1.n0 VGND 0.1427f ; **FLOATING
C4360 XCH1LP_N/D2.n0 VGND 0.06775f ; **FLOATING
C4361 XCH1LP_N/D2.t0 VGND 0.07135f ; **FLOATING
C4362 XCH1LP_N/D2.t1 VGND 0.07135f ; **FLOATING
C4363 XCH1LP_N/D2.n1 VGND 0.1427f ; **FLOATING
C4364 XCH1LP_N/S3.t1 VGND 0.07135f ; **FLOATING
C4365 XCH1LP_N/S3.t0 VGND 0.07135f ; **FLOATING
C4366 XCH1LP_N/S3.n0 VGND 0.1427f ; **FLOATING
C4367 XCH1LP_N/D4.n0 VGND 0.06775f ; **FLOATING
C4368 XCH1LP_N/D4.t0 VGND 0.07135f ; **FLOATING
C4369 XCH1LP_N/D4.t1 VGND 0.07135f ; **FLOATING
C4370 XCH1LP_N/D4.n1 VGND 0.1427f ; **FLOATING
C4371 XCH1LP_N/S4.t0 VGND 0.11646f ; **FLOATING
C4372 XCH1_SW3A/G.n0 VGND 0.03309f ; **FLOATING
C4373 XCH1_SW3A/G.n1 VGND 0.00446f ; **FLOATING
C4374 XCH1_SW3A/G.n2 VGND 0.03348f ; **FLOATING
C4375 XCH1_SW3A/G.n3 VGND 0.00371f ; **FLOATING
C4376 XCH1_SW3A/G.n4 VGND 0.03348f ; **FLOATING
C4377 XCH1_SW3A/G.n5 VGND 0.03348f ; **FLOATING
C4378 XCH1_SW3A/G.n6 VGND 0.03348f ; **FLOATING
C4379 XCH1_SW3A/G.t0 VGND 0.02016f ; **FLOATING
C4380 XCH1_SW3A/G.n7 VGND 0.03397f ; **FLOATING
C4381 XCH1_SW3A/G.t1 VGND 0.02016f ; **FLOATING
C4382 XCH1_SW3A/G.n8 VGND 0.03348f ; **FLOATING
C4383 XCH1_SW3A/G.n9 VGND 0.01205f ; **FLOATING
C4384 XCH1_SW3A/G.t2 VGND 0.02016f ; **FLOATING
C4385 XCH1_SW3A/G.n10 VGND 0.03348f ; **FLOATING
C4386 XCH1_SW3A/G.n11 VGND 0.01205f ; **FLOATING
C4387 XCH1_SW3A/G.t3 VGND 0.02016f ; **FLOATING
C4388 XCH1_SW3A/G.n12 VGND 0.03348f ; **FLOATING
C4389 XCH1_SW3A/G.n13 VGND 0.01205f ; **FLOATING
C4390 XCH1_SW3A/G.t4 VGND 0.02016f ; **FLOATING
C4391 XCH1_SW3A/G.n14 VGND 0.03397f ; **FLOATING
C4392 XCH1_SW3A/G.n15 VGND 0.01647f ; **FLOATING
C4393 XCH1_SW3A/G.n16 VGND 0.06329f ; **FLOATING
C4394 XCH1_SW3A/G.n17 VGND 0.01647f ; **FLOATING
C4395 XCH1_SW3A/G.n18 VGND 0.03348f ; **FLOATING
C4396 XCH1_SW3A/D0.n0 VGND 0.03483f ; **FLOATING
C4397 XCH1_SW3A/D0.t0 VGND 0.11646f ; **FLOATING
C4398 XCH1_SW3A/S1.t0 VGND 0.07135f ; **FLOATING
C4399 XCH1_SW3A/S1.t1 VGND 0.07135f ; **FLOATING
C4400 XCH1_SW3A/S1.n0 VGND 0.1427f ; **FLOATING
C4401 XCH1_SW3A/D2.n0 VGND 0.06775f ; **FLOATING
C4402 XCH1_SW3A/D2.t0 VGND 0.07135f ; **FLOATING
C4403 XCH1_SW3A/D2.t1 VGND 0.07135f ; **FLOATING
C4404 XCH1_SW3A/D2.n1 VGND 0.1427f ; **FLOATING
C4405 XCH1_SW3A/S3.t1 VGND 0.07135f ; **FLOATING
C4406 XCH1_SW3A/S3.t0 VGND 0.07135f ; **FLOATING
C4407 XCH1_SW3A/S3.n0 VGND 0.1427f ; **FLOATING
C4408 XCH1_SW3A/D4.n0 VGND 0.06775f ; **FLOATING
C4409 XCH1_SW3A/D4.t0 VGND 0.07135f ; **FLOATING
C4410 XCH1_SW3A/D4.t1 VGND 0.07135f ; **FLOATING
C4411 XCH1_SW3A/D4.n1 VGND 0.1427f ; **FLOATING
C4412 XCH1_SW3A/S4.t0 VGND 0.11646f ; **FLOATING
C4413 XCH1_SW4B/G.n0 VGND 0.03309f ; **FLOATING
C4414 XCH1_SW4B/G.n1 VGND 0.00446f ; **FLOATING
C4415 XCH1_SW4B/G.n2 VGND 0.03348f ; **FLOATING
C4416 XCH1_SW4B/G.n3 VGND 0.00371f ; **FLOATING
C4417 XCH1_SW4B/G.n4 VGND 0.03348f ; **FLOATING
C4418 XCH1_SW4B/G.n5 VGND 0.03348f ; **FLOATING
C4419 XCH1_SW4B/G.n6 VGND 0.03348f ; **FLOATING
C4420 XCH1_SW4B/G.t0 VGND 0.02016f ; **FLOATING
C4421 XCH1_SW4B/G.n7 VGND 0.03397f ; **FLOATING
C4422 XCH1_SW4B/G.t1 VGND 0.02016f ; **FLOATING
C4423 XCH1_SW4B/G.n8 VGND 0.03348f ; **FLOATING
C4424 XCH1_SW4B/G.n9 VGND 0.01205f ; **FLOATING
C4425 XCH1_SW4B/G.t2 VGND 0.02016f ; **FLOATING
C4426 XCH1_SW4B/G.n10 VGND 0.03348f ; **FLOATING
C4427 XCH1_SW4B/G.n11 VGND 0.01205f ; **FLOATING
C4428 XCH1_SW4B/G.t3 VGND 0.02016f ; **FLOATING
C4429 XCH1_SW4B/G.n12 VGND 0.03348f ; **FLOATING
C4430 XCH1_SW4B/G.n13 VGND 0.01205f ; **FLOATING
C4431 XCH1_SW4B/G.t4 VGND 0.02016f ; **FLOATING
C4432 XCH1_SW4B/G.n14 VGND 0.03397f ; **FLOATING
C4433 XCH1_SW4B/G.n15 VGND 0.01647f ; **FLOATING
C4434 XCH1_SW4B/G.n16 VGND 0.06329f ; **FLOATING
C4435 XCH1_SW4B/G.n17 VGND 0.01647f ; **FLOATING
C4436 XCH1_SW4B/G.n18 VGND 0.03348f ; **FLOATING
C4437 XCH1_SW4B/D0.n0 VGND 0.03483f ; **FLOATING
C4438 XCH1_SW4B/D0.t0 VGND 0.11646f ; **FLOATING
C4439 XCH1_SW4B/S1.t0 VGND 0.07135f ; **FLOATING
C4440 XCH1_SW4B/S1.t1 VGND 0.07135f ; **FLOATING
C4441 XCH1_SW4B/S1.n0 VGND 0.1427f ; **FLOATING
C4442 XCH1_SW4B/D2.n0 VGND 0.06775f ; **FLOATING
C4443 XCH1_SW4B/D2.t0 VGND 0.07135f ; **FLOATING
C4444 XCH1_SW4B/D2.t1 VGND 0.07135f ; **FLOATING
C4445 XCH1_SW4B/D2.n1 VGND 0.1427f ; **FLOATING
C4446 XCH1_SW4B/S3.t1 VGND 0.07135f ; **FLOATING
C4447 XCH1_SW4B/S3.t0 VGND 0.07135f ; **FLOATING
C4448 XCH1_SW4B/S3.n0 VGND 0.1427f ; **FLOATING
C4449 XCH1_SW4B/D4.n0 VGND 0.06775f ; **FLOATING
C4450 XCH1_SW4B/D4.t0 VGND 0.07135f ; **FLOATING
C4451 XCH1_SW4B/D4.t1 VGND 0.07135f ; **FLOATING
C4452 XCH1_SW4B/D4.n1 VGND 0.1427f ; **FLOATING
C4453 XCH1_SW4B/S4.t0 VGND 0.11646f ; **FLOATING
C4454 XCH1_SW4A/G.n0 VGND 0.03309f ; **FLOATING
C4455 XCH1_SW4A/G.n1 VGND 0.00446f ; **FLOATING
C4456 XCH1_SW4A/G.n2 VGND 0.03348f ; **FLOATING
C4457 XCH1_SW4A/G.n3 VGND 0.00371f ; **FLOATING
C4458 XCH1_SW4A/G.n4 VGND 0.03348f ; **FLOATING
C4459 XCH1_SW4A/G.n5 VGND 0.03348f ; **FLOATING
C4460 XCH1_SW4A/G.n6 VGND 0.03348f ; **FLOATING
C4461 XCH1_SW4A/G.t0 VGND 0.02016f ; **FLOATING
C4462 XCH1_SW4A/G.n7 VGND 0.03397f ; **FLOATING
C4463 XCH1_SW4A/G.t1 VGND 0.02016f ; **FLOATING
C4464 XCH1_SW4A/G.n8 VGND 0.03348f ; **FLOATING
C4465 XCH1_SW4A/G.n9 VGND 0.01205f ; **FLOATING
C4466 XCH1_SW4A/G.t2 VGND 0.02016f ; **FLOATING
C4467 XCH1_SW4A/G.n10 VGND 0.03348f ; **FLOATING
C4468 XCH1_SW4A/G.n11 VGND 0.01205f ; **FLOATING
C4469 XCH1_SW4A/G.t3 VGND 0.02016f ; **FLOATING
C4470 XCH1_SW4A/G.n12 VGND 0.03348f ; **FLOATING
C4471 XCH1_SW4A/G.n13 VGND 0.01205f ; **FLOATING
C4472 XCH1_SW4A/G.t4 VGND 0.02016f ; **FLOATING
C4473 XCH1_SW4A/G.n14 VGND 0.03397f ; **FLOATING
C4474 XCH1_SW4A/G.n15 VGND 0.01647f ; **FLOATING
C4475 XCH1_SW4A/G.n16 VGND 0.06329f ; **FLOATING
C4476 XCH1_SW4A/G.n17 VGND 0.01647f ; **FLOATING
C4477 XCH1_SW4A/G.n18 VGND 0.03348f ; **FLOATING
C4478 XCH1_SW4A/D0.n0 VGND 0.03483f ; **FLOATING
C4479 XCH1_SW4A/D0.t0 VGND 0.11646f ; **FLOATING
C4480 XCH1_SW4A/S1.t0 VGND 0.07135f ; **FLOATING
C4481 XCH1_SW4A/S1.t1 VGND 0.07135f ; **FLOATING
C4482 XCH1_SW4A/S1.n0 VGND 0.1427f ; **FLOATING
C4483 XCH1_SW4A/D2.n0 VGND 0.06775f ; **FLOATING
C4484 XCH1_SW4A/D2.t0 VGND 0.07135f ; **FLOATING
C4485 XCH1_SW4A/D2.t1 VGND 0.07135f ; **FLOATING
C4486 XCH1_SW4A/D2.n1 VGND 0.1427f ; **FLOATING
C4487 XCH1_SW4A/S3.t1 VGND 0.07135f ; **FLOATING
C4488 XCH1_SW4A/S3.t0 VGND 0.07135f ; **FLOATING
C4489 XCH1_SW4A/S3.n0 VGND 0.1427f ; **FLOATING
C4490 XCH1_SW4A/D4.n0 VGND 0.06775f ; **FLOATING
C4491 XCH1_SW4A/D4.t0 VGND 0.07135f ; **FLOATING
C4492 XCH1_SW4A/D4.t1 VGND 0.07135f ; **FLOATING
C4493 XCH1_SW4A/D4.n1 VGND 0.1427f ; **FLOATING
C4494 XCH1_SW4A/S4.t0 VGND 0.11646f ; **FLOATING
C4495 lon VGND 31.67259f
C4496 XLN3_N/G.n0 VGND 0.00884f ; **FLOATING
C4497 XLN3_N/G.n1 VGND 0.01476f ; **FLOATING
C4498 XLN3_N/G.n2 VGND 0.03932f ; **FLOATING
C4499 XLN3_N/G.n3 VGND 0.0045f ; **FLOATING
C4500 XLN3_N/G.n4 VGND 0.0348f ; **FLOATING
C4501 XLN3_N/G.n5 VGND 0.0045f ; **FLOATING
C4502 XLN3_N/G.n6 VGND 0.03932f ; **FLOATING
C4503 XLN3_N/G.n7 VGND 0.01367f ; **FLOATING
C4504 XLN3_N/G.n8 VGND 0.0348f ; **FLOATING
C4505 XLN3_N/G.n9 VGND 0.0348f ; **FLOATING
C4506 XLN3_N/G.n10 VGND 0.0348f ; **FLOATING
C4507 XLN3_N/G.n11 VGND 0.0348f ; **FLOATING
C4508 XLN3_N/G.n12 VGND 0.0348f ; **FLOATING
C4509 XLN3_N/G.n13 VGND 0.0348f ; **FLOATING
C4510 XLN3_N/G.n14 VGND 0.0348f ; **FLOATING
C4511 XLN3_N/G.t0 VGND 0.02236f ; **FLOATING
C4512 XLN3_N/G.n15 VGND 0.0353f ; **FLOATING
C4513 XLN3_N/G.t1 VGND 0.02236f ; **FLOATING
C4514 XLN3_N/G.n16 VGND 0.0348f ; **FLOATING
C4515 XLN3_N/G.n17 VGND 0.01217f ; **FLOATING
C4516 XLN3_N/G.t2 VGND 0.02236f ; **FLOATING
C4517 XLN3_N/G.n18 VGND 0.0348f ; **FLOATING
C4518 XLN3_N/G.n19 VGND 0.01217f ; **FLOATING
C4519 XLN3_N/G.t3 VGND 0.02236f ; **FLOATING
C4520 XLN3_N/G.n20 VGND 0.0348f ; **FLOATING
C4521 XLN3_N/G.n21 VGND 0.01217f ; **FLOATING
C4522 XLN3_N/G.t4 VGND 0.02236f ; **FLOATING
C4523 XLN3_N/G.n22 VGND 0.0348f ; **FLOATING
C4524 XLN3_N/G.n23 VGND 0.01217f ; **FLOATING
C4525 XLN3_N/G.t5 VGND 0.02236f ; **FLOATING
C4526 XLN3_N/G.n24 VGND 0.0348f ; **FLOATING
C4527 XLN3_N/G.n25 VGND 0.01217f ; **FLOATING
C4528 XLN3_N/G.t6 VGND 0.02236f ; **FLOATING
C4529 XLN3_N/G.n26 VGND 0.0348f ; **FLOATING
C4530 XLN3_N/G.n27 VGND 0.01217f ; **FLOATING
C4531 XLN3_N/G.t7 VGND 0.02236f ; **FLOATING
C4532 XLN3_N/G.n28 VGND 0.0348f ; **FLOATING
C4533 XLN3_N/G.n29 VGND 0.01217f ; **FLOATING
C4534 XLN3_N/G.t8 VGND 0.02236f ; **FLOATING
C4535 XLN3_N/G.n30 VGND 0.0353f ; **FLOATING
C4536 XLN3_N/G.n31 VGND 0.01662f ; **FLOATING
C4537 XLN3_N/G.n32 VGND 0.03932f ; **FLOATING
C4538 XLN3_N/G.n33 VGND 0.01476f ; **FLOATING
C4539 XLN3_N/G.n34 VGND 0.01476f ; **FLOATING
C4540 XLN3_N/G.n35 VGND 0.01476f ; **FLOATING
C4541 XLN3_N/G.n36 VGND 0.03932f ; **FLOATING
C4542 XLN3_N/G.n37 VGND 0.01662f ; **FLOATING
C4543 XLN3_N/G.n38 VGND 0.0348f ; **FLOATING
C4544 XLN3_N/D0.t0 VGND 0.1254f ; **FLOATING
C4545 XLN3_N/S1.t1 VGND 0.07819f ; **FLOATING
C4546 XLN3_N/S1.t0 VGND 0.07819f ; **FLOATING
C4547 XLN3_N/S1.n0 VGND 0.15638f ; **FLOATING
C4548 XLN3_N/D2.t0 VGND 0.07819f ; **FLOATING
C4549 XLN3_N/D2.t1 VGND 0.07819f ; **FLOATING
C4550 XLN3_N/D2.n0 VGND 0.15638f ; **FLOATING
C4551 XLN3_N/S3.t1 VGND 0.07819f ; **FLOATING
C4552 XLN3_N/S3.t0 VGND 0.07819f ; **FLOATING
C4553 XLN3_N/S3.n0 VGND 0.15638f ; **FLOATING
C4554 XLN3_N/D4.t0 VGND 0.07819f ; **FLOATING
C4555 XLN3_N/D4.t1 VGND 0.07819f ; **FLOATING
C4556 XLN3_N/D4.n0 VGND 0.15638f ; **FLOATING
C4557 XLN3_N/S5.t0 VGND 0.07819f ; **FLOATING
C4558 XLN3_N/S5.t1 VGND 0.07819f ; **FLOATING
C4559 XLN3_N/S5.n0 VGND 0.15638f ; **FLOATING
C4560 XLN3_N/D6.t1 VGND 0.07819f ; **FLOATING
C4561 XLN3_N/D6.t0 VGND 0.07819f ; **FLOATING
C4562 XLN3_N/D6.n0 VGND 0.15638f ; **FLOATING
C4563 XLN3_N/S7.t0 VGND 0.07819f ; **FLOATING
C4564 XLN3_N/S7.t1 VGND 0.07819f ; **FLOATING
C4565 XLN3_N/S7.n0 VGND 0.15638f ; **FLOATING
C4566 XLN3_N/D8.t0 VGND 0.07819f ; **FLOATING
C4567 XLN3_N/D8.t1 VGND 0.07819f ; **FLOATING
C4568 XLN3_N/D8.n0 VGND 0.15638f ; **FLOATING
C4569 XLN3_N/S8.t0 VGND 0.1254f ; **FLOATING
C4570 XCH2LN_P/B.n0 VGND 0.02385f ; **FLOATING
C4571 XCH2LN_P/B.n1 VGND 0.04765f ; **FLOATING
C4572 XCH2LN_P/B.n2 VGND 0.26426f ; **FLOATING
C4573 XCH2LN_P/B.n3 VGND 0.0461f ; **FLOATING
C4574 XCH2LN_P/B.t2 VGND 0.17216f ; **FLOATING
C4575 XCH2LN_P/B.n4 VGND 0.04765f ; **FLOATING
C4576 XCH2LN_P/B.n5 VGND 0.04765f ; **FLOATING
C4577 XCH2LN_P/B.t0 VGND 0.25476f ; **FLOATING
C4578 XCH2LN_P/B.t1 VGND 0.17216f ; **FLOATING
C4579 XCH2LN_P/B.t3 VGND 0.17216f ; **FLOATING
C4580 XCH2LN_P/B.t4 VGND 0.25476f ; **FLOATING
C4581 XCH2LN_P/B.n6 VGND 0.26426f ; **FLOATING
C4582 XCH2LN_P/B.n7 VGND 0.04738f ; **FLOATING
C4583 XCH2LN_P/G.n0 VGND 0.07604f ; **FLOATING
C4584 XCH2LN_P/G.n1 VGND 0.01025f ; **FLOATING
C4585 XCH2LN_P/G.n2 VGND 0.09845f ; **FLOATING
C4586 XCH2LN_P/G.n3 VGND 0.00854f ; **FLOATING
C4587 XCH2LN_P/G.n4 VGND 0.09845f ; **FLOATING
C4588 XCH2LN_P/G.n5 VGND 0.09845f ; **FLOATING
C4589 XCH2LN_P/G.n6 VGND 0.09845f ; **FLOATING
C4590 XCH2LN_P/G.t0 VGND 0.08936f ; **FLOATING
C4591 XCH2LN_P/G.n7 VGND 0.09959f ; **FLOATING
C4592 XCH2LN_P/G.t1 VGND 0.08936f ; **FLOATING
C4593 XCH2LN_P/G.n8 VGND 0.09845f ; **FLOATING
C4594 XCH2LN_P/G.n9 VGND 0.0277f ; **FLOATING
C4595 XCH2LN_P/G.t2 VGND 0.08936f ; **FLOATING
C4596 XCH2LN_P/G.n10 VGND 0.09845f ; **FLOATING
C4597 XCH2LN_P/G.n11 VGND 0.0277f ; **FLOATING
C4598 XCH2LN_P/G.t3 VGND 0.08936f ; **FLOATING
C4599 XCH2LN_P/G.n12 VGND 0.09845f ; **FLOATING
C4600 XCH2LN_P/G.n13 VGND 0.0277f ; **FLOATING
C4601 XCH2LN_P/G.t4 VGND 0.08936f ; **FLOATING
C4602 XCH2LN_P/G.n14 VGND 0.09959f ; **FLOATING
C4603 XCH2LN_P/G.n15 VGND 0.03784f ; **FLOATING
C4604 XCH2LN_P/G.n16 VGND 0.14544f ; **FLOATING
C4605 XCH2LN_P/G.n17 VGND 0.03784f ; **FLOATING
C4606 XCH2LN_P/G.n18 VGND 0.09845f ; **FLOATING
C4607 XCH2LN_P/D0.n0 VGND 0.19369f ; **FLOATING
C4608 XCH2LN_P/D0.t0 VGND 0.33005f ; **FLOATING
C4609 XCH2LN_P/S1.t0 VGND 0.13508f ; **FLOATING
C4610 XCH2LN_P/S1.t1 VGND 0.13508f ; **FLOATING
C4611 XCH2LN_P/S1.n0 VGND 0.27017f ; **FLOATING
C4612 XCH2LN_P/D2.n0 VGND 0.26834f ; **FLOATING
C4613 XCH2LN_P/D2.t1 VGND 0.13508f ; **FLOATING
C4614 XCH2LN_P/D2.t0 VGND 0.13508f ; **FLOATING
C4615 XCH2LN_P/D2.n1 VGND 0.27017f ; **FLOATING
C4616 XCH2LN_P/S3.t0 VGND 0.13508f ; **FLOATING
C4617 XCH2LN_P/S3.t1 VGND 0.13508f ; **FLOATING
C4618 XCH2LN_P/S3.n0 VGND 0.27017f ; **FLOATING
C4619 XCH2LN_P/D4.n0 VGND 0.26834f ; **FLOATING
C4620 XCH2LN_P/D4.t0 VGND 0.13508f ; **FLOATING
C4621 XCH2LN_P/D4.t1 VGND 0.13508f ; **FLOATING
C4622 XCH2LN_P/D4.n1 VGND 0.27017f ; **FLOATING
C4623 XCH2LN_P/S4.t0 VGND 0.33005f ; **FLOATING
C4624 XCH2LN_N/G.n0 VGND 0.03309f ; **FLOATING
C4625 XCH2LN_N/G.n1 VGND 0.00446f ; **FLOATING
C4626 XCH2LN_N/G.n2 VGND 0.03348f ; **FLOATING
C4627 XCH2LN_N/G.n3 VGND 0.00371f ; **FLOATING
C4628 XCH2LN_N/G.n4 VGND 0.03348f ; **FLOATING
C4629 XCH2LN_N/G.n5 VGND 0.03348f ; **FLOATING
C4630 XCH2LN_N/G.n6 VGND 0.03348f ; **FLOATING
C4631 XCH2LN_N/G.t0 VGND 0.02016f ; **FLOATING
C4632 XCH2LN_N/G.n7 VGND 0.03397f ; **FLOATING
C4633 XCH2LN_N/G.t1 VGND 0.02016f ; **FLOATING
C4634 XCH2LN_N/G.n8 VGND 0.03348f ; **FLOATING
C4635 XCH2LN_N/G.n9 VGND 0.01205f ; **FLOATING
C4636 XCH2LN_N/G.t2 VGND 0.02016f ; **FLOATING
C4637 XCH2LN_N/G.n10 VGND 0.03348f ; **FLOATING
C4638 XCH2LN_N/G.n11 VGND 0.01205f ; **FLOATING
C4639 XCH2LN_N/G.t3 VGND 0.02016f ; **FLOATING
C4640 XCH2LN_N/G.n12 VGND 0.03348f ; **FLOATING
C4641 XCH2LN_N/G.n13 VGND 0.01205f ; **FLOATING
C4642 XCH2LN_N/G.t4 VGND 0.02016f ; **FLOATING
C4643 XCH2LN_N/G.n14 VGND 0.03397f ; **FLOATING
C4644 XCH2LN_N/G.n15 VGND 0.01647f ; **FLOATING
C4645 XCH2LN_N/G.n16 VGND 0.06329f ; **FLOATING
C4646 XCH2LN_N/G.n17 VGND 0.01647f ; **FLOATING
C4647 XCH2LN_N/G.n18 VGND 0.03348f ; **FLOATING
C4648 XCH2LN_N/D0.n0 VGND 0.03483f ; **FLOATING
C4649 XCH2LN_N/D0.t0 VGND 0.11646f ; **FLOATING
C4650 XCH2LN_N/S1.t0 VGND 0.07135f ; **FLOATING
C4651 XCH2LN_N/S1.t1 VGND 0.07135f ; **FLOATING
C4652 XCH2LN_N/S1.n0 VGND 0.1427f ; **FLOATING
C4653 XCH2LN_N/D2.n0 VGND 0.06775f ; **FLOATING
C4654 XCH2LN_N/D2.t0 VGND 0.07135f ; **FLOATING
C4655 XCH2LN_N/D2.t1 VGND 0.07135f ; **FLOATING
C4656 XCH2LN_N/D2.n1 VGND 0.1427f ; **FLOATING
C4657 XCH2LN_N/S3.t1 VGND 0.07135f ; **FLOATING
C4658 XCH2LN_N/S3.t0 VGND 0.07135f ; **FLOATING
C4659 XCH2LN_N/S3.n0 VGND 0.1427f ; **FLOATING
C4660 XCH2LN_N/D4.n0 VGND 0.06775f ; **FLOATING
C4661 XCH2LN_N/D4.t0 VGND 0.07135f ; **FLOATING
C4662 XCH2LN_N/D4.t1 VGND 0.07135f ; **FLOATING
C4663 XCH2LN_N/D4.n1 VGND 0.1427f ; **FLOATING
C4664 XCH2LN_N/S4.t0 VGND 0.11646f ; **FLOATING
C4665 XCH2_SW1B/G.n0 VGND 0.03309f ; **FLOATING
C4666 XCH2_SW1B/G.n1 VGND 0.00446f ; **FLOATING
C4667 XCH2_SW1B/G.n2 VGND 0.03348f ; **FLOATING
C4668 XCH2_SW1B/G.n3 VGND 0.00371f ; **FLOATING
C4669 XCH2_SW1B/G.n4 VGND 0.03348f ; **FLOATING
C4670 XCH2_SW1B/G.n5 VGND 0.03348f ; **FLOATING
C4671 XCH2_SW1B/G.n6 VGND 0.03348f ; **FLOATING
C4672 XCH2_SW1B/G.t0 VGND 0.02016f ; **FLOATING
C4673 XCH2_SW1B/G.n7 VGND 0.03397f ; **FLOATING
C4674 XCH2_SW1B/G.t1 VGND 0.02016f ; **FLOATING
C4675 XCH2_SW1B/G.n8 VGND 0.03348f ; **FLOATING
C4676 XCH2_SW1B/G.n9 VGND 0.01205f ; **FLOATING
C4677 XCH2_SW1B/G.t2 VGND 0.02016f ; **FLOATING
C4678 XCH2_SW1B/G.n10 VGND 0.03348f ; **FLOATING
C4679 XCH2_SW1B/G.n11 VGND 0.01205f ; **FLOATING
C4680 XCH2_SW1B/G.t3 VGND 0.02016f ; **FLOATING
C4681 XCH2_SW1B/G.n12 VGND 0.03348f ; **FLOATING
C4682 XCH2_SW1B/G.n13 VGND 0.01205f ; **FLOATING
C4683 XCH2_SW1B/G.t4 VGND 0.02016f ; **FLOATING
C4684 XCH2_SW1B/G.n14 VGND 0.03397f ; **FLOATING
C4685 XCH2_SW1B/G.n15 VGND 0.01647f ; **FLOATING
C4686 XCH2_SW1B/G.n16 VGND 0.06329f ; **FLOATING
C4687 XCH2_SW1B/G.n17 VGND 0.01647f ; **FLOATING
C4688 XCH2_SW1B/G.n18 VGND 0.03348f ; **FLOATING
C4689 XCH2_SW1B/D0.n0 VGND 0.03483f ; **FLOATING
C4690 XCH2_SW1B/D0.t0 VGND 0.11646f ; **FLOATING
C4691 XCH2_SW1B/S1.t0 VGND 0.07135f ; **FLOATING
C4692 XCH2_SW1B/S1.t1 VGND 0.07135f ; **FLOATING
C4693 XCH2_SW1B/S1.n0 VGND 0.1427f ; **FLOATING
C4694 XCH2_SW1B/D2.n0 VGND 0.06775f ; **FLOATING
C4695 XCH2_SW1B/D2.t0 VGND 0.07135f ; **FLOATING
C4696 XCH2_SW1B/D2.t1 VGND 0.07135f ; **FLOATING
C4697 XCH2_SW1B/D2.n1 VGND 0.1427f ; **FLOATING
C4698 XCH2_SW1B/S3.t1 VGND 0.07135f ; **FLOATING
C4699 XCH2_SW1B/S3.t0 VGND 0.07135f ; **FLOATING
C4700 XCH2_SW1B/S3.n0 VGND 0.1427f ; **FLOATING
C4701 XCH2_SW1B/D4.n0 VGND 0.06775f ; **FLOATING
C4702 XCH2_SW1B/D4.t0 VGND 0.07135f ; **FLOATING
C4703 XCH2_SW1B/D4.t1 VGND 0.07135f ; **FLOATING
C4704 XCH2_SW1B/D4.n1 VGND 0.1427f ; **FLOATING
C4705 XCH2_SW1B/S4.t0 VGND 0.11646f ; **FLOATING
C4706 XCH1_TAILB/G.n0 VGND 0.01076f ; **FLOATING
C4707 XCH1_TAILB/G.n1 VGND 0.0185f ; **FLOATING
C4708 XCH1_TAILB/G.n2 VGND 0.04382f ; **FLOATING
C4709 XCH1_TAILB/G.n3 VGND 0.01076f ; **FLOATING
C4710 XCH1_TAILB/G.n4 VGND 0.01076f ; **FLOATING
C4711 XCH1_TAILB/G.n5 VGND 0.04382f ; **FLOATING
C4712 XCH1_TAILB/G.n6 VGND 0.01738f ; **FLOATING
C4713 XCH1_TAILB/G.t0 VGND 0.12842f ; **FLOATING
C4714 XCH1_TAILB/G.t8 VGND 0.12842f ; **FLOATING
C4715 XCH1_TAILB/G.n7 VGND 0.04775f ; **FLOATING
C4716 XCH1_TAILB/G.n8 VGND 0.03705f ; **FLOATING
C4717 XCH1_TAILB/G.n9 VGND 0.03705f ; **FLOATING
C4718 XCH1_TAILB/G.n10 VGND 0.04382f ; **FLOATING
C4719 XCH1_TAILB/G.n11 VGND 0.03705f ; **FLOATING
C4720 XCH1_TAILB/G.n12 VGND 0.0185f ; **FLOATING
C4721 XCH1_TAILB/G.n13 VGND 0.03705f ; **FLOATING
C4722 XCH1_TAILB/G.n14 VGND 0.0185f ; **FLOATING
C4723 XCH1_TAILB/G.n15 VGND 0.03705f ; **FLOATING
C4724 XCH1_TAILB/G.n16 VGND 0.0185f ; **FLOATING
C4725 XCH1_TAILB/G.n17 VGND 0.03705f ; **FLOATING
C4726 XCH1_TAILB/G.n18 VGND 0.04382f ; **FLOATING
C4727 XCH1_TAILB/G.n19 VGND 0.03705f ; **FLOATING
C4728 XCH1_TAILB/G.n20 VGND 0.04775f ; **FLOATING
C4729 XCH1_TAILB/G.t7 VGND 0.12744f ; **FLOATING
C4730 XCH1_TAILB/G.t6 VGND 0.12744f ; **FLOATING
C4731 XCH1_TAILB/G.t5 VGND 0.12744f ; **FLOATING
C4732 XCH1_TAILB/G.t4 VGND 0.12744f ; **FLOATING
C4733 XCH1_TAILB/G.t3 VGND 0.12744f ; **FLOATING
C4734 XCH1_TAILB/G.t2 VGND 0.12744f ; **FLOATING
C4735 XCH1_TAILB/G.t1 VGND 0.12744f ; **FLOATING
C4736 XCH1_TAILB/D0.n0 VGND 0.08968f ; **FLOATING
C4737 XCH1_TAILB/D0.t0 VGND 0.11121f ; **FLOATING
C4738 XCH1_TAILB/S1.t0 VGND 0.06606f ; **FLOATING
C4739 XCH1_TAILB/S1.t1 VGND 0.06606f ; **FLOATING
C4740 XCH1_TAILB/S1.n0 VGND 0.13212f ; **FLOATING
C4741 XCH1_TAILB/D2.n0 VGND 0.17937f ; **FLOATING
C4742 XCH1_TAILB/D2.t1 VGND 0.06606f ; **FLOATING
C4743 XCH1_TAILB/D2.t0 VGND 0.06606f ; **FLOATING
C4744 XCH1_TAILB/D2.n1 VGND 0.13212f ; **FLOATING
C4745 XCH1_TAILB/S3.t1 VGND 0.06606f ; **FLOATING
C4746 XCH1_TAILB/S3.t0 VGND 0.06606f ; **FLOATING
C4747 XCH1_TAILB/S3.n0 VGND 0.13212f ; **FLOATING
C4748 XCH1_TAILB/D4.n0 VGND 0.17937f ; **FLOATING
C4749 XCH1_TAILB/D4.t1 VGND 0.06606f ; **FLOATING
C4750 XCH1_TAILB/D4.t0 VGND 0.06606f ; **FLOATING
C4751 XCH1_TAILB/D4.n1 VGND 0.13212f ; **FLOATING
C4752 XCH1_TAILB/S5.t0 VGND 0.06606f ; **FLOATING
C4753 XCH1_TAILB/S5.t1 VGND 0.06606f ; **FLOATING
C4754 XCH1_TAILB/S5.n0 VGND 0.13212f ; **FLOATING
C4755 XCH1_TAILB/D6.n0 VGND 0.17937f ; **FLOATING
C4756 XCH1_TAILB/D6.t1 VGND 0.06606f ; **FLOATING
C4757 XCH1_TAILB/D6.t0 VGND 0.06606f ; **FLOATING
C4758 XCH1_TAILB/D6.n1 VGND 0.13212f ; **FLOATING
C4759 XCH1_TAILB/S7.t0 VGND 0.06606f ; **FLOATING
C4760 XCH1_TAILB/S7.t1 VGND 0.06606f ; **FLOATING
C4761 XCH1_TAILB/S7.n0 VGND 0.13212f ; **FLOATING
C4762 XCH1_TAILB/D8.n0 VGND 0.17937f ; **FLOATING
C4763 XCH1_TAILB/D8.t1 VGND 0.06606f ; **FLOATING
C4764 XCH1_TAILB/D8.t0 VGND 0.06606f ; **FLOATING
C4765 XCH1_TAILB/D8.n1 VGND 0.13212f ; **FLOATING
C4766 XCH1_TAILB/S8.t0 VGND 0.11121f ; **FLOATING
C4767 VDPWR VGND 0.14869p
C4768 XLP1_P/B.n0 VGND 0.01611f ; **FLOATING
C4769 XLP1_P/B.n1 VGND 0.03212f ; **FLOATING
C4770 XLP1_P/B.n2 VGND 0.17206f ; **FLOATING
C4771 XLP1_P/B.n3 VGND 0.03072f ; **FLOATING
C4772 XLP1_P/B.t1 VGND 0.11447f ; **FLOATING
C4773 XLP1_P/B.n4 VGND 0.03212f ; **FLOATING
C4774 XLP1_P/B.n5 VGND 0.03212f ; **FLOATING
C4775 XLP1_P/B.t0 VGND 0.17357f ; **FLOATING
C4776 XLP1_P/B.t2 VGND 0.17357f ; **FLOATING
C4777 XLP1_P/B.n6 VGND 0.17206f ; **FLOATING
C4778 XLP1_P/B.n7 VGND 0.03203f ; **FLOATING
C4779 XLP1_P/G.n0 VGND 0.00171f ; **FLOATING
C4780 XLP1_P/G.n1 VGND 0.08731f ; **FLOATING
C4781 XLP1_P/G.n2 VGND 0.08731f ; **FLOATING
C4782 XLP1_P/G.t0 VGND 0.07224f ; **FLOATING
C4783 XLP1_P/G.n3 VGND 0.42819f ; **FLOATING
C4784 XLP1_P/G.t1 VGND 0.05085f ; **FLOATING
C4785 XLP1_P/G.t2 VGND 0.07224f ; **FLOATING
C4786 XLP1_P/G.n4 VGND 0.08731f ; **FLOATING
C4787 XLP1_P/D0.n0 VGND 0.11881f ; **FLOATING
C4788 XLP1_P/D0.t0 VGND 0.14921f ; **FLOATING
C4789 XLP1_P/S1.n0 VGND 0.16046f ; **FLOATING
C4790 XLP1_P/S1.t1 VGND 0.06187f ; **FLOATING
C4791 XLP1_P/S1.t0 VGND 0.06187f ; **FLOATING
C4792 XLP1_P/S1.n1 VGND 0.12375f ; **FLOATING
C4793 XLP1_P/D2.n0 VGND 0.16567f ; **FLOATING
C4794 XLP1_P/D2.t1 VGND 0.06187f ; **FLOATING
C4795 XLP1_P/D2.t0 VGND 0.06187f ; **FLOATING
C4796 XLP1_P/D2.n1 VGND 0.12375f ; **FLOATING
C4797 XLP1_P/S2.n0 VGND 0.11507f ; **FLOATING
C4798 XLP1_P/S2.t0 VGND 0.14921f ; **FLOATING
C4799 XCH2LP_P/B.n0 VGND 0.02385f ; **FLOATING
C4800 XCH2LP_P/B.n1 VGND 0.04765f ; **FLOATING
C4801 XCH2LP_P/B.n2 VGND 0.26426f ; **FLOATING
C4802 XCH2LP_P/B.n3 VGND 0.0461f ; **FLOATING
C4803 XCH2LP_P/B.t2 VGND 0.17216f ; **FLOATING
C4804 XCH2LP_P/B.n4 VGND 0.04765f ; **FLOATING
C4805 XCH2LP_P/B.n5 VGND 0.04765f ; **FLOATING
C4806 XCH2LP_P/B.t0 VGND 0.25476f ; **FLOATING
C4807 XCH2LP_P/B.t1 VGND 0.17216f ; **FLOATING
C4808 XCH2LP_P/B.t3 VGND 0.17216f ; **FLOATING
C4809 XCH2LP_P/B.t4 VGND 0.25476f ; **FLOATING
C4810 XCH2LP_P/B.n6 VGND 0.26426f ; **FLOATING
C4811 XCH2LP_P/B.n7 VGND 0.04738f ; **FLOATING
C4812 XCH2LP_P/G.n0 VGND 0.07604f ; **FLOATING
C4813 XCH2LP_P/G.n1 VGND 0.01025f ; **FLOATING
C4814 XCH2LP_P/G.n2 VGND 0.09845f ; **FLOATING
C4815 XCH2LP_P/G.n3 VGND 0.00854f ; **FLOATING
C4816 XCH2LP_P/G.n4 VGND 0.09845f ; **FLOATING
C4817 XCH2LP_P/G.n5 VGND 0.09845f ; **FLOATING
C4818 XCH2LP_P/G.n6 VGND 0.09845f ; **FLOATING
C4819 XCH2LP_P/G.t0 VGND 0.08936f ; **FLOATING
C4820 XCH2LP_P/G.n7 VGND 0.09959f ; **FLOATING
C4821 XCH2LP_P/G.t1 VGND 0.08936f ; **FLOATING
C4822 XCH2LP_P/G.n8 VGND 0.09845f ; **FLOATING
C4823 XCH2LP_P/G.n9 VGND 0.0277f ; **FLOATING
C4824 XCH2LP_P/G.t2 VGND 0.08936f ; **FLOATING
C4825 XCH2LP_P/G.n10 VGND 0.09845f ; **FLOATING
C4826 XCH2LP_P/G.n11 VGND 0.0277f ; **FLOATING
C4827 XCH2LP_P/G.t3 VGND 0.08936f ; **FLOATING
C4828 XCH2LP_P/G.n12 VGND 0.09845f ; **FLOATING
C4829 XCH2LP_P/G.n13 VGND 0.0277f ; **FLOATING
C4830 XCH2LP_P/G.t4 VGND 0.08936f ; **FLOATING
C4831 XCH2LP_P/G.n14 VGND 0.09959f ; **FLOATING
C4832 XCH2LP_P/G.n15 VGND 0.03784f ; **FLOATING
C4833 XCH2LP_P/G.n16 VGND 0.14544f ; **FLOATING
C4834 XCH2LP_P/G.n17 VGND 0.03784f ; **FLOATING
C4835 XCH2LP_P/G.n18 VGND 0.09845f ; **FLOATING
C4836 XCH2LP_P/D0.n0 VGND 0.19369f ; **FLOATING
C4837 XCH2LP_P/D0.t0 VGND 0.33005f ; **FLOATING
C4838 XCH2LP_P/S1.t0 VGND 0.13508f ; **FLOATING
C4839 XCH2LP_P/S1.t1 VGND 0.13508f ; **FLOATING
C4840 XCH2LP_P/S1.n0 VGND 0.27017f ; **FLOATING
C4841 XCH2LP_P/D2.n0 VGND 0.26834f ; **FLOATING
C4842 XCH2LP_P/D2.t1 VGND 0.13508f ; **FLOATING
C4843 XCH2LP_P/D2.t0 VGND 0.13508f ; **FLOATING
C4844 XCH2LP_P/D2.n1 VGND 0.27017f ; **FLOATING
C4845 XCH2LP_P/S3.t0 VGND 0.13508f ; **FLOATING
C4846 XCH2LP_P/S3.t1 VGND 0.13508f ; **FLOATING
C4847 XCH2LP_P/S3.n0 VGND 0.27017f ; **FLOATING
C4848 XCH2LP_P/D4.n0 VGND 0.26834f ; **FLOATING
C4849 XCH2LP_P/D4.t0 VGND 0.13508f ; **FLOATING
C4850 XCH2LP_P/D4.t1 VGND 0.13508f ; **FLOATING
C4851 XCH2LP_P/D4.n1 VGND 0.27017f ; **FLOATING
C4852 XCH2LP_P/S4.t0 VGND 0.33005f ; **FLOATING
C4853 XCH2_SW2B/G.n0 VGND 0.03309f ; **FLOATING
C4854 XCH2_SW2B/G.n1 VGND 0.00446f ; **FLOATING
C4855 XCH2_SW2B/G.n2 VGND 0.03348f ; **FLOATING
C4856 XCH2_SW2B/G.n3 VGND 0.00371f ; **FLOATING
C4857 XCH2_SW2B/G.n4 VGND 0.03348f ; **FLOATING
C4858 XCH2_SW2B/G.n5 VGND 0.03348f ; **FLOATING
C4859 XCH2_SW2B/G.n6 VGND 0.03348f ; **FLOATING
C4860 XCH2_SW2B/G.t0 VGND 0.02016f ; **FLOATING
C4861 XCH2_SW2B/G.n7 VGND 0.03397f ; **FLOATING
C4862 XCH2_SW2B/G.t1 VGND 0.02016f ; **FLOATING
C4863 XCH2_SW2B/G.n8 VGND 0.03348f ; **FLOATING
C4864 XCH2_SW2B/G.n9 VGND 0.01205f ; **FLOATING
C4865 XCH2_SW2B/G.t2 VGND 0.02016f ; **FLOATING
C4866 XCH2_SW2B/G.n10 VGND 0.03348f ; **FLOATING
C4867 XCH2_SW2B/G.n11 VGND 0.01205f ; **FLOATING
C4868 XCH2_SW2B/G.t3 VGND 0.02016f ; **FLOATING
C4869 XCH2_SW2B/G.n12 VGND 0.03348f ; **FLOATING
C4870 XCH2_SW2B/G.n13 VGND 0.01205f ; **FLOATING
C4871 XCH2_SW2B/G.t4 VGND 0.02016f ; **FLOATING
C4872 XCH2_SW2B/G.n14 VGND 0.03397f ; **FLOATING
C4873 XCH2_SW2B/G.n15 VGND 0.01647f ; **FLOATING
C4874 XCH2_SW2B/G.n16 VGND 0.06329f ; **FLOATING
C4875 XCH2_SW2B/G.n17 VGND 0.01647f ; **FLOATING
C4876 XCH2_SW2B/G.n18 VGND 0.03348f ; **FLOATING
C4877 XCH2_SW2B/D0.n0 VGND 0.03483f ; **FLOATING
C4878 XCH2_SW2B/D0.t0 VGND 0.11646f ; **FLOATING
C4879 XCH2_SW2B/S1.t0 VGND 0.07135f ; **FLOATING
C4880 XCH2_SW2B/S1.t1 VGND 0.07135f ; **FLOATING
C4881 XCH2_SW2B/S1.n0 VGND 0.1427f ; **FLOATING
C4882 XCH2_SW2B/D2.n0 VGND 0.06775f ; **FLOATING
C4883 XCH2_SW2B/D2.t0 VGND 0.07135f ; **FLOATING
C4884 XCH2_SW2B/D2.t1 VGND 0.07135f ; **FLOATING
C4885 XCH2_SW2B/D2.n1 VGND 0.1427f ; **FLOATING
C4886 XCH2_SW2B/S3.t1 VGND 0.07135f ; **FLOATING
C4887 XCH2_SW2B/S3.t0 VGND 0.07135f ; **FLOATING
C4888 XCH2_SW2B/S3.n0 VGND 0.1427f ; **FLOATING
C4889 XCH2_SW2B/D4.n0 VGND 0.06775f ; **FLOATING
C4890 XCH2_SW2B/D4.t0 VGND 0.07135f ; **FLOATING
C4891 XCH2_SW2B/D4.t1 VGND 0.07135f ; **FLOATING
C4892 XCH2_SW2B/D4.n1 VGND 0.1427f ; **FLOATING
C4893 XCH2_SW2B/S4.t0 VGND 0.11646f ; **FLOATING
C4894 ch2_lop VGND 42.79408f
C4895 XCH2_SW1A/G.n0 VGND 0.03309f ; **FLOATING
C4896 XCH2_SW1A/G.n1 VGND 0.00446f ; **FLOATING
C4897 XCH2_SW1A/G.n2 VGND 0.03348f ; **FLOATING
C4898 XCH2_SW1A/G.n3 VGND 0.00371f ; **FLOATING
C4899 XCH2_SW1A/G.n4 VGND 0.03348f ; **FLOATING
C4900 XCH2_SW1A/G.n5 VGND 0.03348f ; **FLOATING
C4901 XCH2_SW1A/G.n6 VGND 0.03348f ; **FLOATING
C4902 XCH2_SW1A/G.t0 VGND 0.02016f ; **FLOATING
C4903 XCH2_SW1A/G.n7 VGND 0.03397f ; **FLOATING
C4904 XCH2_SW1A/G.t1 VGND 0.02016f ; **FLOATING
C4905 XCH2_SW1A/G.n8 VGND 0.03348f ; **FLOATING
C4906 XCH2_SW1A/G.n9 VGND 0.01205f ; **FLOATING
C4907 XCH2_SW1A/G.t2 VGND 0.02016f ; **FLOATING
C4908 XCH2_SW1A/G.n10 VGND 0.03348f ; **FLOATING
C4909 XCH2_SW1A/G.n11 VGND 0.01205f ; **FLOATING
C4910 XCH2_SW1A/G.t3 VGND 0.02016f ; **FLOATING
C4911 XCH2_SW1A/G.n12 VGND 0.03348f ; **FLOATING
C4912 XCH2_SW1A/G.n13 VGND 0.01205f ; **FLOATING
C4913 XCH2_SW1A/G.t4 VGND 0.02016f ; **FLOATING
C4914 XCH2_SW1A/G.n14 VGND 0.03397f ; **FLOATING
C4915 XCH2_SW1A/G.n15 VGND 0.01647f ; **FLOATING
C4916 XCH2_SW1A/G.n16 VGND 0.06329f ; **FLOATING
C4917 XCH2_SW1A/G.n17 VGND 0.01647f ; **FLOATING
C4918 XCH2_SW1A/G.n18 VGND 0.03348f ; **FLOATING
C4919 XCH2_SW1A/D0.n0 VGND 0.03483f ; **FLOATING
C4920 XCH2_SW1A/D0.t0 VGND 0.11646f ; **FLOATING
C4921 XCH2_SW1A/S1.t0 VGND 0.07135f ; **FLOATING
C4922 XCH2_SW1A/S1.t1 VGND 0.07135f ; **FLOATING
C4923 XCH2_SW1A/S1.n0 VGND 0.1427f ; **FLOATING
C4924 XCH2_SW1A/D2.n0 VGND 0.06775f ; **FLOATING
C4925 XCH2_SW1A/D2.t0 VGND 0.07135f ; **FLOATING
C4926 XCH2_SW1A/D2.t1 VGND 0.07135f ; **FLOATING
C4927 XCH2_SW1A/D2.n1 VGND 0.1427f ; **FLOATING
C4928 XCH2_SW1A/S3.t1 VGND 0.07135f ; **FLOATING
C4929 XCH2_SW1A/S3.t0 VGND 0.07135f ; **FLOATING
C4930 XCH2_SW1A/S3.n0 VGND 0.1427f ; **FLOATING
C4931 XCH2_SW1A/D4.n0 VGND 0.06775f ; **FLOATING
C4932 XCH2_SW1A/D4.t0 VGND 0.07135f ; **FLOATING
C4933 XCH2_SW1A/D4.t1 VGND 0.07135f ; **FLOATING
C4934 XCH2_SW1A/D4.n1 VGND 0.1427f ; **FLOATING
C4935 XCH2_SW1A/S4.t0 VGND 0.11646f ; **FLOATING
C4936 vbias VGND 70.39903f
C4937 XCH1_TAILA/G.n0 VGND 0.01076f ; **FLOATING
C4938 XCH1_TAILA/G.n1 VGND 0.0185f ; **FLOATING
C4939 XCH1_TAILA/G.n2 VGND 0.04382f ; **FLOATING
C4940 XCH1_TAILA/G.n3 VGND 0.01076f ; **FLOATING
C4941 XCH1_TAILA/G.n4 VGND 0.01076f ; **FLOATING
C4942 XCH1_TAILA/G.n5 VGND 0.04382f ; **FLOATING
C4943 XCH1_TAILA/G.n6 VGND 0.01738f ; **FLOATING
C4944 XCH1_TAILA/G.t0 VGND 0.12842f ; **FLOATING
C4945 XCH1_TAILA/G.t8 VGND 0.12842f ; **FLOATING
C4946 XCH1_TAILA/G.n7 VGND 0.04775f ; **FLOATING
C4947 XCH1_TAILA/G.n8 VGND 0.03705f ; **FLOATING
C4948 XCH1_TAILA/G.n9 VGND 0.03705f ; **FLOATING
C4949 XCH1_TAILA/G.n10 VGND 0.04382f ; **FLOATING
C4950 XCH1_TAILA/G.n11 VGND 0.03705f ; **FLOATING
C4951 XCH1_TAILA/G.n12 VGND 0.0185f ; **FLOATING
C4952 XCH1_TAILA/G.n13 VGND 0.03705f ; **FLOATING
C4953 XCH1_TAILA/G.n14 VGND 0.0185f ; **FLOATING
C4954 XCH1_TAILA/G.n15 VGND 0.03705f ; **FLOATING
C4955 XCH1_TAILA/G.n16 VGND 0.0185f ; **FLOATING
C4956 XCH1_TAILA/G.n17 VGND 0.03705f ; **FLOATING
C4957 XCH1_TAILA/G.n18 VGND 0.04382f ; **FLOATING
C4958 XCH1_TAILA/G.n19 VGND 0.03705f ; **FLOATING
C4959 XCH1_TAILA/G.n20 VGND 0.04775f ; **FLOATING
C4960 XCH1_TAILA/G.t7 VGND 0.12744f ; **FLOATING
C4961 XCH1_TAILA/G.t6 VGND 0.12744f ; **FLOATING
C4962 XCH1_TAILA/G.t5 VGND 0.12744f ; **FLOATING
C4963 XCH1_TAILA/G.t4 VGND 0.12744f ; **FLOATING
C4964 XCH1_TAILA/G.t3 VGND 0.12744f ; **FLOATING
C4965 XCH1_TAILA/G.t2 VGND 0.12744f ; **FLOATING
C4966 XCH1_TAILA/G.t1 VGND 0.12744f ; **FLOATING
C4967 XCH1_TAILA/D0.n0 VGND 0.08968f ; **FLOATING
C4968 XCH1_TAILA/D0.t0 VGND 0.11121f ; **FLOATING
C4969 XCH1_TAILA/S1.t0 VGND 0.06606f ; **FLOATING
C4970 XCH1_TAILA/S1.t1 VGND 0.06606f ; **FLOATING
C4971 XCH1_TAILA/S1.n0 VGND 0.13212f ; **FLOATING
C4972 XCH1_TAILA/D2.n0 VGND 0.17937f ; **FLOATING
C4973 XCH1_TAILA/D2.t1 VGND 0.06606f ; **FLOATING
C4974 XCH1_TAILA/D2.t0 VGND 0.06606f ; **FLOATING
C4975 XCH1_TAILA/D2.n1 VGND 0.13212f ; **FLOATING
C4976 XCH1_TAILA/S3.t1 VGND 0.06606f ; **FLOATING
C4977 XCH1_TAILA/S3.t0 VGND 0.06606f ; **FLOATING
C4978 XCH1_TAILA/S3.n0 VGND 0.13212f ; **FLOATING
C4979 XCH1_TAILA/D4.n0 VGND 0.17937f ; **FLOATING
C4980 XCH1_TAILA/D4.t1 VGND 0.06606f ; **FLOATING
C4981 XCH1_TAILA/D4.t0 VGND 0.06606f ; **FLOATING
C4982 XCH1_TAILA/D4.n1 VGND 0.13212f ; **FLOATING
C4983 XCH1_TAILA/S5.t0 VGND 0.06606f ; **FLOATING
C4984 XCH1_TAILA/S5.t1 VGND 0.06606f ; **FLOATING
C4985 XCH1_TAILA/S5.n0 VGND 0.13212f ; **FLOATING
C4986 XCH1_TAILA/D6.n0 VGND 0.17937f ; **FLOATING
C4987 XCH1_TAILA/D6.t1 VGND 0.06606f ; **FLOATING
C4988 XCH1_TAILA/D6.t0 VGND 0.06606f ; **FLOATING
C4989 XCH1_TAILA/D6.n1 VGND 0.13212f ; **FLOATING
C4990 XCH1_TAILA/S7.t0 VGND 0.06606f ; **FLOATING
C4991 XCH1_TAILA/S7.t1 VGND 0.06606f ; **FLOATING
C4992 XCH1_TAILA/S7.n0 VGND 0.13212f ; **FLOATING
C4993 XCH1_TAILA/D8.n0 VGND 0.17937f ; **FLOATING
C4994 XCH1_TAILA/D8.t1 VGND 0.06606f ; **FLOATING
C4995 XCH1_TAILA/D8.t0 VGND 0.06606f ; **FLOATING
C4996 XCH1_TAILA/D8.n1 VGND 0.13212f ; **FLOATING
C4997 XCH1_TAILA/S8.t0 VGND 0.11121f ; **FLOATING
C4998 XCH2_TAILB/G.n0 VGND 0.01076f ; **FLOATING
C4999 XCH2_TAILB/G.n1 VGND 0.0185f ; **FLOATING
C5000 XCH2_TAILB/G.n2 VGND 0.04382f ; **FLOATING
C5001 XCH2_TAILB/G.n3 VGND 0.01076f ; **FLOATING
C5002 XCH2_TAILB/G.n4 VGND 0.01076f ; **FLOATING
C5003 XCH2_TAILB/G.n5 VGND 0.04382f ; **FLOATING
C5004 XCH2_TAILB/G.n6 VGND 0.01738f ; **FLOATING
C5005 XCH2_TAILB/G.t0 VGND 0.12842f ; **FLOATING
C5006 XCH2_TAILB/G.t8 VGND 0.12842f ; **FLOATING
C5007 XCH2_TAILB/G.n7 VGND 0.04775f ; **FLOATING
C5008 XCH2_TAILB/G.n8 VGND 0.03705f ; **FLOATING
C5009 XCH2_TAILB/G.n9 VGND 0.03705f ; **FLOATING
C5010 XCH2_TAILB/G.n10 VGND 0.04382f ; **FLOATING
C5011 XCH2_TAILB/G.n11 VGND 0.03705f ; **FLOATING
C5012 XCH2_TAILB/G.n12 VGND 0.0185f ; **FLOATING
C5013 XCH2_TAILB/G.n13 VGND 0.03705f ; **FLOATING
C5014 XCH2_TAILB/G.n14 VGND 0.0185f ; **FLOATING
C5015 XCH2_TAILB/G.n15 VGND 0.03705f ; **FLOATING
C5016 XCH2_TAILB/G.n16 VGND 0.0185f ; **FLOATING
C5017 XCH2_TAILB/G.n17 VGND 0.03705f ; **FLOATING
C5018 XCH2_TAILB/G.n18 VGND 0.04382f ; **FLOATING
C5019 XCH2_TAILB/G.n19 VGND 0.03705f ; **FLOATING
C5020 XCH2_TAILB/G.n20 VGND 0.04775f ; **FLOATING
C5021 XCH2_TAILB/G.t7 VGND 0.12744f ; **FLOATING
C5022 XCH2_TAILB/G.t6 VGND 0.12744f ; **FLOATING
C5023 XCH2_TAILB/G.t5 VGND 0.12744f ; **FLOATING
C5024 XCH2_TAILB/G.t4 VGND 0.12744f ; **FLOATING
C5025 XCH2_TAILB/G.t3 VGND 0.12744f ; **FLOATING
C5026 XCH2_TAILB/G.t2 VGND 0.12744f ; **FLOATING
C5027 XCH2_TAILB/G.t1 VGND 0.12744f ; **FLOATING
C5028 XCH2_TAILB/D0.n0 VGND 0.08968f ; **FLOATING
C5029 XCH2_TAILB/D0.t0 VGND 0.11121f ; **FLOATING
C5030 XCH2_TAILB/S1.t0 VGND 0.06606f ; **FLOATING
C5031 XCH2_TAILB/S1.t1 VGND 0.06606f ; **FLOATING
C5032 XCH2_TAILB/S1.n0 VGND 0.13212f ; **FLOATING
C5033 XCH2_TAILB/D2.n0 VGND 0.17937f ; **FLOATING
C5034 XCH2_TAILB/D2.t1 VGND 0.06606f ; **FLOATING
C5035 XCH2_TAILB/D2.t0 VGND 0.06606f ; **FLOATING
C5036 XCH2_TAILB/D2.n1 VGND 0.13212f ; **FLOATING
C5037 XCH2_TAILB/S3.t1 VGND 0.06606f ; **FLOATING
C5038 XCH2_TAILB/S3.t0 VGND 0.06606f ; **FLOATING
C5039 XCH2_TAILB/S3.n0 VGND 0.13212f ; **FLOATING
C5040 XCH2_TAILB/D4.n0 VGND 0.17937f ; **FLOATING
C5041 XCH2_TAILB/D4.t1 VGND 0.06606f ; **FLOATING
C5042 XCH2_TAILB/D4.t0 VGND 0.06606f ; **FLOATING
C5043 XCH2_TAILB/D4.n1 VGND 0.13212f ; **FLOATING
C5044 XCH2_TAILB/S5.t0 VGND 0.06606f ; **FLOATING
C5045 XCH2_TAILB/S5.t1 VGND 0.06606f ; **FLOATING
C5046 XCH2_TAILB/S5.n0 VGND 0.13212f ; **FLOATING
C5047 XCH2_TAILB/D6.n0 VGND 0.17937f ; **FLOATING
C5048 XCH2_TAILB/D6.t1 VGND 0.06606f ; **FLOATING
C5049 XCH2_TAILB/D6.t0 VGND 0.06606f ; **FLOATING
C5050 XCH2_TAILB/D6.n1 VGND 0.13212f ; **FLOATING
C5051 XCH2_TAILB/S7.t0 VGND 0.06606f ; **FLOATING
C5052 XCH2_TAILB/S7.t1 VGND 0.06606f ; **FLOATING
C5053 XCH2_TAILB/S7.n0 VGND 0.13212f ; **FLOATING
C5054 XCH2_TAILB/D8.n0 VGND 0.17937f ; **FLOATING
C5055 XCH2_TAILB/D8.t1 VGND 0.06606f ; **FLOATING
C5056 XCH2_TAILB/D8.t0 VGND 0.06606f ; **FLOATING
C5057 XCH2_TAILB/D8.n1 VGND 0.13212f ; **FLOATING
C5058 XCH2_TAILB/S8.t0 VGND 0.11121f ; **FLOATING
C5059 XBIASB/G.n0 VGND 0.0105f ; **FLOATING
C5060 XBIASB/G.n1 VGND 0.01806f ; **FLOATING
C5061 XBIASB/G.n2 VGND 0.04277f ; **FLOATING
C5062 XBIASB/G.n3 VGND 0.0105f ; **FLOATING
C5063 XBIASB/G.n4 VGND 0.0105f ; **FLOATING
C5064 XBIASB/G.n5 VGND 0.04277f ; **FLOATING
C5065 XBIASB/G.n6 VGND 0.01696f ; **FLOATING
C5066 XBIASB/G.t0 VGND 0.11384f ; **FLOATING
C5067 XBIASB/G.t8 VGND 0.11384f ; **FLOATING
C5068 XBIASB/G.n7 VGND 0.04318f ; **FLOATING
C5069 XBIASB/G.n8 VGND 0.03269f ; **FLOATING
C5070 XBIASB/G.n9 VGND 0.03269f ; **FLOATING
C5071 XBIASB/G.n10 VGND 0.04277f ; **FLOATING
C5072 XBIASB/G.n11 VGND 0.03269f ; **FLOATING
C5073 XBIASB/G.n12 VGND 0.01806f ; **FLOATING
C5074 XBIASB/G.n13 VGND 0.03269f ; **FLOATING
C5075 XBIASB/G.n14 VGND 0.01806f ; **FLOATING
C5076 XBIASB/G.n15 VGND 0.03269f ; **FLOATING
C5077 XBIASB/G.n16 VGND 0.01806f ; **FLOATING
C5078 XBIASB/G.n17 VGND 0.03269f ; **FLOATING
C5079 XBIASB/G.n18 VGND 0.04277f ; **FLOATING
C5080 XBIASB/G.n19 VGND 0.03269f ; **FLOATING
C5081 XBIASB/G.n20 VGND 0.04318f ; **FLOATING
C5082 XBIASB/G.t7 VGND 0.11292f ; **FLOATING
C5083 XBIASB/G.t6 VGND 0.11292f ; **FLOATING
C5084 XBIASB/G.t5 VGND 0.11292f ; **FLOATING
C5085 XBIASB/G.t4 VGND 0.11292f ; **FLOATING
C5086 XBIASB/G.t3 VGND 0.11292f ; **FLOATING
C5087 XBIASB/G.t2 VGND 0.11292f ; **FLOATING
C5088 XBIASB/G.t1 VGND 0.11292f ; **FLOATING
C5089 XBIASB/D0.n0 VGND 0.08154f ; **FLOATING
C5090 XBIASB/D0.t0 VGND 0.0963f ; **FLOATING
C5091 XBIASB/S1.n0 VGND 0.15523f ; **FLOATING
C5092 XBIASB/S1.t0 VGND 0.0571f ; **FLOATING
C5093 XBIASB/S1.t1 VGND 0.0571f ; **FLOATING
C5094 XBIASB/S1.n1 VGND 0.1142f ; **FLOATING
C5095 XBIASB/D2.n0 VGND 0.16309f ; **FLOATING
C5096 XBIASB/D2.t1 VGND 0.0571f ; **FLOATING
C5097 XBIASB/D2.t0 VGND 0.0571f ; **FLOATING
C5098 XBIASB/D2.n1 VGND 0.1142f ; **FLOATING
C5099 XBIASB/S3.n0 VGND 0.15523f ; **FLOATING
C5100 XBIASB/S3.t1 VGND 0.0571f ; **FLOATING
C5101 XBIASB/S3.t0 VGND 0.0571f ; **FLOATING
C5102 XBIASB/S3.n1 VGND 0.1142f ; **FLOATING
C5103 XBIASB/D4.n0 VGND 0.16309f ; **FLOATING
C5104 XBIASB/D4.t1 VGND 0.0571f ; **FLOATING
C5105 XBIASB/D4.t0 VGND 0.0571f ; **FLOATING
C5106 XBIASB/D4.n1 VGND 0.1142f ; **FLOATING
C5107 XBIASB/S5.n0 VGND 0.15523f ; **FLOATING
C5108 XBIASB/S5.t1 VGND 0.0571f ; **FLOATING
C5109 XBIASB/S5.t0 VGND 0.0571f ; **FLOATING
C5110 XBIASB/S5.n1 VGND 0.1142f ; **FLOATING
C5111 XBIASB/D6.n0 VGND 0.16309f ; **FLOATING
C5112 XBIASB/D6.t1 VGND 0.0571f ; **FLOATING
C5113 XBIASB/D6.t0 VGND 0.0571f ; **FLOATING
C5114 XBIASB/D6.n1 VGND 0.1142f ; **FLOATING
C5115 XBIASB/S7.n0 VGND 0.15523f ; **FLOATING
C5116 XBIASB/S7.t1 VGND 0.0571f ; **FLOATING
C5117 XBIASB/S7.t0 VGND 0.0571f ; **FLOATING
C5118 XBIASB/S7.n1 VGND 0.1142f ; **FLOATING
C5119 XBIASB/D8.n0 VGND 0.16309f ; **FLOATING
C5120 XBIASB/D8.t0 VGND 0.0571f ; **FLOATING
C5121 XBIASB/D8.t1 VGND 0.0571f ; **FLOATING
C5122 XBIASB/D8.n1 VGND 0.1142f ; **FLOATING
C5123 XBIASB/S8.n0 VGND 0.07761f ; **FLOATING
C5124 XBIASB/S8.t0 VGND 0.0963f ; **FLOATING
C5125 ch2_lon VGND 48.75582f
C5126 XCH2_SW2A/G.n0 VGND 0.03309f ; **FLOATING
C5127 XCH2_SW2A/G.n1 VGND 0.00446f ; **FLOATING
C5128 XCH2_SW2A/G.n2 VGND 0.03348f ; **FLOATING
C5129 XCH2_SW2A/G.n3 VGND 0.00371f ; **FLOATING
C5130 XCH2_SW2A/G.n4 VGND 0.03348f ; **FLOATING
C5131 XCH2_SW2A/G.n5 VGND 0.03348f ; **FLOATING
C5132 XCH2_SW2A/G.n6 VGND 0.03348f ; **FLOATING
C5133 XCH2_SW2A/G.t0 VGND 0.02016f ; **FLOATING
C5134 XCH2_SW2A/G.n7 VGND 0.03397f ; **FLOATING
C5135 XCH2_SW2A/G.t1 VGND 0.02016f ; **FLOATING
C5136 XCH2_SW2A/G.n8 VGND 0.03348f ; **FLOATING
C5137 XCH2_SW2A/G.n9 VGND 0.01205f ; **FLOATING
C5138 XCH2_SW2A/G.t2 VGND 0.02016f ; **FLOATING
C5139 XCH2_SW2A/G.n10 VGND 0.03348f ; **FLOATING
C5140 XCH2_SW2A/G.n11 VGND 0.01205f ; **FLOATING
C5141 XCH2_SW2A/G.t3 VGND 0.02016f ; **FLOATING
C5142 XCH2_SW2A/G.n12 VGND 0.03348f ; **FLOATING
C5143 XCH2_SW2A/G.n13 VGND 0.01205f ; **FLOATING
C5144 XCH2_SW2A/G.t4 VGND 0.02016f ; **FLOATING
C5145 XCH2_SW2A/G.n14 VGND 0.03397f ; **FLOATING
C5146 XCH2_SW2A/G.n15 VGND 0.01647f ; **FLOATING
C5147 XCH2_SW2A/G.n16 VGND 0.06329f ; **FLOATING
C5148 XCH2_SW2A/G.n17 VGND 0.01647f ; **FLOATING
C5149 XCH2_SW2A/G.n18 VGND 0.03348f ; **FLOATING
C5150 XCH2_SW2A/D0.n0 VGND 0.03483f ; **FLOATING
C5151 XCH2_SW2A/D0.t0 VGND 0.11646f ; **FLOATING
C5152 XCH2_SW2A/S1.t0 VGND 0.07135f ; **FLOATING
C5153 XCH2_SW2A/S1.t1 VGND 0.07135f ; **FLOATING
C5154 XCH2_SW2A/S1.n0 VGND 0.1427f ; **FLOATING
C5155 XCH2_SW2A/D2.n0 VGND 0.06775f ; **FLOATING
C5156 XCH2_SW2A/D2.t0 VGND 0.07135f ; **FLOATING
C5157 XCH2_SW2A/D2.t1 VGND 0.07135f ; **FLOATING
C5158 XCH2_SW2A/D2.n1 VGND 0.1427f ; **FLOATING
C5159 XCH2_SW2A/S3.t1 VGND 0.07135f ; **FLOATING
C5160 XCH2_SW2A/S3.t0 VGND 0.07135f ; **FLOATING
C5161 XCH2_SW2A/S3.n0 VGND 0.1427f ; **FLOATING
C5162 XCH2_SW2A/D4.n0 VGND 0.06775f ; **FLOATING
C5163 XCH2_SW2A/D4.t0 VGND 0.07135f ; **FLOATING
C5164 XCH2_SW2A/D4.t1 VGND 0.07135f ; **FLOATING
C5165 XCH2_SW2A/D4.n1 VGND 0.1427f ; **FLOATING
C5166 XCH2_SW2A/S4.t0 VGND 0.11646f ; **FLOATING
C5167 XCH2_SW3B/G.n0 VGND 0.03309f ; **FLOATING
C5168 XCH2_SW3B/G.n1 VGND 0.00446f ; **FLOATING
C5169 XCH2_SW3B/G.n2 VGND 0.03348f ; **FLOATING
C5170 XCH2_SW3B/G.n3 VGND 0.00371f ; **FLOATING
C5171 XCH2_SW3B/G.n4 VGND 0.03348f ; **FLOATING
C5172 XCH2_SW3B/G.n5 VGND 0.03348f ; **FLOATING
C5173 XCH2_SW3B/G.n6 VGND 0.03348f ; **FLOATING
C5174 XCH2_SW3B/G.t0 VGND 0.02016f ; **FLOATING
C5175 XCH2_SW3B/G.n7 VGND 0.03397f ; **FLOATING
C5176 XCH2_SW3B/G.t1 VGND 0.02016f ; **FLOATING
C5177 XCH2_SW3B/G.n8 VGND 0.03348f ; **FLOATING
C5178 XCH2_SW3B/G.n9 VGND 0.01205f ; **FLOATING
C5179 XCH2_SW3B/G.t2 VGND 0.02016f ; **FLOATING
C5180 XCH2_SW3B/G.n10 VGND 0.03348f ; **FLOATING
C5181 XCH2_SW3B/G.n11 VGND 0.01205f ; **FLOATING
C5182 XCH2_SW3B/G.t3 VGND 0.02016f ; **FLOATING
C5183 XCH2_SW3B/G.n12 VGND 0.03348f ; **FLOATING
C5184 XCH2_SW3B/G.n13 VGND 0.01205f ; **FLOATING
C5185 XCH2_SW3B/G.t4 VGND 0.02016f ; **FLOATING
C5186 XCH2_SW3B/G.n14 VGND 0.03397f ; **FLOATING
C5187 XCH2_SW3B/G.n15 VGND 0.01647f ; **FLOATING
C5188 XCH2_SW3B/G.n16 VGND 0.06329f ; **FLOATING
C5189 XCH2_SW3B/G.n17 VGND 0.01647f ; **FLOATING
C5190 XCH2_SW3B/G.n18 VGND 0.03348f ; **FLOATING
C5191 XCH2_SW3B/D0.n0 VGND 0.03483f ; **FLOATING
C5192 XCH2_SW3B/D0.t0 VGND 0.11646f ; **FLOATING
C5193 XCH2_SW3B/S1.t0 VGND 0.07135f ; **FLOATING
C5194 XCH2_SW3B/S1.t1 VGND 0.07135f ; **FLOATING
C5195 XCH2_SW3B/S1.n0 VGND 0.1427f ; **FLOATING
C5196 XCH2_SW3B/D2.n0 VGND 0.06775f ; **FLOATING
C5197 XCH2_SW3B/D2.t0 VGND 0.07135f ; **FLOATING
C5198 XCH2_SW3B/D2.t1 VGND 0.07135f ; **FLOATING
C5199 XCH2_SW3B/D2.n1 VGND 0.1427f ; **FLOATING
C5200 XCH2_SW3B/S3.t1 VGND 0.07135f ; **FLOATING
C5201 XCH2_SW3B/S3.t0 VGND 0.07135f ; **FLOATING
C5202 XCH2_SW3B/S3.n0 VGND 0.1427f ; **FLOATING
C5203 XCH2_SW3B/D4.n0 VGND 0.06775f ; **FLOATING
C5204 XCH2_SW3B/D4.t0 VGND 0.07135f ; **FLOATING
C5205 XCH2_SW3B/D4.t1 VGND 0.07135f ; **FLOATING
C5206 XCH2_SW3B/D4.n1 VGND 0.1427f ; **FLOATING
C5207 XCH2_SW3B/S4.t0 VGND 0.11646f ; **FLOATING
C5208 XCH2_TAILA/G.n0 VGND 0.01076f ; **FLOATING
C5209 XCH2_TAILA/G.n1 VGND 0.0185f ; **FLOATING
C5210 XCH2_TAILA/G.n2 VGND 0.04382f ; **FLOATING
C5211 XCH2_TAILA/G.n3 VGND 0.01076f ; **FLOATING
C5212 XCH2_TAILA/G.n4 VGND 0.01076f ; **FLOATING
C5213 XCH2_TAILA/G.n5 VGND 0.04382f ; **FLOATING
C5214 XCH2_TAILA/G.n6 VGND 0.01738f ; **FLOATING
C5215 XCH2_TAILA/G.t0 VGND 0.12842f ; **FLOATING
C5216 XCH2_TAILA/G.t8 VGND 0.12842f ; **FLOATING
C5217 XCH2_TAILA/G.n7 VGND 0.04775f ; **FLOATING
C5218 XCH2_TAILA/G.n8 VGND 0.03705f ; **FLOATING
C5219 XCH2_TAILA/G.n9 VGND 0.03705f ; **FLOATING
C5220 XCH2_TAILA/G.n10 VGND 0.04382f ; **FLOATING
C5221 XCH2_TAILA/G.n11 VGND 0.03705f ; **FLOATING
C5222 XCH2_TAILA/G.n12 VGND 0.0185f ; **FLOATING
C5223 XCH2_TAILA/G.n13 VGND 0.03705f ; **FLOATING
C5224 XCH2_TAILA/G.n14 VGND 0.0185f ; **FLOATING
C5225 XCH2_TAILA/G.n15 VGND 0.03705f ; **FLOATING
C5226 XCH2_TAILA/G.n16 VGND 0.0185f ; **FLOATING
C5227 XCH2_TAILA/G.n17 VGND 0.03705f ; **FLOATING
C5228 XCH2_TAILA/G.n18 VGND 0.04382f ; **FLOATING
C5229 XCH2_TAILA/G.n19 VGND 0.03705f ; **FLOATING
C5230 XCH2_TAILA/G.n20 VGND 0.04775f ; **FLOATING
C5231 XCH2_TAILA/G.t7 VGND 0.12744f ; **FLOATING
C5232 XCH2_TAILA/G.t6 VGND 0.12744f ; **FLOATING
C5233 XCH2_TAILA/G.t5 VGND 0.12744f ; **FLOATING
C5234 XCH2_TAILA/G.t4 VGND 0.12744f ; **FLOATING
C5235 XCH2_TAILA/G.t3 VGND 0.12744f ; **FLOATING
C5236 XCH2_TAILA/G.t2 VGND 0.12744f ; **FLOATING
C5237 XCH2_TAILA/G.t1 VGND 0.12744f ; **FLOATING
C5238 XCH2_TAILA/D0.n0 VGND 0.08968f ; **FLOATING
C5239 XCH2_TAILA/D0.t0 VGND 0.11121f ; **FLOATING
C5240 XCH2_TAILA/S1.t0 VGND 0.06606f ; **FLOATING
C5241 XCH2_TAILA/S1.t1 VGND 0.06606f ; **FLOATING
C5242 XCH2_TAILA/S1.n0 VGND 0.13212f ; **FLOATING
C5243 XCH2_TAILA/D2.n0 VGND 0.17937f ; **FLOATING
C5244 XCH2_TAILA/D2.t1 VGND 0.06606f ; **FLOATING
C5245 XCH2_TAILA/D2.t0 VGND 0.06606f ; **FLOATING
C5246 XCH2_TAILA/D2.n1 VGND 0.13212f ; **FLOATING
C5247 XCH2_TAILA/S3.t1 VGND 0.06606f ; **FLOATING
C5248 XCH2_TAILA/S3.t0 VGND 0.06606f ; **FLOATING
C5249 XCH2_TAILA/S3.n0 VGND 0.13212f ; **FLOATING
C5250 XCH2_TAILA/D4.n0 VGND 0.17937f ; **FLOATING
C5251 XCH2_TAILA/D4.t1 VGND 0.06606f ; **FLOATING
C5252 XCH2_TAILA/D4.t0 VGND 0.06606f ; **FLOATING
C5253 XCH2_TAILA/D4.n1 VGND 0.13212f ; **FLOATING
C5254 XCH2_TAILA/S5.t0 VGND 0.06606f ; **FLOATING
C5255 XCH2_TAILA/S5.t1 VGND 0.06606f ; **FLOATING
C5256 XCH2_TAILA/S5.n0 VGND 0.13212f ; **FLOATING
C5257 XCH2_TAILA/D6.n0 VGND 0.17937f ; **FLOATING
C5258 XCH2_TAILA/D6.t1 VGND 0.06606f ; **FLOATING
C5259 XCH2_TAILA/D6.t0 VGND 0.06606f ; **FLOATING
C5260 XCH2_TAILA/D6.n1 VGND 0.13212f ; **FLOATING
C5261 XCH2_TAILA/S7.t0 VGND 0.06606f ; **FLOATING
C5262 XCH2_TAILA/S7.t1 VGND 0.06606f ; **FLOATING
C5263 XCH2_TAILA/S7.n0 VGND 0.13212f ; **FLOATING
C5264 XCH2_TAILA/D8.n0 VGND 0.17937f ; **FLOATING
C5265 XCH2_TAILA/D8.t1 VGND 0.06606f ; **FLOATING
C5266 XCH2_TAILA/D8.t0 VGND 0.06606f ; **FLOATING
C5267 XCH2_TAILA/D8.n1 VGND 0.13212f ; **FLOATING
C5268 XCH2_TAILA/S8.t0 VGND 0.11121f ; **FLOATING
C5269 lp1 VGND 11.91477f
C5270 clk VGND 17.7264f
C5271 XLP1_N/G.n0 VGND 0 ; **FLOATING
C5272 XLP1_N/G.n1 VGND 0.02705f ; **FLOATING
C5273 XLP1_N/G.n2 VGND 0.02705f ; **FLOATING
C5274 XLP1_N/G.t0 VGND 0.0217f ; **FLOATING
C5275 XLP1_N/G.n3 VGND 0.13234f ; **FLOATING
C5276 XLP1_N/G.t1 VGND 0.01152f ; **FLOATING
C5277 XLP1_N/G.t2 VGND 0.0217f ; **FLOATING
C5278 XLP1_N/G.n4 VGND 0.02705f ; **FLOATING
C5279 XLP1_N/D0.n0 VGND 0.05782f ; **FLOATING
C5280 XLP1_N/D0.t0 VGND 0.06633f ; **FLOATING
C5281 XLP1_N/S1.t1 VGND 0.04065f ; **FLOATING
C5282 XLP1_N/S1.t0 VGND 0.04065f ; **FLOATING
C5283 XLP1_N/S1.n0 VGND 0.08129f ; **FLOATING
C5284 XLP1_N/D2.n0 VGND 0.1125f ; **FLOATING
C5285 XLP1_N/D2.t0 VGND 0.04065f ; **FLOATING
C5286 XLP1_N/D2.t1 VGND 0.04065f ; **FLOATING
C5287 XLP1_N/D2.n1 VGND 0.08129f ; **FLOATING
C5288 XLP1_N/S2.t0 VGND 0.06633f ; **FLOATING
C5289 XSELB_P/B.n0 VGND 0.01611f ; **FLOATING
C5290 XSELB_P/B.n1 VGND 0.03212f ; **FLOATING
C5291 XSELB_P/B.n2 VGND 0.17206f ; **FLOATING
C5292 XSELB_P/B.n3 VGND 0.03072f ; **FLOATING
C5293 XSELB_P/B.t1 VGND 0.11447f ; **FLOATING
C5294 XSELB_P/B.n4 VGND 0.03212f ; **FLOATING
C5295 XSELB_P/B.n5 VGND 0.03212f ; **FLOATING
C5296 XSELB_P/B.t0 VGND 0.17357f ; **FLOATING
C5297 XSELB_P/B.t2 VGND 0.17357f ; **FLOATING
C5298 XSELB_P/B.n6 VGND 0.17206f ; **FLOATING
C5299 XSELB_P/B.n7 VGND 0.03203f ; **FLOATING
C5300 XSELB_P/G.n0 VGND 0.00171f ; **FLOATING
C5301 XSELB_P/G.n1 VGND 0.08731f ; **FLOATING
C5302 XSELB_P/G.n2 VGND 0.08731f ; **FLOATING
C5303 XSELB_P/G.t0 VGND 0.07224f ; **FLOATING
C5304 XSELB_P/G.n3 VGND 0.42819f ; **FLOATING
C5305 XSELB_P/G.t1 VGND 0.05085f ; **FLOATING
C5306 XSELB_P/G.t2 VGND 0.07224f ; **FLOATING
C5307 XSELB_P/G.n4 VGND 0.08731f ; **FLOATING
C5308 XSELB_P/D0.n0 VGND 0.11881f ; **FLOATING
C5309 XSELB_P/D0.t0 VGND 0.14921f ; **FLOATING
C5310 XSELB_P/S1.n0 VGND 0.16046f ; **FLOATING
C5311 XSELB_P/S1.t1 VGND 0.06187f ; **FLOATING
C5312 XSELB_P/S1.t0 VGND 0.06187f ; **FLOATING
C5313 XSELB_P/S1.n1 VGND 0.12375f ; **FLOATING
C5314 XSELB_P/D2.n0 VGND 0.16567f ; **FLOATING
C5315 XSELB_P/D2.t1 VGND 0.06187f ; **FLOATING
C5316 XSELB_P/D2.t0 VGND 0.06187f ; **FLOATING
C5317 XSELB_P/D2.n1 VGND 0.12375f ; **FLOATING
C5318 XSELB_P/S2.n0 VGND 0.11507f ; **FLOATING
C5319 XSELB_P/S2.t0 VGND 0.14921f ; **FLOATING
C5320 XCH2LP_N/G.n0 VGND 0.03309f ; **FLOATING
C5321 XCH2LP_N/G.n1 VGND 0.00446f ; **FLOATING
C5322 XCH2LP_N/G.n2 VGND 0.03348f ; **FLOATING
C5323 XCH2LP_N/G.n3 VGND 0.00371f ; **FLOATING
C5324 XCH2LP_N/G.n4 VGND 0.03348f ; **FLOATING
C5325 XCH2LP_N/G.n5 VGND 0.03348f ; **FLOATING
C5326 XCH2LP_N/G.n6 VGND 0.03348f ; **FLOATING
C5327 XCH2LP_N/G.t0 VGND 0.02016f ; **FLOATING
C5328 XCH2LP_N/G.n7 VGND 0.03397f ; **FLOATING
C5329 XCH2LP_N/G.t1 VGND 0.02016f ; **FLOATING
C5330 XCH2LP_N/G.n8 VGND 0.03348f ; **FLOATING
C5331 XCH2LP_N/G.n9 VGND 0.01205f ; **FLOATING
C5332 XCH2LP_N/G.t2 VGND 0.02016f ; **FLOATING
C5333 XCH2LP_N/G.n10 VGND 0.03348f ; **FLOATING
C5334 XCH2LP_N/G.n11 VGND 0.01205f ; **FLOATING
C5335 XCH2LP_N/G.t3 VGND 0.02016f ; **FLOATING
C5336 XCH2LP_N/G.n12 VGND 0.03348f ; **FLOATING
C5337 XCH2LP_N/G.n13 VGND 0.01205f ; **FLOATING
C5338 XCH2LP_N/G.t4 VGND 0.02016f ; **FLOATING
C5339 XCH2LP_N/G.n14 VGND 0.03397f ; **FLOATING
C5340 XCH2LP_N/G.n15 VGND 0.01647f ; **FLOATING
C5341 XCH2LP_N/G.n16 VGND 0.06329f ; **FLOATING
C5342 XCH2LP_N/G.n17 VGND 0.01647f ; **FLOATING
C5343 XCH2LP_N/G.n18 VGND 0.03348f ; **FLOATING
C5344 XCH2LP_N/D0.n0 VGND 0.03483f ; **FLOATING
C5345 XCH2LP_N/D0.t0 VGND 0.11646f ; **FLOATING
C5346 XCH2LP_N/S1.t0 VGND 0.07135f ; **FLOATING
C5347 XCH2LP_N/S1.t1 VGND 0.07135f ; **FLOATING
C5348 XCH2LP_N/S1.n0 VGND 0.1427f ; **FLOATING
C5349 XCH2LP_N/D2.n0 VGND 0.06775f ; **FLOATING
C5350 XCH2LP_N/D2.t0 VGND 0.07135f ; **FLOATING
C5351 XCH2LP_N/D2.t1 VGND 0.07135f ; **FLOATING
C5352 XCH2LP_N/D2.n1 VGND 0.1427f ; **FLOATING
C5353 XCH2LP_N/S3.t1 VGND 0.07135f ; **FLOATING
C5354 XCH2LP_N/S3.t0 VGND 0.07135f ; **FLOATING
C5355 XCH2LP_N/S3.n0 VGND 0.1427f ; **FLOATING
C5356 XCH2LP_N/D4.n0 VGND 0.06775f ; **FLOATING
C5357 XCH2LP_N/D4.t0 VGND 0.07135f ; **FLOATING
C5358 XCH2LP_N/D4.t1 VGND 0.07135f ; **FLOATING
C5359 XCH2LP_N/D4.n1 VGND 0.1427f ; **FLOATING
C5360 XCH2LP_N/S4.t0 VGND 0.11646f ; **FLOATING
C5361 XBIASA/G.n0 VGND 0.0105f ; **FLOATING
C5362 XBIASA/G.n1 VGND 0.01806f ; **FLOATING
C5363 XBIASA/G.n2 VGND 0.04277f ; **FLOATING
C5364 XBIASA/G.n3 VGND 0.0105f ; **FLOATING
C5365 XBIASA/G.n4 VGND 0.0105f ; **FLOATING
C5366 XBIASA/G.n5 VGND 0.04277f ; **FLOATING
C5367 XBIASA/G.n6 VGND 0.01696f ; **FLOATING
C5368 XBIASA/G.t0 VGND 0.11384f ; **FLOATING
C5369 XBIASA/G.t8 VGND 0.11384f ; **FLOATING
C5370 XBIASA/G.n7 VGND 0.04318f ; **FLOATING
C5371 XBIASA/G.n8 VGND 0.03269f ; **FLOATING
C5372 XBIASA/G.n9 VGND 0.03269f ; **FLOATING
C5373 XBIASA/G.n10 VGND 0.04277f ; **FLOATING
C5374 XBIASA/G.n11 VGND 0.03269f ; **FLOATING
C5375 XBIASA/G.n12 VGND 0.01806f ; **FLOATING
C5376 XBIASA/G.n13 VGND 0.03269f ; **FLOATING
C5377 XBIASA/G.n14 VGND 0.01806f ; **FLOATING
C5378 XBIASA/G.n15 VGND 0.03269f ; **FLOATING
C5379 XBIASA/G.n16 VGND 0.01806f ; **FLOATING
C5380 XBIASA/G.n17 VGND 0.03269f ; **FLOATING
C5381 XBIASA/G.n18 VGND 0.04277f ; **FLOATING
C5382 XBIASA/G.n19 VGND 0.03269f ; **FLOATING
C5383 XBIASA/G.n20 VGND 0.04318f ; **FLOATING
C5384 XBIASA/G.t7 VGND 0.11292f ; **FLOATING
C5385 XBIASA/G.t6 VGND 0.11292f ; **FLOATING
C5386 XBIASA/G.t5 VGND 0.11292f ; **FLOATING
C5387 XBIASA/G.t4 VGND 0.11292f ; **FLOATING
C5388 XBIASA/G.t3 VGND 0.11292f ; **FLOATING
C5389 XBIASA/G.t2 VGND 0.11292f ; **FLOATING
C5390 XBIASA/G.t1 VGND 0.11292f ; **FLOATING
C5391 XBIASA/D0.n0 VGND 0.08154f ; **FLOATING
C5392 XBIASA/D0.t0 VGND 0.0963f ; **FLOATING
C5393 XBIASA/S1.n0 VGND 0.15523f ; **FLOATING
C5394 XBIASA/S1.t0 VGND 0.0571f ; **FLOATING
C5395 XBIASA/S1.t1 VGND 0.0571f ; **FLOATING
C5396 XBIASA/S1.n1 VGND 0.1142f ; **FLOATING
C5397 XBIASA/D2.n0 VGND 0.16309f ; **FLOATING
C5398 XBIASA/D2.t1 VGND 0.0571f ; **FLOATING
C5399 XBIASA/D2.t0 VGND 0.0571f ; **FLOATING
C5400 XBIASA/D2.n1 VGND 0.1142f ; **FLOATING
C5401 XBIASA/S3.n0 VGND 0.15523f ; **FLOATING
C5402 XBIASA/S3.t1 VGND 0.0571f ; **FLOATING
C5403 XBIASA/S3.t0 VGND 0.0571f ; **FLOATING
C5404 XBIASA/S3.n1 VGND 0.1142f ; **FLOATING
C5405 XBIASA/D4.n0 VGND 0.16309f ; **FLOATING
C5406 XBIASA/D4.t1 VGND 0.0571f ; **FLOATING
C5407 XBIASA/D4.t0 VGND 0.0571f ; **FLOATING
C5408 XBIASA/D4.n1 VGND 0.1142f ; **FLOATING
C5409 XBIASA/S5.n0 VGND 0.15523f ; **FLOATING
C5410 XBIASA/S5.t1 VGND 0.0571f ; **FLOATING
C5411 XBIASA/S5.t0 VGND 0.0571f ; **FLOATING
C5412 XBIASA/S5.n1 VGND 0.1142f ; **FLOATING
C5413 XBIASA/D6.n0 VGND 0.16309f ; **FLOATING
C5414 XBIASA/D6.t1 VGND 0.0571f ; **FLOATING
C5415 XBIASA/D6.t0 VGND 0.0571f ; **FLOATING
C5416 XBIASA/D6.n1 VGND 0.1142f ; **FLOATING
C5417 XBIASA/S7.n0 VGND 0.15523f ; **FLOATING
C5418 XBIASA/S7.t1 VGND 0.0571f ; **FLOATING
C5419 XBIASA/S7.t0 VGND 0.0571f ; **FLOATING
C5420 XBIASA/S7.n1 VGND 0.1142f ; **FLOATING
C5421 XBIASA/D8.n0 VGND 0.16309f ; **FLOATING
C5422 XBIASA/D8.t0 VGND 0.0571f ; **FLOATING
C5423 XBIASA/D8.t1 VGND 0.0571f ; **FLOATING
C5424 XBIASA/D8.n1 VGND 0.1142f ; **FLOATING
C5425 XBIASA/S8.n0 VGND 0.07761f ; **FLOATING
C5426 XBIASA/S8.t0 VGND 0.0963f ; **FLOATING
C5427 XCH2_SW4B/G.n0 VGND 0.03309f ; **FLOATING
C5428 XCH2_SW4B/G.n1 VGND 0.00446f ; **FLOATING
C5429 XCH2_SW4B/G.n2 VGND 0.03348f ; **FLOATING
C5430 XCH2_SW4B/G.n3 VGND 0.00371f ; **FLOATING
C5431 XCH2_SW4B/G.n4 VGND 0.03348f ; **FLOATING
C5432 XCH2_SW4B/G.n5 VGND 0.03348f ; **FLOATING
C5433 XCH2_SW4B/G.n6 VGND 0.03348f ; **FLOATING
C5434 XCH2_SW4B/G.t0 VGND 0.02016f ; **FLOATING
C5435 XCH2_SW4B/G.n7 VGND 0.03397f ; **FLOATING
C5436 XCH2_SW4B/G.t1 VGND 0.02016f ; **FLOATING
C5437 XCH2_SW4B/G.n8 VGND 0.03348f ; **FLOATING
C5438 XCH2_SW4B/G.n9 VGND 0.01205f ; **FLOATING
C5439 XCH2_SW4B/G.t2 VGND 0.02016f ; **FLOATING
C5440 XCH2_SW4B/G.n10 VGND 0.03348f ; **FLOATING
C5441 XCH2_SW4B/G.n11 VGND 0.01205f ; **FLOATING
C5442 XCH2_SW4B/G.t3 VGND 0.02016f ; **FLOATING
C5443 XCH2_SW4B/G.n12 VGND 0.03348f ; **FLOATING
C5444 XCH2_SW4B/G.n13 VGND 0.01205f ; **FLOATING
C5445 XCH2_SW4B/G.t4 VGND 0.02016f ; **FLOATING
C5446 XCH2_SW4B/G.n14 VGND 0.03397f ; **FLOATING
C5447 XCH2_SW4B/G.n15 VGND 0.01647f ; **FLOATING
C5448 XCH2_SW4B/G.n16 VGND 0.06329f ; **FLOATING
C5449 XCH2_SW4B/G.n17 VGND 0.01647f ; **FLOATING
C5450 XCH2_SW4B/G.n18 VGND 0.03348f ; **FLOATING
C5451 XCH2_SW4B/D0.n0 VGND 0.03483f ; **FLOATING
C5452 XCH2_SW4B/D0.t0 VGND 0.11646f ; **FLOATING
C5453 XCH2_SW4B/S1.t0 VGND 0.07135f ; **FLOATING
C5454 XCH2_SW4B/S1.t1 VGND 0.07135f ; **FLOATING
C5455 XCH2_SW4B/S1.n0 VGND 0.1427f ; **FLOATING
C5456 XCH2_SW4B/D2.n0 VGND 0.06775f ; **FLOATING
C5457 XCH2_SW4B/D2.t0 VGND 0.07135f ; **FLOATING
C5458 XCH2_SW4B/D2.t1 VGND 0.07135f ; **FLOATING
C5459 XCH2_SW4B/D2.n1 VGND 0.1427f ; **FLOATING
C5460 XCH2_SW4B/S3.t1 VGND 0.07135f ; **FLOATING
C5461 XCH2_SW4B/S3.t0 VGND 0.07135f ; **FLOATING
C5462 XCH2_SW4B/S3.n0 VGND 0.1427f ; **FLOATING
C5463 XCH2_SW4B/D4.n0 VGND 0.06775f ; **FLOATING
C5464 XCH2_SW4B/D4.t0 VGND 0.07135f ; **FLOATING
C5465 XCH2_SW4B/D4.t1 VGND 0.07135f ; **FLOATING
C5466 XCH2_SW4B/D4.n1 VGND 0.1427f ; **FLOATING
C5467 XCH2_SW4B/S4.t0 VGND 0.11646f ; **FLOATING
C5468 XCH2_SW3A/G.n0 VGND 0.03309f ; **FLOATING
C5469 XCH2_SW3A/G.n1 VGND 0.00446f ; **FLOATING
C5470 XCH2_SW3A/G.n2 VGND 0.03348f ; **FLOATING
C5471 XCH2_SW3A/G.n3 VGND 0.00371f ; **FLOATING
C5472 XCH2_SW3A/G.n4 VGND 0.03348f ; **FLOATING
C5473 XCH2_SW3A/G.n5 VGND 0.03348f ; **FLOATING
C5474 XCH2_SW3A/G.n6 VGND 0.03348f ; **FLOATING
C5475 XCH2_SW3A/G.t0 VGND 0.02016f ; **FLOATING
C5476 XCH2_SW3A/G.n7 VGND 0.03397f ; **FLOATING
C5477 XCH2_SW3A/G.t1 VGND 0.02016f ; **FLOATING
C5478 XCH2_SW3A/G.n8 VGND 0.03348f ; **FLOATING
C5479 XCH2_SW3A/G.n9 VGND 0.01205f ; **FLOATING
C5480 XCH2_SW3A/G.t2 VGND 0.02016f ; **FLOATING
C5481 XCH2_SW3A/G.n10 VGND 0.03348f ; **FLOATING
C5482 XCH2_SW3A/G.n11 VGND 0.01205f ; **FLOATING
C5483 XCH2_SW3A/G.t3 VGND 0.02016f ; **FLOATING
C5484 XCH2_SW3A/G.n12 VGND 0.03348f ; **FLOATING
C5485 XCH2_SW3A/G.n13 VGND 0.01205f ; **FLOATING
C5486 XCH2_SW3A/G.t4 VGND 0.02016f ; **FLOATING
C5487 XCH2_SW3A/G.n14 VGND 0.03397f ; **FLOATING
C5488 XCH2_SW3A/G.n15 VGND 0.01647f ; **FLOATING
C5489 XCH2_SW3A/G.n16 VGND 0.06329f ; **FLOATING
C5490 XCH2_SW3A/G.n17 VGND 0.01647f ; **FLOATING
C5491 XCH2_SW3A/G.n18 VGND 0.03348f ; **FLOATING
C5492 XCH2_SW3A/D0.n0 VGND 0.03483f ; **FLOATING
C5493 XCH2_SW3A/D0.t0 VGND 0.11646f ; **FLOATING
C5494 XCH2_SW3A/S1.t0 VGND 0.07135f ; **FLOATING
C5495 XCH2_SW3A/S1.t1 VGND 0.07135f ; **FLOATING
C5496 XCH2_SW3A/S1.n0 VGND 0.1427f ; **FLOATING
C5497 XCH2_SW3A/D2.n0 VGND 0.06775f ; **FLOATING
C5498 XCH2_SW3A/D2.t0 VGND 0.07135f ; **FLOATING
C5499 XCH2_SW3A/D2.t1 VGND 0.07135f ; **FLOATING
C5500 XCH2_SW3A/D2.n1 VGND 0.1427f ; **FLOATING
C5501 XCH2_SW3A/S3.t1 VGND 0.07135f ; **FLOATING
C5502 XCH2_SW3A/S3.t0 VGND 0.07135f ; **FLOATING
C5503 XCH2_SW3A/S3.n0 VGND 0.1427f ; **FLOATING
C5504 XCH2_SW3A/D4.n0 VGND 0.06775f ; **FLOATING
C5505 XCH2_SW3A/D4.t0 VGND 0.07135f ; **FLOATING
C5506 XCH2_SW3A/D4.t1 VGND 0.07135f ; **FLOATING
C5507 XCH2_SW3A/D4.n1 VGND 0.1427f ; **FLOATING
C5508 XCH2_SW3A/S4.t0 VGND 0.11646f ; **FLOATING
C5509 select_b VGND 13.6311f
C5510 ui_in[0] VGND 19.02244f
C5511 XSELB_N/G.n0 VGND 0 ; **FLOATING
C5512 XSELB_N/G.n1 VGND 0.02705f ; **FLOATING
C5513 XSELB_N/G.n2 VGND 0.02705f ; **FLOATING
C5514 XSELB_N/G.t0 VGND 0.0217f ; **FLOATING
C5515 XSELB_N/G.n3 VGND 0.13234f ; **FLOATING
C5516 XSELB_N/G.t1 VGND 0.01152f ; **FLOATING
C5517 XSELB_N/G.t2 VGND 0.0217f ; **FLOATING
C5518 XSELB_N/G.n4 VGND 0.02705f ; **FLOATING
C5519 XSELB_N/D0.n0 VGND 0.05782f ; **FLOATING
C5520 XSELB_N/D0.t0 VGND 0.06633f ; **FLOATING
C5521 XSELB_N/S1.t1 VGND 0.04065f ; **FLOATING
C5522 XSELB_N/S1.t0 VGND 0.04065f ; **FLOATING
C5523 XSELB_N/S1.n0 VGND 0.08129f ; **FLOATING
C5524 XSELB_N/D2.n0 VGND 0.1125f ; **FLOATING
C5525 XSELB_N/D2.t0 VGND 0.04065f ; **FLOATING
C5526 XSELB_N/D2.t1 VGND 0.04065f ; **FLOATING
C5527 XSELB_N/D2.n1 VGND 0.08129f ; **FLOATING
C5528 XSELB_N/S2.t0 VGND 0.06633f ; **FLOATING
C5529 XCH2_SW4A/G.n0 VGND 0.03309f ; **FLOATING
C5530 XCH2_SW4A/G.n1 VGND 0.00446f ; **FLOATING
C5531 XCH2_SW4A/G.n2 VGND 0.03348f ; **FLOATING
C5532 XCH2_SW4A/G.n3 VGND 0.00371f ; **FLOATING
C5533 XCH2_SW4A/G.n4 VGND 0.03348f ; **FLOATING
C5534 XCH2_SW4A/G.n5 VGND 0.03348f ; **FLOATING
C5535 XCH2_SW4A/G.n6 VGND 0.03348f ; **FLOATING
C5536 XCH2_SW4A/G.t0 VGND 0.02016f ; **FLOATING
C5537 XCH2_SW4A/G.n7 VGND 0.03397f ; **FLOATING
C5538 XCH2_SW4A/G.t1 VGND 0.02016f ; **FLOATING
C5539 XCH2_SW4A/G.n8 VGND 0.03348f ; **FLOATING
C5540 XCH2_SW4A/G.n9 VGND 0.01205f ; **FLOATING
C5541 XCH2_SW4A/G.t2 VGND 0.02016f ; **FLOATING
C5542 XCH2_SW4A/G.n10 VGND 0.03348f ; **FLOATING
C5543 XCH2_SW4A/G.n11 VGND 0.01205f ; **FLOATING
C5544 XCH2_SW4A/G.t3 VGND 0.02016f ; **FLOATING
C5545 XCH2_SW4A/G.n12 VGND 0.03348f ; **FLOATING
C5546 XCH2_SW4A/G.n13 VGND 0.01205f ; **FLOATING
C5547 XCH2_SW4A/G.t4 VGND 0.02016f ; **FLOATING
C5548 XCH2_SW4A/G.n14 VGND 0.03397f ; **FLOATING
C5549 XCH2_SW4A/G.n15 VGND 0.01647f ; **FLOATING
C5550 XCH2_SW4A/G.n16 VGND 0.06329f ; **FLOATING
C5551 XCH2_SW4A/G.n17 VGND 0.01647f ; **FLOATING
C5552 XCH2_SW4A/G.n18 VGND 0.03348f ; **FLOATING
C5553 XCH2_SW4A/D0.n0 VGND 0.03483f ; **FLOATING
C5554 XCH2_SW4A/D0.t0 VGND 0.11646f ; **FLOATING
C5555 XCH2_SW4A/S1.t0 VGND 0.07135f ; **FLOATING
C5556 XCH2_SW4A/S1.t1 VGND 0.07135f ; **FLOATING
C5557 XCH2_SW4A/S1.n0 VGND 0.1427f ; **FLOATING
C5558 XCH2_SW4A/D2.n0 VGND 0.06775f ; **FLOATING
C5559 XCH2_SW4A/D2.t0 VGND 0.07135f ; **FLOATING
C5560 XCH2_SW4A/D2.t1 VGND 0.07135f ; **FLOATING
C5561 XCH2_SW4A/D2.n1 VGND 0.1427f ; **FLOATING
C5562 XCH2_SW4A/S3.t1 VGND 0.07135f ; **FLOATING
C5563 XCH2_SW4A/S3.t0 VGND 0.07135f ; **FLOATING
C5564 XCH2_SW4A/S3.n0 VGND 0.1427f ; **FLOATING
C5565 XCH2_SW4A/D4.n0 VGND 0.06775f ; **FLOATING
C5566 XCH2_SW4A/D4.t0 VGND 0.07135f ; **FLOATING
C5567 XCH2_SW4A/D4.t1 VGND 0.07135f ; **FLOATING
C5568 XCH2_SW4A/D4.n1 VGND 0.1427f ; **FLOATING
C5569 XCH2_SW4A/S4.t0 VGND 0.11646f ; **FLOATING
C5570 XLN2_P/B.n0 VGND 0.02158f ; **FLOATING
C5571 XLN2_P/B.n1 VGND 0.04309f ; **FLOATING
C5572 XLN2_P/B.n2 VGND 0.21103f ; **FLOATING
C5573 XLN2_P/B.n3 VGND 0.04181f ; **FLOATING
C5574 XLN2_P/B.t2 VGND 0.13586f ; **FLOATING
C5575 XLN2_P/B.n4 VGND 0.04309f ; **FLOATING
C5576 XLN2_P/B.n5 VGND 0.04309f ; **FLOATING
C5577 XLN2_P/B.t0 VGND 0.2044f ; **FLOATING
C5578 XLN2_P/B.t1 VGND 0.13586f ; **FLOATING
C5579 XLN2_P/B.t3 VGND 0.13586f ; **FLOATING
C5580 XLN2_P/B.t4 VGND 0.2044f ; **FLOATING
C5581 XLN2_P/B.n6 VGND 0.21103f ; **FLOATING
C5582 XLN2_P/B.n7 VGND 0.04324f ; **FLOATING
C5583 XLN2_P/G.n0 VGND 0.08361f ; **FLOATING
C5584 XLN2_P/G.n1 VGND 0.01127f ; **FLOATING
C5585 XLN2_P/G.n2 VGND 0.08585f ; **FLOATING
C5586 XLN2_P/G.n3 VGND 0.00939f ; **FLOATING
C5587 XLN2_P/G.n4 VGND 0.08585f ; **FLOATING
C5588 XLN2_P/G.n5 VGND 0.08585f ; **FLOATING
C5589 XLN2_P/G.n6 VGND 0.08585f ; **FLOATING
C5590 XLN2_P/G.t0 VGND 0.05347f ; **FLOATING
C5591 XLN2_P/G.n7 VGND 0.08711f ; **FLOATING
C5592 XLN2_P/G.t1 VGND 0.05347f ; **FLOATING
C5593 XLN2_P/G.n8 VGND 0.08585f ; **FLOATING
C5594 XLN2_P/G.n9 VGND 0.03046f ; **FLOATING
C5595 XLN2_P/G.t2 VGND 0.05347f ; **FLOATING
C5596 XLN2_P/G.n10 VGND 0.08585f ; **FLOATING
C5597 XLN2_P/G.n11 VGND 0.03046f ; **FLOATING
C5598 XLN2_P/G.t3 VGND 0.05347f ; **FLOATING
C5599 XLN2_P/G.n12 VGND 0.08585f ; **FLOATING
C5600 XLN2_P/G.n13 VGND 0.03046f ; **FLOATING
C5601 XLN2_P/G.t4 VGND 0.05347f ; **FLOATING
C5602 XLN2_P/G.n14 VGND 0.08711f ; **FLOATING
C5603 XLN2_P/G.n15 VGND 0.04161f ; **FLOATING
C5604 XLN2_P/G.n16 VGND 0.15992f ; **FLOATING
C5605 XLN2_P/G.n17 VGND 0.04161f ; **FLOATING
C5606 XLN2_P/G.n18 VGND 0.08585f ; **FLOATING
C5607 XLN2_P/D0.n0 VGND 0.04947f ; **FLOATING
C5608 XLN2_P/D0.t0 VGND 0.17821f ; **FLOATING
C5609 XLN2_P/S1.n0 VGND 0.02401f ; **FLOATING
C5610 XLN2_P/S1.t0 VGND 0.07252f ; **FLOATING
C5611 XLN2_P/S1.t1 VGND 0.07252f ; **FLOATING
C5612 XLN2_P/S1.n1 VGND 0.14503f ; **FLOATING
C5613 XLN2_P/D2.n0 VGND 0.06886f ; **FLOATING
C5614 XLN2_P/D2.t1 VGND 0.07252f ; **FLOATING
C5615 XLN2_P/D2.t0 VGND 0.07252f ; **FLOATING
C5616 XLN2_P/D2.n1 VGND 0.14503f ; **FLOATING
C5617 XLN2_P/S3.n0 VGND 0.02401f ; **FLOATING
C5618 XLN2_P/S3.t1 VGND 0.07252f ; **FLOATING
C5619 XLN2_P/S3.t0 VGND 0.07252f ; **FLOATING
C5620 XLN2_P/S3.n1 VGND 0.14503f ; **FLOATING
C5621 XLN2_P/D4.n0 VGND 0.06886f ; **FLOATING
C5622 XLN2_P/D4.t0 VGND 0.07252f ; **FLOATING
C5623 XLN2_P/D4.t1 VGND 0.07252f ; **FLOATING
C5624 XLN2_P/D4.n1 VGND 0.14503f ; **FLOATING
C5625 XLN2_P/S4.n0 VGND 0.01725f ; **FLOATING
C5626 XLN2_P/S4.t0 VGND 0.17821f ; **FLOATING
C5627 vcm VGND 0.11006p
C5628 ln2 VGND 14.08725f
C5629 XLN2_N/G.n0 VGND 0.03082f ; **FLOATING
C5630 XLN2_N/G.n1 VGND 0.00415f ; **FLOATING
C5631 XLN2_N/G.n2 VGND 0.02705f ; **FLOATING
C5632 XLN2_N/G.n3 VGND 0.00346f ; **FLOATING
C5633 XLN2_N/G.n4 VGND 0.02705f ; **FLOATING
C5634 XLN2_N/G.n5 VGND 0.02705f ; **FLOATING
C5635 XLN2_N/G.n6 VGND 0.02705f ; **FLOATING
C5636 XLN2_N/G.t0 VGND 0.01052f ; **FLOATING
C5637 XLN2_N/G.n7 VGND 0.02752f ; **FLOATING
C5638 XLN2_N/G.t1 VGND 0.01052f ; **FLOATING
C5639 XLN2_N/G.n8 VGND 0.02705f ; **FLOATING
C5640 XLN2_N/G.n9 VGND 0.01123f ; **FLOATING
C5641 XLN2_N/G.t2 VGND 0.01052f ; **FLOATING
C5642 XLN2_N/G.n10 VGND 0.02705f ; **FLOATING
C5643 XLN2_N/G.n11 VGND 0.01123f ; **FLOATING
C5644 XLN2_N/G.t3 VGND 0.01052f ; **FLOATING
C5645 XLN2_N/G.n12 VGND 0.02705f ; **FLOATING
C5646 XLN2_N/G.n13 VGND 0.01123f ; **FLOATING
C5647 XLN2_N/G.t4 VGND 0.01052f ; **FLOATING
C5648 XLN2_N/G.n14 VGND 0.02752f ; **FLOATING
C5649 XLN2_N/G.n15 VGND 0.01534f ; **FLOATING
C5650 XLN2_N/G.n16 VGND 0.05894f ; **FLOATING
C5651 XLN2_N/G.n17 VGND 0.01534f ; **FLOATING
C5652 XLN2_N/G.n18 VGND 0.02705f ; **FLOATING
C5653 XLN2_N/D0.n0 VGND 0.05782f ; **FLOATING
C5654 XLN2_N/D0.t0 VGND 0.06633f ; **FLOATING
C5655 XLN2_N/S1.t0 VGND 0.04065f ; **FLOATING
C5656 XLN2_N/S1.t1 VGND 0.04065f ; **FLOATING
C5657 XLN2_N/S1.n0 VGND 0.08129f ; **FLOATING
C5658 XLN2_N/D2.n0 VGND 0.1125f ; **FLOATING
C5659 XLN2_N/D2.t0 VGND 0.04065f ; **FLOATING
C5660 XLN2_N/D2.t1 VGND 0.04065f ; **FLOATING
C5661 XLN2_N/D2.n1 VGND 0.08129f ; **FLOATING
C5662 XLN2_N/S3.t0 VGND 0.04065f ; **FLOATING
C5663 XLN2_N/S3.t1 VGND 0.04065f ; **FLOATING
C5664 XLN2_N/S3.n0 VGND 0.08129f ; **FLOATING
C5665 XLN2_N/D4.n0 VGND 0.1125f ; **FLOATING
C5666 XLN2_N/D4.t1 VGND 0.04065f ; **FLOATING
C5667 XLN2_N/D4.t0 VGND 0.04065f ; **FLOATING
C5668 XLN2_N/D4.n1 VGND 0.08129f ; **FLOATING
C5669 XLN2_N/S4.t0 VGND 0.06633f ; **FLOATING
C5670 XCH1_GM1B/G.n0 VGND 0.03407f ; **FLOATING
C5671 XCH1_GM1B/G.n1 VGND 0.00659f ; **FLOATING
C5672 XCH1_GM1B/G.n2 VGND 0.00576f ; **FLOATING
C5673 XCH1_GM1B/G.t0 VGND 0.07246f ; **FLOATING
C5674 XCH1_GM1B/G.t4 VGND 0.07246f ; **FLOATING
C5675 XCH1_GM1B/G.n3 VGND 0.03617f ; **FLOATING
C5676 XCH1_GM1B/G.n4 VGND 0.02957f ; **FLOATING
C5677 XCH1_GM1B/G.n5 VGND 0.02957f ; **FLOATING
C5678 XCH1_GM1B/G.n6 VGND 0.06549f ; **FLOATING
C5679 XCH1_GM1B/G.n7 VGND 0.02957f ; **FLOATING
C5680 XCH1_GM1B/G.n8 VGND 0.03617f ; **FLOATING
C5681 XCH1_GM1B/G.t3 VGND 0.07184f ; **FLOATING
C5682 XCH1_GM1B/G.t2 VGND 0.07184f ; **FLOATING
C5683 XCH1_GM1B/G.t1 VGND 0.07184f ; **FLOATING
C5684 XCH1_GM1B/D0.n0 VGND 0.08652f ; **FLOATING
C5685 XCH1_GM1B/D0.t0 VGND 0.10058f ; **FLOATING
C5686 XCH1_GM1B/S1.t0 VGND 0.05867f ; **FLOATING
C5687 XCH1_GM1B/S1.t1 VGND 0.05867f ; **FLOATING
C5688 XCH1_GM1B/S1.n0 VGND 0.11734f ; **FLOATING
C5689 XCH1_GM1B/D2.n0 VGND 0.17305f ; **FLOATING
C5690 XCH1_GM1B/D2.t1 VGND 0.05867f ; **FLOATING
C5691 XCH1_GM1B/D2.t0 VGND 0.05867f ; **FLOATING
C5692 XCH1_GM1B/D2.n1 VGND 0.11734f ; **FLOATING
C5693 XCH1_GM1B/S3.t0 VGND 0.05867f ; **FLOATING
C5694 XCH1_GM1B/S3.t1 VGND 0.05867f ; **FLOATING
C5695 XCH1_GM1B/S3.n0 VGND 0.11734f ; **FLOATING
C5696 XCH1_GM1B/D4.n0 VGND 0.17305f ; **FLOATING
C5697 XCH1_GM1B/D4.t1 VGND 0.05867f ; **FLOATING
C5698 XCH1_GM1B/D4.t0 VGND 0.05867f ; **FLOATING
C5699 XCH1_GM1B/D4.n1 VGND 0.11734f ; **FLOATING
C5700 XCH1_GM1B/S4.t0 VGND 0.10058f ; **FLOATING
C5701 tail1 VGND 32.54895f
C5702 gm1_p VGND 20.46745f
C5703 ua[0] VGND 30.9134f
C5704 XCH1_GM1A/G.n0 VGND 0.03407f ; **FLOATING
C5705 XCH1_GM1A/G.n1 VGND 0.00659f ; **FLOATING
C5706 XCH1_GM1A/G.n2 VGND 0.00576f ; **FLOATING
C5707 XCH1_GM1A/G.t0 VGND 0.07246f ; **FLOATING
C5708 XCH1_GM1A/G.t4 VGND 0.07246f ; **FLOATING
C5709 XCH1_GM1A/G.n3 VGND 0.03617f ; **FLOATING
C5710 XCH1_GM1A/G.n4 VGND 0.02957f ; **FLOATING
C5711 XCH1_GM1A/G.n5 VGND 0.02957f ; **FLOATING
C5712 XCH1_GM1A/G.n6 VGND 0.06549f ; **FLOATING
C5713 XCH1_GM1A/G.n7 VGND 0.02957f ; **FLOATING
C5714 XCH1_GM1A/G.n8 VGND 0.03617f ; **FLOATING
C5715 XCH1_GM1A/G.t3 VGND 0.07184f ; **FLOATING
C5716 XCH1_GM1A/G.t2 VGND 0.07184f ; **FLOATING
C5717 XCH1_GM1A/G.t1 VGND 0.07184f ; **FLOATING
C5718 XCH1_GM1A/D0.n0 VGND 0.08652f ; **FLOATING
C5719 XCH1_GM1A/D0.t0 VGND 0.10058f ; **FLOATING
C5720 XCH1_GM1A/S1.t0 VGND 0.05867f ; **FLOATING
C5721 XCH1_GM1A/S1.t1 VGND 0.05867f ; **FLOATING
C5722 XCH1_GM1A/S1.n0 VGND 0.11734f ; **FLOATING
C5723 XCH1_GM1A/D2.n0 VGND 0.17305f ; **FLOATING
C5724 XCH1_GM1A/D2.t1 VGND 0.05867f ; **FLOATING
C5725 XCH1_GM1A/D2.t0 VGND 0.05867f ; **FLOATING
C5726 XCH1_GM1A/D2.n1 VGND 0.11734f ; **FLOATING
C5727 XCH1_GM1A/S3.t0 VGND 0.05867f ; **FLOATING
C5728 XCH1_GM1A/S3.t1 VGND 0.05867f ; **FLOATING
C5729 XCH1_GM1A/S3.n0 VGND 0.11734f ; **FLOATING
C5730 XCH1_GM1A/D4.n0 VGND 0.17305f ; **FLOATING
C5731 XCH1_GM1A/D4.t1 VGND 0.05867f ; **FLOATING
C5732 XCH1_GM1A/D4.t0 VGND 0.05867f ; **FLOATING
C5733 XCH1_GM1A/D4.n1 VGND 0.11734f ; **FLOATING
C5734 XCH1_GM1A/S4.t0 VGND 0.10058f ; **FLOATING
C5735 XCH1_GM2B/G.n0 VGND 0.03407f ; **FLOATING
C5736 XCH1_GM2B/G.n1 VGND 0.00659f ; **FLOATING
C5737 XCH1_GM2B/G.n2 VGND 0.00576f ; **FLOATING
C5738 XCH1_GM2B/G.t0 VGND 0.07246f ; **FLOATING
C5739 XCH1_GM2B/G.t4 VGND 0.07246f ; **FLOATING
C5740 XCH1_GM2B/G.n3 VGND 0.03617f ; **FLOATING
C5741 XCH1_GM2B/G.n4 VGND 0.02957f ; **FLOATING
C5742 XCH1_GM2B/G.n5 VGND 0.02957f ; **FLOATING
C5743 XCH1_GM2B/G.n6 VGND 0.06549f ; **FLOATING
C5744 XCH1_GM2B/G.n7 VGND 0.02957f ; **FLOATING
C5745 XCH1_GM2B/G.n8 VGND 0.03617f ; **FLOATING
C5746 XCH1_GM2B/G.t3 VGND 0.07184f ; **FLOATING
C5747 XCH1_GM2B/G.t2 VGND 0.07184f ; **FLOATING
C5748 XCH1_GM2B/G.t1 VGND 0.07184f ; **FLOATING
C5749 XCH1_GM2B/D0.n0 VGND 0.08652f ; **FLOATING
C5750 XCH1_GM2B/D0.t0 VGND 0.10058f ; **FLOATING
C5751 XCH1_GM2B/S1.t0 VGND 0.05867f ; **FLOATING
C5752 XCH1_GM2B/S1.t1 VGND 0.05867f ; **FLOATING
C5753 XCH1_GM2B/S1.n0 VGND 0.11734f ; **FLOATING
C5754 XCH1_GM2B/D2.n0 VGND 0.17305f ; **FLOATING
C5755 XCH1_GM2B/D2.t1 VGND 0.05867f ; **FLOATING
C5756 XCH1_GM2B/D2.t0 VGND 0.05867f ; **FLOATING
C5757 XCH1_GM2B/D2.n1 VGND 0.11734f ; **FLOATING
C5758 XCH1_GM2B/S3.t0 VGND 0.05867f ; **FLOATING
C5759 XCH1_GM2B/S3.t1 VGND 0.05867f ; **FLOATING
C5760 XCH1_GM2B/S3.n0 VGND 0.11734f ; **FLOATING
C5761 XCH1_GM2B/D4.n0 VGND 0.17305f ; **FLOATING
C5762 XCH1_GM2B/D4.t1 VGND 0.05867f ; **FLOATING
C5763 XCH1_GM2B/D4.t0 VGND 0.05867f ; **FLOATING
C5764 XCH1_GM2B/D4.n1 VGND 0.11734f ; **FLOATING
C5765 XCH1_GM2B/S4.t0 VGND 0.10058f ; **FLOATING
C5766 gm1_n VGND 22.73716f
C5767 XCH1_GM2A/G.n0 VGND 0.03407f ; **FLOATING
C5768 XCH1_GM2A/G.n1 VGND 0.00659f ; **FLOATING
C5769 XCH1_GM2A/G.n2 VGND 0.00576f ; **FLOATING
C5770 XCH1_GM2A/G.t0 VGND 0.07246f ; **FLOATING
C5771 XCH1_GM2A/G.t4 VGND 0.07246f ; **FLOATING
C5772 XCH1_GM2A/G.n3 VGND 0.03617f ; **FLOATING
C5773 XCH1_GM2A/G.n4 VGND 0.02957f ; **FLOATING
C5774 XCH1_GM2A/G.n5 VGND 0.02957f ; **FLOATING
C5775 XCH1_GM2A/G.n6 VGND 0.06549f ; **FLOATING
C5776 XCH1_GM2A/G.n7 VGND 0.02957f ; **FLOATING
C5777 XCH1_GM2A/G.n8 VGND 0.03617f ; **FLOATING
C5778 XCH1_GM2A/G.t3 VGND 0.07184f ; **FLOATING
C5779 XCH1_GM2A/G.t2 VGND 0.07184f ; **FLOATING
C5780 XCH1_GM2A/G.t1 VGND 0.07184f ; **FLOATING
C5781 XCH1_GM2A/D0.n0 VGND 0.08652f ; **FLOATING
C5782 XCH1_GM2A/D0.t0 VGND 0.10058f ; **FLOATING
C5783 XCH1_GM2A/S1.t0 VGND 0.05867f ; **FLOATING
C5784 XCH1_GM2A/S1.t1 VGND 0.05867f ; **FLOATING
C5785 XCH1_GM2A/S1.n0 VGND 0.11734f ; **FLOATING
C5786 XCH1_GM2A/D2.n0 VGND 0.17305f ; **FLOATING
C5787 XCH1_GM2A/D2.t1 VGND 0.05867f ; **FLOATING
C5788 XCH1_GM2A/D2.t0 VGND 0.05867f ; **FLOATING
C5789 XCH1_GM2A/D2.n1 VGND 0.11734f ; **FLOATING
C5790 XCH1_GM2A/S3.t0 VGND 0.05867f ; **FLOATING
C5791 XCH1_GM2A/S3.t1 VGND 0.05867f ; **FLOATING
C5792 XCH1_GM2A/S3.n0 VGND 0.11734f ; **FLOATING
C5793 XCH1_GM2A/D4.n0 VGND 0.17305f ; **FLOATING
C5794 XCH1_GM2A/D4.t1 VGND 0.05867f ; **FLOATING
C5795 XCH1_GM2A/D4.t0 VGND 0.05867f ; **FLOATING
C5796 XCH1_GM2A/D4.n1 VGND 0.11734f ; **FLOATING
C5797 XCH1_GM2A/S4.t0 VGND 0.10058f ; **FLOATING
C5798 XCVCM/C2.t0 VGND 38.743f ; **FLOATING
C5799 XDN_P/B.n0 VGND 0.02158f ; **FLOATING
C5800 XDN_P/B.n1 VGND 0.04309f ; **FLOATING
C5801 XDN_P/B.n2 VGND 0.21103f ; **FLOATING
C5802 XDN_P/B.n3 VGND 0.04181f ; **FLOATING
C5803 XDN_P/B.t2 VGND 0.13586f ; **FLOATING
C5804 XDN_P/B.n4 VGND 0.04309f ; **FLOATING
C5805 XDN_P/B.n5 VGND 0.04309f ; **FLOATING
C5806 XDN_P/B.t0 VGND 0.2044f ; **FLOATING
C5807 XDN_P/B.t1 VGND 0.13586f ; **FLOATING
C5808 XDN_P/B.t3 VGND 0.13586f ; **FLOATING
C5809 XDN_P/B.t4 VGND 0.2044f ; **FLOATING
C5810 XDN_P/B.n6 VGND 0.21103f ; **FLOATING
C5811 XDN_P/B.n7 VGND 0.04324f ; **FLOATING
C5812 XDN_P/G.n0 VGND 0.08361f ; **FLOATING
C5813 XDN_P/G.n1 VGND 0.01127f ; **FLOATING
C5814 XDN_P/G.n2 VGND 0.08585f ; **FLOATING
C5815 XDN_P/G.n3 VGND 0.00939f ; **FLOATING
C5816 XDN_P/G.n4 VGND 0.08585f ; **FLOATING
C5817 XDN_P/G.n5 VGND 0.08585f ; **FLOATING
C5818 XDN_P/G.n6 VGND 0.08585f ; **FLOATING
C5819 XDN_P/G.t0 VGND 0.05347f ; **FLOATING
C5820 XDN_P/G.n7 VGND 0.08711f ; **FLOATING
C5821 XDN_P/G.t1 VGND 0.05347f ; **FLOATING
C5822 XDN_P/G.n8 VGND 0.08585f ; **FLOATING
C5823 XDN_P/G.n9 VGND 0.03046f ; **FLOATING
C5824 XDN_P/G.t2 VGND 0.05347f ; **FLOATING
C5825 XDN_P/G.n10 VGND 0.08585f ; **FLOATING
C5826 XDN_P/G.n11 VGND 0.03046f ; **FLOATING
C5827 XDN_P/G.t3 VGND 0.05347f ; **FLOATING
C5828 XDN_P/G.n12 VGND 0.08585f ; **FLOATING
C5829 XDN_P/G.n13 VGND 0.03046f ; **FLOATING
C5830 XDN_P/G.t4 VGND 0.05347f ; **FLOATING
C5831 XDN_P/G.n14 VGND 0.08711f ; **FLOATING
C5832 XDN_P/G.n15 VGND 0.04161f ; **FLOATING
C5833 XDN_P/G.n16 VGND 0.15992f ; **FLOATING
C5834 XDN_P/G.n17 VGND 0.04161f ; **FLOATING
C5835 XDN_P/G.n18 VGND 0.08585f ; **FLOATING
C5836 XDN_P/D0.n0 VGND 0.04947f ; **FLOATING
C5837 XDN_P/D0.t0 VGND 0.17821f ; **FLOATING
C5838 XDN_P/S1.n0 VGND 0.02401f ; **FLOATING
C5839 XDN_P/S1.t0 VGND 0.07252f ; **FLOATING
C5840 XDN_P/S1.t1 VGND 0.07252f ; **FLOATING
C5841 XDN_P/S1.n1 VGND 0.14503f ; **FLOATING
C5842 XDN_P/D2.n0 VGND 0.06886f ; **FLOATING
C5843 XDN_P/D2.t1 VGND 0.07252f ; **FLOATING
C5844 XDN_P/D2.t0 VGND 0.07252f ; **FLOATING
C5845 XDN_P/D2.n1 VGND 0.14503f ; **FLOATING
C5846 XDN_P/S3.n0 VGND 0.02401f ; **FLOATING
C5847 XDN_P/S3.t1 VGND 0.07252f ; **FLOATING
C5848 XDN_P/S3.t0 VGND 0.07252f ; **FLOATING
C5849 XDN_P/S3.n1 VGND 0.14503f ; **FLOATING
C5850 XDN_P/D4.n0 VGND 0.06886f ; **FLOATING
C5851 XDN_P/D4.t0 VGND 0.07252f ; **FLOATING
C5852 XDN_P/D4.t1 VGND 0.07252f ; **FLOATING
C5853 XDN_P/D4.n1 VGND 0.14503f ; **FLOATING
C5854 XDN_P/S4.n0 VGND 0.01725f ; **FLOATING
C5855 XDN_P/S4.t0 VGND 0.17821f ; **FLOATING
C5856 ch2_lon_raw VGND 21.06126f
C5857 XDN_N/G.n0 VGND 0.03082f ; **FLOATING
C5858 XDN_N/G.n1 VGND 0.00415f ; **FLOATING
C5859 XDN_N/G.n2 VGND 0.02705f ; **FLOATING
C5860 XDN_N/G.n3 VGND 0.00346f ; **FLOATING
C5861 XDN_N/G.n4 VGND 0.02705f ; **FLOATING
C5862 XDN_N/G.n5 VGND 0.02705f ; **FLOATING
C5863 XDN_N/G.n6 VGND 0.02705f ; **FLOATING
C5864 XDN_N/G.t0 VGND 0.01052f ; **FLOATING
C5865 XDN_N/G.n7 VGND 0.02752f ; **FLOATING
C5866 XDN_N/G.t1 VGND 0.01052f ; **FLOATING
C5867 XDN_N/G.n8 VGND 0.02705f ; **FLOATING
C5868 XDN_N/G.n9 VGND 0.01123f ; **FLOATING
C5869 XDN_N/G.t2 VGND 0.01052f ; **FLOATING
C5870 XDN_N/G.n10 VGND 0.02705f ; **FLOATING
C5871 XDN_N/G.n11 VGND 0.01123f ; **FLOATING
C5872 XDN_N/G.t3 VGND 0.01052f ; **FLOATING
C5873 XDN_N/G.n12 VGND 0.02705f ; **FLOATING
C5874 XDN_N/G.n13 VGND 0.01123f ; **FLOATING
C5875 XDN_N/G.t4 VGND 0.01052f ; **FLOATING
C5876 XDN_N/G.n14 VGND 0.02752f ; **FLOATING
C5877 XDN_N/G.n15 VGND 0.01534f ; **FLOATING
C5878 XDN_N/G.n16 VGND 0.05894f ; **FLOATING
C5879 XDN_N/G.n17 VGND 0.01534f ; **FLOATING
C5880 XDN_N/G.n18 VGND 0.02705f ; **FLOATING
C5881 XDN_N/D0.n0 VGND 0.05782f ; **FLOATING
C5882 XDN_N/D0.t0 VGND 0.06633f ; **FLOATING
C5883 XDN_N/S1.t0 VGND 0.04065f ; **FLOATING
C5884 XDN_N/S1.t1 VGND 0.04065f ; **FLOATING
C5885 XDN_N/S1.n0 VGND 0.08129f ; **FLOATING
C5886 XDN_N/D2.n0 VGND 0.1125f ; **FLOATING
C5887 XDN_N/D2.t0 VGND 0.04065f ; **FLOATING
C5888 XDN_N/D2.t1 VGND 0.04065f ; **FLOATING
C5889 XDN_N/D2.n1 VGND 0.08129f ; **FLOATING
C5890 XDN_N/S3.t0 VGND 0.04065f ; **FLOATING
C5891 XDN_N/S3.t1 VGND 0.04065f ; **FLOATING
C5892 XDN_N/S3.n0 VGND 0.08129f ; **FLOATING
C5893 XDN_N/D4.n0 VGND 0.1125f ; **FLOATING
C5894 XDN_N/D4.t1 VGND 0.04065f ; **FLOATING
C5895 XDN_N/D4.t0 VGND 0.04065f ; **FLOATING
C5896 XDN_N/D4.n1 VGND 0.08129f ; **FLOATING
C5897 XDN_N/S4.t0 VGND 0.06633f ; **FLOATING
C5898 XDP_P/B.n0 VGND 0.02158f ; **FLOATING
C5899 XDP_P/B.n1 VGND 0.04309f ; **FLOATING
C5900 XDP_P/B.n2 VGND 0.21103f ; **FLOATING
C5901 XDP_P/B.n3 VGND 0.04181f ; **FLOATING
C5902 XDP_P/B.t2 VGND 0.13586f ; **FLOATING
C5903 XDP_P/B.n4 VGND 0.04309f ; **FLOATING
C5904 XDP_P/B.n5 VGND 0.04309f ; **FLOATING
C5905 XDP_P/B.t0 VGND 0.2044f ; **FLOATING
C5906 XDP_P/B.t1 VGND 0.13586f ; **FLOATING
C5907 XDP_P/B.t3 VGND 0.13586f ; **FLOATING
C5908 XDP_P/B.t4 VGND 0.2044f ; **FLOATING
C5909 XDP_P/B.n6 VGND 0.21103f ; **FLOATING
C5910 XDP_P/B.n7 VGND 0.04324f ; **FLOATING
C5911 XDP_P/G.n0 VGND 0.08361f ; **FLOATING
C5912 XDP_P/G.n1 VGND 0.01127f ; **FLOATING
C5913 XDP_P/G.n2 VGND 0.08585f ; **FLOATING
C5914 XDP_P/G.n3 VGND 0.00939f ; **FLOATING
C5915 XDP_P/G.n4 VGND 0.08585f ; **FLOATING
C5916 XDP_P/G.n5 VGND 0.08585f ; **FLOATING
C5917 XDP_P/G.n6 VGND 0.08585f ; **FLOATING
C5918 XDP_P/G.t0 VGND 0.05347f ; **FLOATING
C5919 XDP_P/G.n7 VGND 0.08711f ; **FLOATING
C5920 XDP_P/G.t1 VGND 0.05347f ; **FLOATING
C5921 XDP_P/G.n8 VGND 0.08585f ; **FLOATING
C5922 XDP_P/G.n9 VGND 0.03046f ; **FLOATING
C5923 XDP_P/G.t2 VGND 0.05347f ; **FLOATING
C5924 XDP_P/G.n10 VGND 0.08585f ; **FLOATING
C5925 XDP_P/G.n11 VGND 0.03046f ; **FLOATING
C5926 XDP_P/G.t3 VGND 0.05347f ; **FLOATING
C5927 XDP_P/G.n12 VGND 0.08585f ; **FLOATING
C5928 XDP_P/G.n13 VGND 0.03046f ; **FLOATING
C5929 XDP_P/G.t4 VGND 0.05347f ; **FLOATING
C5930 XDP_P/G.n14 VGND 0.08711f ; **FLOATING
C5931 XDP_P/G.n15 VGND 0.04161f ; **FLOATING
C5932 XDP_P/G.n16 VGND 0.15992f ; **FLOATING
C5933 XDP_P/G.n17 VGND 0.04161f ; **FLOATING
C5934 XDP_P/G.n18 VGND 0.08585f ; **FLOATING
C5935 XDP_P/D0.n0 VGND 0.04947f ; **FLOATING
C5936 XDP_P/D0.t0 VGND 0.17821f ; **FLOATING
C5937 XDP_P/S1.n0 VGND 0.02401f ; **FLOATING
C5938 XDP_P/S1.t0 VGND 0.07252f ; **FLOATING
C5939 XDP_P/S1.t1 VGND 0.07252f ; **FLOATING
C5940 XDP_P/S1.n1 VGND 0.14503f ; **FLOATING
C5941 XDP_P/D2.n0 VGND 0.06886f ; **FLOATING
C5942 XDP_P/D2.t1 VGND 0.07252f ; **FLOATING
C5943 XDP_P/D2.t0 VGND 0.07252f ; **FLOATING
C5944 XDP_P/D2.n1 VGND 0.14503f ; **FLOATING
C5945 XDP_P/S3.n0 VGND 0.02401f ; **FLOATING
C5946 XDP_P/S3.t1 VGND 0.07252f ; **FLOATING
C5947 XDP_P/S3.t0 VGND 0.07252f ; **FLOATING
C5948 XDP_P/S3.n1 VGND 0.14503f ; **FLOATING
C5949 XDP_P/D4.n0 VGND 0.06886f ; **FLOATING
C5950 XDP_P/D4.t0 VGND 0.07252f ; **FLOATING
C5951 XDP_P/D4.t1 VGND 0.07252f ; **FLOATING
C5952 XDP_P/D4.n1 VGND 0.14503f ; **FLOATING
C5953 XDP_P/S4.n0 VGND 0.01725f ; **FLOATING
C5954 XDP_P/S4.t0 VGND 0.17821f ; **FLOATING
C5955 XLP2_P/B.n0 VGND 0.03174f ; **FLOATING
C5956 XLP2_P/B.n1 VGND 0.06343f ; **FLOATING
C5957 XLP2_P/B.n2 VGND 0.30697f ; **FLOATING
C5958 XLP2_P/B.n3 VGND 0.06218f ; **FLOATING
C5959 XLP2_P/B.t4 VGND 0.19297f ; **FLOATING
C5960 XLP2_P/B.n4 VGND 0.06343f ; **FLOATING
C5961 XLP2_P/B.n5 VGND 0.06343f ; **FLOATING
C5962 XLP2_P/B.t0 VGND 0.28519f ; **FLOATING
C5963 XLP2_P/B.t1 VGND 0.19297f ; **FLOATING
C5964 XLP2_P/B.t2 VGND 0.19297f ; **FLOATING
C5965 XLP2_P/B.t3 VGND 0.19297f ; **FLOATING
C5966 XLP2_P/B.t5 VGND 0.19297f ; **FLOATING
C5967 XLP2_P/B.t6 VGND 0.19297f ; **FLOATING
C5968 XLP2_P/B.t7 VGND 0.19297f ; **FLOATING
C5969 XLP2_P/B.t8 VGND 0.28519f ; **FLOATING
C5970 XLP2_P/B.n6 VGND 0.30697f ; **FLOATING
C5971 XLP2_P/B.n7 VGND 0.06351f ; **FLOATING
C5972 XLP2_P/G.n0 VGND 0.0192f ; **FLOATING
C5973 XLP2_P/G.n1 VGND 0.03206f ; **FLOATING
C5974 XLP2_P/G.n2 VGND 0.08542f ; **FLOATING
C5975 XLP2_P/G.n3 VGND 0.00978f ; **FLOATING
C5976 XLP2_P/G.n4 VGND 0.09831f ; **FLOATING
C5977 XLP2_P/G.n5 VGND 0.00978f ; **FLOATING
C5978 XLP2_P/G.n6 VGND 0.08542f ; **FLOATING
C5979 XLP2_P/G.n7 VGND 0.0297f ; **FLOATING
C5980 XLP2_P/G.n8 VGND 0.09831f ; **FLOATING
C5981 XLP2_P/G.n9 VGND 0.09831f ; **FLOATING
C5982 XLP2_P/G.n10 VGND 0.09831f ; **FLOATING
C5983 XLP2_P/G.n11 VGND 0.09831f ; **FLOATING
C5984 XLP2_P/G.n12 VGND 0.09831f ; **FLOATING
C5985 XLP2_P/G.n13 VGND 0.09831f ; **FLOATING
C5986 XLP2_P/G.n14 VGND 0.09831f ; **FLOATING
C5987 XLP2_P/G.t0 VGND 0.09401f ; **FLOATING
C5988 XLP2_P/G.n15 VGND 0.0994f ; **FLOATING
C5989 XLP2_P/G.t1 VGND 0.09401f ; **FLOATING
C5990 XLP2_P/G.n16 VGND 0.09831f ; **FLOATING
C5991 XLP2_P/G.n17 VGND 0.02643f ; **FLOATING
C5992 XLP2_P/G.t2 VGND 0.09401f ; **FLOATING
C5993 XLP2_P/G.n18 VGND 0.09831f ; **FLOATING
C5994 XLP2_P/G.n19 VGND 0.02643f ; **FLOATING
C5995 XLP2_P/G.t3 VGND 0.09401f ; **FLOATING
C5996 XLP2_P/G.n20 VGND 0.09831f ; **FLOATING
C5997 XLP2_P/G.n21 VGND 0.02643f ; **FLOATING
C5998 XLP2_P/G.t4 VGND 0.09401f ; **FLOATING
C5999 XLP2_P/G.n22 VGND 0.09831f ; **FLOATING
C6000 XLP2_P/G.n23 VGND 0.02643f ; **FLOATING
C6001 XLP2_P/G.t5 VGND 0.09401f ; **FLOATING
C6002 XLP2_P/G.n24 VGND 0.09831f ; **FLOATING
C6003 XLP2_P/G.n25 VGND 0.02643f ; **FLOATING
C6004 XLP2_P/G.t6 VGND 0.09401f ; **FLOATING
C6005 XLP2_P/G.n26 VGND 0.09831f ; **FLOATING
C6006 XLP2_P/G.n27 VGND 0.02643f ; **FLOATING
C6007 XLP2_P/G.t7 VGND 0.09401f ; **FLOATING
C6008 XLP2_P/G.n28 VGND 0.09831f ; **FLOATING
C6009 XLP2_P/G.n29 VGND 0.02643f ; **FLOATING
C6010 XLP2_P/G.t8 VGND 0.09401f ; **FLOATING
C6011 XLP2_P/G.n30 VGND 0.0994f ; **FLOATING
C6012 XLP2_P/G.n31 VGND 0.03611f ; **FLOATING
C6013 XLP2_P/G.n32 VGND 0.08542f ; **FLOATING
C6014 XLP2_P/G.n33 VGND 0.03206f ; **FLOATING
C6015 XLP2_P/G.n34 VGND 0.03206f ; **FLOATING
C6016 XLP2_P/G.n35 VGND 0.03206f ; **FLOATING
C6017 XLP2_P/G.n36 VGND 0.08542f ; **FLOATING
C6018 XLP2_P/G.n37 VGND 0.03611f ; **FLOATING
C6019 XLP2_P/G.n38 VGND 0.09831f ; **FLOATING
C6020 XLP2_P/D0.n0 VGND 0.20111f ; **FLOATING
C6021 XLP2_P/D0.t0 VGND 0.36455f ; **FLOATING
C6022 XLP2_P/S1.n0 VGND 0.26116f ; **FLOATING
C6023 XLP2_P/S1.t0 VGND 0.1491f ; **FLOATING
C6024 XLP2_P/S1.t1 VGND 0.1491f ; **FLOATING
C6025 XLP2_P/S1.n1 VGND 0.2982f ; **FLOATING
C6026 XLP2_P/D2.n0 VGND 0.27845f ; **FLOATING
C6027 XLP2_P/D2.t1 VGND 0.1491f ; **FLOATING
C6028 XLP2_P/D2.t0 VGND 0.1491f ; **FLOATING
C6029 XLP2_P/D2.n1 VGND 0.2982f ; **FLOATING
C6030 XLP2_P/S3.n0 VGND 0.26116f ; **FLOATING
C6031 XLP2_P/S3.t1 VGND 0.1491f ; **FLOATING
C6032 XLP2_P/S3.t0 VGND 0.1491f ; **FLOATING
C6033 XLP2_P/S3.n1 VGND 0.2982f ; **FLOATING
C6034 XLP2_P/D4.n0 VGND 0.27845f ; **FLOATING
C6035 XLP2_P/D4.t1 VGND 0.1491f ; **FLOATING
C6036 XLP2_P/D4.t0 VGND 0.1491f ; **FLOATING
C6037 XLP2_P/D4.n1 VGND 0.2982f ; **FLOATING
C6038 XLP2_P/S5.n0 VGND 0.26116f ; **FLOATING
C6039 XLP2_P/S5.t0 VGND 0.1491f ; **FLOATING
C6040 XLP2_P/S5.t1 VGND 0.1491f ; **FLOATING
C6041 XLP2_P/S5.n1 VGND 0.2982f ; **FLOATING
C6042 XLP2_P/D6.n0 VGND 0.27845f ; **FLOATING
C6043 XLP2_P/D6.t1 VGND 0.1491f ; **FLOATING
C6044 XLP2_P/D6.t0 VGND 0.1491f ; **FLOATING
C6045 XLP2_P/D6.n1 VGND 0.2982f ; **FLOATING
C6046 XLP2_P/S7.n0 VGND 0.26116f ; **FLOATING
C6047 XLP2_P/S7.t1 VGND 0.1491f ; **FLOATING
C6048 XLP2_P/S7.t0 VGND 0.1491f ; **FLOATING
C6049 XLP2_P/S7.n1 VGND 0.2982f ; **FLOATING
C6050 XLP2_P/D8.n0 VGND 0.27845f ; **FLOATING
C6051 XLP2_P/D8.t0 VGND 0.1491f ; **FLOATING
C6052 XLP2_P/D8.t1 VGND 0.1491f ; **FLOATING
C6053 XLP2_P/D8.n1 VGND 0.2982f ; **FLOATING
C6054 XLP2_P/S8.n0 VGND 0.18862f ; **FLOATING
C6055 XLP2_P/S8.t0 VGND 0.36455f ; **FLOATING
C6056 ch2_lop_raw VGND 16.10769f
C6057 XDP_N/G.n0 VGND 0.03082f ; **FLOATING
C6058 XDP_N/G.n1 VGND 0.00415f ; **FLOATING
C6059 XDP_N/G.n2 VGND 0.02705f ; **FLOATING
C6060 XDP_N/G.n3 VGND 0.00346f ; **FLOATING
C6061 XDP_N/G.n4 VGND 0.02705f ; **FLOATING
C6062 XDP_N/G.n5 VGND 0.02705f ; **FLOATING
C6063 XDP_N/G.n6 VGND 0.02705f ; **FLOATING
C6064 XDP_N/G.t0 VGND 0.01052f ; **FLOATING
C6065 XDP_N/G.n7 VGND 0.02752f ; **FLOATING
C6066 XDP_N/G.t1 VGND 0.01052f ; **FLOATING
C6067 XDP_N/G.n8 VGND 0.02705f ; **FLOATING
C6068 XDP_N/G.n9 VGND 0.01123f ; **FLOATING
C6069 XDP_N/G.t2 VGND 0.01052f ; **FLOATING
C6070 XDP_N/G.n10 VGND 0.02705f ; **FLOATING
C6071 XDP_N/G.n11 VGND 0.01123f ; **FLOATING
C6072 XDP_N/G.t3 VGND 0.01052f ; **FLOATING
C6073 XDP_N/G.n12 VGND 0.02705f ; **FLOATING
C6074 XDP_N/G.n13 VGND 0.01123f ; **FLOATING
C6075 XDP_N/G.t4 VGND 0.01052f ; **FLOATING
C6076 XDP_N/G.n14 VGND 0.02752f ; **FLOATING
C6077 XDP_N/G.n15 VGND 0.01534f ; **FLOATING
C6078 XDP_N/G.n16 VGND 0.05894f ; **FLOATING
C6079 XDP_N/G.n17 VGND 0.01534f ; **FLOATING
C6080 XDP_N/G.n18 VGND 0.02705f ; **FLOATING
C6081 XDP_N/D0.n0 VGND 0.05782f ; **FLOATING
C6082 XDP_N/D0.t0 VGND 0.06633f ; **FLOATING
C6083 XDP_N/S1.t0 VGND 0.04065f ; **FLOATING
C6084 XDP_N/S1.t1 VGND 0.04065f ; **FLOATING
C6085 XDP_N/S1.n0 VGND 0.08129f ; **FLOATING
C6086 XDP_N/D2.n0 VGND 0.1125f ; **FLOATING
C6087 XDP_N/D2.t0 VGND 0.04065f ; **FLOATING
C6088 XDP_N/D2.t1 VGND 0.04065f ; **FLOATING
C6089 XDP_N/D2.n1 VGND 0.08129f ; **FLOATING
C6090 XDP_N/S3.t0 VGND 0.04065f ; **FLOATING
C6091 XDP_N/S3.t1 VGND 0.04065f ; **FLOATING
C6092 XDP_N/S3.n0 VGND 0.08129f ; **FLOATING
C6093 XDP_N/D4.n0 VGND 0.1125f ; **FLOATING
C6094 XDP_N/D4.t1 VGND 0.04065f ; **FLOATING
C6095 XDP_N/D4.t0 VGND 0.04065f ; **FLOATING
C6096 XDP_N/D4.n1 VGND 0.08129f ; **FLOATING
C6097 XDP_N/S4.t0 VGND 0.06633f ; **FLOATING
C6098 X1DN_P/B.n0 VGND 0.02158f ; **FLOATING
C6099 X1DN_P/B.n1 VGND 0.04309f ; **FLOATING
C6100 X1DN_P/B.n2 VGND 0.21103f ; **FLOATING
C6101 X1DN_P/B.n3 VGND 0.04181f ; **FLOATING
C6102 X1DN_P/B.t2 VGND 0.13586f ; **FLOATING
C6103 X1DN_P/B.n4 VGND 0.04309f ; **FLOATING
C6104 X1DN_P/B.n5 VGND 0.04309f ; **FLOATING
C6105 X1DN_P/B.t0 VGND 0.2044f ; **FLOATING
C6106 X1DN_P/B.t1 VGND 0.13586f ; **FLOATING
C6107 X1DN_P/B.t3 VGND 0.13586f ; **FLOATING
C6108 X1DN_P/B.t4 VGND 0.2044f ; **FLOATING
C6109 X1DN_P/B.n6 VGND 0.21103f ; **FLOATING
C6110 X1DN_P/B.n7 VGND 0.04324f ; **FLOATING
C6111 X1DN_P/G.n0 VGND 0.08361f ; **FLOATING
C6112 X1DN_P/G.n1 VGND 0.01127f ; **FLOATING
C6113 X1DN_P/G.n2 VGND 0.08585f ; **FLOATING
C6114 X1DN_P/G.n3 VGND 0.00939f ; **FLOATING
C6115 X1DN_P/G.n4 VGND 0.08585f ; **FLOATING
C6116 X1DN_P/G.n5 VGND 0.08585f ; **FLOATING
C6117 X1DN_P/G.n6 VGND 0.08585f ; **FLOATING
C6118 X1DN_P/G.t0 VGND 0.05347f ; **FLOATING
C6119 X1DN_P/G.n7 VGND 0.08711f ; **FLOATING
C6120 X1DN_P/G.t1 VGND 0.05347f ; **FLOATING
C6121 X1DN_P/G.n8 VGND 0.08585f ; **FLOATING
C6122 X1DN_P/G.n9 VGND 0.03046f ; **FLOATING
C6123 X1DN_P/G.t2 VGND 0.05347f ; **FLOATING
C6124 X1DN_P/G.n10 VGND 0.08585f ; **FLOATING
C6125 X1DN_P/G.n11 VGND 0.03046f ; **FLOATING
C6126 X1DN_P/G.t3 VGND 0.05347f ; **FLOATING
C6127 X1DN_P/G.n12 VGND 0.08585f ; **FLOATING
C6128 X1DN_P/G.n13 VGND 0.03046f ; **FLOATING
C6129 X1DN_P/G.t4 VGND 0.05347f ; **FLOATING
C6130 X1DN_P/G.n14 VGND 0.08711f ; **FLOATING
C6131 X1DN_P/G.n15 VGND 0.04161f ; **FLOATING
C6132 X1DN_P/G.n16 VGND 0.15992f ; **FLOATING
C6133 X1DN_P/G.n17 VGND 0.04161f ; **FLOATING
C6134 X1DN_P/G.n18 VGND 0.08585f ; **FLOATING
C6135 X1DN_P/D0.n0 VGND 0.04947f ; **FLOATING
C6136 X1DN_P/D0.t0 VGND 0.17821f ; **FLOATING
C6137 X1DN_P/S1.n0 VGND 0.02401f ; **FLOATING
C6138 X1DN_P/S1.t0 VGND 0.07252f ; **FLOATING
C6139 X1DN_P/S1.t1 VGND 0.07252f ; **FLOATING
C6140 X1DN_P/S1.n1 VGND 0.14503f ; **FLOATING
C6141 X1DN_P/D2.n0 VGND 0.06886f ; **FLOATING
C6142 X1DN_P/D2.t1 VGND 0.07252f ; **FLOATING
C6143 X1DN_P/D2.t0 VGND 0.07252f ; **FLOATING
C6144 X1DN_P/D2.n1 VGND 0.14503f ; **FLOATING
C6145 X1DN_P/S3.n0 VGND 0.02401f ; **FLOATING
C6146 X1DN_P/S3.t1 VGND 0.07252f ; **FLOATING
C6147 X1DN_P/S3.t0 VGND 0.07252f ; **FLOATING
C6148 X1DN_P/S3.n1 VGND 0.14503f ; **FLOATING
C6149 X1DN_P/D4.n0 VGND 0.06886f ; **FLOATING
C6150 X1DN_P/D4.t0 VGND 0.07252f ; **FLOATING
C6151 X1DN_P/D4.t1 VGND 0.07252f ; **FLOATING
C6152 X1DN_P/D4.n1 VGND 0.14503f ; **FLOATING
C6153 X1DN_P/S4.n0 VGND 0.01725f ; **FLOATING
C6154 X1DN_P/S4.t0 VGND 0.17821f ; **FLOATING
C6155 lop VGND 34.3919f
C6156 XLP2_N/G.n0 VGND 0.00884f ; **FLOATING
C6157 XLP2_N/G.n1 VGND 0.01476f ; **FLOATING
C6158 XLP2_N/G.n2 VGND 0.03932f ; **FLOATING
C6159 XLP2_N/G.n3 VGND 0.0045f ; **FLOATING
C6160 XLP2_N/G.n4 VGND 0.0348f ; **FLOATING
C6161 XLP2_N/G.n5 VGND 0.0045f ; **FLOATING
C6162 XLP2_N/G.n6 VGND 0.03932f ; **FLOATING
C6163 XLP2_N/G.n7 VGND 0.01367f ; **FLOATING
C6164 XLP2_N/G.n8 VGND 0.0348f ; **FLOATING
C6165 XLP2_N/G.n9 VGND 0.0348f ; **FLOATING
C6166 XLP2_N/G.n10 VGND 0.0348f ; **FLOATING
C6167 XLP2_N/G.n11 VGND 0.0348f ; **FLOATING
C6168 XLP2_N/G.n12 VGND 0.0348f ; **FLOATING
C6169 XLP2_N/G.n13 VGND 0.0348f ; **FLOATING
C6170 XLP2_N/G.n14 VGND 0.0348f ; **FLOATING
C6171 XLP2_N/G.t0 VGND 0.02236f ; **FLOATING
C6172 XLP2_N/G.n15 VGND 0.0353f ; **FLOATING
C6173 XLP2_N/G.t1 VGND 0.02236f ; **FLOATING
C6174 XLP2_N/G.n16 VGND 0.0348f ; **FLOATING
C6175 XLP2_N/G.n17 VGND 0.01217f ; **FLOATING
C6176 XLP2_N/G.t2 VGND 0.02236f ; **FLOATING
C6177 XLP2_N/G.n18 VGND 0.0348f ; **FLOATING
C6178 XLP2_N/G.n19 VGND 0.01217f ; **FLOATING
C6179 XLP2_N/G.t3 VGND 0.02236f ; **FLOATING
C6180 XLP2_N/G.n20 VGND 0.0348f ; **FLOATING
C6181 XLP2_N/G.n21 VGND 0.01217f ; **FLOATING
C6182 XLP2_N/G.t4 VGND 0.02236f ; **FLOATING
C6183 XLP2_N/G.n22 VGND 0.0348f ; **FLOATING
C6184 XLP2_N/G.n23 VGND 0.01217f ; **FLOATING
C6185 XLP2_N/G.t5 VGND 0.02236f ; **FLOATING
C6186 XLP2_N/G.n24 VGND 0.0348f ; **FLOATING
C6187 XLP2_N/G.n25 VGND 0.01217f ; **FLOATING
C6188 XLP2_N/G.t6 VGND 0.02236f ; **FLOATING
C6189 XLP2_N/G.n26 VGND 0.0348f ; **FLOATING
C6190 XLP2_N/G.n27 VGND 0.01217f ; **FLOATING
C6191 XLP2_N/G.t7 VGND 0.02236f ; **FLOATING
C6192 XLP2_N/G.n28 VGND 0.0348f ; **FLOATING
C6193 XLP2_N/G.n29 VGND 0.01217f ; **FLOATING
C6194 XLP2_N/G.t8 VGND 0.02236f ; **FLOATING
C6195 XLP2_N/G.n30 VGND 0.0353f ; **FLOATING
C6196 XLP2_N/G.n31 VGND 0.01662f ; **FLOATING
C6197 XLP2_N/G.n32 VGND 0.03932f ; **FLOATING
C6198 XLP2_N/G.n33 VGND 0.01476f ; **FLOATING
C6199 XLP2_N/G.n34 VGND 0.01476f ; **FLOATING
C6200 XLP2_N/G.n35 VGND 0.01476f ; **FLOATING
C6201 XLP2_N/G.n36 VGND 0.03932f ; **FLOATING
C6202 XLP2_N/G.n37 VGND 0.01662f ; **FLOATING
C6203 XLP2_N/G.n38 VGND 0.0348f ; **FLOATING
C6204 XLP2_N/D0.t0 VGND 0.1254f ; **FLOATING
C6205 XLP2_N/S1.t1 VGND 0.07819f ; **FLOATING
C6206 XLP2_N/S1.t0 VGND 0.07819f ; **FLOATING
C6207 XLP2_N/S1.n0 VGND 0.15638f ; **FLOATING
C6208 XLP2_N/D2.t0 VGND 0.07819f ; **FLOATING
C6209 XLP2_N/D2.t1 VGND 0.07819f ; **FLOATING
C6210 XLP2_N/D2.n0 VGND 0.15638f ; **FLOATING
C6211 XLP2_N/S3.t1 VGND 0.07819f ; **FLOATING
C6212 XLP2_N/S3.t0 VGND 0.07819f ; **FLOATING
C6213 XLP2_N/S3.n0 VGND 0.15638f ; **FLOATING
C6214 XLP2_N/D4.t0 VGND 0.07819f ; **FLOATING
C6215 XLP2_N/D4.t1 VGND 0.07819f ; **FLOATING
C6216 XLP2_N/D4.n0 VGND 0.15638f ; **FLOATING
C6217 XLP2_N/S5.t0 VGND 0.07819f ; **FLOATING
C6218 XLP2_N/S5.t1 VGND 0.07819f ; **FLOATING
C6219 XLP2_N/S5.n0 VGND 0.15638f ; **FLOATING
C6220 XLP2_N/D6.t1 VGND 0.07819f ; **FLOATING
C6221 XLP2_N/D6.t0 VGND 0.07819f ; **FLOATING
C6222 XLP2_N/D6.n0 VGND 0.15638f ; **FLOATING
C6223 XLP2_N/S7.t0 VGND 0.07819f ; **FLOATING
C6224 XLP2_N/S7.t1 VGND 0.07819f ; **FLOATING
C6225 XLP2_N/S7.n0 VGND 0.15638f ; **FLOATING
C6226 XLP2_N/D8.t0 VGND 0.07819f ; **FLOATING
C6227 XLP2_N/D8.t1 VGND 0.07819f ; **FLOATING
C6228 XLP2_N/D8.n0 VGND 0.15638f ; **FLOATING
C6229 XLP2_N/S8.t0 VGND 0.1254f ; **FLOATING
C6230 XXN_P/B.n0 VGND 0.02158f ; **FLOATING
C6231 XXN_P/B.n1 VGND 0.04309f ; **FLOATING
C6232 XXN_P/B.n2 VGND 0.21103f ; **FLOATING
C6233 XXN_P/B.n3 VGND 0.04181f ; **FLOATING
C6234 XXN_P/B.t2 VGND 0.13586f ; **FLOATING
C6235 XXN_P/B.n4 VGND 0.04309f ; **FLOATING
C6236 XXN_P/B.n5 VGND 0.04309f ; **FLOATING
C6237 XXN_P/B.t0 VGND 0.2044f ; **FLOATING
C6238 XXN_P/B.t1 VGND 0.13586f ; **FLOATING
C6239 XXN_P/B.t3 VGND 0.13586f ; **FLOATING
C6240 XXN_P/B.t4 VGND 0.2044f ; **FLOATING
C6241 XXN_P/B.n6 VGND 0.21103f ; **FLOATING
C6242 XXN_P/B.n7 VGND 0.04324f ; **FLOATING
C6243 XXN_P/G.n0 VGND 0.08361f ; **FLOATING
C6244 XXN_P/G.n1 VGND 0.01127f ; **FLOATING
C6245 XXN_P/G.n2 VGND 0.08585f ; **FLOATING
C6246 XXN_P/G.n3 VGND 0.00939f ; **FLOATING
C6247 XXN_P/G.n4 VGND 0.08585f ; **FLOATING
C6248 XXN_P/G.n5 VGND 0.08585f ; **FLOATING
C6249 XXN_P/G.n6 VGND 0.08585f ; **FLOATING
C6250 XXN_P/G.t0 VGND 0.05347f ; **FLOATING
C6251 XXN_P/G.n7 VGND 0.08711f ; **FLOATING
C6252 XXN_P/G.t1 VGND 0.05347f ; **FLOATING
C6253 XXN_P/G.n8 VGND 0.08585f ; **FLOATING
C6254 XXN_P/G.n9 VGND 0.03046f ; **FLOATING
C6255 XXN_P/G.t2 VGND 0.05347f ; **FLOATING
C6256 XXN_P/G.n10 VGND 0.08585f ; **FLOATING
C6257 XXN_P/G.n11 VGND 0.03046f ; **FLOATING
C6258 XXN_P/G.t3 VGND 0.05347f ; **FLOATING
C6259 XXN_P/G.n12 VGND 0.08585f ; **FLOATING
C6260 XXN_P/G.n13 VGND 0.03046f ; **FLOATING
C6261 XXN_P/G.t4 VGND 0.05347f ; **FLOATING
C6262 XXN_P/G.n14 VGND 0.08711f ; **FLOATING
C6263 XXN_P/G.n15 VGND 0.04161f ; **FLOATING
C6264 XXN_P/G.n16 VGND 0.15992f ; **FLOATING
C6265 XXN_P/G.n17 VGND 0.04161f ; **FLOATING
C6266 XXN_P/G.n18 VGND 0.08585f ; **FLOATING
C6267 XXN_P/D0.n0 VGND 0.04947f ; **FLOATING
C6268 XXN_P/D0.t0 VGND 0.17821f ; **FLOATING
C6269 XXN_P/S1.n0 VGND 0.02401f ; **FLOATING
C6270 XXN_P/S1.t0 VGND 0.07252f ; **FLOATING
C6271 XXN_P/S1.t1 VGND 0.07252f ; **FLOATING
C6272 XXN_P/S1.n1 VGND 0.14503f ; **FLOATING
C6273 XXN_P/D2.n0 VGND 0.06886f ; **FLOATING
C6274 XXN_P/D2.t1 VGND 0.07252f ; **FLOATING
C6275 XXN_P/D2.t0 VGND 0.07252f ; **FLOATING
C6276 XXN_P/D2.n1 VGND 0.14503f ; **FLOATING
C6277 XXN_P/S3.n0 VGND 0.02401f ; **FLOATING
C6278 XXN_P/S3.t1 VGND 0.07252f ; **FLOATING
C6279 XXN_P/S3.t0 VGND 0.07252f ; **FLOATING
C6280 XXN_P/S3.n1 VGND 0.14503f ; **FLOATING
C6281 XXN_P/D4.n0 VGND 0.06886f ; **FLOATING
C6282 XXN_P/D4.t0 VGND 0.07252f ; **FLOATING
C6283 XXN_P/D4.t1 VGND 0.07252f ; **FLOATING
C6284 XXN_P/D4.n1 VGND 0.14503f ; **FLOATING
C6285 XXN_P/S4.n0 VGND 0.01725f ; **FLOATING
C6286 XXN_P/S4.t0 VGND 0.17821f ; **FLOATING
C6287 XCH1LN_P/B.n0 VGND 0.02385f ; **FLOATING
C6288 XCH1LN_P/B.n1 VGND 0.04765f ; **FLOATING
C6289 XCH1LN_P/B.n2 VGND 0.26426f ; **FLOATING
C6290 XCH1LN_P/B.n3 VGND 0.0461f ; **FLOATING
C6291 XCH1LN_P/B.t2 VGND 0.17216f ; **FLOATING
C6292 XCH1LN_P/B.n4 VGND 0.04765f ; **FLOATING
C6293 XCH1LN_P/B.n5 VGND 0.04765f ; **FLOATING
C6294 XCH1LN_P/B.t0 VGND 0.25476f ; **FLOATING
C6295 XCH1LN_P/B.t1 VGND 0.17216f ; **FLOATING
C6296 XCH1LN_P/B.t3 VGND 0.17216f ; **FLOATING
C6297 XCH1LN_P/B.t4 VGND 0.25476f ; **FLOATING
C6298 XCH1LN_P/B.n6 VGND 0.26426f ; **FLOATING
C6299 XCH1LN_P/B.n7 VGND 0.04738f ; **FLOATING
C6300 XCH1LN_P/G.n0 VGND 0.07604f ; **FLOATING
C6301 XCH1LN_P/G.n1 VGND 0.01025f ; **FLOATING
C6302 XCH1LN_P/G.n2 VGND 0.09845f ; **FLOATING
C6303 XCH1LN_P/G.n3 VGND 0.00854f ; **FLOATING
C6304 XCH1LN_P/G.n4 VGND 0.09845f ; **FLOATING
C6305 XCH1LN_P/G.n5 VGND 0.09845f ; **FLOATING
C6306 XCH1LN_P/G.n6 VGND 0.09845f ; **FLOATING
C6307 XCH1LN_P/G.t0 VGND 0.08936f ; **FLOATING
C6308 XCH1LN_P/G.n7 VGND 0.09959f ; **FLOATING
C6309 XCH1LN_P/G.t1 VGND 0.08936f ; **FLOATING
C6310 XCH1LN_P/G.n8 VGND 0.09845f ; **FLOATING
C6311 XCH1LN_P/G.n9 VGND 0.0277f ; **FLOATING
C6312 XCH1LN_P/G.t2 VGND 0.08936f ; **FLOATING
C6313 XCH1LN_P/G.n10 VGND 0.09845f ; **FLOATING
C6314 XCH1LN_P/G.n11 VGND 0.0277f ; **FLOATING
C6315 XCH1LN_P/G.t3 VGND 0.08936f ; **FLOATING
C6316 XCH1LN_P/G.n12 VGND 0.09845f ; **FLOATING
C6317 XCH1LN_P/G.n13 VGND 0.0277f ; **FLOATING
C6318 XCH1LN_P/G.t4 VGND 0.08936f ; **FLOATING
C6319 XCH1LN_P/G.n14 VGND 0.09959f ; **FLOATING
C6320 XCH1LN_P/G.n15 VGND 0.03784f ; **FLOATING
C6321 XCH1LN_P/G.n16 VGND 0.14544f ; **FLOATING
C6322 XCH1LN_P/G.n17 VGND 0.03784f ; **FLOATING
C6323 XCH1LN_P/G.n18 VGND 0.09845f ; **FLOATING
C6324 XCH1LN_P/D0.n0 VGND 0.19369f ; **FLOATING
C6325 XCH1LN_P/D0.t0 VGND 0.33005f ; **FLOATING
C6326 XCH1LN_P/S1.t0 VGND 0.13508f ; **FLOATING
C6327 XCH1LN_P/S1.t1 VGND 0.13508f ; **FLOATING
C6328 XCH1LN_P/S1.n0 VGND 0.27017f ; **FLOATING
C6329 XCH1LN_P/D2.n0 VGND 0.26834f ; **FLOATING
C6330 XCH1LN_P/D2.t1 VGND 0.13508f ; **FLOATING
C6331 XCH1LN_P/D2.t0 VGND 0.13508f ; **FLOATING
C6332 XCH1LN_P/D2.n1 VGND 0.27017f ; **FLOATING
C6333 XCH1LN_P/S3.t0 VGND 0.13508f ; **FLOATING
C6334 XCH1LN_P/S3.t1 VGND 0.13508f ; **FLOATING
C6335 XCH1LN_P/S3.n0 VGND 0.27017f ; **FLOATING
C6336 XCH1LN_P/D4.n0 VGND 0.26834f ; **FLOATING
C6337 XCH1LN_P/D4.t0 VGND 0.13508f ; **FLOATING
C6338 XCH1LN_P/D4.t1 VGND 0.13508f ; **FLOATING
C6339 XCH1LN_P/D4.n1 VGND 0.27017f ; **FLOATING
C6340 XCH1LN_P/S4.t0 VGND 0.33005f ; **FLOATING
